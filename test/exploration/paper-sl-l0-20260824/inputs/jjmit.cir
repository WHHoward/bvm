* Frozen local copy for PAPER-SL-L0; SHA is recorded in the manifest.
* Unified JJ Model — area-scaled jjmit for all circuits
* ColdFlux SFQ5ee standard: Ic×RN=1.6mV, R0/RN=10, CAP∝IC
.model jjmit jj(RTYPE=1, VG=2.8m, CAP=0.07p, r0=160, rn=16, icrit=0.1m)
