* RENDER_FIXTURE_ONLY — not JoSIM experiment evidence
* Generated top-level deck; component parameters live only in source snapshots.
.title BVM array -> QB/CB/sJTL topology fixture
.include "snapshot/sources/bvm_cell_0923.cir"
.include "snapshot/sources/BQ_0923.cir"
.include "snapshot/sources/CB_0923.cir"
.include "snapshot/sources/sJTL_0923.cir"
.include "stimulus.inc"

XBVM1 WL1 BL1 SE1 BVM1_SL BVM
XBQ1 BVM1_SL MERGE1 BQ
XSJTL1_01 MERGE1 L1_01 sJTL
XSJTL1_02 L1_01 L1_02 sJTL
XSJTL1_03 L1_02 L1_03 sJTL
XSJTL1_04 L1_03 L1_04 sJTL
XSJTL1_05 L1_04 L1_05 sJTL
XSJTL1_06 L1_05 L1_06 sJTL
XSJTL1_07 L1_06 L1_07 sJTL
XSJTL1_08 L1_07 L1_08 sJTL
XSJTL1_09 L1_08 L1_09 sJTL
XSJTL1_10 L1_09 L1_10 sJTL
XSJTL1_11 L1_10 L1_11 sJTL
XSJTL1_12 L1_11 L1_12 sJTL
XSJTL1_13 L1_12 L1_13 sJTL
XPOSTCB1 L1_13 MERGE2 CB
XBVM2 WL2 BL2 SE2 BVM2_SL BVM
XBQ2 BVM2_SL QB2_RAW BQ
XQBCB2 QB2_RAW MERGE2 CB
XSJTL2_01 MERGE2 L2_01 sJTL
XSJTL2_02 L2_01 FINAL_OUT sJTL

R_TERM FINAL_OUT 0 2
.print I(I_WL1)
.print I(I_BL1)
.print I(I_SE1)
.print P(B_JM1|XBVM1)
.print V(B_JM1|XBVM1)
.print I(B_JM1|XBVM1)
.print P(B_JM2|XBVM1)
.print V(B_JM2|XBVM1)
.print I(B_JM2|XBVM1)
.print P(B_JS1|XBVM1)
.print V(B_JS1|XBVM1)
.print I(B_JS1|XBVM1)
.print P(B_JS2|XBVM1)
.print V(B_JS2|XBVM1)
.print I(B_JS2|XBVM1)
.print I(L_M1|XBVM1)
.print V(L_M1|XBVM1)
.print I(L_M2|XBVM1)
.print V(L_M2|XBVM1)
.print I(L_M3|XBVM1)
.print V(L_M3|XBVM1)
.print I(L_PM|XBVM1)
.print V(L_PM|XBVM1)
.print I(L_SL|XBVM1)
.print V(L_SL|XBVM1)
.print I(R_SL|XBVM1)
.print V(R_SL|XBVM1)
.print V(BVM1_SL)
.print P(BJ1|XBQ1)
.print V(BJ1|XBQ1)
.print I(BJ1|XBQ1)
.print P(BJ2|XBQ1)
.print V(BJ2|XBQ1)
.print I(BJ2|XBQ1)
.print P(BJ3|XBQ1)
.print V(BJ3|XBQ1)
.print I(BJ3|XBQ1)
.print I(LIN|XBQ1)
.print V(LIN|XBQ1)
.print I(L1|XBQ1)
.print V(L1|XBQ1)
.print I(L2|XBQ1)
.print V(L2|XBQ1)
.print I(L3|XBQ1)
.print V(L3|XBQ1)
.print V(MERGE1)
.print I(I_WL2)
.print I(I_BL2)
.print I(I_SE2)
.print P(B_JM1|XBVM2)
.print V(B_JM1|XBVM2)
.print I(B_JM1|XBVM2)
.print P(B_JM2|XBVM2)
.print V(B_JM2|XBVM2)
.print I(B_JM2|XBVM2)
.print P(B_JS1|XBVM2)
.print V(B_JS1|XBVM2)
.print I(B_JS1|XBVM2)
.print P(B_JS2|XBVM2)
.print V(B_JS2|XBVM2)
.print I(B_JS2|XBVM2)
.print I(L_M1|XBVM2)
.print V(L_M1|XBVM2)
.print I(L_M2|XBVM2)
.print V(L_M2|XBVM2)
.print I(L_M3|XBVM2)
.print V(L_M3|XBVM2)
.print I(L_PM|XBVM2)
.print V(L_PM|XBVM2)
.print I(L_SL|XBVM2)
.print V(L_SL|XBVM2)
.print I(R_SL|XBVM2)
.print V(R_SL|XBVM2)
.print V(BVM2_SL)
.print P(BJ1|XBQ2)
.print V(BJ1|XBQ2)
.print I(BJ1|XBQ2)
.print P(BJ2|XBQ2)
.print V(BJ2|XBQ2)
.print I(BJ2|XBQ2)
.print P(BJ3|XBQ2)
.print V(BJ3|XBQ2)
.print I(BJ3|XBQ2)
.print I(LIN|XBQ2)
.print V(LIN|XBQ2)
.print I(L1|XBQ2)
.print V(L1|XBQ2)
.print I(L2|XBQ2)
.print V(L2|XBQ2)
.print I(L3|XBQ2)
.print V(L3|XBQ2)
.print V(QB2_RAW)
.print P(BJ1|XPOSTCB1)
.print V(BJ1|XPOSTCB1)
.print I(BJ1|XPOSTCB1)
.print P(BJ2|XPOSTCB1)
.print V(BJ2|XPOSTCB1)
.print I(BJ2|XPOSTCB1)
.print I(L1|XPOSTCB1)
.print V(L1|XPOSTCB1)
.print I(L2|XPOSTCB1)
.print V(L2|XPOSTCB1)
.print I(L3|XPOSTCB1)
.print V(L3|XPOSTCB1)
.print I(L4|XPOSTCB1)
.print V(L4|XPOSTCB1)
.print V(MERGE2)
.print P(BJ1|XSJTL1_01)
.print V(BJ1|XSJTL1_01)
.print I(BJ1|XSJTL1_01)
.print I(L1|XSJTL1_01)
.print V(L1|XSJTL1_01)
.print I(L2|XSJTL1_01)
.print V(L2|XSJTL1_01)
.print V(L1_01)
.print P(BJ1|XSJTL1_02)
.print V(BJ1|XSJTL1_02)
.print I(BJ1|XSJTL1_02)
.print I(L1|XSJTL1_02)
.print V(L1|XSJTL1_02)
.print I(L2|XSJTL1_02)
.print V(L2|XSJTL1_02)
.print V(L1_02)
.print P(BJ1|XSJTL1_03)
.print V(BJ1|XSJTL1_03)
.print I(BJ1|XSJTL1_03)
.print I(L1|XSJTL1_03)
.print V(L1|XSJTL1_03)
.print I(L2|XSJTL1_03)
.print V(L2|XSJTL1_03)
.print V(L1_03)
.print P(BJ1|XSJTL1_04)
.print V(BJ1|XSJTL1_04)
.print I(BJ1|XSJTL1_04)
.print I(L1|XSJTL1_04)
.print V(L1|XSJTL1_04)
.print I(L2|XSJTL1_04)
.print V(L2|XSJTL1_04)
.print V(L1_04)
.print P(BJ1|XSJTL1_05)
.print V(BJ1|XSJTL1_05)
.print I(BJ1|XSJTL1_05)
.print I(L1|XSJTL1_05)
.print V(L1|XSJTL1_05)
.print I(L2|XSJTL1_05)
.print V(L2|XSJTL1_05)
.print V(L1_05)
.print P(BJ1|XSJTL1_06)
.print V(BJ1|XSJTL1_06)
.print I(BJ1|XSJTL1_06)
.print I(L1|XSJTL1_06)
.print V(L1|XSJTL1_06)
.print I(L2|XSJTL1_06)
.print V(L2|XSJTL1_06)
.print V(L1_06)
.print P(BJ1|XSJTL1_07)
.print V(BJ1|XSJTL1_07)
.print I(BJ1|XSJTL1_07)
.print I(L1|XSJTL1_07)
.print V(L1|XSJTL1_07)
.print I(L2|XSJTL1_07)
.print V(L2|XSJTL1_07)
.print V(L1_07)
.print P(BJ1|XSJTL1_08)
.print V(BJ1|XSJTL1_08)
.print I(BJ1|XSJTL1_08)
.print I(L1|XSJTL1_08)
.print V(L1|XSJTL1_08)
.print I(L2|XSJTL1_08)
.print V(L2|XSJTL1_08)
.print V(L1_08)
.print P(BJ1|XSJTL1_09)
.print V(BJ1|XSJTL1_09)
.print I(BJ1|XSJTL1_09)
.print I(L1|XSJTL1_09)
.print V(L1|XSJTL1_09)
.print I(L2|XSJTL1_09)
.print V(L2|XSJTL1_09)
.print V(L1_09)
.print P(BJ1|XSJTL1_10)
.print V(BJ1|XSJTL1_10)
.print I(BJ1|XSJTL1_10)
.print I(L1|XSJTL1_10)
.print V(L1|XSJTL1_10)
.print I(L2|XSJTL1_10)
.print V(L2|XSJTL1_10)
.print V(L1_10)
.print P(BJ1|XSJTL1_11)
.print V(BJ1|XSJTL1_11)
.print I(BJ1|XSJTL1_11)
.print I(L1|XSJTL1_11)
.print V(L1|XSJTL1_11)
.print I(L2|XSJTL1_11)
.print V(L2|XSJTL1_11)
.print V(L1_11)
.print P(BJ1|XSJTL1_12)
.print V(BJ1|XSJTL1_12)
.print I(BJ1|XSJTL1_12)
.print I(L1|XSJTL1_12)
.print V(L1|XSJTL1_12)
.print I(L2|XSJTL1_12)
.print V(L2|XSJTL1_12)
.print V(L1_12)
.print P(BJ1|XSJTL1_13)
.print V(BJ1|XSJTL1_13)
.print I(BJ1|XSJTL1_13)
.print I(L1|XSJTL1_13)
.print V(L1|XSJTL1_13)
.print I(L2|XSJTL1_13)
.print V(L2|XSJTL1_13)
.print V(L1_13)
.print P(BJ1|XQBCB2)
.print V(BJ1|XQBCB2)
.print I(BJ1|XQBCB2)
.print P(BJ2|XQBCB2)
.print V(BJ2|XQBCB2)
.print I(BJ2|XQBCB2)
.print I(L1|XQBCB2)
.print V(L1|XQBCB2)
.print I(L2|XQBCB2)
.print V(L2|XQBCB2)
.print I(L3|XQBCB2)
.print V(L3|XQBCB2)
.print I(L4|XQBCB2)
.print V(L4|XQBCB2)
.print V(FINAL_OUT)
.print P(BJ1|XSJTL2_01)
.print V(BJ1|XSJTL2_01)
.print I(BJ1|XSJTL2_01)
.print I(L1|XSJTL2_01)
.print V(L1|XSJTL2_01)
.print I(L2|XSJTL2_01)
.print V(L2|XSJTL2_01)
.print V(L2_01)
.print P(BJ1|XSJTL2_02)
.print V(BJ1|XSJTL2_02)
.print I(BJ1|XSJTL2_02)
.print I(L1|XSJTL2_02)
.print V(L1|XSJTL2_02)
.print I(L2|XSJTL2_02)
.print V(L2|XSJTL2_02)
.print V(R_TERM)
.print I(R_TERM)
.tran 0.01p 200p
.end
