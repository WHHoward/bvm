.include jjmit.cir
.include bvm_cell.cir
.include r5c-receiver.cir

* R5-A case logical1-read0-control: canonical stimulus; biased quantizer via weak mutual.

XBVM1 WL1 BL1 SE1 SL1 BVM
XTRIG SL1 R5A_SOURCE_CAPTURE

I_WL1 0 WL1 pwl(0p 0 10p 0 11p +100U 20p +100U 21p 0 170p 0)
I_BL1 0 BL1 pwl(0p 0 10p 0 11p +100U 20p +100U 21p 0 170p 0)
I_SE1 0 SE1 pwl(0p 0 170p 0)

.tran 0.0125p 170p
* R5-A probes: source, primary, quantizer, guards, storage, stimulus record.
.print P(B_TRIG|XTRIG) V(B_TRIG|XTRIG) I(B_TRIG|XTRIG) I(R_IN|XTRIG)
.print I(L_TX|XTRIG)
.print P(B_SET|XTRIG) V(B_SET|XTRIG) I(B_SET|XTRIG) I(L_QB|XTRIG) I(R_GAUGE|XTRIG)
.print V(SL1) V(N6|XBVM1)
.print P(B_JM1|XBVM1) V(B_JM1|XBVM1) P(B_JM2|XBVM1) V(B_JM2|XBVM1)
.print P(B_JS1|XBVM1) V(B_JS1|XBVM1) P(B_JS2|XBVM1) V(B_JS2|XBVM1)
.print I(I_WL1) I(I_BL1) I(I_SE1)
