* 2x2 BVM row/column selection platform; two isolated column merge chains; no T1.
* MERGE_Cn_Lm names are electrical shared nodes, not MERGE subcircuit instances.
* Per column: QB1->MERGE1->sJTL1->CB1->MERGE2; QB2 also feeds MERGE2->sJTL2->CB2->VOUT.
* Canonical component sources are direct includes and remain unchanged.
.include ../../../../../circuits/models/jjmit.cir
.include ../../../../../circuits/bvm/bvm_cell_0923.cir
.include ../../../../../circuits/qb/BQ_0928.cir
.include ../../../../../circuits/sJTL_0923.cir
.include ../../../../../circuits/CB/CB_0928.cir

* One PWL current driver for each independent input line.
.include stimulus.inc

* One 2-ohm termination per independent column VOUT.
* FINAL READ has zero BL drive.
XBVM_R1C1 WL_R1 BL_C1 SE_R1C1 SL_R1C1 BVM
XBQ_R1C1 SL_R1C1 MERGE_C1_L1 BQ
XSJTL_C1_L1 MERGE_C1_L1 SJTL_OUT_C1_L1 sJTL
XCB_C1_L1 SJTL_OUT_C1_L1 MERGE_C1_L2 CB
XBVM_R2C1 WL_R2 BL_C1 SE_R2C1 SL_R2C1 BVM
XBQ_R2C1 SL_R2C1 MERGE_C1_L2 BQ
XSJTL_C1_L2 MERGE_C1_L2 SJTL_OUT_C1_L2 sJTL
XCB_C1_L2 SJTL_OUT_C1_L2 VOUT_C1 CB
R_TERM_C1 VOUT_C1 0 2
XBVM_R1C2 WL_R1 BL_C2 SE_R1C2 SL_R1C2 BVM
XBQ_R1C2 SL_R1C2 MERGE_C2_L1 BQ
XSJTL_C2_L1 MERGE_C2_L1 SJTL_OUT_C2_L1 sJTL
XCB_C2_L1 SJTL_OUT_C2_L1 MERGE_C2_L2 CB
XBVM_R2C2 WL_R2 BL_C2 SE_R2C2 SL_R2C2 BVM
XBQ_R2C2 SL_R2C2 MERGE_C2_L2 BQ
XSJTL_C2_L2 MERGE_C2_L2 SJTL_OUT_C2_L2 sJTL
XCB_C2_L2 SJTL_OUT_C2_L2 VOUT_C2 CB
R_TERM_C2 VOUT_C2 0 2

* Registered raw probes.
.print I(I_WL_R1)
.print I(I_WL_R2)
.print I(I_BL_C1)
.print I(I_BL_C2)
.print I(I_SE_R1C1)
.print I(I_SE_R1C2)
.print I(I_SE_R2C1)
.print I(I_SE_R2C2)
.print I(R_WL|XBVM_R1C1)
.print I(R_BL|XBVM_R1C1)
.print I(R_SE|XBVM_R1C1)
.print V(SL_R1C1)
.print I(L_SL|XBVM_R1C1)
.print P(B_JM1|XBVM_R1C1)
.print V(B_JM1|XBVM_R1C1)
.print P(B_JM2|XBVM_R1C1)
.print V(B_JM2|XBVM_R1C1)
.print P(B_JS1|XBVM_R1C1)
.print V(B_JS1|XBVM_R1C1)
.print P(B_JS2|XBVM_R1C1)
.print V(B_JS2|XBVM_R1C1)
.print P(BJ1|XBQ_R1C1)
.print V(BJ1|XBQ_R1C1)
.print P(BJ2|XBQ_R1C1)
.print V(BJ2|XBQ_R1C1)
.print P(BJ3|XBQ_R1C1)
.print V(BJ3|XBQ_R1C1)
.print I(BJ1|XBQ_R1C1)
.print I(BJ2|XBQ_R1C1)
.print I(BJ3|XBQ_R1C1)
.print I(LIN|XBQ_R1C1)
.print V(LIN|XBQ_R1C1)
.print I(L1|XBQ_R1C1)
.print V(L1|XBQ_R1C1)
.print I(L2|XBQ_R1C1)
.print V(L2|XBQ_R1C1)
.print I(L3|XBQ_R1C1)
.print V(L3|XBQ_R1C1)
.print I(RJ1|XBQ_R1C1)
.print V(RJ1|XBQ_R1C1)
.print I(RJ2|XBQ_R1C1)
.print V(RJ2|XBQ_R1C1)
.print I(RJ3|XBQ_R1C1)
.print V(RJ3|XBQ_R1C1)
.print I(IB2|XBQ_R1C1)
.print V(MERGE_C1_L1)
.print P(BJ1|XSJTL_C1_L1)
.print V(BJ1|XSJTL_C1_L1)
.print I(BJ1|XSJTL_C1_L1)
.print I(L1|XSJTL_C1_L1)
.print V(L1|XSJTL_C1_L1)
.print I(L2|XSJTL_C1_L1)
.print V(L2|XSJTL_C1_L1)
.print I(RJ1|XSJTL_C1_L1)
.print V(RJ1|XSJTL_C1_L1)
.print I(IB1|XSJTL_C1_L1)
.print V(SJTL_OUT_C1_L1)
.print P(BJ1|XCB_C1_L1)
.print V(BJ1|XCB_C1_L1)
.print P(BJ2|XCB_C1_L1)
.print V(BJ2|XCB_C1_L1)
.print I(BJ1|XCB_C1_L1)
.print I(BJ2|XCB_C1_L1)
.print I(L1|XCB_C1_L1)
.print V(L1|XCB_C1_L1)
.print I(L2|XCB_C1_L1)
.print V(L2|XCB_C1_L1)
.print I(L3|XCB_C1_L1)
.print V(L3|XCB_C1_L1)
.print I(L4|XCB_C1_L1)
.print V(L4|XCB_C1_L1)
.print I(RJ1|XCB_C1_L1)
.print V(RJ1|XCB_C1_L1)
.print I(RJ2|XCB_C1_L1)
.print V(RJ2|XCB_C1_L1)
.print I(IB1|XCB_C1_L1)
.print V(VOUT_C1)
.print I(R_TERM_C1)
.print I(R_WL|XBVM_R1C2)
.print I(R_BL|XBVM_R1C2)
.print I(R_SE|XBVM_R1C2)
.print V(SL_R1C2)
.print I(L_SL|XBVM_R1C2)
.print P(B_JM1|XBVM_R1C2)
.print V(B_JM1|XBVM_R1C2)
.print P(B_JM2|XBVM_R1C2)
.print V(B_JM2|XBVM_R1C2)
.print P(B_JS1|XBVM_R1C2)
.print V(B_JS1|XBVM_R1C2)
.print P(B_JS2|XBVM_R1C2)
.print V(B_JS2|XBVM_R1C2)
.print P(BJ1|XBQ_R1C2)
.print V(BJ1|XBQ_R1C2)
.print P(BJ2|XBQ_R1C2)
.print V(BJ2|XBQ_R1C2)
.print P(BJ3|XBQ_R1C2)
.print V(BJ3|XBQ_R1C2)
.print I(BJ1|XBQ_R1C2)
.print I(BJ2|XBQ_R1C2)
.print I(BJ3|XBQ_R1C2)
.print I(LIN|XBQ_R1C2)
.print V(LIN|XBQ_R1C2)
.print I(L1|XBQ_R1C2)
.print V(L1|XBQ_R1C2)
.print I(L2|XBQ_R1C2)
.print V(L2|XBQ_R1C2)
.print I(L3|XBQ_R1C2)
.print V(L3|XBQ_R1C2)
.print I(RJ1|XBQ_R1C2)
.print V(RJ1|XBQ_R1C2)
.print I(RJ2|XBQ_R1C2)
.print V(RJ2|XBQ_R1C2)
.print I(RJ3|XBQ_R1C2)
.print V(RJ3|XBQ_R1C2)
.print I(IB2|XBQ_R1C2)
.print V(MERGE_C2_L1)
.print P(BJ1|XSJTL_C2_L1)
.print V(BJ1|XSJTL_C2_L1)
.print I(BJ1|XSJTL_C2_L1)
.print I(L1|XSJTL_C2_L1)
.print V(L1|XSJTL_C2_L1)
.print I(L2|XSJTL_C2_L1)
.print V(L2|XSJTL_C2_L1)
.print I(RJ1|XSJTL_C2_L1)
.print V(RJ1|XSJTL_C2_L1)
.print I(IB1|XSJTL_C2_L1)
.print V(SJTL_OUT_C2_L1)
.print P(BJ1|XCB_C2_L1)
.print V(BJ1|XCB_C2_L1)
.print P(BJ2|XCB_C2_L1)
.print V(BJ2|XCB_C2_L1)
.print I(BJ1|XCB_C2_L1)
.print I(BJ2|XCB_C2_L1)
.print I(L1|XCB_C2_L1)
.print V(L1|XCB_C2_L1)
.print I(L2|XCB_C2_L1)
.print V(L2|XCB_C2_L1)
.print I(L3|XCB_C2_L1)
.print V(L3|XCB_C2_L1)
.print I(L4|XCB_C2_L1)
.print V(L4|XCB_C2_L1)
.print I(RJ1|XCB_C2_L1)
.print V(RJ1|XCB_C2_L1)
.print I(RJ2|XCB_C2_L1)
.print V(RJ2|XCB_C2_L1)
.print I(IB1|XCB_C2_L1)
.print V(VOUT_C2)
.print I(R_TERM_C2)
.print I(R_WL|XBVM_R2C1)
.print I(R_BL|XBVM_R2C1)
.print I(R_SE|XBVM_R2C1)
.print V(SL_R2C1)
.print I(L_SL|XBVM_R2C1)
.print P(B_JM1|XBVM_R2C1)
.print V(B_JM1|XBVM_R2C1)
.print P(B_JM2|XBVM_R2C1)
.print V(B_JM2|XBVM_R2C1)
.print P(B_JS1|XBVM_R2C1)
.print V(B_JS1|XBVM_R2C1)
.print P(B_JS2|XBVM_R2C1)
.print V(B_JS2|XBVM_R2C1)
.print P(BJ1|XBQ_R2C1)
.print V(BJ1|XBQ_R2C1)
.print P(BJ2|XBQ_R2C1)
.print V(BJ2|XBQ_R2C1)
.print P(BJ3|XBQ_R2C1)
.print V(BJ3|XBQ_R2C1)
.print I(BJ1|XBQ_R2C1)
.print I(BJ2|XBQ_R2C1)
.print I(BJ3|XBQ_R2C1)
.print I(LIN|XBQ_R2C1)
.print V(LIN|XBQ_R2C1)
.print I(L1|XBQ_R2C1)
.print V(L1|XBQ_R2C1)
.print I(L2|XBQ_R2C1)
.print V(L2|XBQ_R2C1)
.print I(L3|XBQ_R2C1)
.print V(L3|XBQ_R2C1)
.print I(RJ1|XBQ_R2C1)
.print V(RJ1|XBQ_R2C1)
.print I(RJ2|XBQ_R2C1)
.print V(RJ2|XBQ_R2C1)
.print I(RJ3|XBQ_R2C1)
.print V(RJ3|XBQ_R2C1)
.print I(IB2|XBQ_R2C1)
.print V(MERGE_C1_L2)
.print P(BJ1|XSJTL_C1_L2)
.print V(BJ1|XSJTL_C1_L2)
.print I(BJ1|XSJTL_C1_L2)
.print I(L1|XSJTL_C1_L2)
.print V(L1|XSJTL_C1_L2)
.print I(L2|XSJTL_C1_L2)
.print V(L2|XSJTL_C1_L2)
.print I(RJ1|XSJTL_C1_L2)
.print V(RJ1|XSJTL_C1_L2)
.print I(IB1|XSJTL_C1_L2)
.print V(SJTL_OUT_C1_L2)
.print P(BJ1|XCB_C1_L2)
.print V(BJ1|XCB_C1_L2)
.print P(BJ2|XCB_C1_L2)
.print V(BJ2|XCB_C1_L2)
.print I(BJ1|XCB_C1_L2)
.print I(BJ2|XCB_C1_L2)
.print I(L1|XCB_C1_L2)
.print V(L1|XCB_C1_L2)
.print I(L2|XCB_C1_L2)
.print V(L2|XCB_C1_L2)
.print I(L3|XCB_C1_L2)
.print V(L3|XCB_C1_L2)
.print I(L4|XCB_C1_L2)
.print V(L4|XCB_C1_L2)
.print I(RJ1|XCB_C1_L2)
.print V(RJ1|XCB_C1_L2)
.print I(RJ2|XCB_C1_L2)
.print V(RJ2|XCB_C1_L2)
.print I(IB1|XCB_C1_L2)
.print I(R_WL|XBVM_R2C2)
.print I(R_BL|XBVM_R2C2)
.print I(R_SE|XBVM_R2C2)
.print V(SL_R2C2)
.print I(L_SL|XBVM_R2C2)
.print P(B_JM1|XBVM_R2C2)
.print V(B_JM1|XBVM_R2C2)
.print P(B_JM2|XBVM_R2C2)
.print V(B_JM2|XBVM_R2C2)
.print P(B_JS1|XBVM_R2C2)
.print V(B_JS1|XBVM_R2C2)
.print P(B_JS2|XBVM_R2C2)
.print V(B_JS2|XBVM_R2C2)
.print P(BJ1|XBQ_R2C2)
.print V(BJ1|XBQ_R2C2)
.print P(BJ2|XBQ_R2C2)
.print V(BJ2|XBQ_R2C2)
.print P(BJ3|XBQ_R2C2)
.print V(BJ3|XBQ_R2C2)
.print I(BJ1|XBQ_R2C2)
.print I(BJ2|XBQ_R2C2)
.print I(BJ3|XBQ_R2C2)
.print I(LIN|XBQ_R2C2)
.print V(LIN|XBQ_R2C2)
.print I(L1|XBQ_R2C2)
.print V(L1|XBQ_R2C2)
.print I(L2|XBQ_R2C2)
.print V(L2|XBQ_R2C2)
.print I(L3|XBQ_R2C2)
.print V(L3|XBQ_R2C2)
.print I(RJ1|XBQ_R2C2)
.print V(RJ1|XBQ_R2C2)
.print I(RJ2|XBQ_R2C2)
.print V(RJ2|XBQ_R2C2)
.print I(RJ3|XBQ_R2C2)
.print V(RJ3|XBQ_R2C2)
.print I(IB2|XBQ_R2C2)
.print V(MERGE_C2_L2)
.print P(BJ1|XSJTL_C2_L2)
.print V(BJ1|XSJTL_C2_L2)
.print I(BJ1|XSJTL_C2_L2)
.print I(L1|XSJTL_C2_L2)
.print V(L1|XSJTL_C2_L2)
.print I(L2|XSJTL_C2_L2)
.print V(L2|XSJTL_C2_L2)
.print I(RJ1|XSJTL_C2_L2)
.print V(RJ1|XSJTL_C2_L2)
.print I(IB1|XSJTL_C2_L2)
.print V(SJTL_OUT_C2_L2)
.print P(BJ1|XCB_C2_L2)
.print V(BJ1|XCB_C2_L2)
.print P(BJ2|XCB_C2_L2)
.print V(BJ2|XCB_C2_L2)
.print I(BJ1|XCB_C2_L2)
.print I(BJ2|XCB_C2_L2)
.print I(L1|XCB_C2_L2)
.print V(L1|XCB_C2_L2)
.print I(L2|XCB_C2_L2)
.print V(L2|XCB_C2_L2)
.print I(L3|XCB_C2_L2)
.print V(L3|XCB_C2_L2)
.print I(L4|XCB_C2_L2)
.print V(L4|XCB_C2_L2)
.print I(RJ1|XCB_C2_L2)
.print V(RJ1|XCB_C2_L2)
.print I(RJ2|XCB_C2_L2)
.print V(RJ2|XCB_C2_L2)
.print I(IB1|XCB_C2_L2)
.tran 0.01p 250p
.end
