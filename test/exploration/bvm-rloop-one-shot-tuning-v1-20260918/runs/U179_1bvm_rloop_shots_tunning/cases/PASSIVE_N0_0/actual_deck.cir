* PASSIVE: BVM array -> COMMON_SL -> JSL1..8; no QB/JTL/terminal.
.include ../../snapshot/sources/jjmit.cir
.include ../../snapshot/sources/bvm_tunable.cir
.include stimulus.inc

XBVM1 WL1 BL1 SE1 COMMON_SL BVM

B_JSL1 COMMON_SL JSL_NODE1 jjmit area=5.0
B_JSL2 JSL_NODE1 JSL_NODE2 jjmit area=5.0
B_JSL3 JSL_NODE2 JSL_NODE3 jjmit area=5.0
B_JSL4 JSL_NODE3 JSL_NODE4 jjmit area=5.0
B_JSL5 JSL_NODE4 JSL_NODE5 jjmit area=5.0
B_JSL6 JSL_NODE5 JSL_NODE6 jjmit area=5.0
B_JSL7 JSL_NODE6 JSL_NODE7 jjmit area=5.0
B_JSL8 JSL_NODE7 0 jjmit area=5.0

.print I(I_WL1) I(I_BL1) I(I_SE1)
.print P(B_JM1|XBVM1) V(B_JM1|XBVM1) I(B_JM1|XBVM1)
.print P(B_JM2|XBVM1) V(B_JM2|XBVM1) I(B_JM2|XBVM1)
.print P(B_JS1|XBVM1) V(B_JS1|XBVM1) I(B_JS1|XBVM1)
.print P(B_JS2|XBVM1) V(B_JS2|XBVM1) I(B_JS2|XBVM1)
.print I(L_M1|XBVM1) V(L_M1|XBVM1)
.print I(L_M2|XBVM1) V(L_M2|XBVM1)
.print I(L_M3|XBVM1) V(L_M3|XBVM1)
.print I(L_PM|XBVM1) V(L_PM|XBVM1)
.print I(L_S1|XBVM1) V(L_S1|XBVM1)
.print I(L_S2|XBVM1) V(L_S2|XBVM1)
.print I(L_S3|XBVM1) V(L_S3|XBVM1)
.print I(R_S|XBVM1) V(R_S|XBVM1)
.print I(L_PSL|XBVM1) V(L_PSL|XBVM1)
.print I(R_SL|XBVM1) V(R_SL|XBVM1)
.print I(L_SL|XBVM1) V(L_SL|XBVM1)
.print I(R_JM1|XBVM1) V(R_JM1|XBVM1)
.print I(R_SE|XBVM1) V(R_SE|XBVM1)
.print I(L_PSE|XBVM1) V(L_PSE|XBVM1)
.print V(COMMON_SL)
.print P(B_JSL1) V(B_JSL1) I(B_JSL1)
.print P(B_JSL2) V(B_JSL2) I(B_JSL2)
.print P(B_JSL3) V(B_JSL3) I(B_JSL3)
.print P(B_JSL4) V(B_JSL4) I(B_JSL4)
.print P(B_JSL5) V(B_JSL5) I(B_JSL5)
.print P(B_JSL6) V(B_JSL6) I(B_JSL6)
.print P(B_JSL7) V(B_JSL7) I(B_JSL7)
.print P(B_JSL8) V(B_JSL8) I(B_JSL8)
.tran 0.1p 200p
.end
