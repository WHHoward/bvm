** BQ with Single direction **

.subckt D0_JTL IN OUT

L1 IN 1 2.5p
L2 1 OUT 2.5p
BJ1 1 0 jjmit area=2.5
RJ1 1 0 4

IB1 0 1 pwl(0 0 5p 190u)
.ends D0_JTL
