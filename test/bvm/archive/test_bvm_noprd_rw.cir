* BVM W1→R1→W0→R0  — 50GHz, WL=100μA read & write, no separate PRD
.include ../../circuits/bvm/bvm_cell.cir
XBVM1 WL1 BL1 SE1 SL1 BVM
B_SLload1 SL1 0 jj320 area=12

* WL: W1(10-20ps), Read1 bias(70-80ps), W0(130-140ps), Read0 bias(190-200ps)
* Same 100μA for write AND read row selection
I_WL1 0 WL1 pwl(0 0 5p 0
+ 10p 100U 20p 100U 25p 0
+ 70p 100U 80p 100U 85p 0
+ 130p -100U 140p -100U 145p 0
+ 190p 100U 200p 100U 205p 0
+ 220p 0)

* BL: W1(10-20ps), W0(130-140ps)
I_BL1 0 BL1 pwl(0 0 5p 0
+ 10p 100U 20p 100U 25p 0
+ 70p 0 85p 0
+ 130p -100U 140p -100U 145p 0
+ 190p 0 220p 0)

* SE: Read1(70-80ps), Read0(190-200ps) — 200μA
I_SE1 0 SE1 pwl(0 0
+ 70p 0 75p 200U 85p 200U 90p 0
+ 190p 0 195p 200U 205p 200U 210p 0
+ 220p 0)

.tran 0.25p 220p 0 0.5p 0 DST
.print I(I_WL1) I(I_BL1) I(I_SE1)
.print V(B_JM1|XBVM1) P(B_JM1|XBVM1)
.print I(L_M1|XBVM1)
.print I(B_SLload1)
.end
