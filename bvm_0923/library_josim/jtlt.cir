* Author: L. Schindler
* Version: 3.0
* Last modification date: 9 August 2022
* Last modification by: T. Hall

* Copyright (c) 2018-2022 Lieze Schindler, Tessa Hall, Stellenbosch University

* Permission is hereby granted, free of charge, to any person obtaining a copy
* of this cell library and associated documentation files (the "Library"), to deal
* in the Library without restriction, including without limitation the rights
* to use, copy, modify, merge, publish, distribute, sublicense, and/or sell
* copies of the Library, and to permit persons to whom the Library is
* furnished to do so, subject to the following conditions:

* The above copyright notice and this permission notice shall be included in all
* copies or substantial portions of the Library.

* THE LIBRARY IS PROVIDED "AS IS", WITHOUT WARRANTY OF ANY KIND, EXPRESS OR
* IMPLIED, INCLUDING BUT NOT LIMITED TO THE WARRANTIES OF MERCHANTABILITY,
* FITNESS FOR A PARTICULAR PURPOSE AND NONINFRINGEMENT. IN NO EVENT SHALL THE
* AUTHORS OR COPYRIGHT HOLDERS BE LIABLE FOR ANY CLAIM, DAMAGES OR OTHER
* LIABILITY, WHETHER IN AN ACTION OF CONTRACT, TORT OR OTHERWISE, ARISING FROM,
* OUT OF OR IN CONNECTION WITH THE LIBRARY OR THE USE OR OTHER DEALINGS IN THE
* LIBRARY.

*For questions about the library, contact Tessa Hall, 19775539@sun.ac.za

*$Ports		a	q
.subckt jtlt a q
.model jjmit jj(rtype=1, vg=2.8mV, cap=0.07pF, r0=160, rn=16, icrit=0.1mA)

B1 1 2 jjmit  area=1.6
B2 4 5 jjmit  area=2
B3 8 9 jjmit  area=2.5
IB1 0 3 pwl(0 0 5p 112u)
IB2 0 7 pwl(0 0 5p 315u)
LB1 3 1 2p
LB2 7 6 2p
L1 a 1 2p
L2 1 4 6.4625p
L3 4 6 1.4265p
L4 6 8 2.2384p
L5 8 10 2p
RD 10 q 1.36
LP1 2 0 0.5p
LP2 5 0 0.5p
LP3 9 0 0.5p
RB1 1 101 4.2874
LRB1 101 0 2.9224p
RB2 4 104 3.43
LRB2 104 0 2.4380p
RB3 8 108 2.744
LRB3 108 0 2.05p

.ends
