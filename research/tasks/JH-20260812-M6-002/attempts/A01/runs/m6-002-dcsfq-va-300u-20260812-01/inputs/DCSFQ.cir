* DCSFQ — ColdFlux RSFQ Standard Cell
* Source: IARPA SuperTools/ColdFlux Cell Library v3.0
* MIT-LL SFQ Process | JoSIM-compatible
* Ports: a q
* Junctions: 3 total
*   B1: area=2.25, IC=225uA
*   B2: area=2.25, IC=225uA
*   B3: area=B3
*
* Bias: 2.6mV DC bias line (resistors calculated per ColdFlux methodology)
* Usage: .include circuits/standard/DCSFQ.cir
*        .model jjmit jj(rtype=1, vg=2.8m, cap=0.07p, r0=160, rn=16, icrit=0.1m)
*
.subckt THmitll_DCSFQ a q
.param Phi0=2.067833848E-15
.param B0=1
.param Ic0=0.0001
.param IcRs=100u*6.859904418
.param B0Rs=IcRs/Ic0*B0
.param Rsheet=2
.param Lsheet=1.13e-12
.param LP=0.5p
.param IC=2.5
.param LB=2p
.param BiasCoef=0.7
.param B1=2.25
.param B2=2.25
.param B3=IC
.param IB1=275u
.param IB2=B3*Ic0*BiasCoef
.param LB1=LB
.param LB2=LB
.param L1=1p
.param L2=3.9p
.param L3=0.6p
.param L4=1.1p
.param L5=4.5p
.param L6=Phi0/(4*IC*Ic0)
.param LP2=LP
.param LP3=LP
.param RB1=B0Rs/B1
.param RB2=B0Rs/B2
.param RB3=B0Rs/B3
.param LRB1=(RB1/Rsheet)*Lsheet
.param LRB2=(RB2/Rsheet)*Lsheet+LP
.param LRB3=(RB3/Rsheet)*Lsheet+LP
B1 2 3 jjmit area=B1
B2 5 6 jjmit area=B2
B3 7 8 jjmit area=B3
IB1 0 4 pwl(0 0 5p IB1)
IB2 0 9 pwl(0 0 5p IB2)
LB1 4 3 2.825E-012
LB2 9 7 2.942E-012
L1 a 1 1.672E-012
L2 1 0 3.901E-012
L3 1 2 5.953E-013
L4 3 5 1.1E-012
L5 5 7 4.542E-012
L6 7 q 2.012E-012
LP2 6 0 3.924E-013
LP3 8 0 3.841E-013
RB1 2 102 RB1
LRB1 102 3 LRB1
RB2 5 105 RB2
LRB2 105 0 LRB2
RB3 7 107 RB3
LRB3 107 0 LRB3
.ends
