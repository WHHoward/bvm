* QB Multi-Level — BVM-equivalent currents 0/1/2/3/4 × 32μA
* All models self-contained
.model jj18  jj(RTYPE=1, IC=18U,  RN=13.9, R0=41.7, CAP=0.10P, VG=2.8M, DELV=0.1M)
.model jj112 jj(RTYPE=1, IC=112U, RN=2.2,  R0=6.6,  CAP=0.55P, VG=2.8M, DELV=0.1M)
.model jj189 jj(RTYPE=1, IC=189U, RN=1.3,  R0=3.9,  CAP=1.0P,  VG=2.8M, DELV=0.1M)

L_IN1  IN1     N_JS_IN    0.8P
B_JS1  N_JS_IN N_JS_OUT   jj18 area=1
R_SH1  N_JS_IN N_JS_OUT   10
B_JL11 N_JS_OUT 0          jj112 area=1
L_L11  N_JS_OUT N_MID      3.91P
R_RB1  N_MID   IBIAS1     8.5
L_L21  N_MID   N_PRE_OUT   3.91P
B_JL21 N_PRE_OUT 0         jj189 area=1
L_L01  N_PRE_OUT OUT1      1.323P
R_LOAD OUT1 0 12.0
I_IBIAS IBIAS1 0 DC 40U

I_IN 0 IN1 pwl(0 0 8p 0
+ 10p 0U   20p 0U   22p 0
+ 30p 0
+ 32p 32U  42p 32U  44p 0
+ 52p 0
+ 54p 64U  64p 64U  66p 0
+ 74p 0
+ 76p 96U  86p 96U  88p 0
+ 98p 0
+ 100p 128U 110p 128U 112p 0
+ 130p 0)

.tran 0.2p 130p 0 0.4p 0 DST
.print I(I_IN) V(B_JS1) P(B_JS1) V(OUT1)
.end
