* XOR Comprehensive Test — ColdFlux Standard Cell (11 JJs)
*
* XOR Topology (dual symmetric input + clocked readout):
*   A侧: a-L1-1-B1-2-GND   1-L2-4-[B2(4-5-GND) + B3(4-6)]
*   B侧: b-L4-8-B4-9-GND   8-L5-11-[B5(11-12-GND)+B6(11-13)]
*   合流: L3(6-7) + L6(13-7) -> 7-B7(7-15)-L7-16
*   时钟: clk-L8-18-B9(18-19-GND)  L9(18-21)-B10(21-16)
*   输出: 16-L10-22-B11(22-23-GND)-L11(22-q)
*
* Truth table (RSFQ clocked XOR):
*   A⊕B = Q:  0⊕0=0  1⊕0=1  1⊕1=0  0⊕1=1
*
* Data MUST arrive BEFORE clock for proper sampling.
* Test:
*   Cycle 1: CLK@15ps (A=0,B=0) → Q=0 (should NOT fire)
*   Cycle 2: A@20ps → CLK@35ps (1⊕0) → Q=1
*   Cycle 3: A@50ps, B@55ps → CLK@70ps (1⊕1) → Q=0
*   Cycle 4: B@85ps → CLK@100ps (0⊕1) → Q=1

.include ../../circuits/models/jjmit.cir
.include ../../circuits/standard/XOR.cir
.include ../../circuits/standard/JTL.cir

* Input A: SFQ @20ps (cycle2), @50ps (cycle3)
V_IA INA 0 pwl(0 0 10p 0 20p 0 21p 1.5m 23p 1.5m 24p 0 50p 0 51p 1.5m 53p 1.5m 54p 0 120p 0)
R_IA INA N1 3
L_IA N1 SFQ_A 0.5p

* Input B: SFQ @55ps (cycle3), @85ps (cycle4)
V_IB INB 0 pwl(0 0 10p 0 55p 0 56p 1.5m 58p 1.5m 59p 0 85p 0 86p 1.5m 88p 1.5m 89p 0 120p 0)
R_IB INB N2 3
L_IB N2 SFQ_B 0.5p

* Clock: @15ps (0⊕0), @35ps (1⊕0), @70ps (1⊕1), @100ps (0⊕1)
V_CLK CLK 0 pwl(0 0 10p 0 15p 0 16p 1.5m 18p 1.5m 19p 0 35p 0 36p 1.5m 38p 1.5m 39p 0 70p 0 71p 1.5m 73p 1.5m 74p 0 100p 0 101p 1.5m 103p 1.5m 104p 0 120p 0)
R_CLK CLK N3 3
L_CLK N3 SFQ_CLK 0.5p

* DUT: XOR
XXOR SFQ_A SFQ_B SFQ_CLK SFQ_Q THmitll_XOR

* Load JTL
XLOAD SFQ_Q SFQ_OUT THmitll_JTL
R_TERM SFQ_OUT 0 1

.tran 0.1p 120p

* All 11 junction phases
.print P(B1|XXOR) P(B2|XXOR) P(B3|XXOR) P(B4|XXOR) P(B5|XXOR) P(B6|XXOR)
.print P(B7|XXOR) P(B8|XXOR) P(B9|XXOR) P(B10|XXOR) P(B11|XXOR)

* Key node voltages (for junction V calculations)
.print V(1|XXOR) V(2|XXOR) V(4|XXOR) V(5|XXOR) V(6|XXOR) V(7|XXOR)
.print V(8|XXOR) V(9|XXOR) V(11|XXOR) V(12|XXOR) V(13|XXOR)
.print V(15|XXOR) V(16|XXOR) V(17|XXOR) V(18|XXOR) V(19|XXOR)
.print V(21|XXOR) V(22|XXOR) V(23|XXOR)

* All 11 inductor currents
.print I(L1|XXOR) I(L2|XXOR) I(L3|XXOR) I(L4|XXOR) I(L5|XXOR)
.print I(L6|XXOR) I(L7|XXOR) I(L8|XXOR) I(L9|XXOR) I(L10|XXOR) I(L11|XXOR)

* All bias resistor currents
.print I(RB1|XXOR) I(RB2|XXOR) I(RB3|XXOR) I(RB4|XXOR) I(RB5|XXOR)
.print I(RB6|XXOR) I(RB7|XXOR) I(RB8|XXOR) I(RB9|XXOR) I(RB10|XXOR) I(RB11|XXOR)

* I/O voltages + Load phases
.print V(SFQ_A) V(SFQ_B) V(SFQ_CLK) V(SFQ_Q)
.print P(B1|XLOAD) P(B2|XLOAD)
.end
