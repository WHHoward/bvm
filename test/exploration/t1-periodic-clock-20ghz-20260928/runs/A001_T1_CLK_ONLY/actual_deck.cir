* T1 periodic CLK-only fixture; data input I is tied to ground.
* Scheme B external bias. This ideal voltage pulse is not an SFQ clock claim.
.include ../../../../../circuits/models/jjmit.cir
.include ../../../../../circuits/t1/t1_cell.cir
V_BIAS1 N_BIAS1 0 DC 1.8m
V_BIAS2 N_BIAS2 0 DC 1.8m
V_BIAS3 N_BIAS3 0 DC 1.8m
R_S S 0 12
R_C C 0 12
V_TRIG_CLK CLK_RAW 0 PULSE(0 1.2m 170p 1p 1p 2p 50p)
R_TRIG_CLK CLK_RAW CLK 5
XT1 0 CLK S C N_BIAS1 N_BIAS2 N_BIAS3 T1
.print V(CLK_RAW)
.print V(CLK)
.print I(R_TRIG_CLK)
.print V(S)
.print V(C)
.print I(R_S)
.print I(R_C)
.print V(N_BIAS1)
.print V(N_BIAS2)
.print V(N_BIAS3)
.print P(B_J1|XT1)
.print V(B_J1|XT1)
.print I(B_J1|XT1)
.print P(B_J2|XT1)
.print V(B_J2|XT1)
.print I(B_J2|XT1)
.print P(B_J3|XT1)
.print V(B_J3|XT1)
.print I(B_J3|XT1)
.print P(B_J4|XT1)
.print V(B_J4|XT1)
.print I(B_J4|XT1)
.print P(B_J5|XT1)
.print V(B_J5|XT1)
.print I(B_J5|XT1)
.print P(B_J6|XT1)
.print V(B_J6|XT1)
.print I(B_J6|XT1)
.print P(B_J7|XT1)
.print V(B_J7|XT1)
.print I(B_J7|XT1)
.print P(B_J8|XT1)
.print V(B_J8|XT1)
.print I(B_J8|XT1)
.print P(B_J9|XT1)
.print V(B_J9|XT1)
.print I(B_J9|XT1)
.print P(B_J10|XT1)
.print V(B_J10|XT1)
.print I(B_J10|XT1)
.print P(B_J11|XT1)
.print V(B_J11|XT1)
.print I(B_J11|XT1)
.print I(L1|XT1)
.print V(L1|XT1)
.print I(L2|XT1)
.print V(L2|XT1)
.print I(L3|XT1)
.print V(L3|XT1)
.print I(L4|XT1)
.print V(L4|XT1)
.print I(L5|XT1)
.print V(L5|XT1)
.print I(L6|XT1)
.print V(L6|XT1)
.print I(L7|XT1)
.print V(L7|XT1)
.print I(L8|XT1)
.print V(L8|XT1)
.print I(L9|XT1)
.print V(L9|XT1)
.print I(L10|XT1)
.print V(L10|XT1)
.print I(L11|XT1)
.print V(L11|XT1)
.print I(L12|XT1)
.print V(L12|XT1)
.print I(L13|XT1)
.print V(L13|XT1)
.print I(L14|XT1)
.print V(L14|XT1)
.print I(L15|XT1)
.print V(L15|XT1)
.print I(L16|XT1)
.print V(L16|XT1)
.print I(L17|XT1)
.print V(L17|XT1)
.print I(RB1|XT1)
.print V(RB1|XT1)
.print I(RB2|XT1)
.print V(RB2|XT1)
.print I(RB3|XT1)
.print V(RB3|XT1)
.print I(R_J10|XT1)
.print V(R_J10|XT1)
.print I(R_J11|XT1)
.print V(R_J11|XT1)
.print I(R_J3|XT1)
.print V(R_J3|XT1)
.print I(R_J4|XT1)
.print V(R_J4|XT1)
.print I(R_J5|XT1)
.print V(R_J5|XT1)
.print I(R_J6|XT1)
.print V(R_J6|XT1)
.print I(R_J7|XT1)
.print V(R_J7|XT1)
.print I(R_J8|XT1)
.print V(R_J8|XT1)
.print I(R_J9|XT1)
.print V(R_J9|XT1)
.tran 0.01p 370p
.end
