* R13-A logical0-read0-control raw-replay: DCSFQ_BVM current replay.
.include ../../../../../circuits/models/jjmit.cir
.include ../../../../../circuits/interface/DCSFQ_BVM.cir
XREPLAY IN_REPLAY Q_REPLAY THmitll_DCSFQ_BVM
R_LOAD Q_REPLAY 0 10
I_REPLAY 0 IN_REPLAY pwl(0 0 0.0125p -0.04900212u 0.025p -0.09668976u 0.0375p -0.1429848u 0.05p -0.1878877u 0.0625p -0.2314252u 0.075p -0.2736331u 0.0875p -0.3145502u 0.1p -0.3542163u 0.1125p -0.3926715u 0.125p -0.4299557u 0.1375p -0.4661089u
+ 0.15p -0.5011707u 0.1625p -0.5351803u 0.175p -0.5681767u 0.1875p -0.6001981u 0.2p -0.6312827u 0.2125p -0.6614676u 0.225p -0.6907896u 0.2375p -0.7192848u 0.25p -0.7469883u 0.2625p -0.7739347u 0.275p -0.8001578u 0.2875p -0.8256902u
+ 0.3p -0.8505639u 0.3125p -0.8748099u 0.325p -0.8984582u 0.3375p -0.9215377u 0.35p -0.9440763u 0.3625p -0.9661009u 0.375p -0.9876374u 0.3875p -1.00871u 0.4p -1.029343u 0.4125p -1.049559u 0.425p -1.069378u 0.4375p -1.088822u
+ 0.45p -1.107908u 0.4625p -1.126656u 0.475p -1.145081u 0.4875p -1.1632u 0.5p -1.181027u 0.5125p -1.198575u 0.525p -1.215857u 0.5375p -1.232883u 0.55p -1.249666u 0.5625p -1.266212u 0.575p -1.282532u 0.5875p -1.298631u
+ 0.6p -1.314517u 0.6125p -1.330194u 0.625p -1.345668u 0.6375p -1.360943u 0.65p -1.37602u 0.6625p -1.390903u 0.675p -1.405593u 0.6875p -1.42009u 0.7p -1.434396u 0.7125p -1.44851u 0.725p -1.46243u 0.7375p -1.476157u
+ 0.75p -1.489687u 0.7625p -1.503019u 0.775p -1.516151u 0.7875p -1.52908u 0.8p -1.541802u 0.8125p -1.554315u 0.825p -1.566615u 0.8375p -1.578699u 0.85p -1.590564u 0.8625p -1.602206u 0.875p -1.613621u 0.8875p -1.624806u
+ 0.9p -1.635759u 0.9125p -1.646475u 0.925p -1.656952u 0.9375p -1.667188u 0.95p -1.677179u 0.9625p -1.686924u 0.975p -1.696422u 0.9875p -1.705669u 1p -1.714667u 1.0125p -1.723413u 1.025p -1.731908u 1.0375p -1.740153u
+ 1.05p -1.748147u 1.0625p -1.755892u 1.075p -1.763389u 1.0875p -1.770642u 1.1p -1.777653u 1.1125p -1.784424u 1.125p -1.790961u 1.1375p -1.797267u 1.15p -1.803347u 1.1625p -1.809206u 1.175p -1.814851u 1.1875p -1.820289u
+ 1.2p -1.825525u 1.2125p -1.830568u 1.225p -1.835426u 1.2375p -1.840107u 1.25p -1.844621u 1.2625p -1.848975u 1.275p -1.853181u 1.2875p -1.857249u 1.3p -1.861188u 1.3125p -1.865011u 1.325p -1.868728u 1.3375p -1.87235u
+ 1.35p -1.87589u 1.3625p -1.87936u 1.375p -1.882771u 1.3875p -1.886136u 1.4p -1.889468u 1.4125p -1.892779u 1.425p -1.896082u 1.4375p -1.89939u 1.45p -1.902714u 1.4625p -1.906068u 1.475p -1.909465u 1.4875p -1.912916u
+ 1.5p -1.916434u 1.5125p -1.920032u 1.525p -1.92372u 1.5375p -1.92751u 1.55p -1.931414u 1.5625p -1.935442u 1.575p -1.939606u 1.5875p -1.943915u 1.6p -1.948379u 1.6125p -1.953008u 1.625p -1.95781u 1.6375p -1.962793u
+ 1.65p -1.967965u 1.6625p -1.973335u 1.675p -1.978907u 1.6875p -1.984688u 1.7p -1.990684u 1.7125p -1.9969u 1.725p -2.003338u 1.7375p -2.010004u 1.75p -2.016899u 1.7625p -2.024026u 1.775p -2.031386u 1.7875p -2.03898u
+ 1.8p -2.046807u 1.8125p -2.054867u 1.825p -2.063158u 1.8375p -2.071678u 1.8625p -2.089394u 1.875p -2.098581u 1.8875p -2.107981u 1.9p -2.117589u 1.9125p -2.127398u 1.925p -2.1374u 1.9375p -2.147589u 1.95p -2.157957u
+ 1.9625p -2.168493u 1.975p -2.179189u 1.9875p -2.190035u 2p -2.201021u 2.0125p -2.212134u 2.025p -2.223364u 2.0375p -2.2347u 2.05p -2.246127u 2.0625p -2.257635u 2.075p -2.269209u 2.0875p -2.280837u 2.1p -2.292504u
+ 2.1125p -2.304197u 2.125p -2.315901u 2.1375p -2.327603u 2.15p -2.339288u 2.1625p -2.350942u 2.175p -2.362549u 2.1875p -2.374095u 2.2p -2.385566u 2.2125p -2.396947u 2.225p -2.408223u 2.2375p -2.41938u 2.25p -2.430405u
+ 2.2625p -2.441282u 2.275p -2.451999u 2.2875p -2.462541u 2.3p -2.472896u 2.3125p -2.48305u 2.325p -2.492992u 2.3375p -2.502708u 2.35p -2.512188u 2.3625p -2.52142u 2.375p -2.530393u 2.3875p -2.539098u 2.4p -2.547524u
+ 2.4125p -2.555662u 2.425p -2.563504u 2.4375p -2.571042u 2.45p -2.578269u 2.4625p -2.585177u 2.475p -2.591761u 2.4875p -2.598016u 2.5p -2.603937u 2.5125p -2.60952u 2.525p -2.614762u 2.5375p -2.619659u 2.55p -2.624211u
+ 2.5625p -2.628417u 2.575p -2.632275u 2.5875p -2.635787u 2.6p -2.638953u 2.6125p -2.641776u 2.625p -2.644257u 2.6375p -2.6464u 2.65p -2.648209u 2.6625p -2.649689u 2.675p -2.650844u 2.6875p -2.651681u 2.7p -2.652207u
+ 2.7125p -2.652428u 2.725p -2.652352u 2.7375p -2.651988u 2.75p -2.651345u 2.7625p -2.650432u 2.775p -2.649259u 2.7875p -2.647838u 2.8p -2.646178u 2.8125p -2.644291u 2.825p -2.642189u 2.8375p -2.639885u 2.85p -2.63739u
+ 2.8625p -2.634718u 2.875p -2.631882u 2.8875p -2.628895u 2.9p -2.625771u 2.9125p -2.622524u 2.925p -2.619168u 2.9375p -2.615716u 2.95p -2.612183u 2.9625p -2.608583u 2.975p -2.604931u 2.9875p -2.60124u 3p -2.597525u
+ 3.0125p -2.5938u 3.025p -2.590078u 3.0375p -2.586373u 3.05p -2.5827u 3.0625p -2.579071u 3.075p -2.575499u 3.0875p -2.571998u 3.1p -2.56858u 3.1125p -2.565256u 3.125p -2.562039u 3.1375p -2.558941u 3.15p -2.555971u
+ 3.1625p -2.553141u 3.175p -2.550461u 3.1875p -2.54794u 3.2p -2.545587u 3.2125p -2.543411u 3.225p -2.541419u 3.2375p -2.53962u 3.25p -2.53802u 3.2625p -2.536625u 3.275p -2.535441u 3.2875p -2.534472u 3.3p -2.533723u
+ 3.3125p -2.533199u 3.325p -2.532901u 3.3375p -2.532832u 3.35p -2.532995u 3.3625p -2.533389u 3.375p -2.534017u 3.3875p -2.534877u 3.4p -2.535968u 3.4125p -2.53729u 3.425p -2.53884u 3.4375p -2.540616u 3.45p -2.542614u
+ 3.4625p -2.54483u 3.475p -2.547259u 3.4875p -2.549898u 3.5p -2.552739u 3.5125p -2.555778u 3.525p -2.559006u 3.5375p -2.562418u 3.55p -2.566005u 3.5625p -2.56976u 3.575p -2.573672u 3.5875p -2.577735u 3.6p -2.581938u
+ 3.6125p -2.586271u 3.625p -2.590725u 3.6375p -2.595289u 3.65p -2.599952u 3.6625p -2.604704u 3.675p -2.609533u 3.6875p -2.614428u 3.7p -2.619377u 3.7125p -2.624369u 3.725p -2.629392u 3.7375p -2.634434u 3.75p -2.639483u
+ 3.7625p -2.644527u 3.775p -2.649555u 3.7875p -2.654554u 3.8p -2.659513u 3.8125p -2.66442u 3.825p -2.669263u 3.8375p -2.67403u 3.85p -2.678712u 3.8625p -2.683296u 3.875p -2.687772u 3.8875p -2.692129u 3.9p -2.696357u
+ 3.9125p -2.700447u 3.925p -2.704388u 3.9375p -2.708171u 3.95p -2.711787u 3.9625p -2.715229u 3.975p -2.718487u 3.9875p -2.721555u 4p -2.724425u 4.0125p -2.727091u 4.025p -2.729546u 4.0375p -2.731784u 4.05p -2.733802u
+ 4.0625p -2.735593u 4.075p -2.737154u 4.0875p -2.738482u 4.1p -2.739573u 4.1125p -2.740426u 4.125p -2.741037u 4.1375p -2.741406u 4.15p -2.741533u 4.1625p -2.741417u 4.175p -2.741058u 4.1875p -2.740457u 4.2p -2.739617u
+ 4.2125p -2.738539u 4.225p -2.737226u 4.2375p -2.735681u 4.25p -2.733909u 4.2625p -2.731912u 4.275p -2.729697u 4.2875p -2.727269u 4.3p -2.724632u 4.3125p -2.721795u 4.325p -2.718763u 4.3375p -2.715544u 4.35p -2.712146u
+ 4.3625p -2.708576u 4.375p -2.704844u 4.3875p -2.700957u 4.4p -2.696926u 4.4125p -2.69276u 4.425p -2.688469u 4.4375p -2.684064u 4.45p -2.679553u 4.4625p -2.67495u 4.475p -2.670264u 4.4875p -2.665506u 4.5p -2.660688u
+ 4.5125p -2.655822u 4.525p -2.650919u 4.5375p -2.645991u 4.55p -2.64105u 4.5625p -2.636107u 4.575p -2.631175u 4.5875p -2.626266u 4.6p -2.621391u 4.6125p -2.616562u 4.625p -2.611791u 4.6375p -2.60709u 4.65p -2.60247u
+ 4.6625p -2.597943u 4.675p -2.593521u 4.6875p -2.589213u 4.7p -2.585032u 4.7125p -2.580987u 4.725p -2.577089u 4.7375p -2.573349u 4.75p -2.569776u 4.7625p -2.566379u 4.775p -2.563169u 4.7875p -2.560153u 4.8p -2.55734u
+ 4.8125p -2.554739u 4.825p -2.552357u 4.8375p -2.550201u 4.85p -2.548279u 4.8625p -2.546596u 4.875p -2.545159u 4.8875p -2.543974u 4.9p -2.543045u 4.9125p -2.542378u 4.925p -2.541976u 4.9375p -2.541843u 4.95p -2.541982u
+ 4.9625p -2.542397u 4.975p -2.543088u 4.9875p -2.544059u 5p -2.54531u 5.0125p -2.49784u 5.025p -2.451965u 5.0375p -2.407764u 5.05p -2.365236u 5.0625p -2.324352u 5.075p -2.285074u 5.0875p -2.247363u 5.1p -2.211174u
+ 5.1125p -2.176465u 5.125p -2.143192u 5.1375p -2.11131u 5.15p -2.080776u 5.1625p -2.051544u 5.175p -2.023571u 5.1875p -1.996811u 5.2p -1.971219u 5.2125p -1.946752u 5.225p -1.923364u 5.2375p -1.901013u 5.25p -1.879653u
+ 5.2625p -1.859242u 5.275p -1.839736u 5.2875p -1.821093u 5.3p -1.803272u 5.3125p -1.78623u 5.325p -1.769928u 5.3375p -1.754324u 5.35p -1.739381u 5.3625p -1.725058u 5.375p -1.71132u 5.3875p -1.698128u 5.4p -1.685448u
+ 5.4125p -1.673244u 5.425p -1.661482u 5.4375p -1.65013u 5.45p -1.639155u 5.4625p -1.628527u 5.475p -1.618216u 5.4875p -1.608193u 5.5p -1.59843u 5.5125p -1.588902u 5.525p -1.579582u 5.5375p -1.570446u 5.55p -1.561473u
+ 5.5625p -1.552638u 5.575p -1.543922u 5.5875p -1.535305u 5.6p -1.526768u 5.6125p -1.518294u 5.625p -1.509866u 5.6375p -1.50147u 5.65p -1.49309u 5.6625p -1.484713u 5.675p -1.476329u 5.6875p -1.467924u 5.7p -1.459489u
+ 5.7125p -1.451016u 5.725p -1.442495u 5.7375p -1.433919u 5.75p -1.425281u 5.7625p -1.416577u 5.775p -1.407801u 5.7875p -1.398949u 5.8p -1.390017u 5.8125p -1.381003u 5.825p -1.371906u 5.8375p -1.362723u 5.85p -1.353454u
+ 5.8625p -1.344099u 5.875p -1.334658u 5.8875p -1.325132u 5.9p -1.315522u 5.9125p -1.30583u 5.925p -1.296058u 5.9375p -1.286208u 5.95p -1.276283u 5.9625p -1.266287u 5.975p -1.256222u 5.9875p -1.246091u 6p -1.235899u
+ 6.0125p -1.225649u 6.025p -1.215344u 6.0375p -1.204989u 6.05p -1.194588u 6.0625p -1.184144u 6.075p -1.173661u 6.0875p -1.163144u 6.1p -1.152596u 6.1125p -1.142021u 6.125p -1.131422u 6.1375p -1.120802u 6.15p -1.110166u
+ 6.1625p -1.099516u 6.175p -1.088856u 6.1875p -1.078187u 6.2p -1.067513u 6.2125p -1.056836u 6.225p -1.046157u 6.2375p -1.03548u 6.25p -1.024804u 6.2625p -1.014133u 6.275p -1.003466u 6.2875p -0.9928053u 6.3p -0.9821505u
+ 6.3125p -0.9715023u 6.325p -0.9608607u 6.3375p -0.9502256u 6.35p -0.9395964u 6.3625p -0.9289727u 6.375p -0.9183534u 6.3875p -0.9077375u 6.4p -0.8971236u 6.4125p -0.8865103u 6.425p -0.8758958u 6.4375p -0.8652782u 6.45p -0.8546556u
+ 6.4625p -0.8440258u 6.475p -0.8333865u 6.4875p -0.8227352u 6.5p -0.8120695u 6.5125p -0.8013869u 6.525p -0.7906847u 6.5375p -0.7799602u 6.55p -0.7692108u 6.5625p -0.7584339u 6.575p -0.7476267u 6.5875p -0.7367868u 6.6p -0.7259116u
+ 6.6125p -0.7149985u 6.625p -0.7040454u 6.6375p -0.6930499u 6.65p -0.6820101u 6.6625p -0.6709239u 6.675p -0.6597896u 6.6875p -0.6486057u 6.7p -0.6373709u 6.7125p -0.6260841u 6.725p -0.6147444u 6.7375p -0.6033512u 6.75p -0.5919042u
+ 6.7625p -0.5804034u 6.775p -0.5688491u 6.7875p -0.5572419u 6.8p -0.5455826u 6.8125p -0.5338726u 6.825p -0.5221134u 6.8375p -0.5103069u 6.85p -0.4984556u 6.8625p -0.4865619u 6.875p -0.474629u 6.8875p -0.4626603u 6.9p -0.4506594u
+ 6.9125p -0.4386306u 6.925p -0.4265783u 6.9375p -0.4145073u 6.95p -0.402423u 6.9625p -0.3903308u 6.975p -0.3782367u 6.9875p -0.3661469u 7p -0.3540682u 7.0125p -0.3420073u 7.025p -0.3299715u 7.0375p -0.3179683u 7.05p -0.3060057u
+ 7.0625p -0.2940916u 7.075p -0.2822344u 7.0875p -0.2704427u 7.1p -0.2587254u 7.1125p -0.2470914u 7.125p -0.2355499u 7.1375p -0.2241104u 7.15p -0.2127823u 7.1625p -0.2015753u 7.175p -0.1904991u 7.1875p -0.1795636u 7.2p -0.1687786u
+ 7.2125p -0.158154u 7.225p -0.1476997u 7.2375p -0.1374257u 7.25p -0.1273419u 7.2625p -0.1174579u 7.275p -0.1077836u 7.2875p -0.09832842u 7.3p -0.08910195u 7.3125p -0.08011345u 7.325p -0.071372u 7.3375p -0.0628865u 7.35p -0.0546656u
+ 7.3625p -0.0467177u 7.375p -0.03905089u 7.3875p -0.03167299u 7.4p -0.02459146u 7.4125p -0.01781344u 7.425p -0.01134567u 7.4375p -0.005194511u 7.45p 0.0006340785u 7.4625p 0.006134577u 7.475p 0.01130191u 7.4875p 0.01613146u 7.5p 0.02061908u
+ 7.5125p 0.02476115u 7.525p 0.02855451u 7.5375p 0.03199655u 7.55p 0.03508518u 7.5625p 0.03781885u 7.575p 0.04019655u 7.5875p 0.04221784u 7.6p 0.04388284u 7.6125p 0.04519223u 7.625p 0.04614726u 7.6375p 0.04674975u 7.65p 0.04700211u
+ 7.6625p 0.0469073u 7.675p 0.04646889u 7.6875p 0.04569096u 7.7p 0.04457822u 7.7125p 0.04313588u 7.725p 0.04136975u 7.7375p 0.03928615u 7.75p 0.03689194u 7.7625p 0.03419452u 7.775p 0.03120179u 7.7875p 0.02792214u 7.8p 0.02436446u
+ 7.8125p 0.02053809u 7.825p 0.01645284u 7.8375p 0.01211893u 7.85p 0.007547024u 7.8625p 0.002748153u 7.875p -0.002266262u 7.8875p -0.007484451u 7.9p -0.01289431u 7.9125p -0.01848344u 7.925p -0.02423915u 7.9375p -0.03014847u 7.95p -0.03619825u
+ 7.9625p -0.04237507u 7.975p -0.04866538u 7.9875p -0.05505544u 8p -0.06153141u 8.0125p -0.06807932u 8.025p -0.07468514u 8.0375p -0.08133482u 8.05p -0.08801425u 8.0625p -0.09470936u 8.075p -0.1014061u 8.0875p -0.1080905u 8.1p -0.1147487u
+ 8.1125p -0.121367u 8.125p -0.1279316u 8.1375p -0.1344293u 8.15p -0.1408467u 8.1625p -0.1471709u 8.175p -0.1533891u 8.1875p -0.1594889u 8.2p -0.165458u 8.2125p -0.1712848u 8.225p -0.1769575u 8.2375p -0.1824653u 8.25p -0.1877973u
+ 8.2625p -0.1929433u 8.275p -0.1978933u 8.2875p -0.202638u 8.3p -0.2071684u 8.3125p -0.211476u 8.325p -0.215553u 8.3375p -0.2193918u 8.35p -0.2229855u 8.3625p -0.2263278u 8.375p -0.2294129u 8.3875p -0.2322354u 8.4p -0.2347908u
+ 8.4125p -0.2370749u 8.425p -0.2390842u 8.4375p -0.2408157u 8.45p -0.2422672u 8.4625p -0.2434368u 8.475p -0.2443234u 8.4875p -0.2449265u 8.5p -0.2452461u 8.5125p -0.2452828u 8.525p -0.2450378u 8.5375p -0.244513u 8.55p -0.2437106u
+ 8.5625p -0.2426336u 8.575p -0.2412855u 8.5875p -0.2396703u 8.6p -0.2377926u 8.6125p -0.2356574u 8.625p -0.2332705u 8.6375p -0.2306377u 8.65p -0.2277658u 8.6625p -0.2246618u 8.675p -0.221333u 8.6875p -0.2177875u 8.7p -0.2140336u
+ 8.7125p -0.2100798u 8.725p -0.2059354u 8.7375p -0.2016096u 8.75p -0.1971123u 8.7625p -0.1924534u 8.775p -0.1876433u 8.7875p -0.1826926u 8.8p -0.1776119u 8.8125p -0.1724124u 8.825p -0.1671051u 8.8375p -0.1617015u 8.85p -0.1562129u
+ 8.8625p -0.150651u 8.875p -0.1450274u 8.8875p -0.1393538u 8.9p -0.1336419u 8.9125p -0.1279035u 8.925p -0.1221502u 8.9375p -0.1163938u 8.95p -0.1106458u 8.9625p -0.1049177u 8.975p -0.09922081u 8.9875p -0.09356646u 9p -0.08796567u
+ 9.0125p -0.08242931u 9.025p -0.07696801u 9.0375p -0.07159221u 9.05p -0.06631205u 9.0625p -0.06113742u 9.075p -0.0560779u 9.0875p -0.05114276u 9.1p -0.04634093u 9.1125p -0.041681u 9.125p -0.03717117u 9.1375p -0.03281928u 9.15p -0.02863275u
+ 9.1625p -0.0246186u 9.175p -0.02078342u 9.1875p -0.01713336u 9.2p -0.01367413u 9.2125p -0.01041097u 9.225p -0.007348668u 9.2375p -0.004491521u 9.25p -0.001843353u 9.2625p 0.000592501u 9.275p 0.002813196u 9.2875p 0.004816384u 9.3p 0.006600213u
+ 9.3125p 0.008163331u 9.325p 0.009504884u 9.3375p 0.01062452u 9.35p 0.01152237u 9.3625p 0.01219907u 9.375p 0.01265575u 9.3875p 0.01289401u 9.4p 0.01291593u 9.4125p 0.01272407u 9.425p 0.01232145u 9.4375p 0.01171153u 9.45p 0.01089824u
+ 9.4625p 0.00988591u 9.475p 0.008679319u 9.4875p 0.007283641u 9.5p 0.005704451u 9.5125p 0.0039477u 9.525p 0.00201971u 9.5375p -7.284849e-05u 9.55p -0.002322969u 9.5625p -0.004723327u 9.575p -0.007266299u 9.5875p -0.009943976u 9.6p -0.01274819u
+ 9.6125p -0.01567052u 9.625p -0.01870232u 9.6375p -0.02183475u 9.65p -0.02505877u 9.6625p -0.02836518u 9.675p -0.03174463u 9.6875p -0.03518765u 9.7p -0.03868466u 9.7125p -0.042226u 9.725p -0.04580196u 9.7375p -0.04940276u 9.75p -0.05301864u
+ 9.7625p -0.0566398u 9.775p -0.06025649u 9.7875p -0.06385898u 9.8p -0.06743764u 9.8125p -0.07098288u 9.825p -0.07448524u 9.8375p -0.07793537u 9.85p -0.08132407u 9.8625p -0.0846423u 9.875p -0.08788118u 9.8875p -0.09103206u 9.9p -0.09408648u
+ 9.9125p -0.09703622u 9.925p -0.09987331u 9.9375p -0.10259u 9.95p -0.1051789u 9.9625p -0.1076329u 9.975p -0.1099451u 9.9875p -0.112109u 10p -0.1141184u 10.0125p -0.271271u 10.025p -0.4240244u 10.0375p -0.5723464u 10.05p -0.7164851u
+ 10.0625p -0.8567761u 10.075p -0.9935762u 10.0875p -1.127241u 10.1p -1.258117u 10.1125p -1.386538u 10.125p -1.512827u 10.1375p -1.637293u 10.15p -1.760232u 10.1625p -1.881926u 10.175p -2.002645u 10.1875p -2.122646u 10.2p -2.242171u
+ 10.2125p -2.361451u 10.225p -2.480703u 10.2375p -2.600129u 10.25p -2.719921u 10.2625p -2.840256u 10.275p -2.961299u 10.2875p -3.0832u 10.3p -3.206101u 10.3125p -3.330125u 10.325p -3.455387u 10.3375p -3.581988u 10.35p -3.710017u
+ 10.3625p -3.83955u 10.375p -3.970653u 10.3875p -4.103378u 10.4p -4.237766u 10.4125p -4.373849u 10.425p -4.511646u 10.4375p -4.651164u 10.45p -4.792401u 10.4625p -4.935346u 10.475p -5.079975u 10.4875p -5.226258u 10.5p -5.374152u
+ 10.5125p -5.523607u 10.525p -5.674565u 10.5375p -5.826957u 10.55p -5.98071u 10.5625p -6.135739u 10.575p -6.291956u 10.5875p -6.449262u 10.6p -6.607556u 10.6125p -6.766727u 10.625p -6.926661u 10.6375p -7.087238u 10.65p -7.248333u
+ 10.6625p -7.409817u 10.675p -7.571556u 10.6875p -7.733413u 10.7p -7.89525u 10.7125p -8.056922u 10.725p -8.218286u 10.7375p -8.379194u 10.75p -8.539498u 10.7625p -8.699048u 10.775p -8.857695u 10.7875p -9.015289u 10.8p -9.171679u
+ 10.8125p -9.326715u 10.825p -9.48025u 10.8375p -9.632135u 10.85p -9.782224u 10.8625p -9.930375u 10.875p -10.07645u 10.8875p -10.2203u 10.9p -10.36179u 10.9125p -10.5008u 10.925p -10.63719u 10.9375p -10.77084u 10.95p -10.90163u
+ 10.9625p -11.02944u 10.975p -11.15416u 10.9875p -11.27569u 11p -11.39391u 11.0125p -11.35344u 11.025p -11.31372u 11.0375p -11.27469u 11.05p -11.23601u 11.0625p -11.19728u 11.075p -11.15807u 11.0875p -11.11796u 11.1p -11.07653u
+ 11.1125p -11.03342u 11.125p -10.98825u 11.1375p -10.94067u 11.15p -10.89037u 11.1625p -10.83702u 11.175p -10.78035u 11.1875p -10.72009u 11.2p -10.65599u 11.2125p -10.58784u 11.225p -10.51541u 11.2375p -10.43852u 11.25p -10.35701u
+ 11.2625p -10.27074u 11.275p -10.17956u 11.2875p -10.08337u 11.3p -9.982082u 11.3125p -9.875623u 11.325p -9.763938u 11.3375p -9.646992u 11.35p -9.524767u 11.3625p -9.39726u 11.375p -9.264489u 11.3875p -9.126485u 11.4p -8.983298u
+ 11.4125p -8.834992u 11.425p -8.681646u 11.4375p -8.523355u 11.45p -8.360228u 11.4625p -8.192387u 11.475p -8.01997u 11.4875p -7.843123u 11.5p -7.66201u 11.5125p -7.476803u 11.525p -7.287687u 11.5375p -7.094856u 11.55p -6.898517u
+ 11.5625p -6.698884u 11.575p -6.496182u 11.5875p -6.290642u 11.6p -6.082506u 11.6125p -5.872021u 11.625p -5.659441u 11.6375p -5.445028u 11.65p -5.229048u 11.6625p -5.011771u 11.675p -4.793474u 11.6875p -4.574435u 11.7p -4.354938u
+ 11.7125p -4.135268u 11.725p -3.915712u 11.7375p -3.69656u 11.75p -3.4781u 11.7625p -3.260624u 11.775p -3.04442u 11.7875p -2.829779u 11.8p -2.616988u 11.8125p -2.406333u 11.825p -2.198099u 11.8375p -1.992565u 11.85p -1.79001u
+ 11.8625p -1.590706u 11.875p -1.394924u 11.8875p -1.202927u 11.9p -1.014975u 11.9125p -0.8313204u 11.925p -0.6522104u 11.9375p -0.4778854u 11.95p -0.3085785u 11.9625p -0.1445156u 11.975p 0.01408534u 11.9875p 0.1670147u 12p 0.3140712u
+ 12.0125p 0.4550627u 12.025p 0.5898062u 12.0375p 0.7181281u 12.05p 0.8398648u 12.0625p 0.9548627u 12.075p 1.062978u 12.0875p 1.164079u 12.1p 1.258043u 12.1125p 1.344759u 12.125p 1.424126u 12.1375p 1.496057u 12.15p 1.560473u
+ 12.1625p 1.617309u 12.175p 1.66651u 12.1875p 1.708033u 12.2p 1.741848u 12.2125p 1.767935u 12.225p 1.786285u 12.2375p 1.796903u 12.25p 1.799804u 12.2625p 1.795016u 12.275p 1.782575u 12.2875p 1.762534u 12.3p 1.734952u
+ 12.3125p 1.699902u 12.325p 1.657466u 12.3375p 1.60774u 12.35p 1.550827u 12.3625p 1.486843u 12.375p 1.415912u 12.3875p 1.338171u 12.4p 1.253763u 12.4125p 1.162843u 12.425p 1.065574u 12.4375p 0.9621293u 12.45p 0.8526887u
+ 12.4625p 0.7374416u 12.475p 0.6165848u 12.4875p 0.4903228u 12.5p 0.3588673u 12.5125p 0.2224368u 12.525p 0.08125618u 12.5375p -0.06444332u 12.55p -0.214425u 12.5625p -0.3684466u 12.575p -0.5262611u 12.5875p -0.6876169u 12.6p -0.8522583u
+ 12.6125p -1.019926u 12.625p -1.190357u 12.6375p -1.363285u 12.65p -1.538443u 12.6625p -1.715561u 12.675p -1.894366u 12.6875p -2.074585u 12.7p -2.255944u 12.7125p -2.438169u 12.725p -2.620987u 12.7375p -2.804121u 12.75p -2.9873u
+ 12.7625p -3.170251u 12.775p -3.352705u 12.7875p -3.534391u 12.8p -3.715045u 12.8125p -3.894403u 12.825p -4.072204u 12.8375p -4.248192u 12.85p -4.422112u 12.8625p -4.593717u 12.875p -4.76276u 12.8875p -4.929003u 12.9p -5.092211u
+ 12.9125p -5.252152u 12.925p -5.408604u 12.9375p -5.561348u 12.95p -5.710171u 12.9625p -5.854869u 12.975p -5.995241u 12.9875p -6.131095u 13p -6.262246u 13.0125p -6.388515u 13.025p -6.50973u 13.0375p -6.625728u 13.05p -6.736354u
+ 13.0625p -6.841458u 13.075p -6.940899u 13.0875p -7.034546u 13.1p -7.122274u 13.1125p -7.203965u 13.125p -7.279512u 13.1375p -7.348813u 13.15p -7.411778u 13.1625p -7.468322u 13.175p -7.518368u 13.1875p -7.561851u 13.2p -7.598709u
+ 13.2125p -7.628893u 13.225p -7.652358u 13.2375p -7.66907u 13.25p -7.679002u 13.2625p -7.682134u 13.275p -7.678455u 13.2875p -7.667962u 13.3p -7.650658u 13.3125p -7.626555u 13.325p -7.595673u 13.3375p -7.558038u 13.35p -7.513683u
+ 13.3625p -7.46265u 13.375p -7.404987u 13.3875p -7.340748u 13.4p -7.269995u 13.4125p -7.192797u 13.425p -7.109228u 13.4375p -7.01937u 13.45p -6.92331u 13.4625p -6.821142u 13.475p -6.712966u 13.4875p -6.598888u 13.5p -6.479018u
+ 13.5125p -6.353475u 13.525p -6.22238u 13.5375p -6.085863u 13.55p -5.944055u 13.5625p -5.797097u 13.575p -5.645131u 13.5875p -5.488307u 13.6p -5.326777u 13.6125p -5.160699u 13.625p -4.990237u 13.6375p -4.815557u 13.65p -4.63683u
+ 13.6625p -4.454233u 13.675p -4.267944u 13.6875p -4.078148u 13.7p -3.885032u 13.7125p -3.688788u 13.725p -3.489609u 13.7375p -3.287694u 13.75p -3.083245u 13.7625p -2.876466u 13.775p -2.667564u 13.7875p -2.456751u 13.8p -2.24424u
+ 13.8125p -2.030245u 13.825p -1.814986u 13.8375p -1.598683u 13.85p -1.381557u 13.8625p -1.163834u 13.875p -0.9457379u 13.8875p -0.7274973u 13.9p -0.5093402u 13.9125p -0.2914963u 13.925p -0.07419568u 13.9375p 0.1423306u 13.95p 0.3578514u
+ 13.9625p 0.5721354u 13.975p 0.7849513u 13.9875p 0.9960684u 14p 1.205257u 14.0125p 1.412286u 14.025p 1.61693u 14.0375p 1.818961u 14.05p 2.018154u 14.0625p 2.214287u 14.075p 2.407139u 14.0875p 2.596493u 14.1p 2.782132u
+ 14.1125p 2.963847u 14.125p 3.141427u 14.1375p 3.31467u 14.15p 3.483375u 14.1625p 3.647345u 14.175p 3.80639u 14.1875p 3.960323u 14.2p 4.108963u 14.2125p 4.252135u 14.225p 4.389669u 14.2375p 4.521402u 14.25p 4.647177u
+ 14.2625p 4.766843u 14.275p 4.880256u 14.2875p 4.987281u 14.3p 5.087788u 14.3125p 5.181656u 14.325p 5.268771u 14.3375p 5.349028u 14.35p 5.422329u 14.3625p 5.488586u 14.375p 5.547717u 14.3875p 5.599652u 14.4p 5.644327u
+ 14.4125p 5.681689u 14.425p 5.711694u 14.4375p 5.734305u 14.45p 5.749496u 14.4625p 5.757252u 14.475p 5.757563u 14.4875p 5.750433u 14.5p 5.735873u 14.5125p 5.713904u 14.525p 5.684557u 14.5375p 5.647871u 14.55p 5.603895u
+ 14.5625p 5.55269u 14.575p 5.494321u 14.5875p 5.428867u 14.6p 5.356414u 14.6125p 5.277057u 14.625p 5.1909u 14.6375p 5.098056u 14.65p 4.998646u 14.6625p 4.8928u 14.675p 4.780656u 14.6875p 4.662358u 14.7p 4.538062u
+ 14.7125p 4.407927u 14.725p 4.272123u 14.7375p 4.130824u 14.75p 3.984212u 14.7625p 3.832477u 14.775p 3.675813u 14.7875p 3.514421u 14.8p 3.348508u 14.8125p 3.178285u 14.825p 3.003968u 14.8375p 2.82578u 14.85p 2.643946u
+ 14.8625p 2.458696u 14.875p 2.270263u 14.8875p 2.078885u 14.9p 1.8848u 14.9125p 1.688252u 14.925p 1.489485u 14.9375p 1.288746u 14.95p 1.086282u 14.9625p 0.8823435u 14.975p 0.6771797u 14.9875p 0.4710414u 15p 0.2641792u
+ 15.0125p 0.05684339u 15.025p -0.1507164u 15.0375p -0.3582515u 15.05p -0.5655147u 15.0625p -0.7722604u 15.075p -0.978245u 15.0875p -1.183227u 15.1p -1.386969u 15.1125p -1.589235u 15.125p -1.789794u 15.1375p -1.988416u 15.15p -2.184878u
+ 15.1625p -2.37896u 15.175p -2.570447u 15.1875p -2.759127u 15.2p -2.944797u 15.2125p -3.127255u 15.225p -3.306308u 15.2375p -3.481768u 15.25p -3.653452u 15.2625p -3.821184u 15.275p -3.984795u 15.2875p -4.144123u 15.3p -4.299012u
+ 15.3125p -4.449314u 15.325p -4.594887u 15.3375p -4.735597u 15.35p -4.871319u 15.3625p -5.001933u 15.375p -5.127329u 15.3875p -5.247403u 15.4p -5.362062u 15.4125p -5.471216u 15.425p -5.574789u 15.4375p -5.672709u 15.45p -5.764912u
+ 15.4625p -5.851346u 15.475p -5.931963u 15.4875p -6.006725u 15.5p -6.075603u 15.5125p -6.138575u 15.525p -6.195627u 15.5375p -6.246753u 15.55p -6.291957u 15.5625p -6.331249u 15.575p -6.364648u 15.5875p -6.392179u 15.6p -6.413876u
+ 15.6125p -6.429782u 15.625p -6.439945u 15.6375p -6.444423u 15.65p -6.443279u 15.6625p -6.436584u 15.675p -6.424416u 15.6875p -6.40686u 15.7p -6.384008u 15.7125p -6.355958u 15.725p -6.322815u 15.7375p -6.284689u 15.75p -6.241698u
+ 15.7625p -6.193964u 15.775p -6.141615u 15.7875p -6.084786u 15.8p -6.023616u 15.8125p -5.958247u 15.825p -5.88883u 15.8375p -5.815519u 15.85p -5.738469u 15.8625p -5.657845u 15.875p -5.573812u 15.8875p -5.486538u 15.9p -5.396198u
+ 15.9125p -5.302968u 15.925p -5.207026u 15.9375p -5.108555u 15.95p -5.007737u 15.9625p -4.904761u 15.975p -4.799813u 15.9875p -4.693084u 16p -4.584764u 16.0125p -4.475046u 16.025p -4.364122u 16.0375p -4.252185u 16.05p -4.139429u
+ 16.0625p -4.026048u 16.075p -3.912234u 16.0875p -3.798179u 16.1p -3.684075u 16.1125p -3.570112u 16.125p -3.456479u 16.1375p -3.343362u 16.15p -3.230945u 16.1625p -3.119412u 16.175p -3.008941u 16.1875p -2.899709u 16.2p -2.79189u
+ 16.2125p -2.685653u 16.225p -2.581164u 16.2375p -2.478586u 16.25p -2.378076u 16.2625p -2.279788u 16.275p -2.18387u 16.2875p -2.090465u 16.3p -1.999712u 16.3125p -1.911744u 16.325p -1.826687u 16.3375p -1.744664u 16.35p -1.665788u
+ 16.3625p -1.59017u 16.375p -1.517911u 16.3875p -1.449108u 16.4p -1.38385u 16.4125p -1.32222u 16.425p -1.264293u 16.4375p -1.210138u 16.45p -1.159816u 16.4625p -1.113382u 16.475p -1.070883u 16.4875p -1.032358u 16.5p -0.997839u
+ 16.5125p -0.9673522u 16.525p -0.9409149u 16.5375p -0.9185374u 16.55p -0.9002227u 16.5625p -0.8859668u 16.575p -0.8757581u 16.5875p -0.8695782u 16.6p -0.8674014u 16.6125p -0.8691952u 16.625p -0.8749202u 16.6375p -0.8845303u 16.65p -0.8979725u
+ 16.6625p -0.9151879u 16.675p -0.9361106u 16.6875p -0.9606691u 16.7p -0.9887857u 16.7125p -1.020377u 16.725p -1.055353u 16.7375p -1.09362u 16.75p -1.135078u 16.7625p -1.179622u 16.775p -1.227142u 16.7875p -1.277525u 16.8p -1.33065u
+ 16.8125p -1.386396u 16.825p -1.444636u 16.8375p -1.505239u 16.85p -1.568071u 16.8625p -1.632995u 16.875p -1.699871u 16.8875p -1.768556u 16.9p -1.838904u 16.9125p -1.910768u 16.925p -1.983999u 16.9375p -2.058445u 16.95p -2.133953u
+ 16.9625p -2.210369u 16.975p -2.287538u 16.9875p -2.365304u 17p -2.443512u 17.0125p -2.522003u 17.025p -2.600623u 17.0375p -2.679215u 17.05p -2.757623u 17.0625p -2.835693u 17.075p -2.91327u 17.0875p -2.990202u 17.1p -3.066337u
+ 17.1125p -3.141527u 17.125p -3.215624u 17.1375p -3.288483u 17.15p -3.359961u 17.1625p -3.429917u 17.175p -3.498215u 17.1875p -3.564721u 17.2p -3.629302u 17.2125p -3.691833u 17.225p -3.752188u 17.2375p -3.810249u 17.25p -3.865899u
+ 17.2625p -3.919026u 17.275p -3.969523u 17.2875p -4.017288u 17.3p -4.062222u 17.3125p -4.104231u 17.325p -4.143229u 17.3375p -4.17913u 17.35p -4.211857u 17.3625p -4.241338u 17.375p -4.267504u 17.3875p -4.290295u 17.4p -4.309653u
+ 17.4125p -4.325528u 17.425p -4.337876u 17.4375p -4.346656u 17.45p -4.351835u 17.4625p -4.353387u 17.475p -4.351289u 17.4875p -4.345525u 17.5p -4.336086u 17.5125p -4.322967u 17.525p -4.30617u 17.5375p -4.285704u 17.55p -4.261581u
+ 17.5625p -4.233821u 17.575p -4.202449u 17.5875p -4.167496u 17.6p -4.128998u 17.6125p -4.086997u 17.625p -4.041541u 17.6375p -3.992683u 17.65p -3.940481u 17.6625p -3.884998u 17.675p -3.826303u 17.6875p -3.76447u 17.7p -3.699576u
+ 17.7125p -3.631706u 17.725p -3.560947u 17.7375p -3.487391u 17.75p -3.411135u 17.7625p -3.332281u 17.775p -3.250932u 17.7875p -3.167199u 17.8p -3.081192u 17.8125p -2.993029u 17.825p -2.902829u 17.8375p -2.810715u 17.85p -2.716812u
+ 17.8625p -2.62125u 17.875p -2.524158u 17.8875p -2.425671u 17.9p -2.325925u 17.9125p -2.225057u 17.925p -2.123208u 17.9375p -2.020519u 17.95p -1.917133u 17.9625p -1.813193u 17.975p -1.708846u 17.9875p -1.604236u 18p -1.499511u
+ 18.0125p -1.394817u 18.025p -1.290302u 18.0375p -1.186112u 18.05p -1.082394u 18.0625p -0.9792935u 18.075p -0.876957u 18.0875p -0.7755285u 18.1p -0.6751514u 18.1125p -0.5759677u 18.125p -0.4781175u 18.1375p -0.3817396u 18.15p -0.2869705u
+ 18.1625p -0.1939444u 18.175p -0.1027932u 18.1875p -0.0136461u 18.2p 0.07337045u 18.2125p 0.1581331u 18.225p 0.2405218u 18.2375p 0.3204198u 18.25p 0.397714u 18.2625p 0.4722951u 18.275p 0.5440578u 18.2875p 0.6129006u 18.3p 0.6787269u
+ 18.3125p 0.7414439u 18.325p 0.8009638u 18.3375p 0.8572034u 18.35p 0.9100844u 18.3625p 0.9595334u 18.375p 1.005482u 18.3875p 1.047868u 18.4p 1.086633u 18.4125p 1.121725u 18.425p 1.153097u 18.4375p 1.180709u 18.45p 1.204525u
+ 18.4625p 1.224514u 18.475p 1.240654u 18.4875p 1.252927u 18.5p 1.261319u 18.5125p 1.265825u 18.525p 1.266444u 18.5375p 1.263181u 18.55p 1.256049u 18.5625p 1.245064u 18.575p 1.230249u 18.5875p 1.211634u 18.6p 1.189252u
+ 18.6125p 1.163145u 18.625p 1.133358u 18.6375p 1.099943u 18.65p 1.062956u 18.6625p 1.022462u 18.675p 0.978526u 18.6875p 0.9312229u 18.7p 0.8806301u 18.7125p 0.8268307u 18.725p 0.7699127u 18.7375p 0.7099684u 18.75p 0.647095u
+ 18.7625p 0.5813938u 18.775p 0.5129706u 18.7875p 0.4419349u 18.8p 0.3684004u 18.8125p 0.2924841u 18.825p 0.2143067u 18.8375p 0.1339923u 18.85p 0.05166798u 18.8625p -0.03253638u 18.875p -0.1184881u 18.8875p -0.2060519u 18.9p -0.2950905u
+ 18.9125p -0.3854644u 18.925p -0.4770323u 18.9375p -0.5696512u 18.95p -0.6631769u 18.9625p -0.7574637u 18.975p -0.8523654u 18.9875p -0.9477346u 19p -1.043424u 19.0125p -1.139285u 19.025p -1.23517u 19.0375p -1.330931u 19.05p -1.426421u
+ 19.0625p -1.521492u 19.075p -1.615999u 19.0875p -1.709797u 19.1p -1.802741u 19.1125p -1.894689u 19.125p -1.9855u 19.1375p -2.075036u 19.15p -2.16316u 19.1625p -2.249736u 19.175p -2.334632u 19.1875p -2.417718u 19.2p -2.498868u
+ 19.2125p -2.577957u 19.225p -2.654864u 19.2375p -2.729471u 19.25p -2.801663u 19.2625p -2.87133u 19.275p -2.938363u 19.2875p -3.002659u 19.3p -3.064118u 19.3125p -3.122645u 19.325p -3.178147u 19.3375p -3.230537u 19.35p -3.279732u
+ 19.3625p -3.325653u 19.375p -3.368225u 19.3875p -3.407378u 19.4p -3.443048u 19.4125p -3.475173u 19.425p -3.503698u 19.4375p -3.528572u 19.45p -3.549748u 19.4625p -3.567185u 19.475p -3.580845u 19.4875p -3.590698u 19.5p -3.596717u
+ 19.5125p -3.598879u 19.525p -3.597167u 19.5375p -3.59157u 19.55p -3.582081u 19.5625p -3.568696u 19.575p -3.551419u 19.5875p -3.530257u 19.6p -3.505222u 19.6125p -3.476332u 19.625p -3.443607u 19.6375p -3.407076u 19.65p -3.366768u
+ 19.6625p -3.32272u 19.675p -3.274971u 19.6875p -3.223568u 19.7p -3.168559u 19.7125p -3.109998u 19.725p -3.047943u 19.7375p -2.982456u 19.75p -2.913603u 19.7625p -2.841455u 19.775p -2.766086u 19.7875p -2.687574u 19.8p -2.606002u
+ 19.8125p -2.521455u 19.825p -2.434023u 19.8375p -2.343798u 19.85p -2.250877u 19.8625p -2.155358u 19.875p -2.057346u 19.8875p -1.956945u 19.9p -1.854265u 19.9125p -1.749416u 19.925p -1.642513u 19.9375p -1.533673u 19.95p -1.423015u
+ 19.9625p -1.31066u 19.975p -1.196733u 19.9875p -1.081359u 20p -0.9646648u 20.0125p -0.6914775u 20.025p -0.4214646u 20.0375p -0.1547855u 20.05p 0.108679u 20.0625p 0.3691345u 20.075p 0.6268062u 20.0875p 0.8819173u 20.1p 1.134681u
+ 20.1125p 1.385298u 20.125p 1.633957u 20.1375p 1.880831u 20.15p 2.126083u 20.1625p 2.36986u 20.175p 2.612297u 20.1875p 2.853518u 20.2p 3.093633u 20.2125p 3.332739u 20.225p 3.570921u 20.2375p 3.808253u 20.25p 4.044797u
+ 20.2625p 4.280603u 20.275p 4.515708u 20.2875p 4.75014u 20.3p 4.983916u 20.3125p 5.217041u 20.325p 5.449511u 20.3375p 5.68131u 20.35p 5.912414u 20.3625p 6.142787u 20.375p 6.372386u 20.3875p 6.601159u 20.4p 6.829043u
+ 20.4125p 7.055968u 20.425p 7.281857u 20.4375p 7.506624u 20.45p 7.730176u 20.4625p 7.952412u 20.475p 8.173227u 20.4875p 8.392508u 20.5p 8.610136u 20.5125p 8.825987u 20.525p 9.039934u 20.5375p 9.251841u 20.55p 9.461574u
+ 20.5625p 9.668989u 20.575p 9.873943u 20.5875p 10.07629u 20.6p 10.27588u 20.6125p 10.47256u 20.625p 10.66618u 20.6375p 10.85658u 20.65p 11.04361u 20.6625p 11.22712u 20.675p 11.40696u 20.6875p 11.58296u 20.7p 11.75498u
+ 20.7125p 11.92286u 20.725p 12.08646u 20.7375p 12.24564u 20.75p 12.40025u 20.7625p 12.55014u 20.775p 12.69519u 20.7875p 12.83527u 20.8p 12.97024u 20.8125p 13.09998u 20.825p 13.22438u 20.8375p 13.34333u 20.85p 13.45672u
+ 20.8625p 13.56445u 20.875p 13.66643u 20.8875p 13.76258u 20.9p 13.85281u 20.9125p 13.93706u 20.925p 14.01526u 20.9375p 14.08735u 20.95p 14.15329u 20.9625p 14.21304u 20.975p 14.26657u 20.9875p 14.31385u 21p 14.35488u
+ 21.0125p 14.23434u 21.025p 14.11178u 21.0375p 13.98723u 21.05p 13.86046u 21.0625p 13.73117u 21.075p 13.59904u 21.0875p 13.46375u 21.1p 13.32501u 21.1125p 13.18255u 21.125p 13.03612u 21.1375p 12.8855u 21.15p 12.73048u
+ 21.1625p 12.57088u 21.175p 12.40654u 21.1875p 12.23732u 21.2p 12.06311u 21.2125p 11.8838u 21.225p 11.69933u 21.2375p 11.50963u 21.25p 11.31469u 21.2625p 11.11448u 21.275p 10.90902u 21.2875p 10.69832u 21.3p 10.48245u
+ 21.3125p 10.26146u 21.325p 10.03544u 21.3375p 9.804488u 21.35p 9.568728u 21.3625p 9.328295u 21.375p 9.083342u 21.3875p 8.834038u 21.4p 8.580566u 21.4125p 8.323125u 21.425p 8.061928u 21.4375p 7.797201u 21.45p 7.529183u
+ 21.4625p 7.258124u 21.475p 6.984286u 21.4875p 6.707943u 21.5p 6.429376u 21.5125p 6.148878u 21.525p 5.866748u 21.5375p 5.583295u 21.55p 5.298833u 21.5625p 5.013684u 21.575p 4.728174u 21.5875p 4.442634u 21.6p 4.157399u
+ 21.6125p 3.872807u 21.625p 3.589198u 21.6375p 3.306916u 21.65p 3.026302u 21.6625p 2.7477u 21.675p 2.471453u 21.6875p 2.1979u 21.7p 1.927382u 21.7125p 1.660235u 21.725p 1.39679u 21.7375p 1.137378u 21.75p 0.8823206u
+ 21.7625p 0.6319373u 21.775p 0.3865399u 21.7875p 0.1464339u 21.8p -0.0880825u 21.8125p -0.316719u 21.825p -0.5391937u 21.8375p -0.7552336u 21.85p -0.964575u 21.8625p -1.166964u 21.875p -1.362158u 21.8875p -1.549924u 21.9p -1.73004u
+ 21.9125p -1.902296u 21.925p -2.066494u 21.9375p -2.222448u 21.95p -2.369985u 21.9625p -2.508943u 21.975p -2.639175u 21.9875p -2.760544u 22p -2.872931u 22.0125p -2.976225u 22.025p -3.070333u 22.0375p -3.155173u 22.05p -3.230677u
+ 22.0625p -3.296791u 22.075p -3.353476u 22.0875p -3.400704u 22.1p -3.438462u 22.1125p -3.46675u 22.125p -3.485583u 22.1375p -3.494988u 22.15p -3.495005u 22.1625p -3.485688u 22.175p -3.467102u 22.1875p -3.439327u 22.2p -3.402454u
+ 22.2125p -3.356587u 22.225p -3.301841u 22.2375p -3.238344u 22.25p -3.166234u 22.2625p -3.085662u 22.275p -2.996788u 22.2875p -2.899783u 22.3p -2.794829u 22.3125p -2.682118u 22.325p -2.561851u 22.3375p -2.434238u 22.35p -2.299498u
+ 22.3625p -2.15786u 22.375p -2.009559u 22.3875p -1.854838u 22.4p -1.69395u 22.4125p -1.527153u 22.425p -1.354711u 22.4375p -1.176896u 22.45p -0.9939856u 22.4625p -0.8062619u 22.475p -0.6140132u 22.4875p -0.4175322u 22.5p -0.2171161u
+ 22.5125p -0.01306593u 22.525p 0.1943134u 22.5375p 0.4047141u 22.55p 0.6178252u 22.5625p 0.8333336u 22.575p 1.050924u 22.5875p 1.270279u 22.6p 1.491082u 22.6125p 1.713012u 22.625p 1.93575u 22.6375p 2.158977u 22.65p 2.382373u
+ 22.6625p 2.60562u 22.675p 2.8284u 22.6875p 3.050397u 22.7p 3.271296u 22.7125p 3.490786u 22.725p 3.708557u 22.7375p 3.924303u 22.75p 4.13772u 22.7625p 4.34851u 22.775p 4.556376u 22.7875p 4.761029u 22.8p 4.962181u
+ 22.8125p 5.159553u 22.825p 5.352869u 22.8375p 5.541859u 22.85p 5.72626u 22.8625p 5.905816u 22.875p 6.080277u 22.8875p 6.249401u 22.9p 6.412951u 22.9125p 6.570701u 22.925p 6.722432u 22.9375p 6.867933u 22.95p 7.007001u
+ 22.9625p 7.139443u 22.975p 7.265074u 22.9875p 7.383721u 23p 7.495217u 23.0125p 7.599408u 23.025p 7.696146u 23.0375p 7.785297u 23.05p 7.866737u 23.0625p 7.940349u 23.075p 8.006029u 23.0875p 8.063685u 23.1p 8.113233u
+ 23.1125p 8.154602u 23.125p 8.18773u 23.1375p 8.212568u 23.15p 8.229076u 23.1625p 8.237226u 23.175p 8.237001u 23.1875p 8.228395u 23.2p 8.211413u 23.2125p 8.18607u 23.225p 8.152392u 23.2375p 8.110417u 23.25p 8.060193u
+ 23.2625p 8.001777u 23.275p 7.935238u 23.2875p 7.860655u 23.3p 7.778117u 23.3125p 7.687721u 23.325p 7.589578u 23.3375p 7.483803u 23.35p 7.370526u 23.3625p 7.24988u 23.375p 7.122013u 23.3875p 6.987077u 23.4p 6.845233u
+ 23.4125p 6.696653u 23.425p 6.541514u 23.4375p 6.380002u 23.45p 6.212308u 23.4625p 6.038633u 23.475p 5.859182u 23.4875p 5.674169u 23.5p 5.483812u 23.5125p 5.288335u 23.525p 5.087969u 23.5375p 4.882949u 23.55p 4.673513u
+ 23.5625p 4.459907u 23.575p 4.24238u 23.5875p 4.021182u 23.6p 3.796571u 23.6125p 3.568805u 23.625p 3.338146u 23.6375p 3.104858u 23.65p 2.869207u 23.6625p 2.631463u 23.675p 2.391894u 23.6875p 2.150771u 23.7p 1.908366u
+ 23.7125p 1.664952u 23.725p 1.420801u 23.7375p 1.176184u 23.75p 0.9313748u 23.7625p 0.6866427u 23.775p 0.4422579u 23.7875p 0.1984888u 23.8p -0.04439817u 23.8125p -0.2861385u 23.825p -0.5264701u 23.8375p -0.7651337u 23.85p -1.001873u
+ 23.8625p -1.236434u 23.875p -1.468569u 23.8875p -1.698031u 23.9p -1.924578u 23.9125p -2.147973u 23.925p -2.367985u 23.9375p -2.584384u 23.95p -2.796949u 23.9625p -3.005462u 23.975p -3.209712u 23.9875p -3.409493u 24p -3.604605u
+ 24.0125p -3.794855u 24.025p -3.980055u 24.0375p -4.160025u 24.05p -4.334591u 24.0625p -4.503586u 24.075p -4.666851u 24.0875p -4.824232u 24.1p -4.975585u 24.1125p -5.120772u 24.125p -5.259662u 24.1375p -5.392132u 24.15p -5.518069u
+ 24.1625p -5.637364u 24.175p -5.749918u 24.1875p -5.855641u 24.2p -5.954449u 24.2125p -6.046267u 24.225p -6.131027u 24.2375p -6.20867u 24.25p -6.279145u 24.2625p -6.342409u 24.275p -6.398428u 24.2875p -6.447173u 24.3p -6.488626u
+ 24.3125p -6.522777u 24.325p -6.549621u 24.3375p -6.569163u 24.35p -6.581417u 24.3625p -6.586402u 24.375p -6.584147u 24.3875p -6.574686u 24.4p -6.558064u 24.4125p -6.53433u 24.425p -6.503543u 24.4375p -6.465768u 24.45p -6.421076u
+ 24.4625p -6.369548u 24.475p -6.31127u 24.4875p -6.246334u 24.5p -6.174841u 24.5125p -6.096897u 24.525p -6.012615u 24.5375p -5.922114u 24.55p -5.825519u 24.5625p -5.722962u 24.575p -5.61458u 24.5875p -5.500517u 24.6p -5.38092u
+ 24.6125p -5.255945u 24.625p -5.125751u 24.6375p -4.990503u 24.65p -4.85037u 24.6625p -4.705527u 24.675p -4.556154u 24.6875p -4.402433u 24.7p -4.244554u 24.7125p -4.082708u 24.725p -3.917091u 24.7375p -3.747904u 24.75p -3.57535u
+ 24.7625p -3.399635u 24.775p -3.22097u 24.7875p -3.039568u 24.8p -2.855644u 24.8125p -2.669416u 24.825p -2.481104u 24.8375p -2.290932u 24.85p -2.099123u 24.8625p -1.905902u 24.875p -1.711498u 24.8875p -1.516138u 24.9p -1.320051u
+ 24.9125p -1.123466u 24.925p -0.9266131u 24.9375p -0.7297223u 24.95p -0.5330228u 24.9625p -0.3367436u 24.975p -0.1411128u 24.9875p 0.05364271u 25p 0.2472972u 25.0125p 0.4396268u 25.025p 0.6304093u 25.0375p 0.8194251u 25.05p 1.006457u
+ 25.0625p 1.19129u 25.075p 1.373713u 25.0875p 1.553519u 25.1p 1.730502u 25.1125p 1.904462u 25.125p 2.075203u 25.1375p 2.242533u 25.15p 2.406265u 25.1625p 2.566217u 25.175p 2.722212u 25.1875p 2.874079u 25.2p 3.021652u
+ 25.2125p 3.164771u 25.225p 3.303282u 25.2375p 3.43704u 25.25p 3.565902u 25.2625p 3.689736u 25.275p 3.808415u 25.2875p 3.921819u 25.3p 4.029837u 25.3125p 4.132362u 25.325p 4.229299u 25.3375p 4.320558u 25.35p 4.406058u
+ 25.3625p 4.485725u 25.375p 4.559494u 25.3875p 4.627308u 25.4p 4.689117u 25.4125p 4.744882u 25.425p 4.79457u 25.4375p 4.838158u 25.45p 4.875628u 25.4625p 4.906976u 25.475p 4.9322u 25.4875p 4.951312u 25.5p 4.964329u
+ 25.5125p 4.971277u 25.525p 4.97219u 25.5375p 4.967111u 25.55p 4.95609u 25.5625p 4.939185u 25.575p 4.916463u 25.5875p 4.887996u 25.6p 4.853867u 25.6125p 4.814164u 25.625p 4.768982u 25.6375p 4.718425u 25.65p 4.662602u
+ 25.6625p 4.601629u 25.675p 4.535629u 25.6875p 4.464732u 25.7p 4.389072u 25.7125p 4.30879u 25.725p 4.224032u 25.7375p 4.134951u 25.75p 4.041702u 25.7625p 3.944447u 25.775p 3.843352u 25.7875p 3.738587u 25.8p 3.630327u
+ 25.8125p 3.518749u 25.825p 3.404034u 25.8375p 3.286368u 25.85p 3.165936u 25.8625p 3.042929u 25.875p 2.917539u 25.8875p 2.789959u 25.9p 2.660384u 25.9125p 2.529012u 25.925p 2.39604u 25.9375p 2.261666u 25.95p 2.126089u
+ 25.9625p 1.989509u 25.975p 1.852123u 25.9875p 1.714129u 26p 1.575725u 26.0125p 1.437108u 26.025p 1.298471u 26.0375p 1.160008u 26.05p 1.02191u 26.0625p 0.884366u 26.075p 0.747562u 26.0875p 0.6116816u 26.1p 0.4769054u
+ 26.1125p 0.3434105u 26.125p 0.2113706u 26.1375p 0.08095555u 26.15p -0.04766891u 26.1625p -0.1743412u 26.175p -0.2989041u 26.1875p -0.4212053u 26.2p -0.5410972u 26.2125p -0.6584373u 26.225p -0.7730884u 26.2375p -0.8849185u 26.25p -0.9938014u
+ 26.2625p -1.099617u 26.275p -1.202249u 26.2875p -1.301591u 26.3p -1.397539u 26.3125p -1.489997u 26.325p -1.578874u 26.3375p -1.664088u 26.35p -1.745561u 26.3625p -1.823223u 26.375p -1.897009u 26.3875p -1.966863u 26.4p -2.032733u
+ 26.4125p -2.094576u 26.425p -2.152354u 26.4375p -2.206037u 26.45p -2.255601u 26.4625p -2.301029u 26.475p -2.342311u 26.4875p -2.379443u 26.5p -2.412427u 26.5125p -2.441273u 26.525p -2.465996u 26.5375p -2.486619u 26.55p -2.50317u
+ 26.5625p -2.515682u 26.575p -2.524197u 26.5875p -2.528762u 26.6p -2.529427u 26.6125p -2.526252u 26.625p -2.519299u 26.6375p -2.508638u 26.65p -2.494342u 26.6625p -2.476491u 26.675p -2.455169u 26.6875p -2.430463u 26.7p -2.402469u
+ 26.7125p -2.371282u 26.725p -2.337006u 26.7375p -2.299744u 26.75p -2.259608u 26.7625p -2.216709u 26.775p -2.171164u 26.7875p -2.123093u 26.8p -2.072616u 26.8125p -2.01986u 26.825p -1.964952u 26.8375p -1.908019u 26.85p -1.849195u
+ 26.8625p -1.788612u 26.875p -1.726404u 26.8875p -1.662708u 26.9p -1.597659u 26.9125p -1.531395u 26.925p -1.464055u 26.9375p -1.395776u 26.95p -1.326697u 26.9625p -1.256956u 26.975p -1.18669u 26.9875p -1.116036u 27p -1.045131u
+ 27.0125p -0.9741094u 27.025p -0.9031045u 27.0375p -0.8322484u 27.05p -0.7616713u 27.0625p -0.6915016u 27.075p -0.6218651u 27.0875p -0.5528854u 27.1p -0.4846835u 27.1125p -0.4173776u 27.125p -0.3510827u 27.1375p -0.2859108u 27.15p -0.2219706u
+ 27.1625p -0.1593672u 27.175p -0.09820192u 27.1875p -0.03857248u 27.2p 0.01942753u 27.2125p 0.07570862u 27.225p 0.1301855u 27.2375p 0.1827773u 27.25p 0.2334075u 27.2625p 0.2820043u 27.275p 0.3285006u 27.2875p 0.3728338u 27.3p 0.4149465u
+ 27.3125p 0.4547859u 27.325p 0.4923043u 27.3375p 0.5274591u 27.35p 0.5602125u 27.3625p 0.590532u 27.375p 0.6183902u 27.3875p 0.6437647u 27.4p 0.6666383u 27.4125p 0.6869988u 27.425p 0.7048393u 27.4375p 0.7201577u 27.45p 0.7329573u
+ 27.4625p 0.743246u 27.475p 0.7510368u 27.4875p 0.7563477u 27.5p 0.7592014u 27.5125p 0.7596252u 27.525p 0.7576513u 27.5375p 0.7533163u 27.55p 0.7466612u 27.5625p 0.7377315u 27.575p 0.7265767u 27.5875p 0.7132507u 27.6p 0.697811u
+ 27.6125p 0.6803193u 27.625p 0.6608407u 27.6375p 0.6394439u 27.65p 0.6162012u 27.6625p 0.5911878u 27.675p 0.5644821u 27.6875p 0.5361656u 27.7p 0.5063221u 27.7125p 0.4750384u 27.725p 0.4424032u 27.7375p 0.4085077u 27.75p 0.3734451u
+ 27.7625p 0.3373102u 27.775p 0.3001995u 27.7875p 0.2622111u 27.8p 0.2234439u 27.8125p 0.1839984u 27.825p 0.1439755u 27.8375p 0.1034768u 27.85p 0.06260465u 27.8625p 0.0214613u 27.875p -0.01985075u 27.8875p -0.06122918u 27.9p -0.102572u
+ 27.9125p -0.1437777u 27.925p -0.1847454u 27.9375p -0.2253754u 27.95p -0.2655687u 27.9625p -0.3052277u 27.975p -0.3442562u 27.9875p -0.3825597u 28p -0.4200453u 28.0125p -0.4566221u 28.025p -0.4922012u 28.0375p -0.5266961u 28.05p -0.5600225u
+ 28.0625p -0.5920988u 28.075p -0.6228459u 28.0875p -0.6521876u 28.1p -0.6800507u 28.1125p -0.7063649u 28.125p -0.7310632u 28.1375p -0.7540817u 28.15p -0.7753602u 28.1625p -0.7948416u 28.175p -0.8124727u 28.1875p -0.8282038u 28.2p -0.8419889u
+ 28.2125p -0.8537859u 28.225p -0.8635566u 28.2375p -0.8712665u 28.25p -0.8768855u 28.2625p -0.880387u 28.275p -0.881749u 28.2875p -0.8809531u 28.3p -0.8779853u 28.3125p -0.8728358u 28.325p -0.8654986u 28.3375p -0.8559722u 28.35p -0.844259u
+ 28.3625p -0.8303656u 28.375p -0.8143028u 28.3875p -0.7960853u 28.4p -0.7757319u 28.4125p -0.7532656u 28.425p -0.7287132u 28.4375p -0.7021054u 28.45p -0.6734767u 28.4625p -0.6428657u 28.475p -0.6103144u 28.4875p -0.5758687u 28.5p -0.5395778u
+ 28.5125p -0.5014947u 28.525p -0.4616755u 28.5375p -0.42018u 28.55p -0.3770707u 28.5625p -0.3324135u 28.575p -0.2862774u 28.5875p -0.2387339u 28.6p -0.1898575u 28.6125p -0.1397253u 28.625p -0.08841683u 28.6375p -0.03601401u 28.65p 0.01739902u
+ 28.6625p 0.07173601u 28.675p 0.1269088u 28.6875p 0.1828274u 28.7p 0.2394002u 28.7125p 0.2965341u 28.725p 0.3541347u 28.7375p 0.4121061u 28.75p 0.4703519u 28.7625p 0.5287743u 28.775p 0.5872752u 28.7875p 0.6457557u 28.8p 0.7041166u
+ 28.8125p 0.7622584u 28.825p 0.8200817u 28.8375p 0.877487u 28.85p 0.9343752u 28.8625p 0.9906476u 28.875p 1.046206u 28.8875p 1.100953u 28.9p 1.154792u 28.9125p 1.207629u 28.925p 1.259368u 28.9375p 1.309916u 28.95p 1.359184u
+ 28.9625p 1.40708u 28.975p 1.453518u 28.9875p 1.498412u 29p 1.541678u 29.0125p 1.583235u 29.025p 1.623003u 29.0375p 1.660908u 29.05p 1.696873u 29.0625p 1.73083u 29.075p 1.76271u 29.0875p 1.792447u 29.1p 1.81998u
+ 29.1125p 1.845251u 29.125p 1.868203u 29.1375p 1.888786u 29.15p 1.90695u 29.1625p 1.922651u 29.175p 1.935848u 29.1875p 1.946504u 29.2p 1.954584u 29.2125p 1.960059u 29.225p 1.962904u 29.2375p 1.963097u 29.25p 1.960619u
+ 29.2625p 1.955458u 29.275p 1.947603u 29.2875p 1.93705u 29.3p 1.923795u 29.3125p 1.907843u 29.325p 1.889199u 29.3375p 1.867875u 29.35p 1.843886u 29.3625p 1.81725u 29.375p 1.787991u 29.3875p 1.756136u 29.4p 1.721715u
+ 29.4125p 1.684764u 29.425p 1.645321u 29.4375p 1.603429u 29.45p 1.559135u 29.4625p 1.512489u 29.475p 1.463543u 29.4875p 1.412356u 29.5p 1.358988u 29.5125p 1.303504u 29.525p 1.24597u 29.5375p 1.186456u 29.55p 1.125037u
+ 29.5625p 1.061789u 29.575p 0.9967905u 29.5875p 0.9301241u 29.6p 0.8618741u 29.6125p 0.7921275u 29.625p 0.7209736u 29.6375p 0.648504u 29.65p 0.5748121u 29.6625p 0.4999934u 29.675p 0.4241452u 29.6875p 0.3473662u 29.7p 0.2697569u
+ 29.7125p 0.1914189u 29.725p 0.1124551u 29.7375p 0.0329694u 29.75p -0.04693349u 29.7625p -0.1271481u 29.775p -0.2075682u 29.7875p -0.2880875u 29.8p -0.3685991u 29.8125p -0.4489962u 29.825p -0.529172u 29.8375p -0.6090199u 29.85p -0.6884336u
+ 29.8625p -0.7673073u 29.875p -0.845536u 29.8875p -0.9230152u 29.9p -0.9996417u 29.9125p -1.075313u 29.925p -1.149929u 29.9375p -1.223388u 29.95p -1.295594u 29.9625p -1.36645u 29.975p -1.43586u 29.9875p -1.503733u 30p -1.569977u
+ 30.0125p -1.634504u 30.025p -1.697228u 30.0375p -1.758064u 30.05p -1.816931u 30.0625p -1.873751u 30.075p -1.928447u 30.0875p -1.980946u 30.1p -2.031178u 30.1125p -2.079075u 30.125p -2.124573u 30.1375p -2.167611u 30.15p -2.208132u
+ 30.1625p -2.24608u 30.175p -2.281405u 30.1875p -2.314058u 30.2p -2.343997u 30.2125p -2.371179u 30.225p -2.395569u 30.2375p -2.417132u 30.25p -2.43584u 30.2625p -2.451665u 30.275p -2.464586u 30.2875p -2.474585u 30.3p -2.481647u
+ 30.3125p -2.48576u 30.325p -2.486919u 30.3375p -2.485119u 30.35p -2.480361u 30.3625p -2.47265u 30.375p -2.461994u 30.3875p -2.448404u 30.4p -2.431897u 30.4125p -2.412492u 30.425p -2.390211u 30.4375p -2.365082u 30.45p -2.337135u
+ 30.4625p -2.306404u 30.475p -2.272927u 30.4875p -2.236744u 30.5p -2.1979u 30.5125p -2.156442u 30.525p -2.112423u 30.5375p -2.065895u 30.55p -2.016916u 30.5625p -1.965548u 30.575p -1.911852u 30.5875p -1.855897u 30.6p -1.797751u
+ 30.6125p -1.737485u 30.625p -1.675176u 30.6375p -1.610899u 30.65p -1.544736u 30.6625p -1.476766u 30.675p -1.407076u 30.6875p -1.33575u 30.7p -1.262878u 30.7125p -1.18855u 30.725p -1.112858u 30.7375p -1.035896u 30.75p -0.9577591u
+ 30.7625p -0.8785439u 30.775p -0.7983486u 30.7875p -0.7172724u 30.8p -0.6354157u 30.8125p -0.5528798u 30.825p -0.4697666u 30.8375p -0.3861789u 30.85p -0.3022199u 30.8625p -0.2179933u 30.875p -0.1336028u 30.8875p -0.04915267u 30.9p 0.03525323u
+ 30.9125p 0.119511u 30.925p 0.2035169u 30.9375p 0.287168u 30.95p 0.3703613u 30.9625p 0.4529952u 30.975p 0.5349682u 30.9875p 0.6161803u 31p 0.6965323u 31.0125p 0.7759263u 31.025p 0.8542657u 31.0375p 0.9314553u 31.05p 1.007402u
+ 31.0625p 1.082013u 31.075p 1.155199u 31.0875p 1.226872u 31.1p 1.296946u 31.1125p 1.365337u 31.125p 1.431963u 31.1375p 1.496746u 31.15p 1.559609u 31.1625p 1.620478u 31.175p 1.679281u 31.1875p 1.735951u 31.2p 1.790421u
+ 31.2125p 1.842629u 31.225p 1.892516u 31.2375p 1.940024u 31.25p 1.985101u 31.2625p 2.027697u 31.275p 2.067765u 31.2875p 2.105261u 31.3p 2.140147u 31.3125p 2.172385u 31.325p 2.201943u 31.3375p 2.228791u 31.35p 2.252905u
+ 31.3625p 2.274262u 31.375p 2.292844u 31.3875p 2.308636u 31.4p 2.321628u 31.4125p 2.331811u 31.425p 2.339183u 31.4375p 2.343743u 31.45p 2.345496u 31.4625p 2.344449u 31.475p 2.340613u 31.4875p 2.334003u 31.5p 2.324637u
+ 31.5125p 2.312537u 31.525p 2.297728u 31.5375p 2.28024u 31.55p 2.260105u 31.5625p 2.237357u 31.575p 2.212037u 31.5875p 2.184187u 31.6p 2.153851u 31.6125p 2.121078u 31.625p 2.085919u 31.6375p 2.04843u 31.65p 2.008667u
+ 31.6625p 1.96669u 31.675p 1.922562u 31.6875p 1.876347u 31.7p 1.828115u 31.7125p 1.777934u 31.725p 1.725876u 31.7375p 1.672017u 31.75p 1.616433u 31.7625p 1.559202u 31.775p 1.500403u 31.7875p 1.44012u 31.8p 1.378435u
+ 31.8125p 1.315434u 31.825p 1.251201u 31.8375p 1.185826u 31.85p 1.119395u 31.8625p 1.051999u 31.875p 0.983727u 31.8875p 0.9146704u 31.9p 0.8449205u 31.9125p 0.774569u 31.925p 0.7037079u 31.9375p 0.6324296u 31.95p 0.5608263u
+ 31.9625p 0.4889902u 31.975p 0.4170133u 31.9875p 0.3449872u 32p 0.2730031u 32.0125p 0.2011516u 32.025p 0.1295226u 32.0375p 0.05820519u 32.05p -0.01271255u 32.0625p -0.08314355u 32.075p -0.1530019u 32.0875p -0.222203u 32.1p -0.2906635u
+ 32.1125p -0.3583019u 32.125p -0.4250378u 32.1375p -0.4907929u 32.15p -0.5554905u 32.1625p -0.6190558u 32.175p -0.681416u 32.1875p -0.7425005u 32.2p -0.8022404u 32.2125p -0.8605697u 32.225p -0.917424u 32.2375p -0.9727418u 32.25p -1.026464u
+ 32.2625p -1.078533u 32.275p -1.128896u 32.2875p -1.1775u 32.3p -1.224297u 32.3125p -1.26924u 32.325p -1.312287u 32.3375p -1.353396u 32.35p -1.39253u 32.3625p -1.429654u 32.375p -1.464736u 32.3875p -1.497746u 32.4p -1.52866u
+ 32.4125p -1.557453u 32.425p -1.584105u 32.4375p -1.6086u 32.45p -1.630922u 32.4625p -1.651061u 32.475p -1.669009u 32.4875p -1.68476u 32.5p -1.698312u 32.5125p -1.709665u 32.525p -1.718823u 32.5375p -1.725792u 32.55p -1.730582u
+ 32.5625p -1.733204u 32.575p -1.733674u 32.5875p -1.732009u 32.6p -1.728229u 32.6125p -1.722357u 32.625p -1.714419u 32.6375p -1.704443u 32.65p -1.692459u 32.6625p -1.678501u 32.675p -1.662605u 32.6875p -1.644807u 32.7p -1.625148u
+ 32.7125p -1.60367u 32.725p -1.580417u 32.7375p -1.555436u 32.75p -1.528775u 32.7625p -1.500484u 32.775p -1.470615u 32.7875p -1.439221u 32.8p -1.406358u 32.8125p -1.372083u 32.825p -1.336454u 32.8375p -1.29953u 32.85p -1.261373u
+ 32.8625p -1.222043u 32.875p -1.181605u 32.8875p -1.140123u 32.9p -1.097661u 32.9125p -1.054284u 32.925p -1.01006u 32.9375p -0.965056u 32.95p -0.9193386u 32.9625p -0.872976u 32.975p -0.8260365u 32.9875p -0.7785884u 33p -0.7307002u
+ 33.0125p -0.6824405u 33.025p -0.6338776u 33.0375p -0.5850798u 33.05p -0.5361151u 33.0625p -0.487051u 33.075p -0.4379546u 33.0875p -0.3888924u 33.1p -0.3399304u 33.1125p -0.2911337u 33.125p -0.2425666u 33.1375p -0.1942925u 33.15p -0.1463738u
+ 33.1625p -0.09887195u 33.175p -0.051847u 33.1875p -0.005357893u 33.2p 0.04053775u 33.2125p 0.0857837u 33.225p 0.1303252u 33.2375p 0.174109u 33.25p 0.2170835u 33.2625p 0.2591987u 33.275p 0.3004064u 33.2875p 0.34066u 33.3p 0.3799148u
+ 33.3125p 0.4181282u 33.325p 0.4552592u 33.3375p 0.4912691u 33.35p 0.5261208u 33.3625p 0.5597797u 33.375p 0.5922129u 33.3875p 0.62339u 33.4p 0.6532824u 33.4125p 0.681864u 33.425p 0.7091105u 33.4375p 0.7350002u 33.45p 0.7595133u
+ 33.4625p 0.7826326u 33.475p 0.8043429u 33.4875p 0.8246312u 33.5p 0.8434869u 33.5125p 0.8609016u 33.525p 0.8768692u 33.5375p 0.8913856u 33.55p 0.9044492u 33.5625p 0.9160604u 33.575p 0.926222u 33.5875p 0.9349386u 33.6p 0.9422173u
+ 33.6125p 0.9480671u 33.625p 0.9524992u 33.6375p 0.9555265u 33.65p 0.9571644u 33.6625p 0.9574298u 33.675p 0.9563418u 33.6875p 0.9539212u 33.7p 0.9501907u 33.7125p 0.9451746u 33.725p 0.9388992u 33.7375p 0.9313921u 33.75p 0.9226827u
+ 33.7625p 0.912802u 33.775p 0.9017822u 33.7875p 0.8896572u 33.8p 0.8764619u 33.8125p 0.8622327u 33.825p 0.8470072u 33.8375p 0.830824u 33.85p 0.8137229u 33.8625p 0.7957446u 33.875p 0.7769306u 33.8875p 0.7573233u 33.9p 0.7369661u
+ 33.9125p 0.7159027u 33.925p 0.6941776u 33.9375p 0.6718358u 33.95p 0.6489227u 33.9625p 0.6254842u 33.975p 0.6015664u 33.9875p 0.5772155u 34p 0.5524781u 34.0125p 0.5274007u 34.025p 0.5020297u 34.0375p 0.4764116u 34.05p 0.4505927u
+ 34.0625p 0.424619u 34.075p 0.3985362u 34.0875p 0.3723896u 34.1p 0.3462241u 34.1125p 0.3200841u 34.125p 0.2940133u 34.1375p 0.268055u 34.15p 0.2422514u 34.1625p 0.2166442u 34.175p 0.1912742u 34.1875p 0.1661813u 34.2p 0.1414045u
+ 34.2125p 0.1169815u 34.225p 0.09294933u 34.2375p 0.06934367u 34.25p 0.04619908u 34.2625p 0.02354893u 34.275p 0.001425318u 34.2875p -0.02014095u 34.3p -0.04112041u 34.3125p -0.06148496u 34.325p -0.08120791u 34.3375p -0.100264u 34.35p -0.1186295u
+ 34.3625p -0.1362821u 34.375p -0.153201u 34.3875p -0.169367u 34.4p -0.1847624u 34.4125p -0.1993711u 34.425p -0.2131787u 34.4375p -0.2261722u 34.45p -0.2383402u 34.4625p -0.2496732u 34.475p -0.260163u 34.4875p -0.2698031u 34.5p -0.2785887u
+ 34.5125p -0.2865166u 34.525p -0.293585u 34.5375p -0.2997939u 34.55p -0.3051449u 34.5625p -0.3096408u 34.575p -0.3132865u 34.5875p -0.3160878u 34.6p -0.3180526u 34.6125p -0.3191898u 34.625p -0.31951u 34.6375p -0.3190251u 34.65p -0.3177485u
+ 34.6625p -0.3156948u 34.675p -0.3128799u 34.6875p -0.3093212u 34.7p -0.3050371u 34.7125p -0.3000474u 34.725p -0.2943728u 34.7375p -0.2880354u 34.75p -0.281058u 34.7625p -0.2734648u 34.775p -0.2652807u 34.7875p -0.2565316u 34.8p -0.2472442u
+ 34.8125p -0.2374461u 34.825p -0.2271657u 34.8375p -0.2164319u 34.85p -0.2052743u 34.8625p -0.1937233u 34.875p -0.1818096u 34.8875p -0.1695645u 34.9p -0.1570195u 34.9125p -0.1442067u 34.925p -0.1311583u 34.9375p -0.1179071u 34.95p -0.1044855u
+ 34.9625p -0.09092651u 34.975p -0.07726296u 34.9875p -0.06352775u 35p -0.04975368u 35.0125p -0.03597346u 35.025p -0.02221961u 35.0375p -0.008524422u 35.05p 0.005080115u 35.0625p 0.01856235u 35.075p 0.03189105u 35.0875p 0.04503543u 35.1p 0.05796521u
+ 35.1125p 0.07065069u 35.125p 0.08306278u 35.1375p 0.09517304u 35.15p 0.1069538u 35.1625p 0.118378u 35.175p 0.1294196u 35.1875p 0.1400533u 35.2p 0.1502547u 35.2125p 0.1600003u 35.225p 0.1692676u 35.2375p 0.1780351u 35.25p 0.1862824u
+ 35.2625p 0.1939902u 35.275p 0.2011401u 35.2875p 0.2077152u 35.3p 0.2136994u 35.3125p 0.219078u 35.325p 0.2238374u 35.3375p 0.2279655u 35.35p 0.2314511u 35.3625p 0.2342846u 35.375p 0.2364573u 35.3875p 0.2379622u 35.4p 0.2387934u
+ 35.4125p 0.2389463u 35.425p 0.2384178u 35.4375p 0.2372058u 35.45p 0.2353099u 35.4625p 0.2327308u 35.475p 0.2294705u 35.4875p 0.2255325u 35.5p 0.2209214u 35.5125p 0.2156432u 35.525p 0.2097052u 35.5375p 0.2031159u 35.55p 0.1958851u
+ 35.5625p 0.1880239u 35.575p 0.1795443u 35.5875p 0.1704599u 35.6p 0.1607853u 35.6125p 0.1505361u 35.625p 0.1397291u 35.6375p 0.1283822u 35.65p 0.1165144u 35.6625p 0.1041457u 35.675p 0.09129676u 35.6875p 0.07798961u 35.7p 0.06424694u
+ 35.7125p 0.05009234u 35.725p 0.03555022u 35.7375p 0.02064575u 35.75p 0.005404832u 35.7625p -0.01014595u 35.775p -0.02597939u 35.7875p -0.04206767u 35.8p -0.05838247u 35.8125p -0.07489493u 35.825p -0.0915758u 35.8375p -0.1083954u 35.85p -0.1253238u
+ 35.8625p -0.1423306u 35.875p -0.1593853u 35.8875p -0.1764573u 35.9p -0.1935156u 35.9125p -0.2105294u 35.925p -0.2274677u 35.9375p -0.2442996u 35.95p -0.2609943u 35.9625p -0.277521u 35.975p -0.2938491u 35.9875p -0.3099485u 36p -0.325789u
+ 36.0125p -0.341341u 36.025p -0.3565752u 36.0375p -0.3714627u 36.05p -0.385975u 36.0625p -0.4000844u 36.075p -0.4137634u 36.0875p -0.4269855u 36.1p -0.4397246u 36.1125p -0.4519554u 36.125p -0.4636533u 36.1375p -0.4747946u 36.15p -0.4853562u
+ 36.1625p -0.495316u 36.175p -0.5046529u 36.1875p -0.5133467u 36.2p -0.521378u 36.2125p -0.5287284u 36.225p -0.5353809u 36.2375p -0.5413191u 36.25p -0.546528u 36.2625p -0.5509935u 36.275p -0.5547028u 36.2875p -0.5576442u 36.3p -0.5598071u
+ 36.3125p -0.5611822u 36.325p -0.5617614u 36.3375p -0.5615378u 36.35p -0.5605056u 36.3625p -0.5586605u 36.375p -0.5559994u 36.3875p -0.5525202u 36.4p -0.5482225u 36.4125p -0.5431067u 36.425p -0.5371749u 36.4375p -0.5304302u 36.45p -0.522877u
+ 36.4625p -0.5145211u 36.475p -0.5053694u 36.4875p -0.49543u 36.5p -0.4847125u 36.5125p -0.4732276u 36.525p -0.460987u 36.5375p -0.4480038u 36.55p -0.4342922u 36.5625p -0.4198677u 36.575p -0.4047468u 36.5875p -0.388947u 36.6p -0.3724871u
+ 36.6125p -0.3553868u 36.625p -0.3376669u 36.6375p -0.3193493u 36.65p -0.3004566u 36.6625p -0.2810125u 36.675p -0.2610417u 36.6875p -0.2405696u 36.7p -0.2196225u 36.7125p -0.1982274u 36.725p -0.1764122u 36.7375p -0.1542054u 36.75p -0.1316363u
+ 36.7625p -0.1087345u 36.775p -0.08553065u 36.7875p -0.06205558u 36.8p -0.03834077u 36.8125p -0.01441811u 36.825p 0.009680092u 36.8375p 0.03392119u 36.85p 0.05827222u 36.8625p 0.08269997u 36.875p 0.107171u 36.8875p 0.1316517u 36.9p 0.1561085u
+ 36.9125p 0.1805074u 36.925p 0.2048148u 36.9375p 0.228997u 36.95p 0.2530202u 36.9625p 0.2768509u 36.975p 0.3004559u 36.9875p 0.3238019u 37p 0.3468563u 37.0125p 0.3695864u 37.025p 0.3919603u 37.0375p 0.4139462u 37.05p 0.4355129u
+ 37.0625p 0.4566298u 37.075p 0.4772667u 37.0875p 0.497394u 37.1p 0.5169831u 37.1125p 0.5360056u 37.125p 0.5544341u 37.1375p 0.5722421u 37.15p 0.5894036u 37.1625p 0.6058938u 37.175p 0.6216885u 37.1875p 0.6367645u 37.2p 0.6510997u
+ 37.2125p 0.6646729u 37.225p 0.6774639u 37.2375p 0.6894537u 37.25p 0.7006241u 37.2625p 0.7109583u 37.275p 0.7204404u 37.2875p 0.729056u 37.3p 0.7367915u 37.3125p 0.7436347u 37.325p 0.7495746u 37.3375p 0.7546014u 37.35p 0.7587066u
+ 37.3625p 0.761883u 37.375p 0.7641245u 37.3875p 0.7654265u 37.4p 0.7657855u 37.4125p 0.7651995u 37.425p 0.7636675u 37.4375p 0.7611902u 37.45p 0.7577692u 37.4625p 0.7534077u 37.475p 0.7481099u 37.4875p 0.7418816u 37.5p 0.7347298u
+ 37.5125p 0.7266625u 37.525p 0.7176892u 37.5375p 0.7078207u 37.55p 0.6970687u 37.5625p 0.6854466u 37.575p 0.6729685u 37.5875p 0.65965u 37.6p 0.6455076u 37.6125p 0.6305591u 37.625p 0.6148234u 37.6375p 0.5983203u 37.65p 0.5810707u
+ 37.6625p 0.5630967u 37.675p 0.5444211u 37.6875p 0.5250679u 37.7p 0.5050616u 37.7125p 0.4844281u 37.725p 0.4631938u 37.7375p 0.4413859u 37.75p 0.4190325u 37.7625p 0.3961624u 37.775p 0.3728048u 37.7875p 0.34899u 37.8p 0.3247485u
+ 37.8125p 0.3001115u 37.825p 0.2751107u 37.8375p 0.2497783u 37.85p 0.2241468u 37.8625p 0.1982492u 37.875p 0.1721187u 37.8875p 0.1457888u 37.9p 0.1192932u 37.9125p 0.09266595u 37.925p 0.06594103u 37.9375p 0.03915259u 37.95p 0.0123348u
+ 37.9625p -0.01447818u 37.975p -0.04125224u 37.9875p -0.06795339u 38p -0.09454777u 38.0125p -0.1210017u 38.025p -0.1472819u 38.0375p -0.1733551u 38.05p -0.1991886u 38.0625p -0.2247499u 38.075p -0.2500072u 38.0875p -0.2749288u 38.1p -0.2994838u
+ 38.1125p -0.3236417u 38.125p -0.3473726u 38.1375p -0.3706473u 38.15p -0.3934371u 38.1625p -0.4157143u 38.175p -0.4374516u 38.1875p -0.4586227u 38.2p -0.479202u 38.2125p -0.4991648u 38.225p -0.5184873u 38.2375p -0.5371464u 38.25p -0.5551202u
+ 38.2625p -0.5723876u 38.275p -0.5889285u 38.2875p -0.6047238u 38.3p -0.6197554u 38.3125p -0.6340065u 38.325p -0.6474609u 38.3375p -0.6601039u 38.35p -0.6719217u 38.3625p -0.6829018u 38.375p -0.6930325u 38.3875p -0.7023036u 38.4p -0.7107059u
+ 38.4125p -0.7182313u 38.425p -0.7248729u 38.4375p -0.7306251u 38.45p -0.7354834u 38.4625p -0.7394445u 38.475p -0.7425061u 38.4875p -0.7446674u 38.5p -0.7459285u 38.5125p -0.7462908u 38.525p -0.7457568u 38.5375p -0.7443304u 38.55p -0.7420163u
+ 38.5625p -0.7388205u 38.575p -0.7347502u 38.5875p -0.7298135u 38.6p -0.7240199u 38.6125p -0.7173798u 38.625p -0.7099046u 38.6375p -0.7016068u 38.65p -0.6925001u 38.6625p -0.682599u 38.675p -0.671919u 38.6875p -0.6604766u 38.7p -0.6482892u
+ 38.7125p -0.6353752u 38.725p -0.6217538u 38.7375p -0.607445u 38.75p -0.5924696u 38.7625p -0.5768493u 38.775p -0.5606065u 38.7875p -0.5437644u 38.8p -0.5263467u 38.8125p -0.5083778u 38.825p -0.4898829u 38.8375p -0.4708875u 38.85p -0.451418u
+ 38.8625p -0.4315009u 38.875p -0.4111634u 38.8875p -0.3904332u 38.9p -0.3693382u 38.9125p -0.3479067u 38.925p -0.3261675u 38.9375p -0.3041493u 38.95p -0.2818815u 38.9625p -0.2593932u 38.975p -0.2367141u 38.9875p -0.2138736u 39p -0.1909016u
+ 39.0125p -0.1678276u 39.025p -0.1446815u 39.0375p -0.1214928u 39.05p -0.09829104u 39.0625p -0.07510573u 39.075p -0.0519661u 39.0875p -0.02890118u 39.1p -0.0059398u 39.1125p 0.01688954u 39.125p 0.03955864u 39.1375p 0.06203965u 39.15p 0.08430514u
+ 39.1625p 0.1063281u 39.175p 0.128082u 39.1875p 0.1495407u 39.2p 0.1706788u 39.2125p 0.1914712u 39.225p 0.2118938u 39.2375p 0.2319226u 39.25p 0.2515346u 39.2625p 0.2707075u 39.275p 0.2894196u 39.2875p 0.3076498u 39.3p 0.3253781u
+ 39.3125p 0.3425851u 39.325p 0.3592521u 39.3375p 0.3753613u 39.35p 0.390896u 39.3625p 0.4058401u 39.375p 0.4201783u 39.3875p 0.4338966u 39.4p 0.4469814u 39.4125p 0.4594205u 39.425p 0.4712023u 39.4375p 0.4823164u 39.45p 0.4927532u
+ 39.4625p 0.5025042u 39.475p 0.5115618u 39.4875p 0.5199193u 39.5p 0.5275711u 39.5125p 0.5345126u 39.525p 0.5407401u 39.5375p 0.546251u 39.55p 0.5510436u 39.5625p 0.5551171u 39.575p 0.5584719u 39.5875p 0.5611093u 39.6p 0.5630313u
+ 39.6125p 0.5642412u 39.625p 0.5647431u 39.6375p 0.5645419u 39.65p 0.5636438u 39.6625p 0.5620555u 39.675p 0.5597847u 39.6875p 0.5568401u 39.7p 0.5532312u 39.7125p 0.5489682u 39.725p 0.5440622u 39.7375p 0.5385253u 39.75p 0.53237u
+ 39.7625p 0.5256098u 39.775p 0.5182589u 39.7875p 0.510332u 39.8p 0.5018447u 39.8125p 0.4928133u 39.825p 0.4832544u 39.8375p 0.4731855u 39.85p 0.4626245u 39.8625p 0.4515898u 39.875p 0.4401005u 39.8875p 0.428176u 39.9p 0.4158362u
+ 39.9125p 0.4031013u 39.925p 0.3899921u 39.9375p 0.3765295u 39.95p 0.3627349u 39.9625p 0.3486299u 39.975p 0.3342364u 39.9875p 0.3195763u 40p 0.304672u 40.0125p 0.2895458u 40.025p 0.2742202u 40.0375p 0.2587179u 40.05p 0.2430613u
+ 40.0625p 0.2272733u 40.075p 0.2113763u 40.0875p 0.195393u 40.1p 0.1793458u 40.1125p 0.1632572u 40.125p 0.1471492u 40.1375p 0.1310441u 40.15p 0.1149635u 40.1625p 0.09892918u 40.175p 0.08296236u 40.1875p 0.06708412u 40.2p 0.05131515u
+ 40.2125p 0.0356758u 40.225p 0.02018606u 40.2375p 0.004865504u 40.25p -0.01026673u 40.2625p -0.02519196u 40.275p -0.03989197u 40.2875p -0.05434904u 40.3p -0.06854599u 40.3125p -0.08246617u 40.325p -0.09609349u 40.3375p -0.1094124u 40.35p -0.1224081u
+ 40.3625p -0.1350663u 40.375p -0.1473732u 40.3875p -0.1593158u 40.4p -0.1708819u 40.4125p -0.1820597u 40.425p -0.1928383u 40.4375p -0.2032072u 40.45p -0.213157u 40.4625p -0.2226786u 40.475p -0.2317641u 40.4875p -0.2404058u 40.5p -0.248597u
+ 40.5125p -0.2563318u 40.525p -0.263605u 40.5375p -0.2704119u 40.55p -0.2767488u 40.5625p -0.2826126u 40.575p -0.288001u 40.5875p -0.2929124u 40.6p -0.297346u 40.6125p -0.3013016u 40.625p -0.3047797u 40.6375p -0.3077816u 40.65p -0.3103093u
+ 40.6625p -0.3123655u 40.675p -0.3139535u 40.6875p -0.3150772u 40.7p -0.3157414u 40.7125p -0.3159514u 40.725p -0.315713u 40.7375p -0.3150328u 40.75p -0.313918u 40.7625p -0.3123762u 40.775p -0.3104158u 40.7875p -0.3080456u 40.8p -0.305275u
+ 40.8125p -0.3021137u 40.825p -0.2985723u 40.8375p -0.2946614u 40.85p -0.2903924u 40.8625p -0.285777u 40.875p -0.2808273u 40.8875p -0.2755557u 40.9p -0.2699751u 40.9125p -0.2640987u 40.925p -0.25794u 40.9375p -0.2515128u 40.95p -0.244831u
+ 40.9625p -0.237909u 40.975p -0.2307613u 40.9875p -0.2234025u 41p -0.2158475u 41.0125p -0.2081113u 41.025p -0.200209u 41.0375p -0.1921558u 41.05p -0.1839669u 41.0625p -0.1756577u 41.075p -0.1672434u 41.0875p -0.1587394u 41.1p -0.1501609u
+ 41.1125p -0.1415232u 41.125p -0.1328414u 41.1375p -0.1241304u 41.15p -0.1154053u 41.1625p -0.1066807u 41.175p -0.09797128u 41.1875p -0.08929133u 41.2p -0.08065505u 41.2125p -0.07207635u 41.225p -0.0635689u 41.2375p -0.05514608u 41.25p -0.04682097u
+ 41.2625p -0.03860635u 41.275p -0.03051464u 41.2875p -0.02255793u 41.3p -0.01474793u 41.3125p -0.00709596u 41.325p 0.0003870515u 41.3375p 0.007690597u 41.35p 0.0148046u 41.3625p 0.02171941u 41.375p 0.02842586u 41.3875p 0.03491523u 41.4p 0.04117926u
+ 41.4125p 0.04721022u 41.425p 0.05300083u 41.4375p 0.05854434u 41.45p 0.0638345u 41.4625p 0.06886557u 41.475p 0.07363236u 41.4875p 0.07813016u 41.5p 0.08235482u 41.5125p 0.08630272u 41.525p 0.08997076u 41.5375p 0.09335639u 41.55p 0.09645759u
+ 41.5625p 0.09927286u 41.575p 0.1018012u 41.5875p 0.1040423u 41.6p 0.1059962u 41.6125p 0.1076634u 41.625p 0.1090452u 41.6375p 0.1101431u 41.65p 0.1109594u 41.6625p 0.1114966u 41.675p 0.1117579u 41.6875p 0.1117468u 41.7p 0.1114675u
+ 41.7125p 0.1109245u 41.725p 0.1101228u 41.7375p 0.1090676u 41.75p 0.107765u 41.7625p 0.1062211u 41.775p 0.1044426u 41.7875p 0.1024363u 41.8p 0.1002099u 41.8125p 0.09777082u 41.825p 0.09512727u 41.8375p 0.09228759u 41.85p 0.08926044u
+ 41.8625p 0.08605477u 41.875p 0.08267979u 41.8875p 0.07914497u 41.9p 0.07545999u 41.9125p 0.07163475u 41.925p 0.06767933u 41.9375p 0.063604u 41.95p 0.05941915u 41.9625p 0.05513535u 41.975p 0.05076323u 41.9875p 0.04631355u 42p 0.04179713u
+ 42.0125p 0.03722484u 42.025p 0.0326076u 42.0375p 0.02795634u 42.05p 0.02328196u 42.0625p 0.01859537u 42.075p 0.01390742u 42.0875p 0.009228905u 42.1p 0.004570523u 42.1125p -5.71135e-05u 42.125p -0.004643516u 42.1375p -0.009178331u 42.15p -0.01365136u
+ 42.1625p -0.01805258u 42.175p -0.02237216u 42.1875p -0.02660046u 42.2p -0.03072807u 42.2125p -0.03474582u 42.225p -0.0386448u 42.2375p -0.04241636u 42.25p -0.04605212u 42.2625p -0.04954403u 42.275p -0.05288431u 42.2875p -0.05606552u 42.3p -0.05908057u
+ 42.3125p -0.06192269u 42.325p -0.06458548u 42.3375p -0.06706289u 42.35p -0.06934927u 42.3625p -0.07143934u 42.375p -0.07332822u 42.3875p -0.07501142u 42.4p -0.07648487u 42.4125p -0.0777449u 42.425p -0.07878827u 42.4375p -0.07961216u 42.45p -0.08021416u
+ 42.4625p -0.08059233u 42.475p -0.08074511u 42.4875p -0.08067143u 42.5p -0.0803706u 42.5125p -0.07984241u 42.525p -0.07908707u 42.5375p -0.0781052u 42.55p -0.0768979u 42.5625p -0.07546665u 42.575p -0.07381339u 42.5875p -0.07194046u 42.6p -0.06985063u
+ 42.6125p -0.06754708u 42.625p -0.06503338u 42.6375p -0.06231352u 42.65p -0.05939187u 42.6625p -0.05627319u 42.675p -0.05296259u 42.6875p -0.04946557u 42.7p -0.04578799u 42.7125p -0.04193603u 42.725p -0.03791621u 42.7375p -0.03373539u 42.75p -0.02940072u
+ 42.7625p -0.02491965u 42.775p -0.02029993u 42.7875p -0.01554956u 42.8p -0.0106768u 42.8125p -0.005690179u 42.825p -0.0005984164u 42.8375p 0.004589534u 42.85p 0.009864526u 42.8625p 0.01521723u 42.875p 0.02063815u 42.8875p 0.02611765u 42.9p 0.03164594u
+ 42.9125p 0.03721314u 42.925p 0.04280924u 42.9375p 0.04842418u 42.95p 0.0540478u 42.9625p 0.05966992u 42.975p 0.06528032u 42.9875p 0.07086876u 43p 0.07642499u 43.0125p 0.08193882u 43.025p 0.08740006u 43.0375p 0.09279859u 43.05p 0.09812437u
+ 43.0625p 0.1033674u 43.075p 0.1085179u 43.0875p 0.113566u 43.1p 0.1185023u 43.1125p 0.1233172u 43.125p 0.1280014u 43.1375p 0.132546u 43.15p 0.1369419u 43.1625p 0.1411806u 43.175p 0.1452536u 43.1875p 0.1491526u 43.2p 0.1528698u
+ 43.2125p 0.1563975u 43.225p 0.1597283u 43.2375p 0.1628551u 43.25p 0.1657711u 43.2625p 0.1684699u 43.275p 0.1709454u 43.2875p 0.1731918u 43.3p 0.1752036u 43.3125p 0.1769757u 43.325p 0.1785035u 43.3375p 0.1797827u 43.35p 0.1808093u
+ 43.3625p 0.1815797u 43.375p 0.1820908u 43.3875p 0.1823399u 43.4p 0.1823246u 43.4125p 0.182043u 43.425p 0.1814936u 43.4375p 0.1806753u 43.45p 0.1795874u 43.4625p 0.1782298u 43.475p 0.1766025u 43.4875p 0.1747062u 43.5p 0.172542u
+ 43.5125p 0.1701112u 43.525p 0.1674158u 43.5375p 0.164458u 43.55p 0.1612406u 43.5625p 0.1577667u 43.575p 0.1540399u 43.5875p 0.150064u 43.6p 0.1458435u 43.6125p 0.1413829u 43.625p 0.1366876u 43.6375p 0.1317629u 43.65p 0.1266147u
+ 43.6625p 0.1212492u 43.675p 0.1156731u 43.6875p 0.1098931u 43.7p 0.1039167u 43.7125p 0.09775126u 43.725p 0.09140475u 43.7375p 0.08488534u 43.75p 0.07820149u 43.7625p 0.07136192u 43.775p 0.06437564u 43.7875p 0.05725189u 43.8p 0.05000014u
+ 43.8125p 0.0426301u 43.825p 0.03515164u 43.8375p 0.02757488u 43.85p 0.01991006u 43.8625p 0.01216761u 43.875p 0.004358095u 43.8875p -0.00350779u 43.9p -0.01141924u 43.9125p -0.01936536u 43.925p -0.02733516u 43.9375p -0.0353176u 43.95p -0.0433016u
+ 43.9625p -0.05127602u 43.975p -0.05922974u 43.9875p -0.06715162u 44p -0.07503056u 44.0125p -0.08285547u 44.025p -0.09061534u 44.0375p -0.09829921u 44.05p -0.1058962u 44.0625p -0.1133956u 44.075p -0.1207866u 44.0875p -0.1280589u 44.1p -0.135202u
+ 44.1125p -0.1422057u 44.125p -0.14906u 44.1375p -0.1557551u 44.15p -0.1622812u 44.1625p -0.1686291u 44.175p -0.1747896u 44.1875p -0.1807537u 44.2p -0.1865128u 44.2125p -0.1920585u 44.225p -0.1973827u 44.2375p -0.2024776u 44.25p -0.2073357u
+ 44.2625p -0.2119499u 44.275p -0.2163134u 44.2875p -0.2204196u 44.3p -0.2242623u 44.3125p -0.227836u 44.325p -0.231135u 44.3375p -0.2341544u 44.35p -0.2368896u 44.3625p -0.2393363u 44.375p -0.2414905u 44.3875p -0.2433489u 44.4p -0.2449084u
+ 44.4125p -0.2461664u 44.425p -0.2471205u 44.4375p -0.2477691u 44.45p -0.2481107u 44.4625p -0.2481443u 44.475p -0.2478695u 44.4875p -0.247286u 44.5p -0.2463942u 44.5125p -0.2451947u 44.525p -0.2436889u 44.5375p -0.2418782u 44.55p -0.2397645u
+ 44.5625p -0.2373504u 44.575p -0.2346386u 44.5875p -0.2316324u 44.6p -0.2283353u 44.6125p -0.2247515u 44.625p -0.2208852u 44.6375p -0.2167414u 44.65p -0.2123252u 44.6625p -0.2076421u 44.675p -0.202698u 44.6875p -0.1974993u 44.7p -0.1920525u
+ 44.7125p -0.1863646u 44.725p -0.1804429u 44.7375p -0.1742949u 44.75p -0.1679286u 44.7625p -0.1613521u 44.775p -0.1545739u 44.7875p -0.1476027u 44.8p -0.1404476u 44.8125p -0.1331178u 44.825p -0.1256227u 44.8375p -0.1179721u 44.85p -0.1101759u
+ 44.8625p -0.102244u 44.875p -0.09418689u 44.8875p -0.08601489u 44.9p -0.07773857u 44.9125p -0.06936865u 44.925p -0.06091595u 44.9375p -0.05239139u 44.95p -0.04380599u 44.9625p -0.03517081u 44.975p -0.02649701u 44.9875p -0.01779576u 45p -0.009078252u
+ 45.0125p -0.000355712u 45.025p 0.008360659u 45.0375p 0.01705968u 45.05p 0.02573019u 45.0625p 0.03436111u 45.075p 0.0429414u 45.0875p 0.05146013u 45.1p 0.05990644u 45.1125p 0.0682696u 45.125p 0.07653901u 45.1375p 0.08470419u 45.15p 0.09275484u
+ 45.1625p 0.1006808u 45.175p 0.1084722u 45.1875p 0.1161191u 45.2p 0.1236122u 45.2125p 0.130942u 45.225p 0.1380994u 45.2375p 0.1450756u 45.25p 0.151862u 45.2625p 0.1584504u 45.275p 0.1648326u 45.2875p 0.171001u 45.3p 0.176948u
+ 45.3125p 0.1826666u 45.325p 0.18815u 45.3375p 0.1933916u 45.35p 0.1983853u 45.3625p 0.2031254u 45.375p 0.2076064u 45.3875p 0.2118232u 45.4p 0.215771u 45.4125p 0.2194456u 45.425p 0.222843u 45.4375p 0.2259595u 45.45p 0.2287919u
+ 45.4625p 0.2313374u 45.475p 0.2335937u 45.4875p 0.2355585u 45.5p 0.2372304u 45.5125p 0.2386079u 45.525p 0.2396904u 45.5375p 0.2404772u 45.55p 0.2409684u 45.5625p 0.2411643u 45.575p 0.2410655u 45.5875p 0.2406733u 45.6p 0.239989u
+ 45.6125p 0.2390146u 45.625p 0.2377523u 45.6375p 0.2362047u 45.65p 0.234375u 45.6625p 0.2322663u 45.675p 0.2298826u 45.6875p 0.2272278u 45.7p 0.2243063u 45.7125p 0.2211231u 45.725p 0.217683u 45.7375p 0.2139917u 45.75p 0.2100548u
+ 45.7625p 0.2058783u 45.775p 0.2014687u 45.7875p 0.1968324u 45.8p 0.1919765u 45.8125p 0.1869081u 45.825p 0.1816345u 45.8375p 0.1761636u 45.85p 0.1705031u 45.8625p 0.1646612u 45.875p 0.1586461u 45.8875p 0.1524665u 45.9p 0.146131u
+ 45.9125p 0.1396485u 45.925p 0.133028u 45.9375p 0.1262786u 45.95p 0.1194097u 45.9625p 0.1124307u 45.975p 0.1053511u 45.9875p 0.09818052u 46p 0.09092861u 46.0125p 0.08360512u 46.025p 0.07621987u 46.0375p 0.06878268u 46.05p 0.06130339u
+ 46.0625p 0.05379188u 46.075p 0.04625798u 46.0875p 0.03871152u 46.1p 0.03116232u 46.1125p 0.02362011u 46.125p 0.0160946u 46.1375p 0.008595386u 46.15p 0.001132013u 46.1625p -0.006286089u 46.175p -0.0136496u 46.1875p -0.02094932u 46.2p -0.02817619u
+ 46.2125p -0.0353213u 46.225p -0.04237589u 46.2375p -0.04933138u 46.25p -0.05617937u 46.2625p -0.06291165u 46.275p -0.0695202u 46.2875p -0.07599725u 46.3p -0.08233522u 46.3125p -0.08852676u 46.325p -0.09456478u 46.3375p -0.1004424u 46.35p -0.1061531u
+ 46.3625p -0.1116905u 46.375p -0.1170486u 46.3875p -0.1222215u 46.4p -0.1272039u 46.4125p -0.1319904u 46.425p -0.1365762u 46.4375p -0.1409567u 46.45p -0.1451276u 46.4625p -0.149085u 46.475p -0.1528251u 46.4875p -0.1563446u 46.5p -0.1596406u
+ 46.5125p -0.1627102u 46.525p -0.1655511u 46.5375p -0.1681613u 46.55p -0.1705391u 46.5625p -0.172683u 46.575p -0.174592u 46.5875p -0.1762653u 46.6p -0.1777026u 46.6125p -0.1789037u 46.625p -0.1798689u 46.6375p -0.1805987u 46.65p -0.1810941u
+ 46.6625p -0.1813562u 46.675p -0.1813865u 46.6875p -0.1811868u 46.7p -0.1807592u 46.7125p -0.1801062u 46.725p -0.1792304u 46.7375p -0.1781349u 46.75p -0.1768228u 46.7625p -0.1752978u 46.775p -0.1735636u 46.7875p -0.1716244u 46.8p -0.1694844u
+ 46.8125p -0.1671482u 46.825p -0.1646206u 46.8375p -0.1619066u 46.85p -0.1590116u 46.8625p -0.155941u 46.875p -0.1527003u 46.8875p -0.1492956u 46.9p -0.1457328u 46.9125p -0.1420182u 46.925p -0.1381581u 46.9375p -0.134159u 46.95p -0.1300277u
+ 46.9625p -0.1257709u 46.975p -0.1213956u 46.9875p -0.1169087u 47p -0.1123175u 47.0125p -0.1076292u 47.025p -0.102851u 47.0375p -0.09799035u 47.05p -0.09305465u 47.0625p -0.08805137u 47.075p -0.08298801u 47.0875p -0.0778721u 47.1p -0.07271118u
+ 47.1125p -0.06751278u 47.125p -0.06228443u 47.1375p -0.05703363u 47.15p -0.05176786u 47.1625p -0.04649455u 47.175p -0.04122107u 47.1875p -0.03595475u 47.2p -0.03070281u 47.2125p -0.02547243u 47.225p -0.02027066u 47.2375p -0.01510446u 47.25p -0.009980689u
+ 47.2625p -0.004906069u 47.275p 0.0001128025u 47.2875p 0.005069466u 47.3p 0.009957612u 47.3125p 0.01477108u 47.325p 0.01950389u 47.3375p 0.02415021u 47.35p 0.02870441u 47.3625p 0.03316101u 47.375p 0.03751477u 47.3875p 0.04176061u 47.4p 0.04589367u
+ 47.4125p 0.0499093u 47.425p 0.05380306u 47.4375p 0.05757072u 47.45p 0.06120831u 47.4625p 0.06471205u 47.475p 0.06807841u 47.4875p 0.0713041u 47.5p 0.07438605u 47.5125p 0.07732146u 47.525p 0.08010775u 47.5375p 0.0827426u 47.55p 0.08522393u
+ 47.5625p 0.0875499u 47.575p 0.08971895u 47.5875p 0.09172975u 47.6p 0.0935812u 47.6125p 0.09527248u 47.625p 0.09680302u 47.6375p 0.09817246u 47.65p 0.09938074u 47.6625p 0.100428u 47.675p 0.1013146u 47.6875p 0.1020413u 47.7p 0.1026089u
+ 47.7125p 0.1030184u 47.725p 0.1032713u 47.7375p 0.1033691u 47.75p 0.1033136u 47.7625p 0.1031068u 47.775p 0.1027509u 47.7875p 0.1022483u 47.8p 0.1016016u 47.8125p 0.1008138u 47.825p 0.09988765u 47.8375p 0.0988265u 47.85p 0.09763369u
+ 47.8625p 0.09631274u 47.875p 0.09486738u 47.8875p 0.09330145u 47.9p 0.09161896u 47.9125p 0.08982408u 47.925p 0.08792107u 47.9375p 0.08591435u 47.95p 0.08380846u 47.9625p 0.08160803u 47.975p 0.0793178u 47.9875p 0.07694261u 48p 0.07448739u
+ 48.0125p 0.07195712u 48.025p 0.06935688u 48.0375p 0.0666918u 48.05p 0.06396704u 48.0625p 0.06118784u 48.075p 0.05835945u 48.0875p 0.05548714u 48.1p 0.05257622u 48.1125p 0.04963198u 48.125p 0.04665974u 48.1375p 0.0436648u 48.15p 0.04065242u
+ 48.1625p 0.03762786u 48.175p 0.03459635u 48.1875p 0.03156307u 48.2p 0.02853313u 48.2125p 0.02551161u 48.225p 0.02250353u 48.2375p 0.0195138u 48.25p 0.01654729u 48.2625p 0.01360875u 48.275p 0.01070287u 48.2875p 0.007834205u 48.3p 0.005007221u
+ 48.3125p 0.002226267u 48.325p -0.0005044319u 48.3375p -0.003180774u 48.35p -0.00579879u 48.3625p -0.008354649u 48.375p -0.01084466u 48.3875p -0.01326529u 48.4p -0.01561314u 48.4125p -0.01788499u 48.425p -0.02007775u 48.4375p -0.02218854u 48.45p -0.0242146u
+ 48.4625p -0.02615336u 48.475p -0.02800245u 48.4875p -0.02975964u 48.5p -0.03142289u 48.5125p -0.03299035u 48.525p -0.03446035u 48.5375p -0.03583139u 48.55p -0.03710219u 48.5625p -0.03827162u 48.575p -0.03933875u 48.5875p -0.04030285u 48.6p -0.04116335u
+ 48.6125p -0.0419199u 48.625p -0.04257231u 48.6375p -0.04312058u 48.65p -0.04356491u 48.6625p -0.04390565u 48.675p -0.04414336u 48.6875p -0.04427877u 48.7p -0.04431279u 48.7125p -0.04424648u 48.725p -0.04408109u 48.7375p -0.04381805u 48.75p -0.04345891u
+ 48.7625p -0.04300543u 48.775p -0.04245949u 48.7875p -0.04182313u 48.8p -0.04109854u 48.8125p -0.04028806u 48.825p -0.03939416u 48.8375p -0.03841944u 48.85p -0.03736663u 48.8625p -0.03623857u 48.875p -0.03503825u 48.8875p -0.03376873u 48.9p -0.0324332u
+ 48.9125p -0.03103494u 48.925p -0.02957732u 48.9375p -0.0280638u 48.95p -0.02649793u 48.9625p -0.02488331u 48.975p -0.02322363u 48.9875p -0.02152262u 49p -0.01978408u 49.0125p -0.01801184u 49.025p -0.01620979u 49.0375p -0.01438183u 49.05p -0.0125319u
+ 49.0625p -0.01066396u 49.075p -0.00878197u 49.0875p -0.006889912u 49.1p -0.004991754u 49.1125p -0.003091458u 49.125p -0.001192972u 49.1375p 0.0006997783u 49.15p 0.002582896u 49.1625p 0.00445252u 49.175p 0.00630483u 49.1875p 0.008136055u 49.2p 0.009942479u
+ 49.2125p 0.01172044u 49.225p 0.01346636u 49.2375p 0.01517671u 49.25p 0.01684806u 49.2625p 0.01847706u 49.275p 0.02006043u 49.2875p 0.02159501u 49.3p 0.02307772u 49.3125p 0.02450562u 49.325p 0.02587582u 49.3375p 0.02718561u 49.35p 0.02843235u
+ 49.3625p 0.02961355u 49.375p 0.03072682u 49.3875p 0.03176994u 49.4p 0.03274079u 49.4125p 0.03363739u 49.425p 0.03445791u 49.4375p 0.03520067u 49.45p 0.03586413u 49.4625p 0.03644687u 49.475p 0.03694766u 49.4875p 0.0373654u 49.5p 0.03769915u
+ 49.5125p 0.03794811u 49.525p 0.03811165u 49.5375p 0.0381893u 49.55p 0.03818072u 49.5625p 0.03808576u 49.575p 0.0379044u 49.5875p 0.03763678u 49.6p 0.03728322u 49.6125p 0.03684415u 49.625p 0.0363202u 49.6375p 0.03571212u 49.65p 0.03502082u
+ 49.6625p 0.03424737u 49.675p 0.03339297u 49.6875p 0.03245897u 49.7p 0.03144686u 49.7125p 0.03035828u 49.725p 0.02919499u 49.7375p 0.0279589u 49.75p 0.02665204u 49.7625p 0.02527655u 49.775p 0.02383473u 49.7875p 0.02232897u 49.8p 0.02076177u
+ 49.8125p 0.01913576u 49.825p 0.01745367u 49.8375p 0.01571831u 49.85p 0.01393262u 49.8625p 0.01209959u 49.875p 0.01022234u 49.8875p 0.008304027u 49.9p 0.006347913u 49.9125p 0.004357318u 49.925p 0.002335625u 49.9375p 0.0002862782u 49.95p -0.001787228u
+ 49.9625p -0.003881352u 49.975p -0.005992511u 49.9875p -0.00811709u 50p -0.01025144u 50.0125p -0.0123919u 50.025p -0.01453479u 50.0375p -0.0166764u 50.05p -0.01881304u 50.0625p -0.02094101u 50.075p -0.02305663u 50.0875p -0.02515622u 50.1p -0.02723612u
+ 50.1125p -0.0292927u 50.125p -0.03132238u 50.1375p -0.03332158u 50.15p -0.03528679u 50.1625p -0.03721455u 50.175p -0.03910143u 50.1875p -0.0409441u 50.2p -0.04273927u 50.2125p -0.04448371u 50.225p -0.04617429u 50.2375p -0.04780796u 50.25p -0.04938174u
+ 50.2625p -0.05089275u 50.275p -0.05233822u 50.2875p -0.05371544u 50.3p -0.05502185u 50.3125p -0.05625498u 50.325p -0.05741246u 50.3375p -0.05849206u 50.35p -0.05949165u 50.3625p -0.06040923u 50.375p -0.06124294u 50.3875p -0.06199102u 50.4p -0.06265188u
+ 50.4125p -0.06322402u 50.425p -0.06370613u 50.4375p -0.064097u 50.45p -0.06439557u 50.4625p -0.06460092u 50.475p -0.0647123u 50.4875p -0.06472907u 50.5p -0.06465076u 50.5125p -0.06447704u 50.525p -0.06420773u 50.5375p -0.0638428u 50.55p -0.06338237u
+ 50.5625p -0.06282669u 50.575p -0.06217619u 50.5875p -0.06143142u 50.6p -0.06059308u 50.6125p -0.05966205u 50.625p -0.0586393u 50.6375p -0.05752598u 50.65p -0.05632337u 50.6625p -0.0550329u 50.675p -0.05365612u 50.6875p -0.05219471u 50.7p -0.05065052u
+ 50.7125p -0.04902549u 50.725p -0.0473217u 50.7375p -0.04554135u 50.75p -0.04368678u 50.7625p -0.04176041u 50.775p -0.0397648u 50.7875p -0.03770262u 50.8p -0.03557664u 50.8125p -0.03338971u 50.825p -0.0311448u 50.8375p -0.02884497u 50.85p -0.02649337u
+ 50.8625p -0.02409321u 50.875p -0.02164781u 50.8875p -0.01916053u 50.9p -0.01663482u 50.9125p -0.01407419u 50.925p -0.01148221u 50.9375p -0.008862475u 50.95p -0.006218664u 50.9625p -0.003554473u 50.975p -0.0008736425u 50.9875p 0.001820061u 51p 0.004522845u
+ 51.0125p 0.007230898u 51.025p 0.009940398u 51.0375p 0.01264751u 51.05p 0.01534841u 51.0625p 0.01803927u 51.075p 0.02071627u 51.0875p 0.0233756u 51.1p 0.02601349u 51.1125p 0.02862619u 51.125p 0.03120997u 51.1375p 0.03376115u 51.15p 0.03627609u
+ 51.1625p 0.0387512u 51.175p 0.04118294u 51.1875p 0.04356785u 51.2p 0.04590249u 51.2125p 0.04818354u 51.225p 0.05040773u 51.2375p 0.05257186u 51.25p 0.05467283u 51.2625p 0.05670762u 51.275p 0.05867331u 51.2875p 0.06056708u 51.3p 0.06238619u
+ 51.3125p 0.06412803u 51.325p 0.06579008u 51.3375p 0.06736995u 51.35p 0.06886536u 51.3625p 0.07027413u 51.375p 0.07159424u 51.3875p 0.07282375u 51.4p 0.0739609u 51.4125p 0.07500401u 51.425p 0.07595157u 51.4375p 0.07680219u 51.45p 0.07755462u
+ 51.4625p 0.07820773u 51.475p 0.07876057u 51.4875p 0.07921229u 51.5p 0.07956222u 51.5125p 0.0798098u 51.525p 0.07995463u 51.5375p 0.07999647u 51.55p 0.07993519u 51.5625p 0.07977083u 51.575p 0.07950358u 51.5875p 0.07913375u 51.6p 0.07866181u
+ 51.6125p 0.07808837u 51.625p 0.07741419u 51.6375p 0.07664015u 51.65p 0.0757673u 51.6625p 0.07479679u 51.675p 0.07372994u 51.6875p 0.07256819u 51.7p 0.0713131u 51.7125p 0.06996637u 51.725p 0.06852984u 51.7375p 0.06700546u 51.75p 0.06539529u
+ 51.7625p 0.06370153u 51.775p 0.06192648u 51.7875p 0.06007255u 51.8p 0.05814227u 51.8125p 0.05613826u 51.825p 0.05406325u 51.8375p 0.05192006u 51.85p 0.0497116u 51.8625p 0.04744088u 51.875p 0.04511097u 51.8875p 0.04272504u 51.9p 0.04028631u
+ 51.9125p 0.03779811u 51.925p 0.03526378u 51.9375p 0.03268676u 51.95p 0.03007053u 51.9625p 0.02741863u 51.975p 0.02473461u 51.9875p 0.0220221u 52p 0.01928475u 52.0125p 0.01652623u 52.025p 0.01375023u 52.0375p 0.01096048u 52.05p 0.008160704u
+ 52.0625p 0.005354635u 52.075p 0.002546013u 52.0875p -0.000261426u 52.1p -0.003063956u 52.1125p -0.005857866u 52.125p -0.008639461u 52.1375p -0.01140507u 52.15p -0.01415106u 52.1625p -0.01687382u 52.175p -0.01956978u 52.1875p -0.02223543u 52.2p -0.02486729u
+ 52.2125p -0.02746195u 52.225p -0.03001604u 52.2375p -0.03252626u 52.25p -0.0349894u 52.2625p -0.03740229u 52.275p -0.03976186u 52.2875p -0.0420651u 52.3p -0.04430911u 52.3125p -0.04649105u 52.325p -0.04860819u 52.3375p -0.0506579u 52.35p -0.05263764u
+ 52.3625p -0.05454496u 52.375p -0.05637755u 52.3875p -0.05813317u 52.4p -0.05980973u 52.4125p -0.06140522u 52.425p -0.06291777u 52.4375p -0.06434561u 52.45p -0.06568711u 52.4625p -0.06694075u 52.475p -0.06810513u 52.4875p -0.06917901u 52.5p -0.07016123u
+ 52.5125p -0.0710508u 52.525p -0.07184682u 52.5375p -0.07254857u 52.55p -0.07315541u 52.5625p -0.07366687u 52.575p -0.07408259u 52.5875p -0.07440236u 52.6p -0.07462608u 52.6125p -0.07475381u 52.625p -0.07478571u 52.6375p -0.0747221u 52.65p -0.0745634u
+ 52.6625p -0.07431019u 52.675p -0.07396316u 52.6875p -0.07352311u 52.7p -0.07299101u 52.7125p -0.0723679u 52.725p -0.07165498u 52.7375p -0.07085355u 52.75p -0.06996503u 52.7625p -0.06899095u 52.775p -0.06793297u 52.7875p -0.06679283u 52.8p -0.0655724u
+ 52.8125p -0.06427363u 52.825p -0.0628986u 52.8375p -0.06144946u 52.85p -0.05992846u 52.8625p -0.05833795u 52.875p -0.05668034u 52.8875p -0.05495816u 52.9p -0.05317398u 52.9125p -0.05133048u 52.925p -0.04943038u 52.9375p -0.04747647u 52.95p -0.04547163u
+ 52.9625p -0.04341877u 52.975p -0.04132085u 52.9875p -0.03918091u 53p -0.03700199u 53.0125p -0.03478721u 53.025p -0.03253971u 53.0375p -0.03026266u 53.05p -0.02795925u 53.0625p -0.0256327u 53.075p -0.02328625u 53.0875p -0.02092315u 53.1p -0.01854665u
+ 53.1125p -0.01616u 53.125p -0.01376647u 53.1375p -0.01136931u 53.15p -0.008971752u 53.1625p -0.006577028u 53.175p -0.004188342u 53.1875p -0.001808873u 53.2p 0.0005582241u 53.2125p 0.002909831u 53.225p 0.005242864u 53.2375p 0.007554281u 53.25p 0.009841088u
+ 53.2625p 0.01210034u 53.275p 0.01432914u 53.2875p 0.01652465u 53.3p 0.0186841u 53.3125p 0.02080478u 53.325p 0.02288404u 53.3375p 0.02491932u 53.35p 0.02690812u 53.3625p 0.02884802u 53.375p 0.03073668u 53.3875p 0.03257186u 53.4p 0.03435138u
+ 53.4125p 0.03607318u 53.425p 0.03773526u 53.4375p 0.03933574u 53.45p 0.04087282u 53.4625p 0.04234482u 53.475p 0.04375013u 53.4875p 0.04508726u 53.5p 0.04635483u 53.5125p 0.04755155u 53.525p 0.04867625u 53.5375p 0.04972786u 53.55p 0.05070542u
+ 53.5625p 0.05160808u 53.575p 0.05243511u 53.5875p 0.05318587u 53.6p 0.05385985u 53.6125p 0.05445663u 53.625p 0.05497593u 53.6375p 0.05541756u 53.65p 0.05578145u 53.6625p 0.05606763u 53.675p 0.05627625u 53.6875p 0.05640757u 53.7p 0.05646193u
+ 53.7125p 0.05643983u 53.725p 0.05634182u 53.7375p 0.05616859u 53.75p 0.05592092u 53.7625p 0.05559969u 53.775p 0.05520588u 53.7875p 0.05474056u 53.8p 0.05420491u 53.8125p 0.0536002u 53.825p 0.05292777u 53.8375p 0.05218907u 53.85p 0.05138563u
+ 53.8625p 0.05051906u 53.875p 0.04959104u 53.8875p 0.04860335u 53.9p 0.04755782u 53.9125p 0.04645636u 53.925p 0.04530095u 53.9375p 0.04409364u 53.95p 0.04283652u 53.9625p 0.04153175u 53.975p 0.04018156u 53.9875p 0.0387882u 54p 0.03735399u
+ 54.0125p 0.03588128u 54.025p 0.03437246u 54.0375p 0.03282997u 54.05p 0.03125626u 54.0625p 0.02965383u 54.075p 0.02802518u 54.0875p 0.02637286u 54.1p 0.02469941u 54.1125p 0.0230074u 54.125p 0.0212994u 54.1375p 0.01957799u 54.15p 0.01784575u
+ 54.1625p 0.01610525u 54.175p 0.01435906u 54.1875p 0.01260976u 54.2p 0.01085987u 54.2125p 0.009111942u 54.225p 0.007368472u 54.2375p 0.005631948u 54.25p 0.003904825u 54.2625p 0.002189528u 54.275p 0.0004884469u 54.2875p -0.001196066u 54.3p -0.002861702u
+ 54.3125p -0.004506195u 54.325p -0.006127326u 54.3375p -0.007722929u 54.35p -0.009290891u 54.3625p -0.01082915u 54.375p -0.01233572u 54.3875p -0.01380865u 54.4p -0.01524607u 54.4125p -0.01664618u 54.425p -0.01800724u 54.4375p -0.01932758u 54.45p -0.02060561u
+ 54.4625p -0.02183981u 54.475p -0.02302874u 54.4875p -0.02417104u 54.5p -0.02526541u 54.5125p -0.02631067u 54.525p -0.02730568u 54.5375p -0.02824941u 54.55p -0.02914091u 54.5625p -0.02997931u 54.575p -0.03076383u 54.5875p -0.03149379u 54.6p -0.03216856u
+ 54.6125p -0.03278764u 54.625p -0.0333506u 54.6375p -0.03385708u 54.65p -0.03430685u 54.6625p -0.03469972u 54.675p -0.03503562u 54.6875p -0.03531457u 54.7p -0.03553665u 54.7125p -0.03570204u 54.725p -0.035811u 54.7375p -0.0358639u 54.75p -0.03586115u
+ 54.7625p -0.03580327u 54.775p -0.03569085u 54.7875p -0.03552457u 54.8p -0.03530518u 54.8125p -0.0350335u 54.825p -0.03471042u 54.8375p -0.03433693u 54.85p -0.03391406u 54.8625p -0.03344292u 54.875p -0.03292468u 54.8875p -0.03236059u 54.9p -0.03175195u
+ 54.9125p -0.03110011u 54.925p -0.0304065u 54.9375p -0.02967257u 54.95p -0.02889986u 54.9625p -0.02808993u 54.975p -0.0272444u 54.9875p -0.02636493u 55p -0.02545321u 55.0125p -0.02451098u 55.025p -0.02354002u 55.0375p -0.02254213u 55.05p -0.02151914u
+ 55.0625p -0.0204729u 55.075p -0.01940531u 55.0875p -0.01831824u 55.1p -0.01721363u 55.1125p -0.01609339u 55.125p -0.01495947u 55.1375p -0.01381382u 55.15p -0.01265838u 55.1625p -0.0114951u 55.175p -0.01032594u 55.1875p -0.009152841u 55.2p -0.007977733u
+ 55.2125p -0.006802543u 55.225p -0.005629183u 55.2375p -0.004459546u 55.25p -0.003295507u 55.2625p -0.002138916u 55.275p -0.0009916013u 55.2875p 0.0001446401u 55.3p 0.001268041u 55.3125p 0.002376866u 55.325p 0.003469417u 55.3375p 0.004544035u 55.35p 0.0055991u
+ 55.3625p 0.006633035u 55.375p 0.007644308u 55.3875p 0.008631437u 55.4p 0.009592985u 55.4125p 0.01052757u 55.425p 0.01143386u 55.4375p 0.01231058u 55.45p 0.01315652u 55.4625p 0.0139705u 55.475p 0.01475144u 55.4875p 0.01549829u 55.5p 0.01621008u
+ 55.5125p 0.01688588u 55.525p 0.01752487u 55.5375p 0.01812624u 55.55p 0.01868928u 55.5625p 0.01921335u 55.575p 0.01969786u 55.5875p 0.02014231u 55.6p 0.02054624u 55.6125p 0.02090928u 55.625p 0.02123113u 55.6375p 0.02151154u 55.65p 0.02175037u
+ 55.6625p 0.02194749u 55.675p 0.0221029u 55.6875p 0.02221663u 55.7p 0.02228878u 55.7125p 0.02231955u 55.725p 0.02230916u 55.7375p 0.02225793u 55.75p 0.02216623u 55.7625p 0.02203451u 55.775p 0.02186327u 55.7875p 0.02165307u 55.8p 0.02140454u
+ 55.8125p 0.02111838u 55.825p 0.02079531u 55.8375p 0.02043615u 55.85p 0.02004176u 55.8625p 0.01961303u 55.875p 0.01915094u 55.8875p 0.0186565u 55.9p 0.01813076u 55.9125p 0.01757483u 55.925p 0.01698987u 55.9375p 0.01637706u 55.95p 0.01573764u
+ 55.9625p 0.01507288u 55.975p 0.01438408u 55.9875p 0.01367259u 56p 0.01293976u 56.0125p 0.012187u 56.025p 0.01141573u 56.0375p 0.0106274u 56.05p 0.009823477u 56.0625p 0.009005449u 56.075p 0.008174817u 56.0875p 0.0073331u 56.1p 0.006481824u
+ 56.1125p 0.005622527u 56.125p 0.004756752u 56.1375p 0.003886044u 56.15p 0.003011951u 56.1625p 0.002136018u 56.175p 0.001259787u 56.1875p 0.0003847937u 56.2p -0.0004874361u 56.2125p -0.001355387u 56.225p -0.002217559u 56.2375p -0.003072466u 56.25p -0.003918643u
+ 56.2625p -0.004754643u 56.275p -0.005579044u 56.2875p -0.006390448u 56.3p -0.007187487u 56.3125p -0.00796882u 56.325p -0.008733137u 56.3375p -0.009479165u 56.35p -0.01020566u 56.3625p -0.01091143u 56.375p -0.0115953u 56.3875p -0.01225616u 56.4p -0.01289292u
+ 56.4125p -0.01350456u 56.425p -0.01409007u 56.4375p -0.01464852u 56.45p -0.01517902u 56.4625p -0.01568071u 56.475p -0.01615282u 56.4875p -0.01659459u 56.5p -0.01700534u 56.5125p -0.01738443u 56.525p -0.01773129u 56.5375p -0.01804539u 56.55p -0.01832627u
+ 56.5625p -0.01857351u 56.575p -0.01878677u 56.5875p -0.01896573u 56.6p -0.01911018u 56.6125p -0.01921992u 56.625p -0.01929484u 56.6375p -0.01933488u 56.65p -0.01934002u 56.6625p -0.01931032u 56.675p -0.01924589u 56.6875p -0.0191469u 56.7p -0.01901357u
+ 56.7125p -0.01884619u 56.725p -0.01864508u 56.7375p -0.01841065u 56.75p -0.01814333u 56.7625p -0.01784363u 56.775p -0.0175121u 56.7875p -0.01714933u 56.8p -0.01675599u 56.8125p -0.01633277u 56.825p -0.01588042u 56.8375p -0.01539974u 56.85p -0.01489157u
+ 56.8625p -0.01435678u 56.875p -0.01379632u 56.8875p -0.01321114u 56.9p -0.01260224u 56.9125p -0.01197067u 56.925p -0.01131751u 56.9375p -0.01064387u 56.95p -0.009950883u 56.9625p -0.009239724u 56.975p -0.008511591u 56.9875p -0.007767708u 57p -0.007009324u
+ 57.0125p -0.006237707u 57.025p -0.005454145u 57.0375p -0.004659945u 57.05p -0.003856428u 57.0625p -0.003044927u 57.075p -0.002226788u 57.0875p -0.001403364u 57.1p -0.0005760148u 57.1125p 0.0002538949u 57.125p 0.001084999u 57.1375p 0.00191593u 57.15p 0.002745325u
+ 57.1625p 0.003571823u 57.175p 0.004394072u 57.1875p 0.005210727u 57.2p 0.006020454u 57.2125p 0.006821932u 57.225p 0.007613857u 57.2375p 0.008394938u 57.25p 0.009163906u 57.2625p 0.009919514u 57.275p 0.01066053u 57.2875p 0.01138577u 57.3p 0.01209404u
+ 57.3125p 0.0127842u 57.325p 0.01345514u 57.3375p 0.01410577u 57.35p 0.01473505u 57.3625p 0.01534196u 57.375p 0.01592552u 57.3875p 0.01648479u 57.4p 0.01701887u 57.4125p 0.01752691u 57.425p 0.01800809u 57.4375p 0.01846162u 57.45p 0.0188868u
+ 57.4625p 0.01928292u 57.475p 0.01964936u 57.4875p 0.01998553u 57.5p 0.02029089u 57.5125p 0.02056494u 57.525p 0.02080725u 57.5375p 0.02101742u 57.55p 0.02119511u 57.5625p 0.02134004u 57.575p 0.02145197u 57.5875p 0.02153071u 57.6p 0.02157613u
+ 57.6125p 0.02158816u 57.625p 0.02156676u 57.6375p 0.02151196u 57.65p 0.02142384u 57.6625p 0.02130252u 57.675p 0.02114819u 57.6875p 0.02096107u 57.7p 0.02074146u 57.7125p 0.02048968u 57.725p 0.02020611u 57.7375p 0.0198912u 57.75p 0.01954542u
+ 57.7625p 0.01916929u 57.775p 0.0187634u 57.7875p 0.01832836u 57.8p 0.01786484u 57.8125p 0.01737355u 57.825p 0.01685524u 57.8375p 0.01631069u 57.85p 0.01574075u 57.8625p 0.01514628u 57.875p 0.01452819u 57.8875p 0.01388742u 57.9p 0.01322495u
+ 57.9125p 0.01254178u 57.925p 0.01183897u 57.9375p 0.01111758u 57.95p 0.0103787u 57.9625p 0.009623457u 57.975p 0.008853004u 57.9875p 0.008068506u 58p 0.007271154u 58.0125p 0.006462156u 58.025p 0.005642738u 58.0375p 0.004814138u 58.05p 0.003977611u
+ 58.0625p 0.003134419u 58.075p 0.002285836u 58.0875p 0.001433141u 58.1p 0.0005776195u 58.1125p -0.0002794414u 58.125p -0.001136752u 58.1375p -0.001993025u 58.15p -0.002846975u 58.1625p -0.003697321u 58.175p -0.00454279u 58.1875p -0.005382115u 58.2p -0.006214044u
+ 58.2125p -0.007037333u 58.225p -0.007850755u 58.2375p -0.008653098u 58.25p -0.009443169u 58.2625p -0.01021979u 58.275p -0.01098182u 58.2875p -0.01172812u 58.3p -0.01245758u 58.3125p -0.01316914u 58.325p -0.01386173u 58.3375p -0.01453435u 58.35p -0.01518599u
+ 58.3625p -0.01581571u 58.375p -0.01642259u 58.3875p -0.01700573u 58.4p -0.01756428u 58.4125p -0.01809744u 58.425p -0.01860442u 58.4375p -0.0190845u 58.45p -0.01953698u 58.4625p -0.01996122u 58.475p -0.02035659u 58.4875p -0.02072255u 58.5p -0.02105857u
+ 58.5125p -0.02136417u 58.525p -0.02163894u 58.5375p -0.02188248u 58.55p -0.02209446u 58.5625p -0.0222746u 58.575p -0.02242266u 58.5875p -0.02253844u 58.6p -0.0226218u 58.6125p -0.02267264u 58.625p -0.02269093u 58.6375p -0.02267666u 58.65p -0.02262988u
+ 58.6625p -0.02255068u 58.675p -0.02243923u 58.6875p -0.0222957u 58.7p -0.02212034u 58.7125p -0.02191343u 58.725p -0.02167532u 58.7375p -0.02140637u 58.75p -0.02110702u 58.7625p -0.02077773u 58.775p -0.02041902u 58.7875p -0.02003143u 58.8p -0.01961556u
+ 58.8125p -0.01917206u 58.825p -0.01870159u 58.8375p -0.01820488u 58.85p -0.01768267u 58.8625p -0.01713576u 58.875p -0.01656496u 58.8875p -0.01597114u 58.9p -0.01535519u 58.9125p -0.01471803u 58.925p -0.01406061u 58.9375p -0.0133839u 58.95p -0.01268892u
+ 58.9625p -0.0119767u 58.975p -0.01124828u 58.9875p -0.01050475u 59p -0.009747204u 59.0125p -0.008976753u 59.025p -0.008194532u 59.0375p -0.007401686u 59.05p -0.006599378u 59.0625p -0.005788779u 59.075p -0.004971071u 59.0875p -0.004147446u 59.1p -0.0033191u
+ 59.1125p -0.002487235u 59.125p -0.001653055u 59.1375p -0.0008177666u 59.15p 1.742665e-05u 59.1625p 0.0008513217u 59.175p 0.001682721u 59.1875p 0.002510431u 59.2p 0.003333269u 59.2125p 0.004150058u 59.225p 0.004959637u 59.2375p 0.005760853u 59.25p 0.00655257u
+ 59.2625p 0.007333667u 59.275p 0.008103044u 59.2875p 0.008859615u 59.3p 0.00960232u 59.3125p 0.01033012u 59.325p 0.01104199u 59.3375p 0.01173696u 59.35p 0.01241404u 59.3625p 0.01307231u 59.375p 0.01371087u 59.3875p 0.01432883u 59.4p 0.01492534u
+ 59.4125p 0.01549961u 59.425p 0.01605085u 59.4375p 0.01657833u 59.45p 0.01708133u 59.4625p 0.01755918u 59.475p 0.01801126u 59.4875p 0.01843698u 59.5p 0.01883578u 59.5125p 0.01920715u 59.525p 0.01955063u 59.5375p 0.01986577u 59.55p 0.0201522u
+ 59.5625p 0.02040956u 59.575p 0.02063757u 59.5875p 0.02083595u 59.6p 0.0210045u 59.6125p 0.02114304u 59.625p 0.02125144u 59.6375p 0.02132962u 59.65p 0.02137755u 59.6625p 0.02139522u 59.675p 0.02138269u 59.6875p 0.02134003u 59.7p 0.0212674u
+ 59.7125p 0.02116497u 59.725p 0.02103295u 59.7375p 0.0208716u 59.75p 0.02068125u 59.7625p 0.02046222u 59.775p 0.0202149u 59.7875p 0.01993972u 59.8p 0.01963715u 59.8125p 0.01930768u 59.825p 0.01895185u 59.8375p 0.01857025u 59.85p 0.01816348u
+ 59.8625p 0.0177322u 59.875p 0.01727707u 59.8875p 0.01679882u 59.9p 0.01629819u 59.9125p 0.01577595u 59.925p 0.01523291u 59.9375p 0.01466989u 59.95p 0.01408776u 59.9625p 0.0134874u 59.975p 0.0128697u 59.9875p 0.01223561u 60p 0.01158608u
+ 60.0125p 0.01092206u 60.025p 0.01024454u 60.0375p 0.009554539u 60.05p 0.008853064u 60.0625p 0.008141149u 60.075p 0.007419838u 60.0875p 0.006690184u 60.1p 0.00595325u 60.1125p 0.005210108u 60.125p 0.004461832u 60.1375p 0.003709502u 60.15p 0.002954202u
+ 60.1625p 0.002197013u 60.175p 0.001439019u 60.1875p 0.0006812998u 60.2p -7.506752e-05u 60.2125p -0.0008290118u 60.225p -0.001579469u 60.2375p -0.002325382u 60.25p -0.003065706u 60.2625p -0.003799406u 60.275p -0.00452546u 60.2875p -0.00524286u 60.3p -0.005950615u
+ 60.3125p -0.00664775u 60.325p -0.007333308u 60.3375p -0.008006352u 60.35p -0.008665969u 60.3625p -0.009311263u 60.375p -0.009941366u 60.3875p -0.01055543u 60.4p -0.01115264u 60.4125p -0.01173221u 60.425p -0.01229336u 60.4375p -0.01283537u 60.45p -0.01335752u
+ 60.4625p -0.01385915u 60.475p -0.01433961u 60.4875p -0.01479829u 60.5p -0.01523462u 60.5125p -0.01564805u 60.525p -0.01603807u 60.5375p -0.01640422u 60.55p -0.01674605u 60.5625p -0.01706318u 60.575p -0.01735522u 60.5875p -0.01762186u 60.6p -0.01786282u
+ 60.6125p -0.01807783u 60.625p -0.01826669u 60.6375p -0.01842922u 60.65p -0.01856528u 60.6625p -0.01867479u 60.675p -0.01875768u 60.6875p -0.01881393u 60.7p -0.01884356u 60.7125p -0.01884662u 60.725p -0.01882321u 60.7375p -0.01877346u 60.75p -0.01869754u
+ 60.7625p -0.01859565u 60.775p -0.01846803u 60.7875p -0.01831497u 60.8p -0.01813678u 60.8125p -0.0179338u 60.825p -0.01770642u 60.8375p -0.01745505u 60.85p -0.01718014u 60.8625p -0.01688217u 60.875p -0.01656166u 60.8875p -0.01621914u 60.9p -0.01585519u
+ 60.9125p -0.0154704u 60.925p -0.01506541u 60.9375p -0.01464087u 60.95p -0.01419745u 60.9625p -0.01373586u 60.975p -0.01325683u 60.9875p -0.01276111u 61p -0.01224946u 61.0125p -0.01172268u 61.025p -0.01118157u 61.0375p -0.01062695u 61.05p -0.01005968u
+ 61.0625p -0.009480602u 61.075p -0.008890587u 61.0875p -0.008290516u 61.1p -0.007681282u 61.1125p -0.007063787u 61.125p -0.006438939u 61.1375p -0.005807655u 61.15p -0.005170857u 61.1625p -0.004529468u 61.175p -0.003884419u 61.1875p -0.003236638u 61.2p -0.002587055u
+ 61.2125p -0.001936597u 61.225p -0.001286191u 61.2375p -0.0006367559u 61.25p 1.079122e-05u 61.2625p 0.0006555415u 61.275p 0.001296594u 61.2875p 0.001933057u 61.3p 0.002564048u 61.3125p 0.003188699u 61.325p 0.003806153u 61.3375p 0.004415567u 61.35p 0.005016114u
+ 61.3625p 0.005606983u 61.375p 0.006187381u 61.3875p 0.006756534u 61.4p 0.007313685u 61.4125p 0.007858101u 61.425p 0.00838907u 61.4375p 0.0089059u 61.45p 0.009407925u 61.4625p 0.009894503u 61.475p 0.01036502u 61.4875p 0.01081887u 61.5p 0.01125551u
+ 61.5125p 0.01167439u 61.525p 0.012075u 61.5375p 0.01245686u 61.55p 0.01281953u 61.5625p 0.01316257u 61.575p 0.01348559u 61.5875p 0.01378825u 61.6p 0.0140702u 61.6125p 0.01433115u 61.625p 0.01457082u 61.6375p 0.014789u 61.65p 0.01498546u
+ 61.6625p 0.01516005u 61.675p 0.01531261u 61.6875p 0.01544306u 61.7p 0.0155513u 61.7125p 0.01563731u 61.725p 0.01570106u 61.7375p 0.01574259u 61.75p 0.01576195u 61.7625p 0.01575922u 61.775p 0.01573452u 61.7875p 0.015688u 61.8p 0.01561984u
+ 61.8125p 0.01553025u 61.825p 0.01541947u 61.8375p 0.01528776u 61.85p 0.01513543u 61.8625p 0.01496279u 61.875p 0.0147702u 61.8875p 0.01455805u 61.9p 0.01432673u 61.9125p 0.01407669u 61.925p 0.01380837u 61.9375p 0.01352225u 61.95p 0.01321884u
+ 61.9625p 0.01289867u 61.975p 0.01256228u 61.9875p 0.01221024u 62p 0.01184314u 62.0125p 0.01146158u 62.025p 0.01106619u 62.0375p 0.0106576u 62.05p 0.01023648u 62.0625p 0.009803487u 62.075p 0.009359312u 62.0875p 0.008904648u 62.1p 0.008440203u
+ 62.1125p 0.007966696u 62.125p 0.007484853u 62.1375p 0.006995409u 62.15p 0.006499105u 62.1625p 0.005996689u 62.175p 0.005488914u 62.1875p 0.004976535u 62.2p 0.004460309u 62.2125p 0.003940997u 62.225p 0.003419358u 62.2375p 0.002896151u 62.25p 0.002372131u
+ 62.2625p 0.001848053u 62.275p 0.001324665u 62.2875p 0.0008027104u 62.3p 0.0002829275u 62.3125p -0.0002339544u 62.325p -0.0007472139u 62.3375p -0.001256139u 62.35p -0.001760029u 62.3625p -0.002258194u 62.375p -0.002749956u 62.3875p -0.003234651u 62.4p -0.003711629u
+ 62.4125p -0.004180257u 62.425p -0.004639914u 62.4375p -0.00509u 62.45p -0.00552993u 62.4625p -0.005959139u 62.475p -0.006377079u 62.4875p -0.006783224u 62.5p -0.007177067u 62.5125p -0.007558123u 62.525p -0.007925928u 62.5375p -0.008280042u 62.55p -0.008620044u
+ 62.5625p -0.008945541u 62.575p -0.00925616u 62.5875p -0.009551555u 62.6p -0.009831401u 62.6125p -0.0100954u 62.625p -0.01034328u 62.6375p -0.0105748u 62.65p -0.01078973u 62.6625p -0.01098787u 62.675p -0.01116906u 62.6875p -0.01133315u 62.7p -0.01148003u
+ 62.7125p -0.0116096u 62.725p -0.01172179u 62.7375p -0.01181657u 62.75p -0.01189393u 62.7625p -0.01195387u 62.775p -0.01199643u 62.7875p -0.01202169u 62.8p -0.01202971u 62.8125p -0.01202063u 62.825p -0.01199457u 62.8375p -0.0119517u 62.85p -0.01189221u
+ 62.8625p -0.0118163u 62.875p -0.0117242u 62.8875p -0.01161618u 62.9p -0.01149251u 62.9125p -0.01135349u 62.925p -0.01119943u 62.9375p -0.01103068u 62.95p -0.01084759u 62.9625p -0.01065055u 62.975p -0.01043995u 62.9875p -0.0102162u 63p -0.009979729u
+ 63.0125p -0.009730992u 63.025p -0.009470446u 63.0375p -0.009198569u 63.05p -0.00891585u 63.0625p -0.008622792u 63.075p -0.008319909u 63.0875p -0.008007729u 63.1p -0.007686787u 63.1125p -0.007357629u 63.125p -0.007020809u 63.1375p -0.00667689u 63.15p -0.006326439u
+ 63.1625p -0.005970031u 63.175p -0.005608245u 63.1875p -0.005241665u 63.2p -0.004870877u 63.2125p -0.00449647u 63.225p -0.004119034u 63.2375p -0.003739158u 63.25p -0.003357432u 63.2625p -0.002974445u 63.275p -0.002590783u 63.2875p -0.002207027u 63.3p -0.001823756u
+ 63.3125p -0.001441545u 63.325p -0.00106096u 63.3375p -0.0006825638u 63.35p -0.0003069087u 63.3625p 6.545942e-05u 63.375p 0.0004340042u 63.3875p 0.000798199u 63.4p 0.001157528u 63.4125p 0.001511486u 63.425p 0.001859581u 63.4375p 0.002201333u 63.45p 0.002536274u
+ 63.4625p 0.002863953u 63.475p 0.003183931u 63.4875p 0.003495785u 63.5p 0.003799108u 63.5125p 0.004093509u 63.525p 0.004378613u 63.5375p 0.004654064u 63.55p 0.004919523u 63.5625p 0.005174668u 63.575p 0.005419196u 63.5875p 0.005652824u 63.6p 0.005875286u
+ 63.6125p 0.006086338u 63.625p 0.006285754u 63.6375p 0.006473328u 63.65p 0.006648875u 63.6625p 0.006812229u 63.675p 0.006963246u 63.6875p 0.007101801u 63.7p 0.00722779u 63.7125p 0.00734113u 63.725p 0.007441758u 63.7375p 0.007529634u 63.75p 0.007604734u
+ 63.7625p 0.007667058u 63.775p 0.007716626u 63.7875p 0.007753476u 63.8p 0.007777667u 63.8125p 0.007789279u 63.825p 0.00778841u 63.8375p 0.007775178u 63.85p 0.007749719u 63.8625p 0.007712188u 63.875p 0.007662758u 63.8875p 0.007601621u 63.9p 0.007528984u
+ 63.9125p 0.007445073u 63.925p 0.007350129u 63.9375p 0.007244411u 63.95p 0.007128191u 63.9625p 0.007001759u 63.975p 0.006865415u 63.9875p 0.006719477u 64p 0.006564274u 64.0125p 0.006400148u 64.025p 0.006227453u 64.0375p 0.006046556u 64.05p 0.005857831u
+ 64.0625p 0.005661666u 64.075p 0.005458455u 64.0875p 0.005248604u 64.1p 0.005032524u 64.1125p 0.004810634u 64.125p 0.00458336u 64.1375p 0.004351135u 64.15p 0.004114394u 64.1625p 0.003873579u 64.175p 0.003629134u 64.1875p 0.003381507u 64.2p 0.003131147u
+ 64.2125p 0.002878506u 64.225p 0.002624034u 64.2375p 0.002368182u 64.25p 0.002111403u 64.2625p 0.001854144u 64.275p 0.001596852u 64.2875p 0.00133997u 64.3p 0.00108394u 64.3125p 0.0008291948u 64.325p 0.0005761664u 64.3375p 0.0003252789u 64.35p 7.695056e-05u
+ 64.3625p -0.0001684077u 64.375p -0.0004103925u 64.3875p -0.0006486089u 64.4p -0.0008826709u 64.4125p -0.001112202u 64.425p -0.001336836u 64.4375p -0.001556216u 64.45p -0.001769999u 64.4625p -0.001977851u 64.475p -0.002179452u 64.4875p -0.002374494u 64.5p -0.002562681u
+ 64.5125p -0.002743731u 64.525p -0.002917379u 64.5375p -0.003083368u 64.55p -0.003241462u 64.5625p -0.003391436u 64.575p -0.003533082u 64.5875p -0.003666205u 64.6p -0.00379063u 64.6125p -0.003906194u 64.625p -0.004012751u 64.6375p -0.004110174u 64.65p -0.004198349u
+ 64.6625p -0.00427718u 64.675p -0.004346588u 64.6875p -0.00440651u 64.7p -0.0044569u 64.7125p -0.004497729u 64.725p -0.004528984u 64.7375p -0.004550669u 64.75p -0.004562805u 64.7625p -0.004565429u 64.775p -0.004558594u 64.7875p -0.00454237u 64.8p -0.004516842u
+ 64.8125p -0.004482111u 64.825p -0.004438295u 64.8375p -0.004385526u 64.85p -0.004323949u 64.8625p -0.004253728u 64.875p -0.004175039u 64.8875p -0.004088071u 64.9p -0.003993028u 64.9125p -0.003890128u 64.925p -0.0037796u 64.9375p -0.003661687u 64.95p -0.003536643u
+ 64.9625p -0.003404734u 64.975p -0.003266236u 64.9875p -0.003121437u 65p -0.002970634u 65.0125p -0.002814133u 65.025p -0.002652251u 65.0375p -0.002485312u 65.05p -0.002313647u 65.0625p -0.002137595u 65.075p -0.001957502u 65.0875p -0.001773719u 65.1p -0.001586605u
+ 65.1125p -0.00139652u 65.125p -0.001203831u 65.1375p -0.001008908u 65.15p -0.0008121224u 65.1625p -0.0006138502u 65.175p -0.0004144679u 65.1875p -0.000214353u 65.2p -1.38838e-05u 65.2125p 0.0001865619u 65.225p 0.0003866069u 65.2375p 0.0005858758u 65.25p 0.0007839948u
+ 65.2625p 0.0009805932u 65.275p 0.001175304u 65.2875p 0.001367762u 65.3p 0.00155761u 65.3125p 0.001744493u 65.325p 0.001928062u 65.3375p 0.002107977u 65.35p 0.002283901u 65.3625p 0.002455506u 65.375p 0.002622473u 65.3875p 0.002784489u 65.4p 0.002941253u
+ 65.4125p 0.003092469u 65.425p 0.003237856u 65.4375p 0.003377138u 65.45p 0.003510055u 65.4625p 0.003636353u 65.475p 0.003755794u 65.4875p 0.003868149u 65.5p 0.003973202u 65.5125p 0.004070751u 65.525p 0.004160604u 65.5375p 0.004242585u 65.55p 0.004316531u
+ 65.5625p 0.00438229u 65.575p 0.004439729u 65.5875p 0.004488724u 65.6p 0.004529168u 65.6125p 0.004560969u 65.625p 0.004584049u 65.6375p 0.004598344u 65.65p 0.004603805u 65.6625p 0.004600398u 65.675p 0.004588106u 65.6875p 0.004566924u 65.7p 0.004536864u
+ 65.7125p 0.004497952u 65.725p 0.004450228u 65.7375p 0.004393749u 65.75p 0.004328585u 65.7625p 0.004254821u 65.775p 0.004172557u 65.7875p 0.004081906u 65.8p 0.003982997u 65.8125p 0.003875972u 65.825p 0.003760984u 65.8375p 0.003638204u 65.85p 0.003507813u
+ 65.8625p 0.003370005u 65.875p 0.003224987u 65.8875p 0.003072979u 65.9p 0.002914211u 65.9125p 0.002748926u 65.925p 0.002577377u 65.9375p 0.002399827u 65.95p 0.002216552u 65.9625p 0.002027834u 65.975p 0.001833966u 65.9875p 0.001635251u 66p 0.001431999u
+ 66.0125p 0.001224527u 66.025p 0.001013162u 66.0375p 0.0007982343u 66.05p 0.0005800835u 66.0625p 0.0003590536u 66.075p 0.0001354938u 66.0875p -9.024173e-05u 66.1p -0.0003177948u 66.1125p -0.0005468039u 66.125p -0.0007769042u 66.1375p -0.001007729u 66.15p -0.001238908u
+ 66.1625p -0.001470074u 66.175p -0.001700853u 66.1875p -0.001930876u 66.2p -0.002159773u 66.2125p -0.002387173u 66.225p -0.00261271u 66.2375p -0.002836018u 66.25p -0.003056734u 66.2625p -0.003274499u 66.275p -0.003488958u 66.2875p -0.00369976u 66.3p -0.003906559u
+ 66.3125p -0.004109014u 66.325p -0.004306791u 66.3375p -0.004499563u 66.35p -0.004687009u 66.3625p -0.004868816u 66.375p -0.005044678u 66.3875p -0.0052143u 66.4p -0.005377394u 66.4125p -0.005533682u 66.425p -0.005682895u 66.4375p -0.005824777u 66.45p -0.005959078u
+ 66.4625p -0.006085565u 66.475p -0.00620401u 66.4875p -0.006314203u 66.5p -0.00641594u 66.5125p -0.006509035u 66.525p -0.006593311u 66.5375p -0.006668604u 66.55p -0.006734766u 66.5625p -0.00679166u 66.575p -0.006839163u 66.5875p -0.006877167u 66.6p -0.006905576u
+ 66.6125p -0.006924309u 66.625p -0.0069333u 66.6375p -0.006932497u 66.65p -0.006921862u 66.6625p -0.006901372u 66.675p -0.006871018u 66.6875p -0.006830806u 66.7p -0.006780756u 66.7125p -0.006720904u 66.725p -0.006651298u 66.7375p -0.006572002u 66.75p -0.006483095u
+ 66.7625p -0.006384669u 66.775p -0.00627683u 66.7875p -0.006159698u 66.8p -0.006033408u 66.8125p -0.005898106u 66.825p -0.005753954u 66.8375p -0.005601126u 66.85p -0.005439808u 66.8625p -0.0052702u 66.875p -0.005092513u 66.8875p -0.004906971u 66.9p -0.004713809u
+ 66.9125p -0.004513273u 66.925p -0.004305621u 66.9375p -0.00409112u 66.95p -0.003870049u 66.9625p -0.003642696u 66.975p -0.003409358u 66.9875p -0.003170341u 67p -0.002925959u 67.0125p -0.002676534u 67.025p -0.002422399u 67.0375p -0.002163888u 67.05p -0.001901346u
+ 67.0625p -0.001635123u 67.075p -0.001365574u 67.0875p -0.00109306u 67.1p -0.0008179454u 67.1125p -0.0005405992u 67.125p -0.0002613941u 67.1375p 1.929469e-05u 67.15p 0.0003010892u 67.1625p 0.0005836098u 67.175p 0.0008664755u 67.1875p 0.001149304u 67.2p 0.001431715u
+ 67.2125p 0.001713324u 67.225p 0.001993753u 67.2375p 0.00227262u 67.25p 0.002549549u 67.2625p 0.002824165u 67.275p 0.003096095u 67.2875p 0.003364972u 67.3p 0.003630429u 67.3125p 0.003892108u 67.325p 0.004149654u 67.3375p 0.004402717u 67.35p 0.004650955u
+ 67.3625p 0.004894029u 67.375p 0.005131611u 67.3875p 0.005363379u 67.4p 0.005589017u 67.4125p 0.00580822u 67.425p 0.006020691u 67.4375p 0.006226141u 67.45p 0.006424292u 67.4625p 0.006614876u 67.475p 0.006797633u 67.4875p 0.006972317u 67.5p 0.007138691u
+ 67.5125p 0.00729653u 67.525p 0.007445619u 67.5375p 0.007585757u 67.55p 0.007716755u 67.5625p 0.007838435u 67.575p 0.007950634u 67.5875p 0.008053198u 67.6p 0.008145989u 67.6125p 0.008228883u 67.625p 0.008301767u 67.6375p 0.008364543u 67.65p 0.008417126u
+ 67.6625p 0.008459445u 67.675p 0.008491442u 67.6875p 0.008513074u 67.7p 0.008524313u 67.7125p 0.008525141u 67.725p 0.008515559u 67.7375p 0.008495577u 67.75p 0.008465223u 67.7625p 0.008424536u 67.775p 0.00837357u 67.7875p 0.008312392u 67.8p 0.008241084u
+ 67.8125p 0.00815974u 67.825p 0.008068467u 67.8375p 0.007967385u 67.85p 0.007856629u 67.8625p 0.007736344u 67.875p 0.007606689u 67.8875p 0.007467834u 67.9p 0.007319962u 67.9125p 0.007163268u 67.925p 0.006997958u 67.9375p 0.006824247u 67.95p 0.006642363u
+ 67.9625p 0.006452545u 67.975p 0.006255039u 67.9875p 0.006050105u 68p 0.005838007u 68.0125p 0.005619024u 68.025p 0.005393438u 68.0375p 0.005161542u 68.05p 0.004923637u 68.0625p 0.00468003u 68.075p 0.004431035u 68.0875p 0.004176973u 68.1p 0.00391817u
+ 68.1125p 0.00365496u 68.125p 0.003387678u 68.1375p 0.003116667u 68.15p 0.002842272u 68.1625p 0.002564843u 68.175p 0.002284732u 68.1875p 0.002002295u 68.2p 0.001717887u 68.2125p 0.001431869u 68.225p 0.0011446u 68.2375p 0.0008564413u 68.25p 0.0005677529u
+ 68.2625p 0.0002788955u 68.275p -9.77115e-06u 68.2875p -0.0002978887u 68.3p -0.0005851006u 68.3125p -0.0008710524u 68.325p -0.001155393u 68.3375p -0.001437773u 68.35p -0.001717848u 68.3625p -0.001995278u 68.375p -0.002269726u 68.3875p -0.002540861u 68.4p -0.002808357u
+ 68.4125p -0.003071895u 68.425p -0.003331161u 68.4375p -0.003585848u 68.45p -0.003835655u 68.4625p -0.00408029u 68.475p -0.004319469u 68.4875p -0.004552914u 68.5p -0.004780358u 68.5125p -0.00500154u 68.525p -0.005216211u 68.5375p -0.00542413u 68.55p -0.005625065u
+ 68.5625p -0.005818795u 68.575p -0.006005109u 68.5875p -0.006183806u 68.6p -0.006354697u 68.6125p -0.006517602u 68.625p -0.006672354u 68.6375p -0.006818795u 68.65p -0.006956781u 68.6625p -0.007086179u 68.675p -0.007206865u 68.6875p -0.007318729u 68.7p -0.007421675u
+ 68.7125p -0.007515614u 68.725p -0.007600474u 68.7375p -0.007676191u 68.75p -0.007742716u 68.7625p -0.007800011u 68.775p -0.007848049u 68.7875p -0.007886818u 68.8p -0.007916315u 68.8125p -0.007936551u 68.825p -0.007947548u 68.8375p -0.007949339u 68.85p -0.007941971u
+ 68.8625p -0.0079255u 68.875p -0.007899996u 68.8875p -0.007865538u 68.9p -0.007822218u 68.9125p -0.007770137u 68.925p -0.007709409u 68.9375p -0.007640156u 68.95p -0.007562512u 68.9625p -0.007476621u 68.975p -0.007382637u 68.9875p -0.007280723u 69p -0.00717105u
+ 69.0125p -0.007053801u 69.025p -0.006929165u 69.0375p -0.006797341u 69.05p -0.006658535u 69.0625p -0.006512961u 69.075p -0.006360842u 69.0875p -0.006202406u 69.1p -0.006037887u 69.1125p -0.005867529u 69.125p -0.005691579u 69.1375p -0.005510289u 69.15p -0.005323919u
+ 69.1625p -0.005132733u 69.175p -0.004936997u 69.1875p -0.004736984u 69.2p -0.004532969u 69.2125p -0.004325232u 69.225p -0.004114054u 69.2375p -0.003899719u 69.25p -0.003682513u 69.2625p -0.003462725u 69.275p -0.003240643u 69.2875p -0.003016557u 69.3p -0.002790759u
+ 69.3125p -0.002563537u 69.325p -0.002335184u 69.3375p -0.002105987u 69.35p -0.001876236u 69.3625p -0.001646216u 69.375p -0.001416213u 69.3875p -0.00118651u 69.4p -0.0009573859u 69.4125p -0.0007291179u 69.425p -0.0005019797u 69.4375p -0.0002762408u 69.45p -5.216727e-05u
+ 69.4625p 0.0001699798u 69.475p 0.0003899436u 69.4875p 0.0006074728u 69.5p 0.000822321u 69.5125p 0.001034248u 69.525p 0.001243018u 69.5375p 0.001448404u 69.55p 0.001650184u 69.5625p 0.001848142u 69.575p 0.00204207u 69.5875p 0.002231768u 69.6p 0.002417041u
+ 69.6125p 0.002597704u 69.625p 0.002773578u 69.6375p 0.002944495u 69.65p 0.003110291u 69.6625p 0.003270813u 69.675p 0.003425917u 69.6875p 0.003575466u 69.7p 0.003719332u 69.7125p 0.003857397u 69.725p 0.003989551u 69.7375p 0.004115692u 69.75p 0.004235729u
+ 69.7625p 0.00434958u 69.775p 0.004457171u 69.7875p 0.004558438u 69.8p 0.004653324u 69.8125p 0.004741786u 69.825p 0.004823785u 69.8375p 0.004899295u 69.85p 0.004968296u 69.8625p 0.005030779u 69.875p 0.005086743u 69.8875p 0.005136198u 69.9p 0.005179159u
+ 69.9125p 0.005215653u 69.925p 0.005245713u 69.9375p 0.005269384u 69.95p 0.005286714u 69.9625p 0.005297765u 69.975p 0.005302603u 69.9875p 0.005301302u 70p 0.005293945u 70.0125p 0.005280622u 70.025p 0.00526143u 70.0375p 0.005236474u 70.05p 0.005205863u
+ 70.0625p 0.005169715u 70.075p 0.005128155u 70.0875p 0.005081311u 70.1p 0.005029319u 70.1125p 0.00497232u 70.125p 0.004910461u 70.1375p 0.004843892u 70.15p 0.004772771u 70.1625p 0.004697256u 70.175p 0.004617514u 70.1875p 0.004533711u 70.2p 0.004446022u
+ 70.2125p 0.00435462u 70.225p 0.004259684u 70.2375p 0.004161396u 70.25p 0.004059939u 70.2625p 0.003955498u 70.275p 0.00384826u 70.2875p 0.003738415u 70.3p 0.003626153u 70.3125p 0.003511664u 70.325p 0.003395139u 70.3375p 0.003276771u 70.35p 0.003156751u
+ 70.3625p 0.003035271u 70.375p 0.002912521u 70.3875p 0.002788691u 70.4p 0.00266397u 70.4125p 0.002538546u 70.425p 0.002412603u 70.4375p 0.002286326u 70.45p 0.002159895u 70.4625p 0.00203349u 70.475p 0.001907287u 70.4875p 0.001781458u 70.5p 0.001656174u
+ 70.5125p 0.001531601u 70.525p 0.001407902u 70.5375p 0.001285235u 70.55p 0.001163755u 70.5625p 0.001043612u 70.575p 0.0009249524u 70.5875p 0.0008079173u 70.6p 0.000692643u 70.6125p 0.0005792607u 70.625p 0.0004678966u 70.6375p 0.0003586716u 70.65p 0.000251701u
+ 70.6625p 0.0001470948u 70.675p 4.495711e-05u 70.6875p -5.461363e-05u 70.7p -0.0001515249u 70.7125p -0.00024569u 70.725p -0.0003370284u 70.7375p -0.0004254657u 70.75p -0.0005109333u 70.7625p -0.0005933691u 70.775p -0.0006727171u 70.7875p -0.0007489274u 70.8p -0.0008219565u
+ 70.8125p -0.000891767u 70.825p -0.0009583277u 70.8375p -0.001021614u 70.85p -0.001081606u 70.8625p -0.001138292u 70.875p -0.001191666u 70.8875p -0.001241725u 70.9p -0.001288476u 70.9125p -0.001331931u 70.925p -0.001372104u 70.9375p -0.00140902u 70.95p -0.001442706u
+ 70.9625p -0.001473195u 70.975p -0.001500527u 70.9875p -0.001524745u 71p -0.001545899u 71.0125p -0.001564042u 71.025p -0.001579232u 71.0375p -0.001591534u 71.05p -0.001601013u 71.0625p -0.001607743u 71.075p -0.0016118u 71.0875p -0.001613261u 71.1p -0.001612212u
+ 71.1125p -0.001608739u 71.125p -0.001602932u 71.1375p -0.001594884u 71.15p -0.001584691u 71.1625p -0.001572451u 71.175p -0.001558267u 71.1875p -0.001542241u 71.2p -0.001524479u 71.2125p -0.001505087u 71.225p -0.001484175u 71.2375p -0.001461852u 71.25p -0.001438229u
+ 71.2625p -0.001413419u 71.275p -0.001387535u 71.2875p -0.001360688u 71.3p -0.001332993u 71.3125p -0.001304563u 71.325p -0.00127551u 71.3375p -0.001245949u 71.35p -0.00121599u 71.3625p -0.001185744u 71.375p -0.001155322u 71.3875p -0.001124833u 71.4p -0.001094383u
+ 71.4125p -0.001064078u 71.425p -0.001034022u 71.4375p -0.001004316u 71.45p -0.0009750603u 71.4625p -0.0009463504u 71.475p -0.0009182812u 71.4875p -0.0008909439u 71.5p -0.0008644271u 71.5125p -0.000838816u 71.525p -0.0008141927u 71.5375p -0.0007906359u 71.55p -0.0007682206u
+ 71.5625p -0.0007470183u 71.575p -0.0007270967u 71.5875p -0.0007085193u 71.6p -0.000691346u 71.6125p -0.0006756322u 71.625p -0.0006614293u 71.6375p -0.0006487843u 71.65p -0.0006377399u 71.6625p -0.0006283343u 71.675p -0.0006206012u 71.6875p -0.0006145698u 71.7p -0.0006102646u
+ 71.7125p -0.0006077056u 71.725p -0.0006069081u 71.7375p -0.0006078827u 71.75p -0.0006106353u 71.7625p -0.0006151672u 71.775p -0.000621475u 71.7875p -0.0006295506u 71.8p -0.0006393813u 71.8125p -0.0006509499u 71.825p -0.0006642345u 71.8375p -0.0006792089u 71.85p -0.0006958423u
+ 71.8625p -0.0007140995u 71.875p -0.0007339411u 71.8875p -0.0007553236u 71.9p -0.0007781991u 71.9125p -0.0008025159u 71.925p -0.0008282182u 71.9375p -0.0008552466u 71.95p -0.0008835378u 71.9625p -0.000913025u 71.975p -0.0009436382u 71.9875p -0.0009753036u 72p -0.001007945u
+ 72.0125p -0.001041482u 72.025p -0.001075832u 72.0375p -0.001110911u 72.05p -0.00114663u 72.0625p -0.001182899u 72.075p -0.001219626u 72.0875p -0.001256717u 72.1p -0.001294075u 72.1125p -0.001331602u 72.125p -0.0013692u 72.1375p -0.001406767u 72.15p -0.001444202u
+ 72.1625p -0.001481402u 72.175p -0.001518264u 72.1875p -0.001554683u 72.2p -0.001590557u 72.2125p -0.00162578u 72.225p -0.001660249u 72.2375p -0.001693859u 72.25p -0.001726507u 72.2625p -0.001758091u 72.275p -0.001788507u 72.2875p -0.001817656u 72.3p -0.001845438u
+ 72.3125p -0.001871754u 72.325p -0.001896509u 72.3375p -0.001919607u 72.35p -0.001940956u 72.3625p -0.001960465u 72.375p -0.001978046u 72.3875p -0.001993613u 72.4p -0.002007084u 72.4125p -0.002018378u 72.425p -0.002027418u 72.4375p -0.002034131u 72.45p -0.002038445u
+ 72.4625p -0.002040294u 72.475p -0.002039614u 72.4875p -0.002036346u 72.5p -0.002030433u 72.5125p -0.002021824u 72.525p -0.002010471u 72.5375p -0.00199633u 72.55p -0.001979363u 72.5625p -0.001959534u 72.575p -0.001936812u 72.5875p -0.001911173u 72.6p -0.001882595u
+ 72.6125p -0.001851062u 72.625p -0.001816562u 72.6375p -0.001779088u 72.65p -0.001738638u 72.6625p -0.001695216u 72.675p -0.001648829u 72.6875p -0.00159949u 72.7p -0.001547216u 72.7125p -0.001492031u 72.725p -0.001433962u 72.7375p -0.001373042u 72.75p -0.001309309u
+ 72.7625p -0.001242804u 72.775p -0.001173575u 72.7875p -0.001101674u 72.8p -0.001027158u 72.8125p -0.0009500883u 72.825p -0.0008705312u 72.8375p -0.0007885573u 72.85p -0.0007042417u 72.8625p -0.000617664u 72.875p -0.0005289078u 72.8875p -0.0004380612u 72.9p -0.0003452161u
+ 72.9125p -0.0002504686u 72.925p -0.0001539183u 72.9375p -5.566866e-05u 72.95p 4.417326e-05u 72.9625p 0.0001454971u 72.975p 0.0002481892u 72.9875p 0.0003521327u 73p 0.0004572081u 73.0125p 0.0005632928u 73.025p 0.0006702617u 73.0375p 0.0007779873u 73.05p 0.0008863398u
+ 73.0625p 0.0009951874u 73.075p 0.001104396u 73.0875p 0.001213831u 73.1p 0.001323354u 73.1125p 0.001432828u 73.125p 0.001542113u 73.1375p 0.001651069u 73.15p 0.001759555u 73.1625p 0.001867428u 73.175p 0.001974548u 73.1875p 0.002080772u 73.2p 0.002185957u
+ 73.2125p 0.002289964u 73.225p 0.00239265u 73.2375p 0.002493875u 73.25p 0.002593499u 73.2625p 0.002691385u 73.275p 0.002787394u 73.2875p 0.002881392u 73.3p 0.002973245u 73.3125p 0.00306282u 73.325p 0.003149989u 73.3375p 0.003234623u 73.35p 0.003316598u
+ 73.3625p 0.00339579u 73.375p 0.003472082u 73.3875p 0.003545357u 73.4p 0.0036155u 73.4125p 0.003682404u 73.425p 0.003745961u 73.4375p 0.003806069u 73.45p 0.003862629u 73.4625p 0.003915547u 73.475p 0.003964733u 73.4875p 0.004010101u 73.5p 0.004051569u
+ 73.5125p 0.004089059u 73.525p 0.004122501u 73.5375p 0.004151825u 73.55p 0.004176971u 73.5625p 0.004197879u 73.575p 0.004214499u 73.5875p 0.004226782u 73.6p 0.004234687u 73.6125p 0.004238177u 73.625p 0.004237221u 73.6375p 0.004231794u 73.65p 0.004221876u
+ 73.6625p 0.004207452u 73.675p 0.004188514u 73.6875p 0.004165058u 73.7p 0.004137086u 73.7125p 0.004104608u 73.725p 0.004067636u 73.7375p 0.004026191u 73.75p 0.003980297u 73.7625p 0.003929986u 73.775p 0.003875294u 73.7875p 0.003816264u 73.8p 0.003752942u
+ 73.8125p 0.003685382u 73.825p 0.003613643u 73.8375p 0.003537789u 73.85p 0.003457888u 73.8625p 0.003374016u 73.875p 0.003286252u 73.8875p 0.003194681u 73.9p 0.003099391u 73.9125p 0.003000479u 73.925p 0.002898042u 73.9375p 0.002792185u 73.95p 0.002683015u
+ 73.9625p 0.002570646u 73.975p 0.002455193u 73.9875p 0.002336779u 74p 0.002215526u 74.0125p 0.002091565u 74.025p 0.001965025u 74.0375p 0.001836044u 74.05p 0.00170476u 74.0625p 0.001571313u 74.075p 0.001435849u 74.0875p 0.001298516u 74.1p 0.001159462u
+ 74.1125p 0.001018839u 74.125p 0.000876803u 74.1375p 0.0007335086u 74.15p 0.0005891141u 74.1625p 0.0004437789u 74.175p 0.0002976637u 74.1875p 0.0001509303u 74.2p 3.741376e-06u 74.2125p -0.0001437395u 74.225p -0.0002913484u 74.2375p -0.000438921u 74.25p -0.0005862931u
+ 74.2625p -0.0007333003u 74.275p -0.0008797788u 74.2875p -0.001025565u 74.3p -0.001170497u 74.3125p -0.001314413u 74.325p -0.001457151u 74.3375p -0.001598554u 74.35p -0.001738463u 74.3625p -0.001876722u 74.375p -0.002013179u 74.3875p -0.00214768u 74.4p -0.002280076u
+ 74.4125p -0.002410221u 74.425p -0.002537971u 74.4375p -0.002663184u 74.45p -0.002785721u 74.4625p -0.002905448u 74.475p -0.003022234u 74.4875p -0.003135949u 74.5p -0.00324647u 74.5125p -0.003353676u 74.525p -0.00345745u 74.5375p -0.00355768u 74.55p -0.003654259u
+ 74.5625p -0.003747082u 74.575p -0.003836049u 74.5875p -0.003921068u 74.6p -0.004002047u 74.6125p -0.004078902u 74.625p -0.004151553u 74.6375p -0.004219924u 74.65p -0.004283947u 74.6625p -0.004343556u 74.675p -0.004398693u 74.6875p -0.004449303u 74.7p -0.004495337u
+ 74.7125p -0.004536753u 74.725p -0.004573512u 74.7375p -0.004605583u 74.75p -0.00463294u 74.7625p -0.00465556u 74.775p -0.004673428u 74.7875p -0.004686535u 74.8p -0.004694877u 74.8125p -0.004698453u 74.825p -0.004697272u 74.8375p -0.004691345u 74.85p -0.004680691u
+ 74.8625p -0.004665332u 74.875p -0.004645296u 74.8875p -0.004620619u 74.9p -0.00459134u 74.9125p -0.004557502u 74.925p -0.004519155u 74.9375p -0.004476355u 74.95p -0.00442916u 74.9625p -0.004377636u 74.975p -0.004321852u 74.9875p -0.004261882u 75p -0.004197804u
+ 75.0125p -0.004129702u 75.025p -0.004057664u 75.0375p -0.003981781u 75.05p -0.003902148u 75.0625p -0.003818867u 75.075p -0.00373204u 75.0875p -0.003641774u 75.1p -0.003548181u 75.1125p -0.003451375u 75.125p -0.003351473u 75.1375p -0.003248596u 75.15p -0.003142867u
+ 75.1625p -0.003034412u 75.175p -0.00292336u 75.1875p -0.002809843u 75.2p -0.002693992u 75.2125p -0.002575945u 75.225p -0.002455838u 75.2375p -0.002333809u 75.25p -0.002210001u 75.2625p -0.002084553u 75.275p -0.00195761u 75.2875p -0.001829315u 75.3p -0.001699813u
+ 75.3125p -0.001569249u 75.325p -0.001437769u 75.3375p -0.00130552u 75.35p -0.001172645u 75.3625p -0.001039293u 75.375p -0.0009056085u 75.3875p -0.0007717363u 75.4p -0.0006378211u 75.4125p -0.0005040065u 75.425p -0.0003704353u 75.4375p -0.0002372488u 75.45p -0.0001045871u
+ 75.4625p 2.741107e-05u 75.475p 0.0001586089u 75.4875p 0.0002888711u 75.5p 0.0004180647u 75.5125p 0.0005460586u 75.525p 0.0006727242u 75.5375p 0.0007979351u 75.55p 0.0009215675u 75.5625p 0.001043501u 75.575p 0.001163616u 75.5875p 0.001281798u 75.6p 0.001397936u
+ 75.6125p 0.001511919u 75.625p 0.001623643u 75.6375p 0.001733004u 75.65p 0.001839906u 75.6625p 0.001944251u 75.675p 0.002045949u 75.6875p 0.002144912u 75.7p 0.002241057u 75.7125p 0.002334304u 75.725p 0.002424576u 75.7375p 0.002511802u 75.75p 0.002595915u
+ 75.7625p 0.002676852u 75.775p 0.002754552u 75.7875p 0.002828961u 75.8p 0.002900029u 75.8125p 0.002967708u 75.825p 0.003031958u 75.8375p 0.003092741u 75.85p 0.003150023u 75.8625p 0.003203776u 75.875p 0.003253975u 75.8875p 0.0033006u 75.9p 0.003343635u
+ 75.9125p 0.003383069u 75.925p 0.003418895u 75.9375p 0.00345111u 75.95p 0.003479715u 75.9625p 0.003504716u 75.975p 0.003526123u 75.9875p 0.003543949u 76p 0.003558213u 76.0125p 0.003568935u 76.025p 0.003576143u 76.0375p 0.003579865u 76.05p 0.003580135u
+ 76.0625p 0.00357699u 76.075p 0.003570471u 76.0875p 0.003560621u 76.1p 0.003547489u 76.1125p 0.003531124u 76.125p 0.003511582u 76.1375p 0.003488919u 76.15p 0.003463195u 76.1625p 0.003434474u 76.175p 0.003402821u 76.1875p 0.003368305u 76.2p 0.003330998u
+ 76.2125p 0.003290972u 76.225p 0.003248303u 76.2375p 0.003203069u 76.25p 0.003155351u 76.2625p 0.003105229u 76.275p 0.003052789u 76.2875p 0.002998115u 76.3p 0.002941295u 76.3125p 0.002882416u 76.325p 0.002821569u 76.3375p 0.002758843u 76.35p 0.002694331u
+ 76.3625p 0.002628126u 76.375p 0.00256032u 76.3875p 0.002491008u 76.4p 0.002420284u 76.4125p 0.002348243u 76.425p 0.002274979u 76.4375p 0.002200588u 76.45p 0.002125165u 76.4625p 0.002048804u 76.475p 0.001971601u 76.4875p 0.001893648u 76.5p 0.00181504u
+ 76.5125p 0.00173587u 76.525p 0.001656229u 76.5375p 0.001576209u 76.55p 0.0014959u 76.5625p 0.001415391u 76.575p 0.001334771u 76.5875p 0.001254124u 76.6p 0.001173537u 76.6125p 0.001093094u 76.625p 0.001012875u 76.6375p 0.0009329625u 76.65p 0.0008534337u
+ 76.6625p 0.0007743655u 76.675p 0.0006958328u 76.6875p 0.0006179081u 76.7p 0.0005406622u 76.7125p 0.0004641634u 76.725p 0.000388478u 76.7375p 0.00031367u 76.75p 0.000239801u 76.7625p 0.0001669303u 76.775p 9.511462e-05u 76.7875p 2.440848e-05u 76.8p -4.51363e-05u
+ 76.8125p -0.0001134704u 76.825p -0.0001805469u 76.8375p -0.0002463218u 76.85p -0.0003107534u 76.8625p -0.0003738027u 76.875p -0.0004354334u 76.8875p -0.0004956118u 76.9p -0.0005543068u 76.9125p -0.0006114899u 76.925p -0.0006671355u 76.9375p -0.0007212202u 76.95p -0.0007737236u
+ 76.9625p -0.0008246276u 76.975p -0.0008739169u 76.9875p -0.0009215785u 77p -0.0009676022u 77.0125p -0.00101198u 77.025p -0.001054707u 77.0375p -0.001095779u 77.05p -0.001135196u 77.0625p -0.001172961u 77.075p -0.001209075u 77.0875p -0.001243547u 77.1p -0.001276384u
+ 77.1125p -0.001307596u 77.125p -0.001337197u 77.1375p -0.001365199u 77.15p -0.001391621u 77.1625p -0.001416479u 77.175p -0.001439794u 77.1875p -0.001461588u 77.2p -0.001481883u 77.2125p -0.001500705u 77.225p -0.001518079u 77.2375p -0.001534034u 77.25p -0.001548599u
+ 77.2625p -0.001561803u 77.275p -0.001573679u 77.2875p -0.001584258u 77.3p -0.001593574u 77.3125p -0.001601661u 77.325p -0.001608554u 77.3375p -0.00161429u 77.35p -0.001618905u 77.3625p -0.001622435u 77.375p -0.001624919u 77.3875p -0.001626394u 77.4p -0.001626899u
+ 77.4125p -0.001626472u 77.425p -0.001625151u 77.4375p -0.001622976u 77.45p -0.001619984u 77.4625p -0.001616215u 77.475p -0.001611707u 77.4875p -0.001606499u 77.5p -0.001600626u 77.5125p -0.001594128u 77.525p -0.001587042u 77.5375p -0.001579402u 77.55p -0.001571246u
+ 77.5625p -0.001562608u 77.575p -0.001553523u 77.5875p -0.001544025u 77.6p -0.001534145u 77.6125p -0.001523916u 77.625p -0.001513369u 77.6375p -0.001502533u 77.65p -0.001491437u 77.6625p -0.00148011u 77.675p -0.001468576u 77.6875p -0.001456862u 77.7p -0.001444992u
+ 77.7125p -0.001432989u 77.725p -0.001420873u 77.7375p -0.001408666u 77.75p -0.001396386u 77.7625p -0.00138405u 77.775p -0.001371675u 77.7875p -0.001359276u 77.8p -0.001346865u 77.8125p -0.001334455u 77.825p -0.001322056u 77.8375p -0.001309678u 77.85p -0.001297327u
+ 77.8625p -0.00128501u 77.875p -0.001272732u 77.8875p -0.001260496u 77.9p -0.001248304u 77.9125p -0.001236157u 77.925p -0.001224054u 77.9375p -0.001211992u 77.95p -0.00119997u 77.9625p -0.001187981u 77.975p -0.00117602u 77.9875p -0.00116408u 78p -0.001152153u
+ 78.0125p -0.001140228u 78.025p -0.001128296u 78.0375p -0.001116345u 78.05p -0.001104361u 78.0625p -0.001092332u 78.075p -0.001080243u 78.0875p -0.001068078u 78.1p -0.001055821u 78.1125p -0.001043455u 78.125p -0.001030962u 78.1375p -0.001018324u 78.15p -0.001005522u
+ 78.1625p -0.0009925357u 78.175p -0.0009793455u 78.1875p -0.0009659308u 78.2p -0.0009522709u 78.2125p -0.0009383445u 78.225p -0.0009241304u 78.2375p -0.0009096069u 78.25p -0.0008947525u 78.2625p -0.0008795454u 78.275p -0.0008639641u 78.2875p -0.0008479871u 78.3p -0.0008315928u
+ 78.3125p -0.0008147602u 78.325p -0.0007974685u 78.3375p -0.000779697u 78.35p -0.0007614259u 78.3625p -0.0007426353u 78.375p -0.0007233064u 78.3875p -0.0007034207u 78.4p -0.0006829604u 78.4125p -0.0006619084u 78.425p -0.0006402485u 78.4375p -0.0006179654u 78.45p -0.0005950444u
+ 78.4625p -0.0005714721u 78.475p -0.0005472359u 78.4875p -0.0005223242u 78.5p -0.0004967268u 78.5125p -0.0004704343u 78.525p -0.0004434387u 78.5375p -0.0004157332u 78.55p -0.0003873124u 78.5625p -0.0003581718u 78.575p -0.0003283088u 78.5875p -0.0002977219u 78.6p -0.0002664109u
+ 78.6125p -0.0002343773u 78.625p -0.0002016239u 78.6375p -0.0001681551u 78.65p -0.0001339768u 78.6625p -9.909626e-05u 78.675p -6.352254e-05u 78.6875p -2.72661e-05u 78.7p 9.660974e-06u 78.7125p 4.724505e-05u 78.725p 8.547092e-05u 78.7375p 0.0001243218u 78.75p 0.0001637792u
+ 78.7625p 0.0002038234u 78.775p 0.0002444327u 78.7875p 0.0002855841u 78.8p 0.000327253u 78.8125p 0.0003694134u 78.825p 0.0004120375u 78.8375p 0.0004550964u 78.85p 0.0004985594u 78.8625p 0.0005423946u 78.875p 0.0005865686u 78.8875p 0.0006310468u 78.9p 0.000675793u
+ 78.9125p 0.00072077u 78.925p 0.0007659391u 78.9375p 0.0008112606u 78.95p 0.0008566935u 78.9625p 0.0009021959u 78.975p 0.0009477245u 78.9875p 0.0009932355u 79p 0.001038684u 79.0125p 0.001084023u 79.025p 0.001129207u 79.0375p 0.001174188u 79.05p 0.001218917u
+ 79.0625p 0.001263347u 79.075p 0.001307427u 79.0875p 0.001351107u 79.1p 0.001394337u 79.1125p 0.001437067u 79.125p 0.001479245u 79.1375p 0.00152082u 79.15p 0.00156174u 79.1625p 0.001601954u 79.175p 0.001641411u 79.1875p 0.001680058u 79.2p 0.001717845u
+ 79.2125p 0.001754721u 79.225p 0.001790635u 79.2375p 0.001825535u 79.25p 0.001859374u 79.2625p 0.0018921u 79.275p 0.001923665u 79.2875p 0.001954022u 79.3p 0.001983122u 79.3125p 0.002010919u 79.325p 0.002037367u 79.3375p 0.002062423u 79.35p 0.002086041u
+ 79.3625p 0.002108181u 79.375p 0.0021288u 79.3875p 0.002147858u 79.4p 0.002165317u 79.4125p 0.00218114u 79.425p 0.002195291u 79.4375p 0.002207735u 79.45p 0.002218439u 79.4625p 0.002227374u 79.475p 0.002234509u 79.4875p 0.002239816u 79.5p 0.002243271u
+ 79.5125p 0.002244849u 79.525p 0.002244528u 79.5375p 0.002242288u 79.55p 0.002238111u 79.5625p 0.002231982u 79.575p 0.002223886u 79.5875p 0.002213811u 79.6p 0.002201748u 79.6125p 0.00218769u 79.625p 0.00217163u 79.6375p 0.002153567u 79.65p 0.0021335u
+ 79.6625p 0.00211143u 79.675p 0.00208736u 79.6875p 0.002061297u 79.7p 0.00203325u 79.7125p 0.00200323u 79.725p 0.001971248u 79.7375p 0.001937321u 79.75p 0.001901467u 79.7625p 0.001863705u 79.775p 0.001824058u 79.7875p 0.00178255u 79.8p 0.001739209u
+ 79.8125p 0.001694063u 79.825p 0.001647144u 79.8375p 0.001598486u 79.85p 0.001548123u 79.8625p 0.001496095u 79.875p 0.001442442u 79.8875p 0.001387204u 79.9p 0.001330428u 79.9125p 0.001272158u 79.925p 0.001212442u 79.9375p 0.001151332u 79.95p 0.001088878u
+ 79.9625p 0.001025135u 79.975p 0.000960157u 79.9875p 0.0008940021u 80p 0.0008267287u 80.0125p 0.000758397u 80.025p 0.0006890689u 80.0375p 0.0006188073u 80.05p 0.000547677u 80.0625p 0.0004757437u 80.075p 0.0004030744u 80.0875p 0.0003297373u 80.1p 0.0002558015u
+ 80.1125p 0.0001813373u 80.125p 0.0001064158u 80.1375p 3.110873e-05u 80.15p -4.451114e-05u 80.1625p -0.0001203706u 80.175p -0.0001963957u 80.1875p -0.0002725122u 80.2p -0.0003486454u 80.2125p -0.0004247202u 80.225p -0.0005006614u 80.2375p -0.0005763937u 80.25p -0.0006518417u
+ 80.2625p -0.0007269299u 80.275p -0.0008015831u 80.2875p -0.0008757265u 80.3p -0.0009492852u 80.3125p -0.001022185u 80.325p -0.001094352u 80.3375p -0.001165714u 80.35p -0.001236196u 80.3625p -0.001305729u 80.375p -0.001374241u 80.3875p -0.001441661u 80.4p -0.001507922u
+ 80.4125p -0.001572954u 80.425p -0.001636691u 80.4375p -0.001699069u 80.45p -0.001760021u 80.4625p -0.001819487u 80.475p -0.001877403u 80.4875p -0.001933712u 80.5p -0.001988354u 80.5125p -0.002041273u 80.525p -0.002092415u 80.5375p -0.002141727u 80.55p -0.002189157u
+ 80.5625p -0.002234657u 80.575p -0.00227818u 80.5875p -0.00231968u 80.6p -0.002359116u 80.6125p -0.002396446u 80.625p -0.002431632u 80.6375p -0.002464637u 80.65p -0.002495428u 80.6625p -0.002523974u 80.675p -0.002550245u 80.6875p -0.002574214u 80.7p -0.002595857u
+ 80.7125p -0.002615152u 80.725p -0.002632079u 80.7375p -0.002646623u 80.75p -0.002658768u 80.7625p -0.002668504u 80.775p -0.002675819u 80.7875p -0.002680709u 80.8p -0.002683168u 80.8125p -0.002683195u 80.825p -0.002680792u 80.8375p -0.002675962u 80.85p -0.002668711u
+ 80.8625p -0.002659047u 80.875p -0.002646983u 80.8875p -0.002632532u 80.9p -0.002615709u 80.9125p -0.002596535u 80.925p -0.00257503u 80.9375p -0.002551218u 80.95p -0.002525125u 80.9625p -0.002496779u 80.975p -0.002466212u 80.9875p -0.002433455u 81p -0.002398545u
+ 81.0125p -0.002361519u 81.025p -0.002322416u 81.0375p -0.002281279u 81.05p -0.002238151u 81.0625p -0.002193078u 81.075p -0.002146107u 81.0875p -0.002097288u 81.1p -0.002046673u 81.1125p -0.001994315u 81.125p -0.001940268u 81.1375p -0.00188459u 81.15p -0.001827338u
+ 81.1625p -0.001768571u 81.175p -0.001708351u 81.1875p -0.001646741u 81.2p -0.001583802u 81.2125p -0.001519601u 81.225p -0.001454203u 81.2375p -0.001387675u 81.25p -0.001320085u 81.2625p -0.001251502u 81.275p -0.001181994u 81.2875p -0.001111633u 81.3p -0.001040489u
+ 81.3125p -0.0009686339u 81.325p -0.0008961389u 81.3375p -0.0008230766u 81.35p -0.0007495195u 81.3625p -0.0006755404u 81.375p -0.0006012122u 81.3875p -0.0005266078u 81.4p -0.0004518002u 81.4125p -0.0003768622u 81.425p -0.0003018664u 81.4375p -0.000226885u 81.45p -0.0001519902u
+ 81.4625p -7.725344e-05u 81.475p -2.74577e-06u 81.4875p 7.146237e-05u 81.5p 0.0001453012u 81.5125p 0.0002187017u 81.525p 0.0002915955u 81.5375p 0.0003639155u 81.55p 0.0004355952u 81.5625p 0.0005065692u 81.575p 0.0005767733u 81.5875p 0.0006461444u 81.6p 0.0007146206u
+ 81.6125p 0.0007821413u 81.625p 0.0008486473u 81.6375p 0.0009140807u 81.65p 0.0009783853u 81.6625p 0.001041506u 81.675p 0.00110339u 81.6875p 0.001163984u 81.7p 0.001223241u 81.7125p 0.00128111u 81.725p 0.001337545u 81.7375p 0.001392502u 81.75p 0.001445937u
+ 81.7625p 0.001497811u 81.775p 0.001548082u 81.7875p 0.001596715u 81.8p 0.001643674u 81.8125p 0.001688926u 81.825p 0.001732438u 81.8375p 0.001774183u 81.85p 0.001814133u 81.8625p 0.001852263u 81.875p 0.001888548u 81.8875p 0.00192297u 81.9p 0.001955508u
+ 81.9125p 0.001986146u 81.925p 0.002014869u 81.9375p 0.002041664u 81.95p 0.002066521u 81.9625p 0.002089431u 81.975p 0.002110389u 81.9875p 0.002129388u 82p 0.002146428u 82.0125p 0.002161507u 82.025p 0.002174628u 82.0375p 0.002185795u 82.05p 0.002195012u
+ 82.0625p 0.002202288u 82.075p 0.002207633u 82.0875p 0.002211057u 82.1p 0.002212573u 82.1125p 0.002212199u 82.125p 0.002209949u 82.1375p 0.002205842u 82.15p 0.0021999u 82.1625p 0.002192145u 82.175p 0.002182599u 82.1875p 0.002171288u 82.2p 0.002158239u
+ 82.2125p 0.002143481u 82.225p 0.002127043u 82.2375p 0.002108956u 82.25p 0.002089253u 82.2625p 0.002067968u 82.275p 0.002045135u 82.2875p 0.002020792u 82.3p 0.001994975u 82.3125p 0.001967722u 82.325p 0.001939074u 82.3375p 0.001909071u 82.35p 0.001877754u
+ 82.3625p 0.001845166u 82.375p 0.001811348u 82.3875p 0.001776346u 82.4p 0.001740203u 82.4125p 0.001702965u 82.425p 0.001664677u 82.4375p 0.001625385u 82.45p 0.001585135u 82.4625p 0.001543975u 82.475p 0.001501952u 82.4875p 0.001459113u 82.5p 0.001415505u
+ 82.5125p 0.001371177u 82.525p 0.001326176u 82.5375p 0.001280551u 82.55p 0.001234349u 82.5625p 0.001187617u 82.575p 0.001140405u 82.5875p 0.001092758u 82.6p 0.001044724u 82.6125p 0.0009963512u 82.625p 0.0009476847u 82.6375p 0.0008987712u 82.65p 0.0008496564u
+ 82.6625p 0.0008003855u 82.675p 0.0007510034u 82.6875p 0.0007015541u 82.7p 0.0006520811u 82.7125p 0.0006026274u 82.725p 0.0005532351u 82.7375p 0.0005039457u 82.75p 0.0004547998u 82.7625p 0.0004058372u 82.775p 0.000357097u 82.7875p 0.0003086173u 82.8p 0.0002604353u
+ 82.8125p 0.0002125873u 82.825p 0.0001651087u 82.8375p 0.0001180338u 82.85p 7.13959e-05u 82.8625p 2.52274e-05u 82.875p -2.044048e-05u 82.8875p -6.557754e-05u 82.9p -0.0001101547u 82.9125p -0.0001541438u 82.925p -0.0001975181u 82.9375p -0.0002402517u 82.95p -0.00028232u
+ 82.9625p -0.0003236995u 82.975p -0.0003643677u 82.9875p -0.0004043035u 83p -0.0004434867u 83.0125p -0.0004818984u 83.025p -0.0005195208u 83.0375p -0.0005563373u 83.05p -0.0005923324u 83.0625p -0.0006274917u 83.075p -0.0006618018u 83.0875p -0.0006952508u 83.1p -0.0007278276u
+ 83.1125p -0.0007595223u 83.125p -0.0007903259u 83.1375p -0.0008202308u 83.15p -0.0008492302u 83.1625p -0.0008773184u 83.175p -0.0009044907u 83.1875p -0.0009307434u 83.2p -0.0009560739u 83.2125p -0.0009804804u 83.225p -0.001003962u 83.2375p -0.001026519u 83.25p -0.001048152u
+ 83.2625p -0.001068863u 83.275p -0.001088655u 83.2875p -0.001107531u 83.3p -0.001125495u 83.3125p -0.001142553u 83.325p -0.001158709u 83.3375p -0.001173971u 83.35p -0.001188346u 83.3625p -0.00120184u 83.375p -0.001214463u 83.3875p -0.001226223u 83.4p -0.00123713u
+ 83.4125p -0.001247193u 83.425p -0.001256423u 83.4375p -0.00126483u 83.45p -0.001272426u 83.4625p -0.001279223u 83.475p -0.001285232u 83.4875p -0.001290465u 83.5p -0.001294935u 83.5125p -0.001298656u 83.525p -0.001301638u 83.5375p -0.001303897u 83.55p -0.001305446u
+ 83.5625p -0.001306297u 83.575p -0.001306464u 83.5875p -0.001305962u 83.6p -0.001304803u 83.6125p -0.001303002u 83.625p -0.001300573u 83.6375p -0.001297529u 83.65p -0.001293883u 83.6625p -0.00128965u 83.675p -0.001284843u 83.6875p -0.001279475u 83.7p -0.001273559u
+ 83.7125p -0.00126711u 83.725p -0.001260139u 83.7375p -0.001252659u 83.75p -0.001244683u 83.7625p -0.001236223u 83.775p -0.001227292u 83.7875p -0.0012179u 83.8p -0.00120806u 83.8125p -0.001197783u 83.825p -0.001187079u 83.8375p -0.001175959u 83.85p -0.001164434u
+ 83.8625p -0.001152514u 83.875p -0.001140207u 83.8875p -0.001127525u 83.9p -0.001114475u 83.9125p -0.001101066u 83.925p -0.001087307u 83.9375p -0.001073205u 83.95p -0.001058769u 83.9625p -0.001044005u 83.975p -0.00102892u 83.9875p -0.001013522u 84p -0.0009978158u
+ 84.0125p -0.0009818083u 84.025p -0.0009655049u 84.0375p -0.0009489109u 84.05p -0.0009320314u 84.0625p -0.0009148711u 84.075p -0.0008974346u 84.0875p -0.000879726u 84.1p -0.0008617493u 84.1125p -0.0008435081u 84.125p -0.000825006u 84.1375p -0.0008062461u 84.15p -0.0007872316u
+ 84.1625p -0.0007679652u 84.175p -0.0007484496u 84.1875p -0.0007286873u 84.2p -0.0007086807u 84.2125p -0.000688432u 84.225p -0.0006679434u 84.2375p -0.0006472168u 84.25p -0.0006262542u 84.2625p -0.0006050576u 84.275p -0.0005836288u 84.2875p -0.0005619697u 84.3p -0.0005400821u
+ 84.3125p -0.000517968u 84.325p -0.0004956292u 84.3375p -0.0004730677u 84.35p -0.0004502857u 84.3625p -0.0004272852u 84.375p -0.0004040686u 84.3875p -0.0003806383u 84.4p -0.0003569968u 84.4125p -0.000333147u 84.425p -0.0003090918u 84.4375p -0.0002848343u 84.45p -0.000260378u
+ 84.4625p -0.0002357265u 84.475p -0.0002108837u 84.4875p -0.0001858537u 84.5p -0.0001606412u 84.5125p -0.0001352508u 84.525p -0.0001096877u 84.5375p -8.395729e-05u 84.55p -5.806548e-05u 84.5625p -3.20184e-05u 84.575p -5.822605e-06u 84.5875p 2.051496e-05u 84.6p 4.698695e-05u
+ 84.6125p 7.358562e-05u 84.625p 0.0001003028u 84.6375p 0.0001271299u 84.65p 0.0001540579u 84.6625p 0.0001810773u 84.675p 0.0002081783u 84.6875p 0.0002353505u 84.7p 0.0002625831u 84.7125p 0.0002898648u 84.725p 0.000317184u 84.7375p 0.0003445284u 84.75p 0.0003718856u
+ 84.7625p 0.0003992424u 84.775p 0.0004265853u 84.7875p 0.0004539005u 84.8p 0.0004811734u 84.8125p 0.0005083894u 84.825p 0.0005355331u 84.8375p 0.0005625889u 84.85p 0.0005895408u 84.8625p 0.0006163722u 84.875p 0.0006430665u 84.8875p 0.0006696062u 84.9p 0.000695974u
+ 84.9125p 0.0007221517u 84.925p 0.0007481213u 84.9375p 0.0007738641u 84.95p 0.0007993612u 84.9625p 0.0008245935u 84.975p 0.0008495416u 84.9875p 0.0008741859u 85p 0.0008985064u 85.0125p 0.0009224831u 85.025p 0.0009460957u 85.0375p 0.0009693238u 85.05p 0.0009921469u
+ 85.0625p 0.001014544u 85.075p 0.001036495u 85.0875p 0.001057979u 85.1p 0.001078975u 85.1125p 0.001099462u 85.125p 0.001119419u 85.1375p 0.001138825u 85.15p 0.001157661u 85.1625p 0.001175904u 85.175p 0.001193536u 85.1875p 0.001210535u 85.2p 0.001226881u
+ 85.2125p 0.001242554u 85.225p 0.001257535u 85.2375p 0.001271805u 85.25p 0.001285343u 85.2625p 0.001298133u 85.275p 0.001310154u 85.2875p 0.001321389u 85.3p 0.001331821u 85.3125p 0.001341432u 85.325p 0.001350206u 85.3375p 0.001358126u 85.35p 0.001365178u
+ 85.3625p 0.001371345u 85.375p 0.001376614u 85.3875p 0.00138097u 85.4p 0.0013844u 85.4125p 0.001386892u 85.425p 0.001388434u 85.4375p 0.001389015u 85.45p 0.001388624u 85.4625p 0.001387252u 85.475p 0.00138489u 85.4875p 0.001381529u 85.5p 0.001377163u
+ 85.5125p 0.001371785u 85.525p 0.00136539u 85.5375p 0.001357973u 85.55p 0.00134953u 85.5625p 0.001340058u 85.575p 0.001329557u 85.5875p 0.001318023u 85.6p 0.001305459u 85.6125p 0.001291864u 85.625p 0.001277241u 85.6375p 0.001261592u 85.65p 0.001244922u
+ 85.6625p 0.001227235u 85.675p 0.001208538u 85.6875p 0.001188837u 85.7p 0.001168141u 85.7125p 0.001146458u 85.725p 0.001123799u 85.7375p 0.001100174u 85.75p 0.001075596u 85.7625p 0.001050078u 85.775p 0.001023634u 85.7875p 0.0009962794u 85.8p 0.0009680297u
+ 85.8125p 0.0009389023u 85.825p 0.0009089153u 85.8375p 0.0008780878u 85.85p 0.0008464399u 85.8625p 0.0008139924u 85.875p 0.0007807675u 85.8875p 0.0007467877u 85.9p 0.000712077u 85.9125p 0.0006766598u 85.925p 0.0006405617u 85.9375p 0.0006038089u 85.95p 0.0005664286u
+ 85.9625p 0.0005284486u 85.975p 0.0004898977u 85.9875p 0.0004508053u 86p 0.0004112015u 86.0125p 0.0003711173u 86.025p 0.0003305839u 86.0375p 0.0002896337u 86.05p 0.0002482994u 86.0625p 0.0002066142u 86.075p 0.000164612u 86.0875p 0.0001223272u 86.1p 7.979462e-05u
+ 86.1125p 3.704952e-05u 86.125p -5.872419e-06u 86.1375p -4.893515e-05u 86.15p -9.210228e-05u 86.1625p -0.0001353371u 86.175p -0.0001786028u 86.1875p -0.0002218621u 86.2p -0.0002650777u 86.2125p -0.0003082121u 86.225p -0.0003512277u 86.2375p -0.0003940869u 86.25p -0.000436752u
+ 86.2625p -0.0004791853u 86.275p -0.0005213493u 86.2875p -0.0005632063u 86.3p -0.000604719u 86.3125p -0.0006458503u 86.325p -0.000686563u 86.3375p -0.0007268205u 86.35p -0.0007665863u 86.3625p -0.0008058243u 86.375p -0.0008444988u 86.3875p -0.0008825743u 86.4p -0.0009200161u
+ 86.4125p -0.0009567897u 86.425p -0.0009928612u 86.4375p -0.001028197u 86.45p -0.001062766u 86.4625p -0.001096533u 86.475p -0.00112947u 86.4875p -0.001161544u 86.5p -0.001192726u 86.5125p -0.001222986u 86.525p -0.001252297u 86.5375p -0.001280631u 86.55p -0.00130796u
+ 86.5625p -0.00133426u 86.575p -0.001359504u 86.5875p -0.001383671u 86.6p -0.001406736u 86.6125p -0.001428677u 86.625p -0.001449474u 86.6375p -0.001469107u 86.65p -0.001487558u 86.6625p -0.001504807u 86.675p -0.00152084u 86.6875p -0.00153564u 86.7p -0.001549193u
+ 86.7125p -0.001561487u 86.725p -0.001572509u 86.7375p -0.001582248u 86.75p -0.001590695u 86.7625p -0.001597843u 86.775p -0.001603683u 86.7875p -0.00160821u 86.8p -0.001611419u 86.8125p -0.001613307u 86.825p -0.001613873u 86.8375p -0.001613115u 86.85p -0.001611033u
+ 86.8625p -0.00160763u 86.875p -0.001602908u 86.8875p -0.001596872u 86.9p -0.001589526u 86.9125p -0.001580879u 86.925p -0.001570937u 86.9375p -0.001559709u 86.95p -0.001547208u 86.9625p -0.001533442u 86.975p -0.001518427u 86.9875p -0.001502174u 87p -0.001484701u
+ 87.0125p -0.001466022u 87.025p -0.001446155u 87.0375p -0.001425119u 87.05p -0.001402933u 87.0625p -0.001379618u 87.075p -0.001355195u 87.0875p -0.001329688u 87.1p -0.001303119u 87.1125p -0.001275514u 87.125p -0.001246898u 87.1375p -0.001217298u 87.15p -0.00118674u
+ 87.1625p -0.001155254u 87.175p -0.001122868u 87.1875p -0.001089613u 87.2p -0.001055518u 87.2125p -0.001020615u 87.225p -0.0009849363u 87.2375p -0.0009485144u 87.25p -0.0009113827u 87.2625p -0.0008735751u 87.275p -0.0008351259u 87.2875p -0.0007960703u 87.3p -0.0007564435u
+ 87.3125p -0.0007162817u 87.325p -0.0006756209u 87.3375p -0.0006344979u 87.35p -0.0005929497u 87.3625p -0.0005510135u 87.375p -0.0005087268u 87.3875p -0.0004661275u 87.4p -0.0004232533u 87.4125p -0.0003801423u 87.425p -0.0003368327u 87.4375p -0.0002933626u 87.45p -0.0002497703u
+ 87.4625p -0.0002060938u 87.475p -0.0001623712u 87.4875p -0.0001186407u 87.5p -7.494006e-05u 87.5125p -3.130694e-05u 87.525p 1.222115e-05u 87.5375p 5.5607e-05u 87.55p 9.881367e-05u 87.5625p 0.0001418045u 87.575p 0.0001845434u 87.5875p 0.0002269943u 87.6p 0.0002691219u
+ 87.6125p 0.0003108911u 87.625p 0.0003522676u 87.6375p 0.0003932173u 87.65p 0.0004337068u 87.6625p 0.0004737035u 87.675p 0.000513175u 87.6875p 0.0005520898u 87.7p 0.000590417u 87.7125p 0.0006281266u 87.725p 0.000665189u 87.7375p 0.0007015756u 87.75p 0.0007372585u
+ 87.7625p 0.0007722106u 87.775p 0.0008064055u 87.7875p 0.0008398179u 87.8p 0.0008724232u 87.8125p 0.0009041977u 87.825p 0.0009351185u 87.8375p 0.000965164u 87.85p 0.000994313u 87.8625p 0.001022546u 87.875p 0.001049843u 87.8875p 0.001076187u 87.9p 0.00110156u
+ 87.9125p 0.001125947u 87.925p 0.001149332u 87.9375p 0.001171701u 87.95p 0.001193042u 87.9625p 0.001213342u 87.975p 0.00123259u 87.9875p 0.001250776u 88p 0.001267892u 88.0125p 0.001283929u 88.025p 0.001298881u 88.0375p 0.001312742u 88.05p 0.001325506u
+ 88.0625p 0.001337171u 88.075p 0.001347734u 88.0875p 0.001357192u 88.1p 0.001365545u 88.1125p 0.001372793u 88.125p 0.001378938u 88.1375p 0.001383982u 88.15p 0.001387927u 88.1625p 0.001390778u 88.175p 0.001392541u 88.1875p 0.001393221u 88.2p 0.001392825u
+ 88.2125p 0.00139136u 88.225p 0.001388837u 88.2375p 0.001385263u 88.25p 0.001380651u 88.2625p 0.00137501u 88.275p 0.001368353u 88.2875p 0.001360693u 88.3p 0.001352043u 88.3125p 0.001342419u 88.325p 0.001331834u 88.3375p 0.001320305u 88.35p 0.001307848u
+ 88.3625p 0.00129448u 88.375p 0.001280219u 88.3875p 0.001265084u 88.4p 0.001249093u 88.4125p 0.001232266u 88.425p 0.001214623u 88.4375p 0.001196184u 88.45p 0.001176971u 88.4625p 0.001157004u 88.475p 0.001136307u 88.4875p 0.0011149u 88.5p 0.001092808u
+ 88.5125p 0.001070052u 88.525p 0.001046657u 88.5375p 0.001022645u 88.55p 0.0009980417u 88.5625p 0.00097287u 88.575p 0.0009471546u 88.5875p 0.0009209201u 88.6p 0.0008941912u 88.6125p 0.0008669928u 88.625p 0.0008393499u 88.6375p 0.0008112875u 88.65p 0.0007828308u
+ 88.6625p 0.0007540049u 88.675p 0.0007248351u 88.6875p 0.0006953464u 88.7p 0.000665564u 88.7125p 0.000635513u 88.725p 0.0006052183u 88.7375p 0.0005747049u 88.75p 0.0005439975u 88.7625p 0.0005131206u 88.775p 0.0004820989u 88.7875p 0.0004509564u 88.8p 0.0004197172u
+ 88.8125p 0.0003884051u 88.825p 0.0003570438u 88.8375p 0.0003256565u 88.85p 0.0002942661u 88.8625p 0.0002628955u 88.875p 0.0002315671u 88.8875p 0.0002003028u 88.9p 0.0001691245u 88.9125p 0.0001380534u 88.925p 0.0001071106u 88.9375p 7.631664e-05u 88.95p 4.569176e-05u
+ 88.9625p 1.525575e-05u 88.975p -1.497205e-05u 88.9875p -4.497269e-05u 89p -7.472767e-05u 89.0125p -0.0001042189u 89.025p -0.0001334289u 89.0375p -0.0001623405u 89.05p -0.000190937u 89.0625p -0.0002192023u 89.075p -0.0002471206u 89.0875p -0.0002746768u 89.1p -0.0003018562u
+ 89.1125p -0.0003286445u 89.125p -0.000355028u 89.1375p -0.0003809935u 89.15p -0.0004065283u 89.1625p -0.0004316201u 89.175p -0.0004562573u 89.1875p -0.0004804285u 89.2p -0.0005041232u 89.2125p -0.000527331u 89.225p -0.0005500423u 89.2375p -0.0005722478u 89.25p -0.0005939388u
+ 89.2625p -0.000615107u 89.275p -0.0006357447u 89.2875p -0.0006558445u 89.3p -0.0006753997u 89.3125p -0.0006944038u 89.325p -0.000712851u 89.3375p -0.0007307359u 89.35p -0.0007480534u 89.3625p -0.000764799u 89.375p -0.0007809686u 89.3875p -0.0007965584u 89.4p -0.0008115653u
+ 89.4125p -0.0008259864u 89.425p -0.0008398192u 89.4375p -0.0008530615u 89.45p -0.0008657118u 89.4625p -0.0008777688u 89.475p -0.0008892314u 89.4875p -0.000900099u 89.5p -0.0009103716u 89.5125p -0.000920049u 89.525p -0.0009291319u 89.5375p -0.0009376208u 89.55p -0.0009455168u
+ 89.5625p -0.0009528213u 89.575p -0.000959536u 89.5875p -0.0009656626u 89.6p -0.0009712034u 89.6125p -0.0009761609u 89.625p -0.0009805377u 89.6375p -0.0009843367u 89.65p -0.0009875612u 89.6625p -0.0009902144u 89.675p -0.0009922999u 89.6875p -0.0009938216u 89.7p -0.0009947835u
+ 89.7125p -0.0009951897u 89.725p -0.0009950445u 89.7375p -0.0009943525u 89.75p -0.0009931183u 89.7625p -0.0009913468u 89.775p -0.0009890429u 89.7875p -0.0009862118u 89.8p -0.0009828587u 89.8125p -0.000978989u 89.825p -0.0009746081u 89.8375p -0.0009697217u 89.85p -0.0009643354u
+ 89.8625p -0.000958455u 89.875p -0.0009520864u 89.8875p -0.0009452357u 89.9p -0.0009379088u 89.9125p -0.0009301119u 89.925p -0.0009218512u 89.9375p -0.0009131331u 89.95p -0.0009039638u 89.9625p -0.0008943499u 89.975p -0.0008842977u 89.9875p -0.0008738138u 90p -0.0008629049u
+ 90.0125p -0.0008515775u 90.025p -0.0008398384u 90.0375p -0.0008276944u 90.05p -0.0008151522u 90.0625p -0.0008022187u 90.075p -0.0007889008u 90.0875p -0.0007752055u 90.1p -0.0007611397u 90.1125p -0.0007467105u 90.125p -0.0007319251u 90.1375p -0.0007167905u 90.15p -0.0007013139u
+ 90.1625p -0.0006855027u 90.175p -0.0006693641u 90.1875p -0.0006529054u 90.2p -0.0006361341u 90.2125p -0.0006190576u 90.225p -0.0006016835u 90.2375p -0.0005840193u 90.25p -0.0005660728u 90.2625p -0.0005478515u 90.275p -0.0005293633u 90.2875p -0.0005106161u 90.3p -0.0004916177u
+ 90.3125p -0.0004723763u 90.325p -0.0004528997u 90.3375p -0.0004331963u 90.35p -0.0004132742u 90.3625p -0.0003931418u 90.375p -0.0003728075u 90.3875p -0.0003522797u 90.4p -0.0003315672u 90.4125p -0.0003106786u 90.425p -0.0002896226u 90.4375p -0.0002684082u 90.45p -0.0002470445u
+ 90.4625p -0.0002255404u 90.475p -0.0002039052u 90.4875p -0.0001821482u 90.5p -0.0001602788u 90.5125p -0.0001383067u 90.525p -0.0001162414u 90.5375p -9.409267e-05u 90.55p -7.187046e-05u 90.5625p -4.958476e-05u 90.575p -2.724567e-05u 90.5875p -4.863424e-06u 90.6p 1.755161e-05u
+ 90.6125p 3.998899e-05u 90.625p 6.24381e-05u 90.6375p 8.488827e-05u 90.65p 0.0001073287u 90.6625p 0.0001297484u 90.675p 0.0001521364u 90.6875p 0.0001744815u 90.7p 0.0001967725u 90.7125p 0.000218998u 90.725p 0.0002411466u 90.7375p 0.0002632067u 90.75p 0.0002851666u
+ 90.7625p 0.0003070147u 90.775p 0.0003287391u 90.7875p 0.0003503279u 90.8p 0.000371769u 90.8125p 0.0003930506u 90.825p 0.0004141604u 90.8375p 0.0004350862u 90.85p 0.0004558159u 90.8625p 0.0004763372u 90.875p 0.0004966376u 90.8875p 0.000516705u 90.9p 0.0005365269u
+ 90.9125p 0.0005560909u 90.925p 0.0005753846u 90.9375p 0.0005943956u 90.95p 0.0006131116u 90.9625p 0.0006315201u 90.975p 0.0006496088u 90.9875p 0.0006673654u 91p 0.0006847776u 91.0125p 0.0007018332u 91.025p 0.0007185201u 91.0375p 0.0007348262u 91.05p 0.0007507395u
+ 91.0625p 0.0007662481u 91.075p 0.0007813403u 91.0875p 0.0007960045u 91.1p 0.000810229u 91.1125p 0.0008240025u 91.125p 0.0008373139u 91.1375p 0.000850152u 91.15p 0.0008625059u 91.1625p 0.0008743651u 91.175p 0.000885719u 91.1875p 0.0008965574u 91.2p 0.0009068702u
+ 91.2125p 0.0009166476u 91.225p 0.0009258801u 91.2375p 0.0009345584u 91.25p 0.0009426735u 91.2625p 0.0009502167u 91.275p 0.0009571796u 91.2875p 0.000963554u 91.3p 0.0009693323u 91.3125p 0.0009745068u 91.325p 0.0009790706u 91.3375p 0.0009830169u 91.35p 0.0009863394u
+ 91.3625p 0.0009890319u 91.375p 0.000991089u 91.3875p 0.0009925054u 91.4p 0.0009932763u 91.4125p 0.0009933973u 91.425p 0.0009928646u 91.4375p 0.0009916745u 91.45p 0.0009898242u 91.4625p 0.0009873108u 91.475p 0.0009841324u 91.4875p 0.0009802872u 91.5p 0.0009757741u
+ 91.5125p 0.0009705923u 91.525p 0.0009647417u 91.5375p 0.0009582226u 91.55p 0.0009510358u 91.5625p 0.0009431826u 91.575p 0.0009346648u 91.5875p 0.0009254848u 91.6p 0.0009156455u 91.6125p 0.0009051502u 91.625p 0.000894003u 91.6375p 0.0008822083u 91.65p 0.000869771u
+ 91.6625p 0.0008566968u 91.675p 0.0008429916u 91.6875p 0.0008286622u 91.7p 0.0008137157u 91.7125p 0.0007981597u 91.725p 0.0007820026u 91.7375p 0.0007652529u 91.75p 0.0007479201u 91.7625p 0.0007300139u 91.775p 0.0007115447u 91.7875p 0.0006925233u 91.8p 0.0006729611u
+ 91.8125p 0.0006528699u 91.825p 0.0006322621u 91.8375p 0.0006111505u 91.85p 0.0005895486u 91.8625p 0.0005674702u 91.875p 0.0005449294u 91.8875p 0.0005219412u 91.9p 0.0004985207u 91.9125p 0.0004746835u 91.925p 0.0004504458u 91.9375p 0.0004258241u 91.95p 0.0004008352u
+ 91.9625p 0.0003754965u 91.975p 0.0003498256u 91.9875p 0.0003238406u 92p 0.0002975599u 92.0125p 0.0002710023u 92.025p 0.0002441869u 92.0375p 0.000217133u 92.05p 0.0001898603u 92.0625p 0.0001623889u 92.075p 0.0001347388u 92.0875p 0.0001069307u 92.1p 7.89852e-05u
+ 92.1125p 5.092322e-05u 92.125p 2.276589e-05u 92.1375p -5.465511e-06u 92.15p -3.374952e-05u 92.1625p -6.206456e-05u 92.175p -9.038892e-05u 92.1875p -0.0001187008u 92.2p -0.0001469783u 92.2125p -0.0001751994u 92.225p -0.0002033423u 92.2375p -0.0002313848u 92.25p -0.0002593049u
+ 92.2625p -0.0002870807u 92.275p -0.0003146901u 92.2875p -0.0003421113u 92.3p -0.0003693225u 92.3125p -0.0003963019u 92.325p -0.0004230278u 92.3375p -0.0004494789u 92.35p -0.0004756338u 92.3625p -0.0005014714u 92.375p -0.0005269707u 92.3875p -0.0005521111u 92.4p -0.0005768721u
+ 92.4125p -0.0006012334u 92.425p -0.0006251752u 92.4375p -0.0006486777u 92.45p -0.0006717217u 92.4625p -0.0006942882u 92.475p -0.0007163585u 92.4875p -0.0007379144u 92.5p -0.0007589381u 92.5125p -0.000779412u 92.525p -0.0007993191u 92.5375p -0.0008186429u 92.55p -0.0008373672u
+ 92.5625p -0.0008554763u 92.575p -0.0008729551u 92.5875p -0.0008897888u 92.6p -0.0009059635u 92.6125p -0.0009214653u 92.625p -0.0009362813u 92.6375p -0.000950399u 92.65p -0.0009638064u 92.6625p -0.0009764921u 92.675p -0.0009884455u 92.6875p -0.0009996563u 92.7p -0.001010115u
+ 92.7125p -0.001019813u 92.725p -0.001028741u 92.7375p -0.001036893u 92.75p -0.001044261u 92.7625p -0.001050838u 92.775p -0.00105662u 92.7875p -0.001061601u 92.8p -0.001065777u 92.8125p -0.001069144u 92.825p -0.0010717u 92.8375p -0.001073442u 92.85p -0.001074368u
+ 92.8625p -0.001074478u 92.875p -0.001073771u 92.8875p -0.001072249u 92.9p -0.001069912u 92.9125p -0.001066762u 92.925p -0.001062802u 92.9375p -0.001058035u 92.95p -0.001052465u 92.9625p -0.001046097u 92.975p -0.001038935u 92.9875p -0.001030987u 93p -0.001022259u
+ 93.0125p -0.001012758u 93.025p -0.001002492u 93.0375p -0.0009914695u 93.05p -0.0009797001u 93.0625p -0.0009671938u 93.075p -0.0009539608u 93.0875p -0.0009400125u 93.1p -0.0009253605u 93.1125p -0.0009100171u 93.125p -0.0008939952u 93.1375p -0.0008773083u 93.15p -0.0008599705u
+ 93.1625p -0.0008419961u 93.175p -0.0008234004u 93.1875p -0.0008041989u 93.2p -0.0007844076u 93.2125p -0.0007640431u 93.225p -0.0007431223u 93.2375p -0.0007216629u 93.25p -0.0006996825u 93.2625p -0.0006771996u 93.275p -0.0006542327u 93.2875p -0.000630801u 93.3p -0.0006069239u
+ 93.3125p -0.0005826211u 93.325p -0.0005579127u 93.3375p -0.000532819u 93.35p -0.0005073609u 93.3625p -0.0004815591u 93.375p -0.0004554348u 93.3875p -0.0004290095u 93.4p -0.0004023047u 93.4125p -0.0003753423u 93.425p -0.0003481441u 93.4375p -0.0003207323u 93.45p -0.000293129u
+ 93.4625p -0.0002653566u 93.475p -0.0002374375u 93.4875p -0.0002093941u 93.5p -0.0001812489u 93.5125p -0.0001530245u 93.525p -0.0001247434u 93.5375p -9.642801e-05u 93.55p -6.810087e-05u 93.5625p -3.978438e-05u 93.575p -1.150083e-05u 93.5875p 1.672754e-05u 93.6p 4.487863e-05u
+ 93.6125p 7.293049e-05u 93.625p 0.0001008613u 93.6375p 0.0001286494u 93.65p 0.0001562734u 93.6625p 0.0001837121u 93.675p 0.0002109445u 93.6875p 0.0002379498u 93.7p 0.0002647076u 93.7125p 0.0002911976u 93.725p 0.0003174u 93.7375p 0.0003432952u 93.75p 0.000368864u
+ 93.7625p 0.0003940875u 93.775p 0.0004189471u 93.7875p 0.0004434247u 93.8p 0.0004675025u 93.8125p 0.0004911631u 93.825p 0.0005143897u 93.8375p 0.0005371657u 93.85p 0.0005594751u 93.8625p 0.0005813022u 93.875p 0.0006026319u 93.8875p 0.0006234495u 93.9p 0.0006437409u
+ 93.9125p 0.0006634924u 93.925p 0.0006826908u 93.9375p 0.0007013235u 93.95p 0.0007193782u 93.9625p 0.0007368435u 93.975p 0.0007537082u 93.9875p 0.0007699618u 94p 0.0007855944u 94.0125p 0.0008005965u 94.025p 0.0008149592u 94.0375p 0.0008286743u 94.05p 0.0008417341u
+ 94.0625p 0.0008541313u 94.075p 0.0008658594u 94.0875p 0.0008769123u 94.1p 0.0008872847u 94.1125p 0.0008969716u 94.125p 0.0009059689u 94.1375p 0.0009142727u 94.15p 0.0009218799u 94.1625p 0.000928788u 94.175p 0.0009349949u 94.1875p 0.0009404994u 94.2p 0.0009453004u
+ 94.2125p 0.0009493978u 94.225p 0.0009527917u 94.2375p 0.000955483u 94.25p 0.0009574731u 94.2625p 0.0009587639u 94.275p 0.0009593578u 94.2875p 0.0009592578u 94.3p 0.0009584675u 94.3125p 0.0009569908u 94.325p 0.0009548323u 94.3375p 0.000951997u 94.35p 0.0009484905u
+ 94.3625p 0.0009443187u 94.375p 0.0009394882u 94.3875p 0.0009340059u 94.4p 0.0009278792u 94.4125p 0.0009211161u 94.425p 0.0009137247u 94.4375p 0.0009057138u 94.45p 0.0008970926u 94.4625p 0.0008878705u 94.475p 0.0008780576u 94.4875p 0.0008676641u 94.5p 0.0008567007u
+ 94.5125p 0.0008451785u 94.525p 0.0008331087u 94.5375p 0.0008205032u 94.55p 0.0008073739u 94.5625p 0.0007937332u 94.575p 0.0007795938u 94.5875p 0.0007649684u 94.6p 0.0007498703u 94.6125p 0.0007343129u 94.625p 0.0007183099u 94.6375p 0.0007018752u 94.65p 0.0006850228u
+ 94.6625p 0.0006677672u 94.675p 0.0006501226u 94.6875p 0.000632104u 94.7p 0.0006137259u 94.7125p 0.0005950036u 94.725p 0.0005759519u 94.7375p 0.0005565862u 94.75p 0.0005369219u 94.7625p 0.0005169742u 94.775p 0.0004967588u 94.7875p 0.0004762913u 94.8p 0.0004555872u
+ 94.8125p 0.0004346622u 94.825p 0.0004135321u 94.8375p 0.0003922125u 94.85p 0.0003707192u 94.8625p 0.000349068u 94.875p 0.0003272746u 94.8875p 0.0003053545u 94.9p 0.0002833235u 94.9125p 0.0002611972u 94.925p 0.0002389911u 94.9375p 0.0002167206u 94.95p 0.0001944012u
+ 94.9625p 0.0001720481u 94.975p 0.0001496764u 94.9875p 0.0001273012u 95p 0.0001049376u 95.0125p 8.260019e-05u 95.025p 6.030375e-05u 95.0375p 3.806276e-05u 95.05p 1.58916e-05u 95.0625p -6.195565e-06u 95.075p -2.818471e-05u 95.0875p -5.0062e-05u 95.1p -7.18138e-05u
+ 95.1125p -9.342666e-05u 95.125p -0.0001148873u 95.1375p -0.0001361828u 95.15p -0.0001573002u 95.1625p -0.0001782271u 95.175p -0.0001989509u 95.1875p -0.0002194596u 95.2p -0.0002397413u 95.2125p -0.0002597844u 95.225p -0.0002795774u 95.2375p -0.0002991092u 95.25p -0.0003183689u
+ 95.2625p -0.0003373458u 95.275p -0.0003560297u 95.2875p -0.0003744104u 95.3p -0.000392478u 95.3125p -0.0004102231u 95.325p -0.0004276363u 95.3375p -0.0004447086u 95.35p -0.0004614314u 95.3625p -0.0004777961u 95.375p -0.0004937945u 95.3875p -0.000509419u 95.4p -0.0005246617u
+ 95.4125p -0.0005395155u 95.425p -0.0005539732u 95.4375p -0.0005680283u 95.45p -0.0005816742u 95.4625p -0.0005949047u 95.475p -0.000607714u 95.4875p -0.0006200966u 95.5p -0.0006320471u 95.5125p -0.0006435605u 95.525p -0.0006546322u 95.5375p -0.0006652575u 95.55p -0.0006754325u
+ 95.5625p -0.0006851532u 95.575p -0.0006944161u 95.5875p -0.0007032177u 95.6p -0.0007115552u 95.6125p -0.0007194257u 95.625p -0.0007268267u 95.6375p -0.0007337561u 95.65p -0.0007402118u 95.6625p -0.0007461923u 95.675p -0.000751696u 95.6875p -0.000756722u 95.7p -0.0007612692u
+ 95.7125p -0.000765337u 95.725p -0.0007689252u 95.7375p -0.0007720335u 95.75p -0.0007746621u 95.7625p -0.0007768114u 95.775p -0.000778482u 95.7875p -0.0007796748u 95.8p -0.000780391u 95.8125p -0.0007806318u 95.825p -0.0007803988u 95.8375p -0.0007796939u 95.85p -0.0007785192u
+ 95.8625p -0.0007768768u 95.875p -0.0007747694u 95.8875p -0.0007721995u 95.9p -0.0007691702u 95.9125p -0.0007656846u 95.925p -0.0007617461u 95.9375p -0.0007573582u 95.95p -0.0007525248u 95.9625p -0.0007472497u 95.975p -0.0007415373u 95.9875p -0.0007353918u 96p -0.0007288179u
+ 96.0125p -0.0007218202u 96.025p -0.0007144039u 96.0375p -0.0007065739u 96.05p -0.0006983358u 96.0625p -0.0006896948u 96.075p -0.0006806568u 96.0875p -0.0006712276u 96.1p -0.0006614132u 96.1125p -0.0006512199u 96.125p -0.000640654u 96.1375p -0.000629722u 96.15p -0.0006184306u
+ 96.1625p -0.0006067867u 96.175p -0.0005947974u 96.1875p -0.0005824697u 96.2p -0.000569811u 96.2125p -0.0005568287u 96.225p -0.0005435305u 96.2375p -0.0005299241u 96.25p -0.0005160174u 96.2625p -0.0005018185u 96.275p -0.0004873354u 96.2875p -0.0004725765u 96.3p -0.0004575502u
+ 96.3125p -0.000442265u 96.325p -0.0004267297u 96.3375p -0.000410953u 96.35p -0.0003949438u 96.3625p -0.0003787111u 96.375p -0.0003622642u 96.3875p -0.0003456121u 96.4p -0.0003287643u 96.4125p -0.0003117302u 96.425p -0.0002945194u 96.4375p -0.0002771415u 96.45p -0.0002596063u
+ 96.4625p -0.0002419235u 96.475p -0.000224103u 96.4875p -0.000206155u 96.5p -0.0001880894u 96.5125p -0.0001699164u 96.525p -0.0001516462u 96.5375p -0.0001332891u 96.55p -0.0001148554u 96.5625p -9.635565e-05u 96.575p -7.780017e-05u 96.5875p -5.919953e-05u 96.6p -4.05643e-05u
+ 96.6125p -2.190508e-05u 96.625p -3.232534e-06u 96.6375p 1.544267e-05u 96.65p 3.41098e-05u 96.6625p 5.275814e-05u 96.675p 7.13769e-05u 96.6875p 8.995532e-05u 96.7p 0.0001084826u 96.7125p 0.000126948u 96.725p 0.0001453406u 96.7375p 0.0001636496u 96.75p 0.0001818644u
+ 96.7625p 0.0001999741u 96.775p 0.0002179679u 96.7875p 0.0002358352u 96.8p 0.0002535652u 96.8125p 0.0002711472u 96.825p 0.0002885707u 96.8375p 0.000305825u 96.85p 0.0003228997u 96.8625p 0.0003397842u 96.875p 0.0003564682u 96.8875p 0.0003729413u 96.9p 0.0003891934u
+ 96.9125p 0.0004052141u 96.925p 0.0004209935u 96.9375p 0.0004365216u 96.95p 0.0004517884u 96.9625p 0.0004667842u 96.975p 0.0004814994u 96.9875p 0.0004959244u 97p 0.0005100497u 97.0125p 0.0005238662u 97.025p 0.0005373647u 97.0375p 0.0005505362u 97.05p 0.0005633719u
+ 97.0625p 0.000575863u 97.075p 0.0005880012u 97.0875p 0.000599778u 97.1p 0.0006111853u 97.1125p 0.0006222152u 97.125p 0.0006328598u 97.1375p 0.0006431116u 97.15p 0.0006529633u 97.1625p 0.0006624076u 97.175p 0.0006714377u 97.1875p 0.0006800468u 97.2p 0.0006882285u
+ 97.2125p 0.0006959764u 97.225p 0.0007032847u 97.2375p 0.0007101476u 97.25p 0.0007165595u 97.2625p 0.0007225152u 97.275p 0.0007280098u 97.2875p 0.0007330386u 97.3p 0.000737597u 97.3125p 0.0007416811u 97.325p 0.000745287u 97.3375p 0.000748411u 97.35p 0.0007510499u
+ 97.3625p 0.0007532008u 97.375p 0.000754861u 97.3875p 0.0007560282u 97.4p 0.0007567003u 97.4125p 0.0007568755u 97.425p 0.0007565526u 97.4375p 0.0007557305u 97.45p 0.0007544083u 97.4625p 0.0007525857u 97.475p 0.0007502627u 97.4875p 0.0007474394u 97.5p 0.0007441165u
+ 97.5125p 0.0007402948u 97.525p 0.0007359758u 97.5375p 0.000731161u 97.55p 0.0007258524u 97.5625p 0.0007200522u 97.575p 0.0007137633u 97.5875p 0.0007069885u 97.6p 0.0006997312u 97.6125p 0.0006919952u 97.625p 0.0006837844u 97.6375p 0.0006751034u 97.65p 0.0006659568u
+ 97.6625p 0.0006563497u 97.675p 0.0006462876u 97.6875p 0.0006357762u 97.7p 0.0006248216u 97.7125p 0.0006134304u 97.725p 0.0006016092u 97.7375p 0.0005893653u 97.75p 0.0005767059u 97.7625p 0.000563639u 97.775p 0.0005501726u 97.7875p 0.0005363151u 97.8p 0.0005220752u
+ 97.8125p 0.0005074619u 97.825p 0.0004924846u 97.8375p 0.0004771529u 97.85p 0.0004614767u 97.8625p 0.0004454661u 97.875p 0.0004291317u 97.8875p 0.0004124843u 97.9p 0.0003955347u 97.9125p 0.0003782943u 97.925p 0.0003607746u 97.9375p 0.0003429874u 97.95p 0.0003249446u
+ 97.9625p 0.0003066586u 97.975p 0.0002881416u 97.9875p 0.0002694065u 98p 0.0002504659u 98.0125p 0.0002313331u 98.025p 0.0002120211u 98.0375p 0.0001925435u 98.05p 0.0001729138u 98.0625p 0.0001531456u 98.075p 0.0001332529u 98.0875p 0.0001132497u 98.1p 9.315006e-05u
+ 98.1125p 7.296822e-05u 98.125p 5.271853e-05u 98.1375p 3.24154e-05u 98.15p 1.207335e-05u 98.1625p -8.293065e-06u 98.175p -2.866921e-05u 98.1875p -4.904041e-05u 98.2p -6.939195e-05u 98.2125p -8.970912e-05u 98.225p -0.0001099772u 98.2375p -0.0001301813u 98.25p -0.0001503069u
+ 98.2625p -0.0001703392u 98.275p -0.0001902636u 98.2875p -0.0002100653u 98.3p -0.00022973u 98.3125p -0.000249243u 98.325p -0.00026859u 98.3375p -0.0002877566u 98.35p -0.0003067288u 98.3625p -0.0003254923u 98.375p -0.0003440333u 98.3875p -0.000362338u 98.4p -0.0003803927u
+ 98.4125p -0.0003981838u 98.425p -0.0004156982u 98.4375p -0.0004329227u 98.45p -0.0004498444u 98.4625p -0.0004664506u 98.475p -0.0004827287u 98.4875p -0.0004986666u 98.5p -0.0005142522u 98.5125p -0.0005294737u 98.525p -0.0005443197u 98.5375p -0.000558779u 98.55p -0.0005728406u
+ 98.5625p -0.0005864938u 98.575p -0.0005997284u 98.5875p -0.0006125342u 98.6p -0.0006249016u 98.6125p -0.0006368212u 98.625p -0.0006482839u 98.6375p -0.000659281u 98.65p -0.0006698042u 98.6625p -0.0006798454u 98.675p -0.000689397u 98.6875p -0.0006984518u 98.7p -0.0007070029u
+ 98.7125p -0.0007150437u 98.725p -0.0007225683u 98.7375p -0.0007295707u 98.75p -0.0007360459u 98.7625p -0.0007419888u 98.775p -0.000747395u 98.7875p -0.0007522603u 98.8p -0.0007565812u 98.8125p -0.0007603544u 98.825p -0.0007635771u 98.8375p -0.0007662468u 98.85p -0.0007683617u
+ 98.8625p -0.0007699203u 98.875p -0.0007709213u 98.8875p -0.0007713642u 98.9p -0.0007712488u 98.9125p -0.0007705752u 98.925p -0.0007693441u 98.9375p -0.0007675566u 98.95p -0.0007652142u 98.9625p -0.0007623188u 98.975p -0.0007588729u 98.9875p -0.0007548792u 99p -0.0007503409u
+ 99.0125p -0.0007452618u 99.025p -0.0007396458u 99.0375p -0.0007334975u 99.05p -0.0007268218u 99.0625p -0.000719624u 99.075p -0.0007119098u 99.0875p -0.0007036853u 99.1p -0.0006949571u 99.1125p -0.000685732u 99.125p -0.0006760174u 99.1375p -0.0006658208u 99.15p -0.0006551504u
+ 99.1625p -0.0006440145u 99.175p -0.0006324218u 99.1875p -0.0006203815u 99.2p -0.0006079029u 99.2125p -0.0005949959u 99.225p -0.0005816706u 99.2375p -0.0005679373u 99.25p -0.0005538068u 99.2625p -0.00053929u 99.275p -0.0005243983u 99.2875p -0.0005091433u 99.3p -0.0004935367u
+ 99.3125p -0.0004775907u 99.325p -0.0004613176u 99.3375p -0.0004447301u 99.35p -0.0004278409u 99.3625p -0.000410663u 99.375p -0.0003932097u 99.3875p -0.0003754944u 99.4p -0.0003575306u 99.4125p -0.0003393323u 99.425p -0.0003209132u 99.4375p -0.0003022876u 99.45p -0.0002834695u
+ 99.4625p -0.0002644734u 99.475p -0.0002453136u 99.4875p -0.0002260048u 99.5p -0.0002065615u 99.5125p -0.0001869985u 99.525p -0.0001673306u 99.5375p -0.0001475725u 99.55p -0.0001277391u 99.5625p -0.0001078453u 99.575p -8.790605e-05u 99.5875p -6.793618e-05u 99.6p -4.795061e-05u
+ 99.6125p -2.796421e-05u 99.625p -7.991802e-06u 99.6375p 1.195182e-05u 99.65p 3.185192e-05u 99.6625p 5.169385e-05u 99.675p 7.146302e-05u 99.6875p 9.114496e-05u 99.7p 0.0001107253u 99.7125p 0.0001301897u 99.725p 0.0001495241u 99.7375p 0.0001687145u 99.75p 0.0001877471u
+ 99.7625p 0.0002066081u 99.775p 0.0002252839u 99.7875p 0.0002437614u 99.8p 0.0002620273u 99.8125p 0.0002800687u 99.825p 0.0002978728u 99.8375p 0.0003154271u 99.85p 0.0003327194u 99.8625p 0.0003497375u 99.875p 0.0003664696u 99.8875p 0.0003829043u 99.9p 0.0003990301u
+ 99.9125p 0.0004148361u 99.925p 0.0004303116u 99.9375p 0.0004454461u 99.95p 0.0004602293u 99.9625p 0.0004746515u 99.975p 0.0004887031u 99.9875p 0.0005023748u 100p 0.0005156578u 100.0125p 0.0005285433u 100.025p 0.0005410232u 100.0375p 0.0005530895u 100.05p 0.0005647345u
+ 100.0625p 0.0005759511u 100.075p 0.0005867323u 100.0875p 0.0005970715u 100.1p 0.0006069627u 100.1125p 0.0006163998u 100.125p 0.0006253774u 100.1375p 0.0006338905u 100.15p 0.0006419342u 100.1625p 0.0006495042u 100.175p 0.0006565965u 100.1875p 0.0006632073u 100.2p 0.0006693335u
+ 100.2125p 0.0006749721u 100.225p 0.0006801206u 100.2375p 0.0006847768u 100.25p 0.000688939u 100.2625p 0.0006926058u 100.275p 0.000695776u 100.2875p 0.0006984491u 100.3p 0.0007006246u 100.3125p 0.0007023028u 100.325p 0.000703484u 100.3375p 0.000704169u 100.35p 0.0007043589u
+ 100.3625p 0.0007040553u 100.375p 0.00070326u 100.3875p 0.0007019752u 100.4p 0.0007002035u 100.4125p 0.0006979478u 100.425p 0.0006952113u 100.4375p 0.0006919975u 100.45p 0.0006883105u 100.4625p 0.0006841543u 100.475p 0.0006795336u 100.4875p 0.0006744532u 100.5p 0.0006689183u
+ 100.5125p 0.0006629343u 100.525p 0.000656507u 100.5375p 0.0006496425u 100.55p 0.0006423471u 100.5625p 0.0006346274u 100.575p 0.0006264904u 100.5875p 0.0006179431u 100.6p 0.000608993u 100.6125p 0.0005996478u 100.625p 0.0005899154u 100.6375p 0.0005798038u 100.65p 0.0005693216u
+ 100.6625p 0.0005584773u 100.675p 0.0005472797u 100.6875p 0.0005357378u 100.7p 0.0005238608u 100.7125p 0.0005116582u 100.725p 0.0004991395u 100.7375p 0.0004863145u 100.75p 0.0004731932u 100.7625p 0.0004597856u 100.775p 0.000446102u 100.7875p 0.0004321527u 100.8p 0.0004179482u
+ 100.8125p 0.0004034993u 100.825p 0.0003888166u 100.8375p 0.000373911u 100.85p 0.0003587936u 100.8625p 0.0003434752u 100.875p 0.0003279672u 100.8875p 0.0003122806u 100.9p 0.0002964269u 100.9125p 0.0002804172u 100.925p 0.0002642631u 100.9375p 0.0002479759u 100.95p 0.0002315672u
+ 100.9625p 0.0002150483u 100.975p 0.0001984309u 100.9875p 0.0001817264u 101p 0.0001649464u 101.0125p 0.0001481024u 101.025p 0.0001312059u 101.0375p 0.0001142684u 101.05p 9.730131e-05u 101.0625p 8.031609e-05u 101.075p 6.33241e-05u 101.0875p 4.633668e-05u 101.1p 2.936509e-05u
+ 101.1125p 1.242054e-05u 101.125p -4.485842e-06u 101.1375p -2.1343e-05u 101.15p -3.813997e-05u 101.1625p -5.486587e-05u 101.175p -7.150992e-05u 101.1875p -8.806146e-05u 101.2p -0.0001045099u 101.2125p -0.0001208448u 101.225p -0.0001370559u 101.2375p -0.000153133u 101.25p -0.0001690659u
+ 101.2625p -0.0001848448u 101.275p -0.0002004599u 101.2875p -0.0002159016u 101.3p -0.0002311604u 101.3125p -0.000246227u 101.325p -0.0002610923u 101.3375p -0.0002757472u 101.35p -0.000290183u 101.3625p -0.0003043911u 101.375p -0.0003183631u 101.3875p -0.0003320906u 101.4p -0.0003455656u
+ 101.4125p -0.0003587802u 101.425p -0.0003717269u 101.4375p -0.0003843981u 101.45p -0.0003967865u 101.4625p -0.0004088851u 101.475p -0.0004206871u 101.4875p -0.0004321859u 101.5p -0.0004433749u 101.5125p -0.0004542481u 101.525p -0.0004647994u 101.5375p -0.0004750231u 101.55p -0.0004849137u
+ 101.5625p -0.0004944659u 101.575p -0.0005036746u 101.5875p -0.000512535u 101.6p -0.0005210425u 101.6125p -0.0005291926u 101.625p -0.0005369814u 101.6375p -0.0005444048u 101.65p -0.0005514592u 101.6625p -0.0005581412u 101.675p -0.0005644476u 101.6875p -0.0005703754u 101.7p -0.0005759221u
+ 101.7125p -0.0005810849u 101.725p -0.0005858619u 101.7375p -0.0005902509u 101.75p -0.0005942503u 101.7625p -0.0005978584u 101.775p -0.0006010741u 101.7875p -0.0006038964u 101.8p -0.0006063244u 101.8125p -0.0006083575u 101.825p -0.0006099956u 101.8375p -0.0006112384u 101.85p -0.0006120862u
+ 101.8625p -0.0006125393u 101.875p -0.0006125984u 101.8875p -0.0006122644u 101.9p -0.0006115383u 101.9125p -0.0006104214u 101.925p -0.0006089153u 101.9375p -0.0006070218u 101.95p -0.0006047428u 101.9625p -0.0006020806u 101.975p -0.0005990376u 101.9875p -0.0005956164u 102p -0.00059182u
+ 102.0125p -0.0005876515u 102.025p -0.000583114u 102.0375p -0.0005782112u 102.05p -0.0005729467u 102.0625p -0.0005673245u 102.075p -0.0005613487u 102.0875p -0.0005550235u 102.1p -0.0005483536u 102.1125p -0.0005413435u 102.125p -0.0005339983u 102.1375p -0.0005263229u 102.15p -0.0005183227u
+ 102.1625p -0.0005100031u 102.175p -0.0005013698u 102.1875p -0.0004924284u 102.2p -0.0004831851u 102.2125p -0.0004736459u 102.225p -0.0004638171u 102.2375p -0.0004537052u 102.25p -0.0004433168u 102.2625p -0.0004326587u 102.275p -0.0004217378u 102.2875p -0.0004105612u 102.3p -0.0003991361u
+ 102.3125p -0.0003874697u 102.325p -0.0003755697u 102.3375p -0.0003634435u 102.35p -0.000351099u 102.3625p -0.0003385439u 102.375p -0.0003257863u 102.3875p -0.0003128342u 102.4p -0.0002996959u 102.4125p -0.0002863796u 102.425p -0.0002728936u 102.4375p -0.0002592466u 102.45p -0.000245447u
+ 102.4625p -0.0002315036u 102.475p -0.000217425u 102.4875p -0.0002032202u 102.5p -0.0001888979u 102.5125p -0.0001744672u 102.525p -0.0001599371u 102.5375p -0.0001453166u 102.55p -0.0001306149u 102.5625p -0.0001158411u 102.575p -0.0001010045u 102.5875p -8.611441e-05u 102.6p -7.118e-05u
+ 102.6125p -5.621064e-05u 102.625p -4.121566e-05u 102.6375p -2.620442e-05u 102.65p -1.118629e-05u 102.6625p 3.829363e-06u 102.675p 1.883315e-05u 102.6875p 3.38157e-05u 102.7p 4.876766e-05u 102.7125p 6.367966e-05u 102.725p 7.854239e-05u 102.7375p 9.334653e-05u 102.75p 0.0001080828u
+ 102.7625p 0.000122742u 102.775p 0.0001373148u 102.7875p 0.0001517923u 102.8p 0.0001661651u 102.8125p 0.0001804243u 102.825p 0.000194561u 102.8375p 0.0002085661u 102.85p 0.0002224309u 102.8625p 0.0002361465u 102.875p 0.0002497043u 102.8875p 0.0002630958u 102.9p 0.0002763123u
+ 102.9125p 0.0002893454u 102.925p 0.000302187u 102.9375p 0.0003148288u 102.95p 0.0003272626u 102.9625p 0.0003394806u 102.975p 0.0003514749u 102.9875p 0.0003632378u 103p 0.0003747618u 103.0125p 0.0003860393u 103.025p 0.0003970631u 103.0375p 0.0004078261u 103.05p 0.0004183213u
+ 103.0625p 0.0004285419u 103.075p 0.0004384811u 103.0875p 0.0004481325u 103.1p 0.0004574897u 103.1125p 0.0004665466u 103.125p 0.0004752973u 103.1375p 0.0004837359u 103.15p 0.0004918568u 103.1625p 0.0004996546u 103.175p 0.0005071242u 103.1875p 0.0005142605u 103.2p 0.0005210586u
+ 103.2125p 0.0005275141u 103.225p 0.0005336225u 103.2375p 0.0005393796u 103.25p 0.0005447816u 103.2625p 0.0005498245u 103.275p 0.0005545051u 103.2875p 0.0005588199u 103.3p 0.000562766u 103.3125p 0.0005663404u 103.325p 0.0005695407u 103.3375p 0.0005723645u 103.35p 0.0005748096u
+ 103.3625p 0.0005768743u 103.375p 0.0005785569u 103.3875p 0.000579856u 103.4p 0.0005807705u 103.4125p 0.0005812996u 103.425p 0.0005814426u 103.4375p 0.0005811992u 103.45p 0.0005805692u 103.4625p 0.0005795528u 103.475p 0.0005781504u 103.4875p 0.0005763626u 103.5p 0.0005741903u
+ 103.5125p 0.0005716347u 103.525p 0.0005686973u 103.5375p 0.0005653796u 103.55p 0.0005616837u 103.5625p 0.0005576116u 103.575p 0.0005531659u 103.5875p 0.0005483492u 103.6p 0.0005431645u 103.6125p 0.000537615u 103.625p 0.0005317042u 103.6375p 0.0005254356u 103.65p 0.0005188134u
+ 103.6625p 0.0005118416u 103.675p 0.0005045247u 103.6875p 0.0004968673u 103.7p 0.0004888745u 103.7125p 0.0004805513u 103.725p 0.0004719031u 103.7375p 0.0004629355u 103.75p 0.0004536544u 103.7625p 0.0004440658u 103.775p 0.000434176u 103.7875p 0.0004239915u 103.8p 0.0004135191u
+ 103.8125p 0.0004027655u 103.825p 0.000391738u 103.8375p 0.0003804438u 103.85p 0.0003688906u 103.8625p 0.0003570859u 103.875p 0.0003450377u 103.8875p 0.0003327541u 103.9p 0.0003202432u 103.9125p 0.0003075135u 103.925p 0.0002945737u 103.9375p 0.0002814323u 103.95p 0.0002680984u
+ 103.9625p 0.0002545809u 103.975p 0.0002408891u 103.9875p 0.0002270322u 104p 0.0002130197u 104.0125p 0.0001988612u 104.025p 0.0001845663u 104.0375p 0.0001701448u 104.05p 0.0001556066u 104.0625p 0.0001409617u 104.075p 0.0001262202u 104.0875p 0.0001113922u 104.1p 9.648792e-05u
+ 104.1125p 8.15177e-05u 104.125p 6.649188e-05u 104.1375p 5.142085e-05u 104.15p 3.631507e-05u 104.1625p 2.118502e-05u 104.175p 6.041225e-06u 104.1875p -9.105781e-06u 104.2p -2.424545e-05u 104.2125p -3.936721e-05u 104.225p -5.446052e-05u 104.2375p -6.951483e-05u 104.25p -8.45196e-05u
+ 104.2625p -9.946432e-05u 104.275p -0.0001143385u 104.2875p -0.0001291318u 104.3p -0.0001438337u 104.3125p -0.0001584339u 104.325p -0.0001729222u 104.3375p -0.0001872884u 104.35p -0.0002015223u 104.3625p -0.0002156139u 104.375p -0.0002295532u 104.3875p -0.0002433305u 104.4p -0.000256936u
+ 104.4125p -0.0002703601u 104.425p -0.0002835933u 104.4375p -0.0002966262u 104.45p -0.0003094497u 104.4625p -0.0003220545u 104.475p -0.0003344319u 104.4875p -0.000346573u 104.5p -0.0003584693u 104.5125p -0.0003701123u 104.525p -0.0003814937u 104.5375p -0.0003926056u 104.55p -0.00040344u
+ 104.5625p -0.0004139892u 104.575p -0.0004242458u 104.5875p -0.0004342025u 104.6p -0.0004438522u 104.6125p -0.0004531882u 104.625p -0.0004622038u 104.6375p -0.0004708927u 104.65p -0.0004792487u 104.6625p -0.0004872658u 104.675p -0.0004949386u 104.6875p -0.0005022615u 104.7p -0.0005092294u
+ 104.7125p -0.0005158374u 104.725p -0.0005220809u 104.7375p -0.0005279555u 104.75p -0.0005334572u 104.7625p -0.000538582u 104.775p -0.0005433265u 104.7875p -0.0005476874u 104.8p -0.0005516617u 104.8125p -0.0005552467u 104.825p -0.00055844u 104.8375p -0.0005612393u 104.85p -0.000563643u
+ 104.8625p -0.0005656494u 104.875p -0.0005672573u 104.8875p -0.0005684656u 104.9p -0.0005692738u 104.9125p -0.0005696813u 104.925p -0.0005696882u 104.9375p -0.0005692947u 104.95p -0.0005685012u 104.9625p -0.0005673085u 104.975p -0.0005657176u 104.9875p -0.0005637301u 105p -0.0005613475u
+ 105.0125p -0.0005585718u 105.025p -0.0005554052u 105.0375p -0.0005518503u 105.05p -0.0005479099u 105.0625p -0.000543587u 105.075p -0.0005388851u 105.0875p -0.0005338078u 105.1p -0.000528359u 105.1125p -0.0005225429u 105.125p -0.000516364u 105.1375p -0.0005098269u 105.15p -0.0005029368u
+ 105.1625p -0.0004956988u 105.175p -0.0004881184u 105.1875p -0.0004802013u 105.2p -0.0004719536u 105.2125p -0.0004633815u 105.225p -0.0004544914u 105.2375p -0.00044529u 105.25p -0.0004357842u 105.2625p -0.0004259811u 105.275p -0.0004158881u 105.2875p -0.0004055127u 105.3p -0.0003948627u
+ 105.3125p -0.000383946u 105.325p -0.0003727706u 105.3375p -0.000361345u 105.35p -0.0003496776u 105.3625p -0.000337777u 105.375p -0.000325652u 105.3875p -0.0003133116u 105.4p -0.000300765u 105.4125p -0.0002880213u 105.425p -0.0002750899u 105.4375p -0.0002619804u 105.45p -0.0002487023u
+ 105.4625p -0.0002352655u 105.475p -0.0002216797u 105.4875p -0.0002079548u 105.5p -0.000194101u 105.5125p -0.0001801282u 105.525p -0.0001660467u 105.5375p -0.0001518667u 105.55p -0.0001375985u 105.5625p -0.0001232525u 105.575p -0.0001088389u 105.5875p -9.436832e-05u 105.6p -7.985109e-05u
+ 105.6125p -6.529768e-05u 105.625p -5.071856e-05u 105.6375p -3.61242e-05u 105.65p -2.152505e-05u 105.6625p -6.931562e-06u 105.675p 7.64585e-06u 105.6875p 2.21968e-05u 105.7p 3.671093e-05u 105.7125p 5.117794e-05u 105.725p 6.558757e-05u 105.7375p 7.992965e-05u 105.75p 9.419404e-05u
+ 105.7625p 0.0001083707u 105.775p 0.0001224497u 105.7875p 0.0001364211u 105.8p 0.0001502753u 105.8125p 0.0001640024u 105.825p 0.000177593u 105.8375p 0.0001910376u 105.85p 0.000204327u 105.8625p 0.0002174519u 105.875p 0.0002304033u 105.8875p 0.0002431723u 105.9p 0.0002557503u
+ 105.9125p 0.0002681285u 105.925p 0.0002802987u 105.9375p 0.0002922525u 105.95p 0.0003039819u 105.9625p 0.0003154789u 105.975p 0.000326736u 105.9875p 0.0003377456u 106p 0.0003485004u 106.0125p 0.0003589932u 106.025p 0.0003692172u 106.0375p 0.0003791656u 106.05p 0.0003888321u
+ 106.0625p 0.0003982102u 106.075p 0.0004072941u 106.0875p 0.0004160778u 106.1p 0.0004245559u 106.1125p 0.0004327229u 106.125p 0.0004405737u 106.1375p 0.0004481036u 106.15p 0.0004553078u 106.1625p 0.000462182u 106.175p 0.000468722u 106.1875p 0.000474924u 106.2p 0.0004807844u
+ 106.2125p 0.0004862997u 106.225p 0.0004914669u 106.2375p 0.000496283u 106.25p 0.0005007456u 106.2625p 0.0005048522u 106.275p 0.0005086007u 106.2875p 0.0005119894u 106.3p 0.0005150167u 106.3125p 0.0005176812u 106.325p 0.000519982u 106.3375p 0.0005219182u 106.35p 0.0005234894u
+ 106.3625p 0.0005246953u 106.375p 0.0005255358u 106.3875p 0.0005260113u 106.4p 0.0005261223u 106.4125p 0.0005258695u 106.425p 0.000525254u 106.4375p 0.0005242771u 106.45p 0.0005229402u 106.4625p 0.0005212452u 106.475p 0.0005191941u 106.4875p 0.0005167892u 106.5p 0.000514033u
+ 106.5125p 0.0005109283u 106.525p 0.0005074779u 106.5375p 0.0005036853u 106.55p 0.0004995537u 106.5625p 0.000495087u 106.575p 0.0004902889u 106.5875p 0.0004851637u 106.6p 0.0004797156u 106.6125p 0.0004739492u 106.625p 0.0004678693u 106.6375p 0.0004614809u 106.65p 0.000454789u
+ 106.6625p 0.0004477991u 106.675p 0.0004405167u 106.6875p 0.0004329474u 106.7p 0.0004250974u 106.7125p 0.0004169725u 106.725p 0.0004085792u 106.7375p 0.0003999237u 106.75p 0.0003910127u 106.7625p 0.000381853u 106.775p 0.0003724514u 106.7875p 0.0003628149u 106.8p 0.0003529508u
+ 106.8125p 0.0003428663u 106.825p 0.0003325689u 106.8375p 0.0003220662u 106.85p 0.0003113657u 106.8625p 0.0003004754u 106.875p 0.0002894031u 106.8875p 0.0002781567u 106.9p 0.0002667444u 106.9125p 0.0002551744u 106.925p 0.0002434548u 106.9375p 0.0002315941u 106.95p 0.0002196006u
+ 106.9625p 0.0002074828u 106.975p 0.0001952492u 106.9875p 0.0001829084u 107p 0.000170469u 107.0125p 0.0001579397u 107.025p 0.0001453291u 107.0375p 0.000132646u 107.05p 0.000119899u 107.0625p 0.0001070971u 107.075p 9.424884e-05u 107.0875p 8.13631e-05u 107.1p 6.844863e-05u
+ 107.1125p 5.551418e-05u 107.125p 4.256849e-05u 107.1375p 2.96203e-05u 107.15p 1.66783e-05u 107.1625p 3.751158e-06u 107.175p -9.152488e-06u 107.1875p -2.202405e-05u 107.2p -3.485498e-05u 107.2125p -4.76368e-05u 107.225p -6.036107e-05u 107.2375p -7.301943e-05u 107.25p -8.560357e-05u
+ 107.2625p -9.810528e-05u 107.275p -0.0001105164u 107.2875p -0.0001228289u 107.3p -0.0001350348u 107.3125p -0.0001471261u 107.325p -0.0001590952u 107.3375p -0.0001709344u 107.35p -0.0001826361u 107.3625p -0.0001941928u 107.375p -0.0002055972u 107.3875p -0.0002168421u 107.4p -0.0002279203u
+ 107.4125p -0.0002388251u 107.425p -0.0002495494u 107.4375p -0.0002600866u 107.45p -0.0002704302u 107.4625p -0.0002805738u 107.475p -0.0002905111u 107.4875p -0.000300236u 107.5p -0.0003097426u 107.5125p -0.000319025u 107.525p -0.0003280777u 107.5375p -0.0003368952u 107.55p -0.0003454721u
+ 107.5625p -0.0003538034u 107.575p -0.0003618841u 107.5875p -0.0003697095u 107.6p -0.0003772749u 107.6125p -0.0003845759u 107.625p -0.0003916083u 107.6375p -0.000398368u 107.65p -0.0004048512u 107.6625p -0.0004110542u 107.675p -0.0004169734u 107.6875p -0.0004226057u 107.7p -0.0004279478u
+ 107.7125p -0.000432997u 107.725p -0.0004377504u 107.7375p -0.0004422056u 107.75p -0.0004463602u 107.7625p -0.0004502121u 107.775p -0.0004537595u 107.7875p -0.0004570005u 107.8p -0.0004599336u 107.8125p -0.0004625575u 107.825p -0.0004648712u 107.8375p -0.0004668736u 107.85p -0.0004685641u
+ 107.8625p -0.0004699422u 107.875p -0.0004710074u 107.8875p -0.0004717598u 107.9p -0.0004721993u 107.9125p -0.0004723263u 107.925p -0.0004721412u 107.9375p -0.0004716448u 107.95p -0.0004708378u 107.9625p -0.0004697213u 107.975p -0.0004682967u 107.9875p -0.0004665654u 108p -0.0004645289u
+ 108.0125p -0.0004621893u 108.025p -0.0004595484u 108.0375p -0.0004566084u 108.05p -0.0004533719u 108.0625p -0.0004498414u 108.075p -0.0004460196u 108.0875p -0.0004419094u 108.1p -0.0004375141u 108.1125p -0.0004328369u 108.125p -0.0004278812u 108.1375p -0.0004226508u 108.15p -0.0004171494u
+ 108.1625p -0.0004113809u 108.175p -0.0004053496u 108.1875p -0.0003990597u 108.2p -0.0003925157u 108.2125p -0.0003857221u 108.225p -0.0003786838u 108.2375p -0.0003714057u 108.25p -0.0003638927u 108.2625p -0.0003561501u 108.275p -0.0003481831u 108.2875p -0.0003399974u 108.3p -0.0003315984u
+ 108.3125p -0.0003229919u 108.325p -0.0003141837u 108.3375p -0.0003051798u 108.35p -0.0002959862u 108.3625p -0.0002866092u 108.375p -0.000277055u 108.3875p -0.0002673301u 108.4p -0.000257441u 108.4125p -0.0002473942u 108.425p -0.0002371965u 108.4375p -0.0002268546u 108.45p -0.0002163755u
+ 108.4625p -0.0002057659u 108.475p -0.0001950331u 108.4875p -0.000184184u 108.5p -0.0001732258u 108.5125p -0.0001621658u 108.525p -0.0001510112u 108.5375p -0.0001397693u 108.55p -0.0001284476u 108.5625p -0.0001170535u 108.575p -0.0001055943u 108.5875p -9.40777e-05u 108.6p -8.251113e-05u
+ 108.6125p -7.090218e-05u 108.625p -5.925841e-05u 108.6375p -4.758742e-05u 108.65p -3.589682e-05u 108.6625p -2.419422e-05u 108.675p -1.248724e-05u 108.6875p -7.834942e-07u 108.7p 1.090942e-05u 108.7125p 2.258389e-05u 108.725p 3.423235e-05u 108.7375p 4.584724e-05u 108.75p 5.742101e-05u
+ 108.7625p 6.894618e-05u 108.775p 8.041526e-05u 108.7875p 9.182083e-05u 108.8p 0.0001031555u 108.8125p 0.0001144119u 108.825p 0.0001255829u 108.8375p 0.000136661u 108.85p 0.0001476393u 108.8625p 0.0001585106u 108.875p 0.0001692678u 108.8875p 0.000179904u 108.9p 0.0001904124u
+ 108.9125p 0.0002007861u 108.925p 0.0002110185u 108.9375p 0.0002211029u 108.95p 0.0002310328u 108.9625p 0.0002408019u 108.975p 0.0002504037u 108.9875p 0.0002598322u 109p 0.0002690813u 109.0125p 0.0002781448u 109.025p 0.0002870172u 109.0375p 0.0002956925u 109.05p 0.0003041652u
+ 109.0625p 0.0003124298u 109.075p 0.0003204811u 109.0875p 0.0003283137u 109.1p 0.0003359228u 109.1125p 0.0003433033u 109.125p 0.0003504505u 109.1375p 0.0003573598u 109.15p 0.0003640268u 109.1625p 0.0003704472u 109.175p 0.0003766168u 109.1875p 0.0003825317u 109.2p 0.000388188u
+ 109.2125p 0.0003935822u 109.225p 0.0003987108u 109.2375p 0.0004035704u 109.25p 0.000408158u 109.2625p 0.0004124706u 109.275p 0.0004165055u 109.2875p 0.0004202601u 109.3p 0.000423732u 109.3125p 0.000426919u 109.325p 0.0004298191u 109.3375p 0.0004324304u 109.35p 0.0004347513u
+ 109.3625p 0.0004367804u 109.375p 0.0004385163u 109.3875p 0.0004399581u 109.4p 0.0004411048u 109.4125p 0.0004419557u 109.425p 0.0004425105u 109.4375p 0.0004427687u 109.45p 0.0004427303u 109.4625p 0.0004423954u 109.475p 0.0004417644u 109.4875p 0.0004408376u 109.5p 0.0004396158u
+ 109.5125p 0.0004380998u 109.525p 0.0004362909u 109.5375p 0.0004341901u 109.55p 0.0004317991u 109.5625p 0.0004291194u 109.575p 0.000426153u 109.5875p 0.0004229018u 109.6p 0.0004193682u 109.6125p 0.0004155546u 109.625p 0.0004114635u 109.6375p 0.0004070978u 109.65p 0.0004024604u
+ 109.6625p 0.0003975547u 109.675p 0.0003923838u 109.6875p 0.0003869513u 109.7p 0.000381261u 109.7125p 0.0003753167u 109.725p 0.0003691224u 109.7375p 0.0003626825u 109.75p 0.0003560013u 109.7625p 0.0003490833u 109.775p 0.0003419332u 109.7875p 0.000334556u 109.8p 0.0003269567u
+ 109.8125p 0.0003191404u 109.825p 0.0003111125u 109.8375p 0.0003028784u 109.85p 0.0002944438u 109.8625p 0.0002858144u 109.875p 0.000276996u 109.8875p 0.0002679948u 109.9p 0.0002588169u 109.9125p 0.0002494684u 109.925p 0.0002399559u 109.9375p 0.0002302857u 109.95p 0.0002204645u
+ 109.9625p 0.000210499u 109.975p 0.000200396u 109.9875p 0.0001901624u 110p 0.0001798052u 110.0125p 0.0001693315u 110.025p 0.0001587484u 110.0375p 0.0001480632u 110.05p 0.0001372831u 110.0625p 0.0001264157u 110.075p 0.0001154682u 110.0875p 0.0001044482u 110.1p 9.336319e-05u
+ 110.1125p 8.222083e-05u 110.125p 7.102872e-05u 110.1375p 5.979452e-05u 110.15p 4.852593e-05u 110.1625p 3.723067e-05u 110.175p 2.591649e-05u 110.1875p 1.459113e-05u 110.2p 3.262363e-06u 110.2125p -8.062049e-06u 110.225p -1.937434e-05u 110.2375p -3.066675e-05u 110.25p -4.193154e-05u
+ 110.2625p -5.316099e-05u 110.275p -6.434738e-05u 110.2875p -7.548305e-05u 110.3p -8.656037e-05u 110.3125p -9.757172e-05u 110.325p -0.0001085096u 110.3375p -0.0001193664u 110.35p -0.0001301348u 110.3625p -0.0001408073u 110.375p -0.0001513767u 110.3875p -0.0001618357u 110.4p -0.000172177u
+ 110.4125p -0.0001823938u 110.425p -0.0001924789u 110.4375p -0.0002024254u 110.45p -0.0002122265u 110.4625p -0.0002218755u 110.475p -0.0002313659u 110.4875p -0.0002406911u 110.5p -0.0002498447u 110.5125p -0.0002588205u 110.525p -0.0002676124u 110.5375p -0.0002762144u 110.55p -0.0002846205u
+ 110.5625p -0.0002928251u 110.575p -0.0003008226u 110.5875p -0.0003086076u 110.6p -0.0003161747u 110.6125p -0.0003235188u 110.625p -0.000330635u 110.6375p -0.0003375185u 110.65p -0.0003441645u 110.6625p -0.0003505686u 110.675p -0.0003567264u 110.6875p -0.000362634u 110.7p -0.0003682872u
+ 110.7125p -0.0003736823u 110.725p -0.0003788157u 110.7375p -0.000383684u 110.75p -0.000388284u 110.7625p -0.0003926126u 110.775p -0.000396667u 110.7875p -0.0004004446u 110.8p -0.0004039429u 110.8125p -0.0004071595u 110.825p -0.0004100926u 110.8375p -0.0004127403u 110.85p -0.0004151008u
+ 110.8625p -0.0004171727u 110.875p -0.0004189548u 110.8875p -0.0004204461u 110.9p -0.0004216458u 110.9125p -0.0004225531u 110.925p -0.0004231677u 110.9375p -0.0004234894u 110.95p -0.0004235182u 110.9625p -0.0004232542u 110.975p -0.000422698u 110.9875p -0.00042185u 111p -0.0004207112u
+ 111.0125p -0.0004192825u 111.025p -0.0004175652u 111.0375p -0.0004155608u 111.05p -0.0004132708u 111.0625p -0.0004106972u 111.075p -0.0004078419u 111.0875p -0.0004047072u 111.1p -0.0004012955u 111.1125p -0.0003976095u 111.125p -0.000393652u 111.1375p -0.0003894259u 111.15p -0.0003849346u
+ 111.1625p -0.0003801813u 111.175p -0.0003751697u 111.1875p -0.0003699035u 111.2p -0.0003643866u 111.2125p -0.0003586231u 111.225p -0.0003526174u 111.2375p -0.0003463737u 111.25p -0.0003398968u 111.2625p -0.0003331915u 111.275p -0.0003262625u 111.2875p -0.0003191151u 111.3p -0.0003117543u
+ 111.3125p -0.0003041857u 111.325p -0.0002964148u 111.3375p -0.000288447u 111.35p -0.0002802884u 111.3625p -0.0002719447u 111.375p -0.0002634221u 111.3875p -0.0002547267u 111.4p -0.0002458647u 111.4125p -0.0002368425u 111.425p -0.0002276667u 111.4375p -0.0002183438u 111.45p -0.0002088806u
+ 111.4625p -0.0001992838u 111.475p -0.0001895603u 111.4875p -0.000179717u 111.5p -0.000169761u 111.5125p -0.0001596993u 111.525p -0.0001495392u 111.5375p -0.0001392879u 111.55p -0.0001289526u 111.5625p -0.0001185407u 111.575p -0.0001080595u 111.5875p -9.751654e-05u 111.6p -8.691918e-05u
+ 111.6125p -7.627491e-05u 111.625p -6.559125e-05u 111.6375p -5.487571e-05u 111.65p -4.413582e-05u 111.6625p -3.337911e-05u 111.675p -2.261314e-05u 111.6875p -1.184542e-05u 111.7p -1.083488e-06u 111.7125p 9.665151e-06u 111.725p 2.039301e-05u 111.7375p 3.109262e-05u 111.75p 4.175656e-05u
+ 111.7625p 5.237743e-05u 111.775p 6.294788e-05u 111.7875p 7.34606e-05u 111.8p 8.390835e-05u 111.8125p 9.428392e-05u 111.825p 0.0001045802u 111.8375p 0.0001147901u 111.85p 0.0001249066u 111.8625p 0.0001349228u 111.875p 0.000144832u 111.8875p 0.0001546272u 111.9p 0.000164302u
+ 111.9125p 0.0001738497u 111.925p 0.0001832638u 111.9375p 0.0001925381u 111.95p 0.0002016663u 111.9625p 0.0002106422u 111.975p 0.0002194598u 111.9875p 0.0002281133u 112p 0.0002365969u 112.0125p 0.0002449049u 112.025p 0.0002530319u 112.0375p 0.0002609725u 112.05p 0.0002687214u
+ 112.0625p 0.0002762737u 112.075p 0.0002836243u 112.0875p 0.0002907685u 112.1p 0.0002977017u 112.1125p 0.0003044194u 112.125p 0.0003109173u 112.1375p 0.0003171912u 112.15p 0.0003232372u 112.1625p 0.0003290514u 112.175p 0.0003346303u 112.1875p 0.0003399703u 112.2p 0.0003450681u
+ 112.2125p 0.0003499207u 112.225p 0.0003545251u 112.2375p 0.0003588784u 112.25p 0.0003629783u 112.2625p 0.0003668221u 112.275p 0.0003704078u 112.2875p 0.0003737332u 112.3p 0.0003767966u 112.3125p 0.0003795963u 112.325p 0.0003821308u 112.3375p 0.0003843988u 112.35p 0.0003863992u
+ 112.3625p 0.0003881312u 112.375p 0.000389594u 112.3875p 0.000390787u 112.4p 0.00039171u 112.4125p 0.0003923628u 112.425p 0.0003927453u 112.4375p 0.000392858u 112.45p 0.000392701u 112.4625p 0.0003922751u 112.475p 0.0003915811u 112.4875p 0.0003906198u 112.5p 0.0003893925u
+ 112.5125p 0.0003879005u 112.525p 0.0003861452u 112.5375p 0.0003841285u 112.55p 0.000381852u 112.5625p 0.000379318u 112.575p 0.0003765286u 112.5875p 0.0003734861u 112.6p 0.0003701932u 112.6125p 0.0003666526u 112.625p 0.0003628672u 112.6375p 0.0003588399u 112.65p 0.0003545741u
+ 112.6625p 0.0003500731u 112.675p 0.0003453404u 112.6875p 0.0003403797u 112.7p 0.0003351949u 112.7125p 0.0003297898u 112.725p 0.0003241686u 112.7375p 0.0003183356u 112.75p 0.0003122951u 112.7625p 0.0003060517u 112.775p 0.00029961u 112.7875p 0.0002929747u 112.8p 0.0002861509u
+ 112.8125p 0.0002791434u 112.825p 0.0002719574u 112.8375p 0.0002645982u 112.85p 0.0002570711u 112.8625p 0.0002493816u 112.875p 0.0002415351u 112.8875p 0.0002335374u 112.9p 0.0002253941u 112.9125p 0.0002171111u 112.925p 0.0002086943u 112.9375p 0.0002001497u 112.95p 0.0001914833u
+ 112.9625p 0.0001827012u 112.975p 0.0001738096u 112.9875p 0.0001648148u 113p 0.000155723u 113.0125p 0.0001465407u 113.025p 0.0001372742u 113.0375p 0.0001279299u 113.05p 0.0001185144u 113.0625p 0.0001090341u 113.075p 9.949561e-05u 113.0875p 8.99055e-05u 113.1p 8.027034e-05u
+ 113.1125p 7.059675e-05u 113.125p 6.089133e-05u 113.1375p 5.116071e-05u 113.15p 4.141151e-05u 113.1625p 3.165036e-05u 113.175p 2.188387e-05u 113.1875p 1.211865e-05u 113.2p 2.361291e-06u 113.2125p -7.381646e-06u 113.225p -1.710361e-05u 113.2375p -2.679809e-05u 113.25p -3.645859e-05u
+ 113.2625p -4.607867e-05u 113.275p -5.565192e-05u 113.2875p -6.517198e-05u 113.3p -7.463255e-05u 113.3125p -8.402736e-05u 113.325p -9.335021e-05u 113.3375p -0.000102595u 113.35p -0.0001117556u 113.3625p -0.000120826u 113.375p -0.0001298003u 113.3875p -0.0001386726u 113.4p -0.0001474373u
+ 113.4125p -0.0001560885u 113.425p -0.0001646206u 113.4375p -0.0001730283u 113.45p -0.000181306u 113.4625p -0.0001894484u 113.475p -0.0001974504u 113.4875p -0.0002053068u 113.5p -0.0002130126u 113.5125p -0.0002205628u 113.525p -0.0002279529u 113.5375p -0.0002351779u 113.55p -0.0002422335u
+ 113.5625p -0.0002491152u 113.575p -0.0002558187u 113.5875p -0.0002623398u 113.6p -0.0002686745u 113.6125p -0.0002748189u 113.625p -0.0002807692u 113.6375p -0.0002865217u 113.65p -0.0002920729u 113.6625p -0.0002974196u 113.675p -0.0003025584u 113.6875p -0.0003074863u 113.7p -0.0003122004u
+ 113.7125p -0.0003166978u 113.725p -0.000320976u 113.7375p -0.0003250324u 113.75p -0.0003288647u 113.7625p -0.0003324708u 113.775p -0.0003358486u 113.7875p -0.0003389962u 113.8p -0.0003419119u 113.8125p -0.0003445942u 113.825p -0.0003470415u 113.8375p -0.0003492528u 113.85p -0.0003512269u
+ 113.8625p -0.0003529628u 113.875p -0.0003544598u 113.8875p -0.0003557173u 113.9p -0.0003567348u 113.9125p -0.000357512u 113.925p -0.0003580488u 113.9375p -0.0003583452u 113.95p -0.0003584013u 113.9625p -0.0003582175u 113.975p -0.0003577944u 113.9875p -0.0003571324u 114p -0.0003562325u
+ 114.0125p -0.0003550956u 114.025p -0.0003537228u 114.0375p -0.0003521153u 114.05p -0.0003502747u 114.0625p -0.0003482024u 114.075p -0.0003459002u 114.0875p -0.0003433699u 114.1p -0.0003406135u 114.1125p -0.0003376332u 114.125p -0.0003344314u 114.1375p -0.0003310104u 114.15p -0.0003273728u
+ 114.1625p -0.0003235214u 114.175p -0.0003194589u 114.1875p -0.0003151884u 114.2p -0.0003107131u 114.2125p -0.0003060361u 114.225p -0.0003011608u 114.2375p -0.0002960908u 114.25p -0.0002908297u 114.2625p -0.0002853811u 114.275p -0.0002797491u 114.2875p -0.0002739374u 114.3p -0.0002679504u
+ 114.3125p -0.000261792u 114.325p -0.0002554667u 114.3375p -0.0002489789u 114.35p -0.0002423331u 114.3625p -0.0002355338u 114.375p -0.0002285857u 114.3875p -0.0002214938u 114.4p -0.0002142628u 114.4125p -0.0002068977u 114.425p -0.0001994035u 114.4375p -0.0001917855u 114.45p -0.0001840487u
+ 114.4625p -0.0001761985u 114.475p -0.0001682402u 114.4875p -0.0001601792u 114.5p -0.0001520209u 114.5125p -0.000143771u 114.525p -0.0001354348u 114.5375p -0.0001270182u 114.55p -0.0001185268u 114.5625p -0.0001099662u 114.575p -0.0001013422u 114.5875p -9.266068e-05u 114.6p -8.392737e-05u
+ 114.6125p -7.514814e-05u 114.625p -6.632886e-05u 114.6375p -5.747543e-05u 114.65p -4.859376e-05u 114.6625p -3.968975e-05u 114.675p -3.076935e-05u 114.6875p -2.183848e-05u 114.7p -1.290308e-05u 114.7125p -3.969085e-06u 114.725p 4.957588e-06u 114.7375p 1.387102e-05u 114.75p 2.276531e-05u
+ 114.7625p 3.163459e-05u 114.775p 4.047298e-05u 114.7875p 4.927465e-05u 114.8p 5.803381e-05u 114.8125p 6.674467e-05u 114.825p 7.540151e-05u 114.8375p 8.399863e-05u 114.85p 9.253038e-05u 114.8625p 0.0001009912u 114.875p 0.0001093754u 114.8875p 0.0001176776u 114.9p 0.0001258924u
+ 114.9125p 0.0001340144u 114.925p 0.0001420382u 114.9375p 0.0001499586u 114.95p 0.0001577705u 114.9625p 0.0001654687u 114.975p 0.0001730483u 114.9875p 0.0001805043u 115p 0.0001878319u 115.0125p 0.0001950263u 115.025p 0.0002020828u 115.0375p 0.0002089968u 115.05p 0.000215764u
+ 115.0625p 0.0002223799u 115.075p 0.0002288402u 115.0875p 0.0002351408u 115.1p 0.0002412777u 115.1125p 0.0002472467u 115.125p 0.0002530443u 115.1375p 0.0002586665u 115.15p 0.0002641099u 115.1625p 0.0002693709u 115.175p 0.0002744462u 115.1875p 0.0002793326u 115.2p 0.0002840269u
+ 115.2125p 0.0002885261u 115.225p 0.0002928275u 115.2375p 0.0002969284u 115.25p 0.0003008261u 115.2625p 0.0003045182u 115.275p 0.0003080023u 115.2875p 0.0003112765u 115.3p 0.0003143385u 115.3125p 0.0003171866u 115.325p 0.0003198191u 115.3375p 0.0003222342u 115.35p 0.0003244306u
+ 115.3625p 0.0003264069u 115.375p 0.0003281621u 115.3875p 0.0003296951u 115.4p 0.000331005u 115.4125p 0.0003320912u 115.425p 0.000332953u 115.4375p 0.0003335901u 115.45p 0.0003340023u 115.4625p 0.0003341894u 115.475p 0.0003341514u 115.4875p 0.0003338885u 115.5p 0.0003334011u
+ 115.5125p 0.0003326897u 115.525p 0.000331755u 115.5375p 0.0003305976u 115.55p 0.0003292186u 115.5625p 0.000327619u 115.575p 0.0003258001u 115.5875p 0.0003237632u 115.6p 0.0003215099u 115.6125p 0.0003190419u 115.625p 0.0003163609u 115.6375p 0.0003134689u 115.65p 0.000310368u
+ 115.6625p 0.0003070604u 115.675p 0.0003035486u 115.6875p 0.000299835u 115.7p 0.0002959223u 115.7125p 0.0002918132u 115.725p 0.0002875106u 115.7375p 0.0002830176u 115.75p 0.0002783374u 115.7625p 0.0002734732u 115.775p 0.0002684285u 115.7875p 0.0002632067u 115.8p 0.0002578115u
+ 115.8125p 0.0002522467u 115.825p 0.0002465162u 115.8375p 0.0002406239u 115.85p 0.0002345739u 115.8625p 0.0002283705u 115.875p 0.0002220178u 115.8875p 0.0002155205u 115.9p 0.0002088828u 115.9125p 0.0002021094u 115.925p 0.0001952051u 115.9375p 0.0001881744u 115.95p 0.0001810224u
+ 115.9625p 0.0001737539u 115.975p 0.0001663739u 115.9875p 0.0001588875u 116p 0.0001512999u 116.0125p 0.0001436162u 116.025p 0.0001358418u 116.0375p 0.0001279819u 116.05p 0.000120042u 116.0625p 0.0001120275u 116.075p 0.0001039439u 116.0875p 9.579676e-05u 116.1p 8.759161e-05u
+ 116.1125p 7.933408e-05u 116.125p 7.102982e-05u 116.1375p 6.268451e-05u 116.15p 5.430385e-05u 116.1625p 4.589355e-05u 116.175p 3.745937e-05u 116.1875p 2.900704e-05u 116.2p 2.054235e-05u 116.2125p 1.207104e-05u 116.225p 3.598907e-06u 116.2375p -4.868295e-06u 116.25p -1.33248e-05u
+ 116.2625p -2.176486e-05u 116.275p -3.018273e-05u 116.2875p -3.857269e-05u 116.3p -4.692905e-05u 116.3125p -5.524612e-05u 116.325p -6.351828e-05u 116.3375p -7.173991e-05u 116.35p -7.990544e-05u 116.3625p -8.800934e-05u 116.375p -9.604612e-05u 116.3875p -0.0001040103u 116.4p -0.0001118966u
+ 116.4125p -0.0001196997u 116.425p -0.0001274142u 116.4375p -0.0001350349u 116.45p -0.0001425568u 116.4625p -0.0001499747u 116.475p -0.0001572838u 116.4875p -0.0001644789u 116.5p -0.0001715554u 116.5125p -0.0001785085u 116.525p -0.0001853335u 116.5375p -0.0001920258u 116.55p -0.000198581u
+ 116.5625p -0.0002049947u 116.575p -0.0002112626u 116.5875p -0.0002173805u 116.6p -0.0002233444u 116.6125p -0.0002291503u 116.625p -0.0002347943u 116.6375p -0.0002402728u 116.65p -0.000245582u 116.6625p -0.0002507186u 116.675p -0.000255679u 116.6875p -0.0002604601u 116.7p -0.0002650587u
+ 116.7125p -0.0002694719u 116.725p -0.0002736967u 116.7375p -0.0002777304u 116.75p -0.0002815704u 116.7625p -0.0002852142u 116.775p -0.0002886596u 116.7875p -0.0002919042u 116.8p -0.0002949461u 116.8125p -0.0002977834u 116.825p -0.0003004142u 116.8375p -0.0003028369u 116.85p -0.0003050502u
+ 116.8625p -0.0003070525u 116.875p -0.0003088428u 116.8875p -0.00031042u 116.9p -0.0003117833u 116.9125p -0.0003129317u 116.925p -0.0003138649u 116.9375p -0.0003145823u 116.95p -0.0003150836u 116.9625p -0.0003153688u 116.975p -0.0003154377u 116.9875p -0.0003152906u 117p -0.0003149277u
+ 117.0125p -0.0003143496u 117.025p -0.0003135568u 117.0375p -0.0003125501u 117.05p -0.0003113303u 117.0625p -0.0003098986u 117.075p -0.0003082561u 117.0875p -0.0003064041u 117.1p -0.0003043442u 117.1125p -0.0003020779u 117.125p -0.000299607u 117.1375p -0.0002969335u 117.15p -0.0002940594u
+ 117.1625p -0.0002909869u 117.175p -0.0002877182u 117.1875p -0.0002842559u 117.2p -0.0002806025u 117.2125p -0.0002767607u 117.225p -0.0002727334u 117.2375p -0.0002685236u 117.25p -0.0002641343u 117.2625p -0.0002595688u 117.275p -0.0002548304u 117.2875p -0.0002499226u 117.3p -0.0002448488u
+ 117.3125p -0.0002396129u 117.325p -0.0002342185u 117.3375p -0.0002286697u 117.35p -0.0002229703u 117.3625p -0.0002171244u 117.375p -0.0002111363u 117.3875p -0.0002050103u 117.4p -0.0001987507u 117.4125p -0.000192362u 117.425p -0.0001858487u 117.4375p -0.0001792155u 117.45p -0.0001724671u
+ 117.4625p -0.0001656082u 117.475p -0.0001586438u 117.4875p -0.0001515788u 117.5p -0.0001444181u 117.5125p -0.0001371668u 117.525p -0.00012983u 117.5375p -0.0001224129u 117.55p -0.0001149206u 117.5625p -0.0001073585u 117.575p -9.973178e-05u 117.5875p -9.204585e-05u 117.6p -8.430605e-05u
+ 117.6125p -7.651779e-05u 117.625p -6.86865e-05u 117.6375p -6.081762e-05u 117.65p -5.291664e-05u 117.6625p -4.498903e-05u 117.675p -3.704029e-05u 117.6875p -2.907594e-05u 117.7p -2.110148e-05u 117.7125p -1.312241e-05u 117.725p -5.144247e-06u 117.7375p 2.827516e-06u 117.75p 1.078739e-05u
+ 117.7625p 1.872991e-05u 117.775p 2.664962e-05u 117.7875p 3.45411e-05u 117.8p 4.239895e-05u 117.8125p 5.021779e-05u 117.825p 5.799229e-05u 117.8375p 6.571716e-05u 117.85p 7.338714e-05u 117.8625p 8.099701e-05u 117.875p 8.854163e-05u 117.8875p 9.601588e-05u 117.9p 0.0001034147u
+ 117.9125p 0.0001107331u 117.925p 0.0001179662u 117.9375p 0.000125109u 117.95p 0.0001321569u 117.9625p 0.000139105u 117.975p 0.0001459488u 117.9875p 0.0001526837u 118p 0.0001593051u 118.0125p 0.0001658087u 118.025p 0.0001721902u 118.0375p 0.0001784454u 118.05p 0.00018457u
+ 118.0625p 0.0001905602u 118.075p 0.000196412u 118.0875p 0.0002021215u 118.1p 0.000207685u 118.1125p 0.000213099u 118.125p 0.0002183598u 118.1375p 0.0002234642u 118.15p 0.0002284087u 118.1625p 0.0002331903u 118.175p 0.000237806u 118.1875p 0.0002422526u 118.2p 0.0002465276u
+ 118.2125p 0.0002506281u 118.225p 0.0002545517u 118.2375p 0.0002582958u 118.25p 0.0002618583u 118.2625p 0.0002652368u 118.275p 0.0002684293u 118.2875p 0.0002714341u 118.3p 0.0002742491u 118.3125p 0.0002768729u 118.325p 0.0002793038u 118.3375p 0.0002815406u 118.35p 0.0002835819u
+ 118.3625p 0.0002854267u 118.375p 0.000287074u 118.3875p 0.0002885229u 118.4p 0.0002897728u 118.4125p 0.0002908231u 118.425p 0.0002916734u 118.4375p 0.0002923234u 118.45p 0.0002927729u 118.4625p 0.0002930221u 118.475p 0.0002930709u 118.4875p 0.0002929197u 118.5p 0.0002925689u
+ 118.5125p 0.000292019u 118.525p 0.0002912707u 118.5375p 0.0002903249u 118.55p 0.0002891824u 118.5625p 0.0002878444u 118.575p 0.0002863121u 118.5875p 0.0002845867u 118.6p 0.0002826699u 118.6125p 0.0002805632u 118.625p 0.0002782683u 118.6375p 0.0002757871u 118.65p 0.0002731216u
+ 118.6625p 0.0002702739u 118.675p 0.0002672462u 118.6875p 0.0002640409u 118.7p 0.0002606603u 118.7125p 0.0002571072u 118.725p 0.0002533842u 118.7375p 0.000249494u 118.75p 0.0002454397u 118.7625p 0.0002412242u 118.775p 0.0002368507u 118.7875p 0.0002323224u 118.8p 0.0002276425u
+ 118.8125p 0.0002228147u 118.825p 0.0002178422u 118.8375p 0.0002127289u 118.85p 0.0002074783u 118.8625p 0.0002020942u 118.875p 0.0001965806u 118.8875p 0.0001909414u 118.9p 0.0001851806u 118.9125p 0.0001793024u 118.925p 0.0001733108u 118.9375p 0.0001672103u 118.95p 0.000161005u
+ 118.9625p 0.0001546993u 118.975p 0.0001482978u 118.9875p 0.0001418048u 119p 0.0001352251u 119.0125p 0.000128563u 119.025p 0.0001218234u 119.0375p 0.0001150109u 119.05p 0.0001081303u 119.0625p 0.0001011863u 119.075p 9.418366e-05u 119.0875p 8.712733e-05u 119.1p 8.002214e-05u
+ 119.1125p 7.287298e-05u 119.125p 6.568478e-05u 119.1375p 5.846245e-05u 119.15p 5.121095e-05u 119.1625p 4.393523e-05u 119.175p 3.664026e-05u 119.1875p 2.933102e-05u 119.2p 2.201246e-05u 119.2125p 1.468957e-05u 119.225p 7.367291e-06u 119.2375p 5.059144e-08u 119.25p -7.255592e-06u
+ 119.2625p -1.454633e-05u 119.275p -2.181673e-05u 119.2875p -2.906189e-05u 119.3p -3.627696e-05u 119.3125p -4.345712e-05u 119.325p -5.059755e-05u 119.3375p -5.769351e-05u 119.35p -6.474025e-05u 119.3625p -7.173311e-05u 119.375p -7.866744e-05u 119.3875p -8.553866e-05u 119.4p -9.234221e-05u
+ 119.4125p -9.907361e-05u 119.425p -0.0001057284u 119.4375p -0.0001123023u 119.45p -0.0001187909u 119.4625p -0.00012519u 119.475p -0.0001314954u 119.4875p -0.000137703u 119.5p -0.0001438088u 119.5125p -0.0001498088u 119.525p -0.0001556991u 119.5375p -0.0001614759u 119.55p -0.0001671356u
+ 119.5625p -0.0001726743u 119.575p -0.0001780888u 119.5875p -0.0001833753u 119.6p -0.0001885307u 119.6125p -0.0001935515u 119.625p -0.0001984347u 119.6375p -0.0002031772u 119.65p -0.0002077759u 119.6625p -0.0002122281u 119.675p -0.0002165308u 119.6875p -0.0002206815u 119.7p -0.0002246776u
+ 119.7125p -0.0002285165u 119.725p -0.0002321961u 119.7375p -0.000235714u 119.75p -0.000239068u 119.7625p -0.0002422563u 119.775p -0.0002452769u 119.7875p -0.0002481279u 119.8p -0.0002508078u 119.8125p -0.0002533149u 119.825p -0.0002556479u 119.8375p -0.0002578054u 119.85p -0.0002597863u
+ 119.8625p -0.0002615894u 119.875p -0.0002632138u 119.8875p -0.0002646587u 119.9p -0.0002659233u 119.9125p -0.0002670071u 119.925p -0.0002679095u 119.9375p -0.0002686303u 119.95p -0.0002691692u 119.9625p -0.0002695261u 119.975p -0.0002697011u 119.9875p -0.0002696941u 120p -0.0002695056u
+ 120.0125p -0.0002691359u 120.025p -0.0002685855u 120.0375p -0.000267855u 120.05p -0.0002669451u 120.0625p -0.0002658568u 120.075p -0.0002645909u 120.0875p -0.0002631486u 120.1p -0.0002615311u 120.1125p -0.0002597397u 120.125p -0.0002577758u 120.1375p -0.000255641u 120.15p -0.000253337u
+ 120.1625p -0.0002508655u 120.175p -0.0002482284u 120.1875p -0.0002454277u 120.2p -0.0002424655u 120.2125p -0.0002393439u 120.225p -0.0002360654u 120.2375p -0.0002326322u 120.25p -0.000229047u 120.2625p -0.0002253122u 120.275p -0.0002214306u 120.2875p -0.0002174051u 120.3p -0.0002132383u
+ 120.3125p -0.0002089335u 120.325p -0.0002044935u 120.3375p -0.0001999216u 120.35p -0.000195221u 120.3625p -0.000190395u 120.375p -0.000185447u 120.3875p -0.0001803804u 120.4p -0.0001751988u 120.4125p -0.0001699059u 120.425p -0.0001645052u 120.4375p -0.0001590006u 120.45p -0.0001533959u
+ 120.4625p -0.000147695u 120.475p -0.0001419017u 120.4875p -0.0001360201u 120.5p -0.0001300542u 120.5125p -0.0001240082u 120.525p -0.0001178861u 120.5375p -0.0001116923u 120.55p -0.0001054308u 120.5625p -9.910597e-05u 120.575p -9.272216e-05u 120.5875p -8.62837e-05u 120.6p -7.979495e-05u
+ 120.6125p -7.326033e-05u 120.625p -6.668426e-05u 120.6375p -6.00712e-05u 120.65p -5.342563e-05u 120.6625p -4.675203e-05u 120.675p -4.005491e-05u 120.6875p -3.333878e-05u 120.7p -2.660816e-05u 120.7125p -1.986758e-05u 120.725p -1.312157e-05u 120.7375p -6.374648e-06u 120.75p 3.686578e-07u
+ 120.7625p 7.103835e-06u 120.775p 1.382638e-05u 120.7875p 2.05318e-05u 120.8p 2.721563e-05u 120.8125p 3.38734e-05u 120.825p 4.050069e-05u 120.8375p 4.709308e-05u 120.85p 5.364621e-05u 120.8625p 6.015571e-05u 120.875p 6.661728e-05u 120.8875p 7.302664e-05u 120.9p 7.937954e-05u
+ 120.9125p 8.567179e-05u 120.925p 9.189923e-05u 120.9375p 9.805777e-05u 120.95p 0.0001041433u 120.9625p 0.000110152u 120.975p 0.0001160797u 120.9875p 0.0001219226u 121p 0.0001276768u 121.0125p 0.0001333387u 121.025p 0.0001389045u 121.0375p 0.0001443706u 121.05p 0.0001497333u
+ 121.0625p 0.0001549893u 121.075p 0.0001601352u 121.0875p 0.0001651674u 121.1p 0.0001700829u 121.1125p 0.0001748785u 121.125p 0.000179551u 121.1375p 0.0001840974u 121.15p 0.0001885148u 121.1625p 0.0001928005u 121.175p 0.0001969515u 121.1875p 0.0002009654u 121.2p 0.0002048394u
+ 121.2125p 0.0002085713u 121.225p 0.0002121586u 121.2375p 0.000215599u 121.25p 0.0002188904u 121.2625p 0.0002220308u 121.275p 0.0002250181u 121.2875p 0.0002278505u 121.3p 0.0002305263u 121.3125p 0.0002330438u 121.325p 0.0002354015u 121.3375p 0.000237598u 121.35p 0.000239632u
+ 121.3625p 0.0002415021u 121.375p 0.0002432075u 121.3875p 0.000244747u 121.4p 0.0002461198u 121.4125p 0.0002473251u 121.425p 0.0002483623u 121.4375p 0.0002492308u 121.45p 0.0002499303u 121.4625p 0.0002504604u 121.475p 0.000250821u 121.4875p 0.0002510119u 121.5p 0.0002510332u
+ 121.5125p 0.0002508851u 121.525p 0.0002505677u 121.5375p 0.0002500816u 121.55p 0.0002494271u 121.5625p 0.0002486049u 121.575p 0.0002476157u 121.5875p 0.0002464603u 121.6p 0.0002451397u 121.6125p 0.0002436549u 121.625p 0.000242007u 121.6375p 0.0002401974u 121.65p 0.0002382274u
+ 121.6625p 0.0002360984u 121.675p 0.0002338122u 121.6875p 0.0002313703u 121.7p 0.0002287746u 121.7125p 0.0002260269u 121.725p 0.0002231293u 121.7375p 0.0002200838u 121.75p 0.0002168927u 121.7625p 0.0002135582u 121.775p 0.0002100828u 121.7875p 0.0002064688u 121.8p 0.000202719u
+ 121.8125p 0.0001988358u 121.825p 0.0001948222u 121.8375p 0.0001906809u 121.85p 0.0001864148u 121.8625p 0.000182027u 121.875p 0.0001775204u 121.8875p 0.0001728984u 121.9p 0.0001681641u 121.9125p 0.0001633208u 121.925p 0.0001583719u 121.9375p 0.0001533208u 121.95p 0.0001481711u
+ 121.9625p 0.0001429263u 121.975p 0.0001375901u 121.9875p 0.0001321661u 122p 0.0001266582u 122.0125p 0.0001210701u 122.025p 0.0001154056u 122.0375p 0.0001096688u 122.05p 0.0001038635u 122.0625p 9.799376e-05u 122.075p 9.206359e-05u 122.0875p 8.607707e-05u 122.1p 8.003832e-05u
+ 122.1125p 7.395146e-05u 122.125p 6.782068e-05u 122.1375p 6.165017e-05u 122.15p 5.544415e-05u 122.1625p 4.920687e-05u 122.175p 4.294257e-05u 122.1875p 3.665555e-05u 122.2p 3.035007e-05u 122.2125p 2.403045e-05u 122.225p 1.770097e-05u 122.2375p 1.136595e-05u 122.25p 5.029691e-06u
+ 122.2625p -1.303507e-06u 122.275p -7.629347e-06u 122.2875p -1.394354e-05u 122.3p -2.024181e-05u 122.3125p -2.651989e-05u 122.325p -3.277354e-05u 122.3375p -3.899853e-05u 122.35p -4.519066e-05u 122.3625p -5.134575e-05u 122.375p -5.745965e-05u 122.3875p -6.352826e-05u 122.4p -6.954748e-05u
+ 122.4125p -7.551327e-05u 122.425p -8.142163e-05u 122.4375p -8.726858e-05u 122.45p -9.305022e-05u 122.4625p -9.876268e-05u 122.475p -0.0001044021u 122.4875p -0.0001099648u 122.5p -0.000115447u 122.5125p -0.000120845u 122.525p -0.0001261553u 122.5375p -0.0001313744u 122.55p -0.0001364987u
+ 122.5625p -0.0001415249u 122.575p -0.0001464497u 122.5875p -0.0001512697u 122.6p -0.0001559819u 122.6125p -0.0001605831u 122.625p -0.0001650702u 122.6375p -0.0001694404u 122.65p -0.0001736907u 122.6625p -0.0001778185u 122.675p -0.0001818209u 122.6875p -0.0001856955u 122.7p -0.0001894396u
+ 122.7125p -0.0001930509u 122.725p -0.000196527u 122.7375p -0.0001998657u 122.75p -0.0002030649u 122.7625p -0.0002061224u 122.775p -0.0002090365u 122.7875p -0.0002118051u 122.8p -0.0002144266u 122.8125p -0.0002168994u 122.825p -0.0002192219u 122.8375p -0.0002213926u 122.85p -0.0002234103u
+ 122.8625p -0.0002252737u 122.875p -0.0002269816u 122.8875p -0.0002285332u 122.9p -0.0002299275u 122.9125p -0.0002311637u 122.925p -0.0002322411u 122.9375p -0.0002331592u 122.95p -0.0002339174u 122.9625p -0.0002345155u 122.975p -0.0002349532u 122.9875p -0.0002352303u 123p -0.0002353469u
+ 123.0125p -0.000235303u 123.025p -0.0002350988u 123.0375p -0.0002347347u 123.05p -0.000234211u 123.0625p -0.0002335283u 123.075p -0.0002326872u 123.0875p -0.0002316885u 123.1p -0.0002305329u 123.1125p -0.0002292216u 123.125p -0.0002277554u 123.1375p -0.0002261356u 123.15p -0.0002243636u
+ 123.1625p -0.0002224405u 123.175p -0.000220368u 123.1875p -0.0002181475u 123.2p -0.0002157808u 123.2125p -0.0002132697u 123.225p -0.000210616u 123.2375p -0.0002078218u 123.25p -0.0002048889u 123.2625p -0.0002018197u 123.275p -0.0001986164u 123.2875p -0.0001952813u 123.3p -0.0001918168u
+ 123.3125p -0.0001882254u 123.325p -0.0001845098u 123.3375p -0.0001806727u 123.35p -0.0001767167u 123.3625p -0.0001726448u 123.375p -0.0001684598u 123.3875p -0.0001641647u 123.4p -0.0001597627u 123.4125p -0.0001552567u 123.425p -0.0001506501u 123.4375p -0.0001459462u 123.45p -0.0001411481u
+ 123.4625p -0.0001362594u 123.475p -0.0001312834u 123.4875p -0.0001262237u 123.5p -0.0001210838u 123.5125p -0.0001158674u 123.525p -0.0001105781u 123.5375p -0.0001052196u 123.55p -9.979559e-05u 123.5625p -9.430996e-05u 123.575p -8.87665e-05u 123.5875p -8.316907e-05u 123.6p -7.752156e-05u
+ 123.6125p -7.182789e-05u 123.625p -6.609201e-05u 123.6375p -6.03179e-05u 123.65p -5.450955e-05u 123.6625p -4.867099e-05u 123.675p -4.280623e-05u 123.6875p -3.691932e-05u 123.7p -3.101433e-05u 123.7125p -2.50953e-05u 123.725p -1.91663e-05u 123.7375p -1.323141e-05u 123.75p -7.294692e-06u
+ 123.7625p -1.360203e-06u 123.775p 4.567996e-06u 123.7875p 1.048586e-05u 123.8p 1.638935e-05u 123.8125p 2.227445e-05u 123.825p 2.813715e-05u 123.8375p 3.397348e-05u 123.85p 3.977948e-05u 123.8625p 4.55512e-05u 123.875p 5.128476e-05u 123.8875p 5.697627e-05u 123.9p 6.26219e-05u
+ 123.9125p 6.821784e-05u 123.925p 7.376034e-05u 123.9375p 7.924566e-05u 123.95p 8.467013e-05u 123.9625p 9.003012e-05u 123.975p 9.532205e-05u 123.9875p 0.0001005424u 124p 0.0001056877u 124.0125p 0.0001107544u 124.025p 0.0001157394u 124.0375p 0.0001206391u 124.05p 0.0001254505u
+ 124.0625p 0.0001301703u 124.075p 0.0001347955u 124.0875p 0.0001393229u 124.1p 0.0001437496u 124.1125p 0.0001480728u 124.125p 0.0001522896u 124.1375p 0.0001563973u 124.15p 0.0001603931u 124.1625p 0.0001642746u 124.175p 0.0001680392u 124.1875p 0.0001716846u 124.2p 0.0001752083u
+ 124.2125p 0.0001786081u 124.225p 0.0001818819u 124.2375p 0.0001850276u 124.25p 0.0001880432u 124.2625p 0.0001909269u 124.275p 0.0001936768u 124.2875p 0.0001962913u 124.3p 0.0001987687u 124.3125p 0.0002011075u 124.325p 0.0002033064u 124.3375p 0.000205364u 124.35p 0.0002072791u
+ 124.3625p 0.0002090506u 124.375p 0.0002106775u 124.3875p 0.0002121589u 124.4p 0.0002134938u 124.4125p 0.0002146818u 124.425p 0.000215722u 124.4375p 0.0002166141u 124.45p 0.0002173575u 124.4625p 0.0002179521u 124.475p 0.0002183976u 124.4875p 0.0002186939u 124.5p 0.000218841u
+ 124.5125p 0.000218839u 124.525p 0.0002186881u 124.5375p 0.0002183886u 124.55p 0.000217941u 124.5625p 0.0002173457u 124.575p 0.0002166034u 124.5875p 0.0002157147u 124.6p 0.0002146805u 124.6125p 0.0002135017u 124.625p 0.0002121792u 124.6375p 0.0002107142u 124.65p 0.0002091078u
+ 124.6625p 0.0002073615u 124.675p 0.0002054764u 124.6875p 0.0002034542u 124.7p 0.0002012963u 124.7125p 0.0001990045u 124.725p 0.0001965805u 124.7375p 0.0001940261u 124.75p 0.0001913432u 124.7625p 0.0001885339u 124.775p 0.0001856002u 124.7875p 0.0001825443u 124.8p 0.0001793684u
+ 124.8125p 0.0001760749u 124.825p 0.0001726662u 124.8375p 0.0001691447u 124.85p 0.000165513u 124.8625p 0.0001617738u 124.875p 0.0001579296u 124.8875p 0.0001539834u 124.9p 0.0001499378u 124.9125p 0.0001457959u 124.925p 0.0001415605u 124.9375p 0.0001372346u 124.95p 0.0001328213u
+ 124.9625p 0.0001283238u 124.975p 0.0001237451u 124.9875p 0.0001190886u 125p 0.0001143575u 125.0125p 0.0001095551u 125.025p 0.0001046847u 125.0375p 9.974983e-05u 125.05p 9.475386e-05u 125.0625p 8.970027e-05u 125.075p 8.459258e-05u 125.0875p 7.943432e-05u 125.1p 7.422906e-05u
+ 125.1125p 6.898041e-05u 125.125p 6.369198e-05u 125.1375p 5.83674e-05u 125.15p 5.301036e-05u 125.1625p 4.762451e-05u 125.175p 4.221355e-05u 125.1875p 3.678119e-05u 125.2p 3.133113e-05u 125.2125p 2.58671e-05u 125.225p 2.039281e-05u 125.2375p 1.491199e-05u 125.25p 9.428365e-06u
+ 125.2625p 3.945649e-06u 125.275p -1.532445e-06u 125.2875p -7.002212e-06u 125.3p -1.245996e-05u 125.3125p -1.790201e-05u 125.325p -2.33247e-05u 125.3375p -2.872439e-05u 125.35p -3.409745e-05u 125.3625p -3.944028e-05u 125.375p -4.474932e-05u 125.3875p -5.0021e-05u 125.4p -5.525182e-05u
+ 125.4125p -6.04383e-05u 125.425p -6.557698e-05u 125.4375p -7.066446e-05u 125.45p -7.569737e-05u 125.4625p -8.067238e-05u 125.475p -8.55862e-05u 125.4875p -9.043559e-05u 125.5p -9.521737e-05u 125.5125p -9.99284e-05u 125.525p -0.0001045656u 125.5375p -0.0001091259u 125.55p -0.0001136063u
+ 125.5625p -0.000118004u 125.575p -0.0001223161u 125.5875p -0.0001265397u 125.6p -0.0001306722u 125.6125p -0.0001347108u 125.625p -0.0001386531u 125.6375p -0.0001424963u 125.65p -0.0001462382u 125.6625p -0.0001498762u 125.675p -0.0001534081u 125.6875p -0.0001568317u 125.7p -0.0001601447u
+ 125.7125p -0.0001633451u 125.725p -0.0001664309u 125.7375p -0.0001694001u 125.75p -0.0001722509u 125.7625p -0.0001749816u 125.775p -0.0001775904u 125.7875p -0.0001800757u 125.8p -0.0001824361u 125.8125p -0.0001846702u 125.825p -0.0001867765u 125.8375p -0.0001887538u 125.85p -0.0001906011u
+ 125.8625p -0.0001923171u 125.875p -0.0001939009u 125.8875p -0.0001953517u 125.9p -0.0001966685u 125.9125p -0.0001978508u 125.925p -0.0001988979u 125.9375p -0.0001998092u 125.95p -0.0002005844u 125.9625p -0.0002012231u 125.975p -0.000201725u 125.9875p -0.00020209u 126p -0.0002023179u
+ 126.0125p -0.000202409u 126.025p -0.0002023632u 126.0375p -0.0002021807u 126.05p -0.0002018619u 126.0625p -0.0002014072u 126.075p -0.000200817u 126.0875p -0.000200092u 126.1p -0.0001992327u 126.1125p -0.00019824u 126.125p -0.0001971146u 126.1375p -0.0001958576u 126.15p -0.0001944698u
+ 126.1625p -0.0001929526u 126.175p -0.0001913069u 126.1875p -0.0001895341u 126.2p -0.0001876356u 126.2125p -0.0001856127u 126.225p -0.0001834671u 126.2375p -0.0001812002u 126.25p -0.0001788139u 126.2625p -0.0001763098u 126.275p -0.0001736899u 126.2875p -0.0001709559u 126.3p -0.0001681099u
+ 126.3125p -0.000165154u 126.325p -0.0001620902u 126.3375p -0.0001589208u 126.35p -0.0001556481u 126.3625p -0.0001522743u 126.375p -0.0001488019u 126.3875p -0.0001452334u 126.4p -0.0001415712u 126.4125p -0.000137818u 126.425p -0.0001339764u 126.4375p -0.000130049u 126.45p -0.0001260387u
+ 126.4625p -0.0001219482u 126.475p -0.0001177804u 126.4875p -0.0001135383u 126.5p -0.0001092246u 126.5125p -0.0001048425u 126.525p -0.000100395u 126.5375p -9.588515e-05u 126.55p -9.131604e-05u 126.5625p -8.669085e-05u 126.575p -8.201276e-05u 126.5875p -7.728497e-05u 126.6p -7.251075e-05u
+ 126.6125p -6.769335e-05u 126.625p -6.283607e-05u 126.6375p -5.794224e-05u 126.65p -5.30152e-05u 126.6625p -4.80583e-05u 126.675p -4.307491e-05u 126.6875p -3.806843e-05u 126.7p -3.304226e-05u 126.7125p -2.79998e-05u 126.725p -2.294447e-05u 126.7375p -1.787969e-05u 126.75p -1.280888e-05u
+ 126.7625p -7.735473e-06u 126.775p -2.662879e-06u 126.7875p 2.405483e-06u 126.8p 7.466203e-06u 126.8125p 1.251588e-05u 126.825p 1.755113e-05u 126.8375p 2.256857e-05u 126.85p 2.756485e-05u 126.8625p 3.253662e-05u 126.875p 3.748057e-05u 126.8875p 4.239339e-05u 126.9p 4.727181e-05u
+ 126.9125p 5.211258e-05u 126.925p 5.691249e-05u 126.9375p 6.166835e-05u 126.95p 6.6377e-05u 126.9625p 7.103534e-05u 126.975p 7.564026e-05u 126.9875p 8.018875e-05u 127p 8.467778e-05u 127.0125p 8.910441e-05u 127.025p 9.346573e-05u 127.0375p 9.775887e-05u 127.05p 0.000101981u
+ 127.0625p 0.0001061294u 127.075p 0.0001102013u 127.0875p 0.0001141941u 127.1p 0.0001181051u 127.1125p 0.0001219319u 127.125p 0.0001256719u 127.1375p 0.0001293227u 127.15p 0.000132882u 127.1625p 0.0001363474u 127.175p 0.0001397168u 127.1875p 0.0001429879u 127.2p 0.0001461587u
+ 127.2125p 0.0001492271u 127.225p 0.0001521912u 127.2375p 0.0001550491u 127.25p 0.000157799u 127.2625p 0.0001604392u 127.275p 0.0001629679u 127.2875p 0.0001653837u 127.3p 0.000167685u 127.3125p 0.0001698704u 127.325p 0.0001719385u 127.3375p 0.0001738881u 127.35p 0.000175718u
+ 127.3625p 0.000177427u 127.375p 0.0001790143u 127.3875p 0.0001804787u 127.4p 0.0001818196u 127.4125p 0.000183036u 127.425p 0.0001841273u 127.4375p 0.000185093u 127.45p 0.0001859325u 127.4625p 0.0001866453u 127.475p 0.0001872312u 127.4875p 0.0001876899u 127.5p 0.0001880212u
+ 127.5125p 0.0001882249u 127.525p 0.0001883012u 127.5375p 0.0001882501u 127.55p 0.0001880718u 127.5625p 0.0001877665u 127.575p 0.0001873346u 127.5875p 0.0001867765u 127.6p 0.0001860927u 127.6125p 0.0001852838u 127.625p 0.0001843505u 127.6375p 0.0001832936u 127.65p 0.0001821138u
+ 127.6625p 0.0001808123u 127.675p 0.0001793898u 127.6875p 0.0001778476u 127.7p 0.0001761868u 127.7125p 0.0001744086u 127.725p 0.0001725145u 127.7375p 0.0001705057u 127.75p 0.0001683838u 127.7625p 0.0001661503u 127.775p 0.0001638068u 127.7875p 0.0001613551u 127.8p 0.0001587969u
+ 127.8125p 0.0001561341u 127.825p 0.0001533686u 127.8375p 0.0001505023u 127.85p 0.0001475373u 127.8625p 0.0001444758u 127.875p 0.0001413198u 127.8875p 0.0001380716u 127.9p 0.0001347336u 127.9125p 0.000131308u 127.925p 0.0001277973u 127.9375p 0.000124204u 127.95p 0.0001205305u
+ 127.9625p 0.0001167794u 127.975p 0.0001129534u 127.9875p 0.0001090552u 128p 0.0001050873u 128.0125p 0.0001010527u 128.025p 9.695407e-05u 128.0375p 9.279428e-05u 128.05p 8.857621e-05u 128.0625p 8.430279e-05u 128.075p 7.997696e-05u 128.0875p 7.560171e-05u 128.1p 7.118006e-05u
+ 128.1125p 6.671505e-05u 128.125p 6.220974e-05u 128.1375p 5.766724e-05u 128.15p 5.309065e-05u 128.1625p 4.848313e-05u 128.175p 4.384781e-05u 128.1875p 3.918788e-05u 128.2p 3.450651e-05u 128.2125p 2.980691e-05u 128.225p 2.509227e-05u 128.2375p 2.03658e-05u 128.25p 1.563074e-05u
+ 128.2625p 1.089028e-05u 128.275p 6.147658e-06u 128.2875p 1.406086e-06u 128.3p -3.331221e-06u 128.3125p -8.061055e-06u 128.325p -1.278022e-05u 128.3375p -1.748552e-05u 128.35p -2.217378e-05u 128.3625p -2.684184e-05u 128.375p -3.148655e-05u 128.3875p -3.610479e-05u 128.4p -4.069345e-05u
+ 128.4125p -4.524945e-05u 128.425p -4.976974e-05u 128.4375p -5.425128e-05u 128.45p -5.869107e-05u 128.4625p -6.308614e-05u 128.475p -6.743356e-05u 128.4875p -7.173043e-05u 128.5p -7.597388e-05u 128.5125p -8.016109e-05u 128.525p -8.428928e-05u 128.5375p -8.83557e-05u 128.55p -9.235767e-05u
+ 128.5625p -9.629253e-05u 128.575p -0.0001001577u 128.5875p -0.0001039506u 128.6p -0.0001076687u 128.6125p -0.0001113096u 128.625p -0.000114871u 128.6375p -0.0001183504u 128.65p -0.0001217456u 128.6625p -0.0001250543u 128.675p -0.0001282745u 128.6875p -0.0001314041u 128.7p -0.0001344409u
+ 128.7125p -0.000137383u 128.725p -0.0001402286u 128.7375p -0.0001429758u 128.75p -0.0001456229u 128.7625p -0.0001481681u 128.775p -0.0001506098u 128.7875p -0.0001529466u 128.8p -0.0001551768u 128.8125p -0.0001572992u 128.825p -0.0001593123u 128.8375p -0.000161215u 128.85p -0.000163006u
+ 128.8625p -0.0001646843u 128.875p -0.0001662488u 128.8875p -0.0001676986u 128.9p -0.0001690329u 128.9125p -0.0001702509u 128.925p -0.0001713518u 128.9375p -0.000172335u 128.95p -0.0001732u 128.9625p -0.0001739464u 128.975p -0.0001745737u 128.9875p -0.0001750817u 129p -0.0001754702u
+ 129.0125p -0.000175739u 129.025p -0.000175888u 129.0375p -0.0001759173u 129.05p -0.0001758271u 129.0625p -0.0001756175u 129.075p -0.0001752887u 129.0875p -0.0001748412u 129.1p -0.0001742753u 129.1125p -0.0001735916u 129.125p -0.0001727907u 129.1375p -0.0001718733u 129.15p -0.0001708401u
+ 129.1625p -0.0001696919u 129.175p -0.0001684297u 129.1875p -0.0001670545u 129.2p -0.0001655672u 129.2125p -0.0001639691u 129.225p -0.0001622614u 129.2375p -0.0001604453u 129.25p -0.0001585222u 129.2625p -0.0001564936u 129.275p -0.0001543609u 129.2875p -0.0001521257u 129.3p -0.0001497896u
+ 129.3125p -0.0001473544u 129.325p -0.0001448218u 129.3375p -0.0001421937u 129.35p -0.0001394719u 129.3625p -0.0001366585u 129.375p -0.0001337553u 129.3875p -0.0001307647u 129.4p -0.0001276885u 129.4125p -0.0001245291u 129.425p -0.0001212887u 129.4375p -0.0001179697u 129.45p -0.0001145742u
+ 129.4625p -0.0001111048u 129.475p -0.000107564u 129.4875p -0.0001039541u 129.5p -0.0001002777u 129.5125p -9.653748e-05u 129.525p -9.273599e-05u 129.5375p -8.887589e-05u 129.55p -8.495989e-05u 129.5625p -8.099073e-05u 129.575p -7.697116e-05u 129.5875p -7.290399e-05u 129.6p -6.879204e-05u
+ 129.6125p -6.463816e-05u 129.625p -6.044525e-05u 129.6375p -5.621619e-05u 129.65p -5.195391e-05u 129.6625p -4.766135e-05u 129.675p -4.334149e-05u 129.6875p -3.899728e-05u 129.7p -3.463172e-05u 129.7125p -3.024781e-05u 129.725p -2.584856e-05u 129.7375p -2.143698e-05u 129.75p -1.701609e-05u
+ 129.7625p -1.258892e-05u 129.775p -8.158486e-06u 129.7875p -3.727815e-06u 129.8p 7.000766e-07u 129.8125p 5.122175e-06u 129.825p 9.535475e-06u 129.8375p 1.393698e-05u 129.85p 1.832371e-05u 129.8625p 2.269269e-05u 129.875p 2.704096e-05u 129.8875p 3.13656e-05u 129.9p 3.566368e-05u
+ 129.9125p 3.99323e-05u 129.925p 4.41686e-05u 129.9375p 4.836973e-05u 129.95p 5.253288e-05u 129.9625p 5.665524e-05u 129.975p 6.073407e-05u 129.9875p 6.476664e-05u 130p 6.875026e-05u 130.0125p 7.268227e-05u 130.025p 7.656007e-05u 130.0375p 8.038108e-05u 130.05p 8.414276e-05u
+ 130.0625p 8.784264e-05u 130.075p 9.147826e-05u 130.0875p 9.504723e-05u 130.1p 9.85472e-05u 130.1125p 0.0001019759u 130.125p 0.000105331u 130.1375p 0.0001086104u 130.15p 0.0001118119u 130.1625p 0.0001149335u 130.175p 0.0001179731u 130.1875p 0.0001209288u 130.2p 0.0001237985u
+ 130.2125p 0.0001265806u 130.225p 0.0001292732u 130.2375p 0.0001318747u 130.25p 0.0001343832u 130.2625p 0.0001367973u 130.275p 0.0001391154u 130.2875p 0.0001413361u 130.3p 0.000143458u 130.3125p 0.0001454797u 130.325p 0.0001474001u 130.3375p 0.0001492178u 130.35p 0.0001509319u
+ 130.3625p 0.0001525413u 130.375p 0.0001540451u 130.3875p 0.0001554422u 130.4p 0.000156732u 130.4125p 0.0001579137u 130.425p 0.0001589866u 130.4375p 0.0001599502u 130.45p 0.0001608038u 130.4625p 0.0001615471u 130.475p 0.0001621798u 130.4875p 0.0001627014u 130.5p 0.0001631119u
+ 130.5125p 0.000163411u 130.525p 0.0001635988u 130.5375p 0.0001636751u 130.55p 0.0001636402u 130.5625p 0.0001634942u 130.575p 0.0001632373u 130.5875p 0.0001628698u 130.6p 0.0001623922u 130.6125p 0.0001618049u 130.625p 0.0001611084u 130.6375p 0.0001603034u 130.65p 0.0001593905u
+ 130.6625p 0.0001583706u 130.675p 0.0001572443u 130.6875p 0.0001560128u 130.7p 0.0001546768u 130.7125p 0.0001532375u 130.725p 0.0001516959u 130.7375p 0.0001500533u 130.75p 0.0001483109u 130.7625p 0.00014647u 130.775p 0.000144532u 130.7875p 0.0001424983u 130.8p 0.0001403705u
+ 130.8125p 0.0001381501u 130.825p 0.0001358387u 130.8375p 0.000133438u 130.85p 0.0001309497u 130.8625p 0.0001283758u 130.875p 0.000125718u 130.8875p 0.0001229782u 130.9p 0.0001201584u 130.9125p 0.0001172607u 130.925p 0.0001142871u 130.9375p 0.0001112396u 130.95p 0.0001081206u
+ 130.9625p 0.0001049321u 130.975p 0.0001016765u 130.9875p 9.835606e-05u 131p 9.497307e-05u 131.0125p 9.152995e-05u 131.025p 8.802909e-05u 131.0375p 8.447296e-05u 131.05p 8.086404e-05u 131.0625p 7.720485e-05u 131.075p 7.349793e-05u 131.0875p 6.974586e-05u 131.1p 6.595125e-05u
+ 131.1125p 6.211672e-05u 131.125p 5.824493e-05u 131.1375p 5.433855e-05u 131.15p 5.040028e-05u 131.1625p 4.643283e-05u 131.175p 4.243893e-05u 131.1875p 3.842132e-05u 131.2p 3.438275e-05u 131.2125p 3.032599e-05u 131.225p 2.625382e-05u 131.2375p 2.216902e-05u 131.25p 1.807436e-05u
+ 131.2625p 1.397265e-05u 131.275p 9.866664e-06u 131.2875p 5.759197e-06u 131.3p 1.653034e-06u 131.3125p -2.449045e-06u 131.325p -6.544265e-06u 131.3375p -1.062986e-05u 131.35p -1.470307e-05u 131.3625p -1.876116e-05u 131.375p -2.28014e-05u 131.3875p -2.682106e-05u 131.4p -3.081746e-05u
+ 131.4125p -3.478792e-05u 131.425p -3.872978e-05u 131.4375p -4.264041e-05u 131.45p -4.651721e-05u 131.4625p -5.035758e-05u 131.475p -5.415897e-05u 131.4875p -5.791887e-05u 131.5p -6.163478e-05u 131.5125p -6.530424e-05u 131.525p -6.892483e-05u 131.5375p -7.249415e-05u 131.55p -7.600987e-05u
+ 131.5625p -7.946965e-05u 131.575p -8.287125e-05u 131.5875p -8.621243e-05u 131.6p -8.9491e-05u 131.6125p -9.270483e-05u 131.625p -9.585182e-05u 131.6375p -9.892994e-05u 131.65p -0.0001019372u 131.6625p -0.0001048716u 131.675p -0.0001077313u 131.6875p -0.0001105145u 131.7p -0.0001132193u
+ 131.7125p -0.0001158441u 131.725p -0.0001183872u 131.7375p -0.0001208468u 131.75p -0.0001232216u 131.7625p -0.00012551u 131.775p -0.0001277105u 131.7875p -0.0001298219u 131.8p -0.0001318426u 131.8125p -0.0001337716u 131.825p -0.0001356077u 131.8375p -0.0001373496u 131.85p -0.0001389964u
+ 131.8625p -0.000140547u 131.875p -0.0001420006u 131.8875p -0.0001433562u 131.9p -0.0001446131u 131.9125p -0.0001457705u 131.925p -0.0001468279u 131.9375p -0.0001477846u 131.95p -0.00014864u 131.9625p -0.0001493938u 131.975p -0.0001500455u 131.9875p -0.0001505949u 132p -0.0001510417u
+ 132.0125p -0.0001513858u 132.025p -0.0001516269u 132.0375p -0.0001517652u 132.05p -0.0001518006u 132.0625p -0.0001517332u 132.075p -0.0001515632u 132.0875p -0.0001512909u 132.1p -0.0001509166u 132.1125p -0.0001504406u 132.125p -0.0001498634u 132.1375p -0.0001491855u 132.15p -0.0001484076u
+ 132.1625p -0.0001475302u 132.175p -0.000146554u 132.1875p -0.0001454799u 132.2p -0.0001443087u 132.2125p -0.0001430413u 132.225p -0.0001416787u 132.2375p -0.000140222u 132.25p -0.0001386722u 132.2625p -0.0001370304u 132.275p -0.000135298u 132.2875p -0.0001334762u 132.3p -0.0001315663u
+ 132.3125p -0.0001295698u 132.325p -0.000127488u 132.3375p -0.0001253226u 132.35p -0.000123075u 132.3625p -0.000120747u 132.375p -0.0001183401u 132.3875p -0.0001158561u 132.4p -0.0001132968u 132.4125p -0.0001106639u 132.425p -0.0001079594u 132.4375p -0.0001051852u 132.45p -0.0001023432u
+ 132.4625p -9.94355e-05u 132.475p -9.646403e-05u 132.4875p -9.343092e-05u 132.5p -9.03383e-05u 132.5125p -8.718833e-05u 132.525p -8.398322e-05u 132.5375p -8.072518e-05u 132.55p -7.741649e-05u 132.5625p -7.405945e-05u 132.575p -7.065637e-05u 132.5875p -6.720962e-05u 132.6p -6.372158e-05u
+ 132.6125p -6.019465e-05u 132.625p -5.663127e-05u 132.6375p -5.303388e-05u 132.65p -4.940495e-05u 132.6625p -4.574699e-05u 132.675p -4.206248e-05u 132.6875p -3.835396e-05u 132.7p -3.462395e-05u 132.7125p -3.087501e-05u 132.725p -2.710969e-05u 132.7375p -2.333055e-05u 132.75p -1.954016e-05u
+ 132.7625p -1.57411e-05u 132.775p -1.193594e-05u 132.7875p -8.127259e-06u 132.8p -4.31764e-06u 132.8125p -5.096538e-07u 132.825p 3.294128e-06u 132.8375p 7.09114e-06u 132.85p 1.087883e-05u 132.8625p 1.465464e-05u 132.875p 1.841604e-05u 132.8875p 2.21605e-05u 132.9p 2.588552e-05u
+ 132.9125p 2.95886e-05u 132.925p 3.326727e-05u 132.9375p 3.691906e-05u 132.95p 4.054154e-05u 132.9625p 4.413231e-05u 132.975p 4.768896e-05u 132.9875p 5.120915e-05u 133p 5.469052e-05u 133.0125p 5.813078e-05u 133.025p 6.152765e-05u 133.0375p 6.487888e-05u 133.05p 6.818227e-05u
+ 133.0625p 7.143563e-05u 133.075p 7.463683e-05u 133.0875p 7.778376e-05u 133.1p 8.087437e-05u 133.1125p 8.390663e-05u 133.125p 8.687855e-05u 133.1375p 8.97882e-05u 133.15p 9.263369e-05u 133.1625p 9.541317e-05u 133.175p 9.812483e-05u 133.1875p 0.0001007669u 133.2p 0.0001033377u
+ 133.2125p 0.0001058356u 133.225p 0.000108259u 133.2375p 0.0001106063u 133.25p 0.000112876u 133.2625p 0.0001150666u 133.275p 0.0001171769u 133.2875p 0.0001192054u 133.3p 0.0001211509u 133.3125p 0.0001230121u 133.325p 0.000124788u 133.3375p 0.0001264773u 133.35p 0.000128079u
+ 133.3625p 0.0001295923u 133.375p 0.0001310161u 133.3875p 0.0001323495u 133.4p 0.0001335919u 133.4125p 0.0001347424u 133.425p 0.0001358004u 133.4375p 0.0001367652u 133.45p 0.0001376364u 133.4625p 0.0001384134u 133.475p 0.0001390959u 133.4875p 0.0001396834u 133.5p 0.0001401757u
+ 133.5125p 0.0001405726u 133.525p 0.0001408738u 133.5375p 0.0001410794u 133.55p 0.0001411892u 133.5625p 0.0001412033u 133.575p 0.0001411219u 133.5875p 0.000140945u 133.6p 0.0001406729u 133.6125p 0.000140306u 133.625p 0.0001398444u 133.6375p 0.0001392887u 133.65p 0.0001386394u
+ 133.6625p 0.000137897u 133.675p 0.0001370621u 133.6875p 0.0001361353u 133.7p 0.0001351175u 133.7125p 0.0001340093u 133.725p 0.0001328117u 133.7375p 0.0001315256u 133.75p 0.0001301519u 133.7625p 0.0001286916u 133.775p 0.0001271459u 133.7875p 0.0001255159u 133.8p 0.0001238027u
+ 133.8125p 0.0001220077u 133.825p 0.0001201322u 133.8375p 0.0001181774u 133.85p 0.0001161449u 133.8625p 0.000114036u 133.875p 0.0001118523u 133.8875p 0.0001095954u 133.9p 0.0001072669u 133.9125p 0.0001048683u 133.925p 0.0001024016u 133.9375p 9.986823e-05u 133.95p 9.727016e-05u
+ 133.9625p 9.460919e-05u 133.975p 9.188719e-05u 133.9875p 8.910607e-05u 134p 8.626777e-05u 134.0125p 8.337428e-05u 134.025p 8.042764e-05u 134.0375p 7.742988e-05u 134.05p 7.438309e-05u 134.0625p 7.128941e-05u 134.075p 6.815096e-05u 134.0875p 6.496994e-05u 134.1p 6.174854e-05u
+ 134.1125p 5.848899e-05u 134.125p 5.519353e-05u 134.1375p 5.186445e-05u 134.15p 4.850404e-05u 134.1625p 4.51146e-05u 134.175p 4.169847e-05u 134.1875p 3.825799e-05u 134.2p 3.479551e-05u 134.2125p 3.131342e-05u 134.225p 2.781409e-05u 134.2375p 2.429991e-05u 134.25p 2.077327e-05u
+ 134.2625p 1.723659e-05u 134.275p 1.369228e-05u 134.2875p 1.014273e-05u 134.3p 6.590369e-06u 134.3125p 3.037601e-06u 134.325p -5.131644e-07u 134.3375p -4.059522e-06u 134.35p -7.599073e-06u 134.3625p -1.112943e-05u 134.375p -1.46482e-05u 134.3875p -1.815301e-05u 134.4p -2.164152e-05u
+ 134.4125p -2.511136e-05u 134.425p -2.85602e-05u 134.4375p -3.198574e-05u 134.45p -3.538568e-05u 134.4625p -3.875773e-05u 134.475p -4.209965e-05u 134.4875p -4.540919e-05u 134.5p -4.868416e-05u 134.5125p -5.192237e-05u 134.525p -5.512166e-05u 134.5375p -5.827991e-05u 134.55p -6.139502e-05u
+ 134.5625p -6.446493e-05u 134.575p -6.748761e-05u 134.5875p -7.046105e-05u 134.6p -7.33833e-05u 134.6125p -7.625243e-05u 134.625p -7.906656e-05u 134.6375p -8.182383e-05u 134.65p -8.452244e-05u 134.6625p -8.716063e-05u 134.675p -8.973667e-05u 134.6875p -9.224889e-05u 134.7p -9.469564e-05u
+ 134.7125p -9.707536e-05u 134.725p -9.938648e-05u 134.7375p -0.0001016275u 134.75p -0.0001037971u 134.7625p -0.0001058937u 134.775p -0.0001079161u 134.7875p -0.0001098629u 134.8p -0.000111733u 134.8125p -0.0001135251u 134.825p -0.0001152381u 134.8375p -0.0001168709u 134.85p -0.0001184226u
+ 134.8625p -0.0001198921u 134.875p -0.0001212786u 134.8875p -0.0001225812u 134.9p -0.0001237991u 134.9125p -0.0001249316u 134.925p -0.000125978u 134.9375p -0.0001269378u 134.95p -0.0001278102u 134.9625p -0.000128595u 134.975p -0.0001292915u 134.9875p -0.0001298995u 135p -0.0001304186u
+ 135.0125p -0.0001308487u 135.025p -0.0001311894u 135.0375p -0.0001314407u 135.05p -0.0001316024u 135.0625p -0.0001316747u 135.075p -0.0001316575u 135.0875p -0.000131551u 135.1p -0.0001313553u 135.1125p -0.0001310706u 135.125p -0.0001306973u 135.1375p -0.0001302358u 135.15p -0.0001296863u
+ 135.1625p -0.0001290495u 135.175p -0.0001283258u 135.1875p -0.0001275158u 135.2p -0.0001266202u 135.2125p -0.0001256397u 135.225p -0.000124575u 135.2375p -0.0001234271u 135.25p -0.0001221966u 135.2625p -0.0001208846u 135.275p -0.0001194921u 135.2875p -0.0001180201u 135.3p -0.0001164697u
+ 135.3125p -0.000114842u 135.325p -0.0001131382u 135.3375p -0.0001113596u 135.35p -0.0001095075u 135.3625p -0.0001075832u 135.375p -0.0001055881u 135.3875p -0.0001035236u 135.4p -0.0001013913u 135.4125p -9.919266e-05u 135.425p -9.692922e-05u 135.4375p -9.460262e-05u 135.45p -9.221452e-05u
+ 135.4625p -8.976661e-05u 135.475p -8.726062e-05u 135.4875p -8.469833e-05u 135.5p -8.208154e-05u 135.5125p -7.941209e-05u 135.525p -7.669186e-05u 135.5375p -7.392276e-05u 135.55p -7.110673e-05u 135.5625p -6.824574e-05u 135.575p -6.534178e-05u 135.5875p -6.239688e-05u 135.6p -5.941308e-05u
+ 135.6125p -5.639247e-05u 135.625p -5.333714e-05u 135.6375p -5.02492e-05u 135.65p -4.71308e-05u 135.6625p -4.398409e-05u 135.675p -4.081124e-05u 135.6875p -3.761443e-05u 135.7p -3.439588e-05u 135.7125p -3.115779e-05u 135.725p -2.790239e-05u 135.7375p -2.463191e-05u 135.75p -2.13486e-05u
+ 135.7625p -1.805469e-05u 135.775p -1.475244e-05u 135.7875p -1.144411e-05u 135.8p -8.131953e-06u 135.8125p -4.818221e-06u 135.825p -1.50517e-06u 135.8375p 1.804948e-06u 135.85p 5.109886e-06u 135.8625p 8.407405e-06u 135.875p 1.169527e-05u 135.8875p 1.497126e-05u 135.9p 1.823317e-05u
+ 135.9125p 2.147878e-05u 135.925p 2.470592e-05u 135.9375p 2.791242e-05u 135.95p 3.109611e-05u 135.9625p 3.425487e-05u 135.975p 3.738657e-05u 135.9875p 4.048913e-05u 136p 4.356046e-05u 136.0125p 4.659852e-05u 136.025p 4.960127e-05u 136.0375p 5.256674e-05u 136.05p 5.549293e-05u
+ 136.0625p 5.837792e-05u 136.075p 6.121979e-05u 136.0875p 6.401666e-05u 136.1p 6.676669e-05u 136.1125p 6.946806e-05u 136.125p 7.2119e-05u 136.1375p 7.471777e-05u 136.15p 7.726266e-05u 136.1625p 7.975201e-05u 136.175p 8.218419e-05u 136.1875p 8.455763e-05u 136.2p 8.687079e-05u
+ 136.2125p 8.912215e-05u 136.225p 9.131028e-05u 136.2375p 9.343375e-05u 136.25p 9.549121e-05u 136.2625p 9.748134e-05u 136.275p 9.940287e-05u 136.2875p 0.0001012546u 136.3p 0.0001030353u 136.3125p 0.0001047439u 136.325p 0.0001063793u 136.3375p 0.0001079405u 136.35p 0.0001094265u
+ 136.3625p 0.0001108364u 136.375p 0.0001121693u 136.3875p 0.0001134245u 136.4p 0.0001146011u 136.4125p 0.0001156986u 136.425p 0.0001167161u 136.4375p 0.0001176531u 136.45p 0.0001185092u 136.4625p 0.0001192837u 136.475p 0.0001199764u 136.4875p 0.0001205867u 136.5p 0.0001211145u
+ 136.5125p 0.0001215594u 136.525p 0.0001219212u 136.5375p 0.0001221999u 136.55p 0.0001223952u 136.5625p 0.0001225073u 136.575p 0.000122536u 136.5875p 0.0001224816u 136.6p 0.0001223441u 136.6125p 0.0001221237u 136.625p 0.0001218207u 136.6375p 0.0001214354u 136.65p 0.0001209682u
+ 136.6625p 0.0001204194u 136.675p 0.0001197896u 136.6875p 0.0001190793u 136.7p 0.0001182891u 136.7125p 0.0001174195u 136.725p 0.0001164713u 136.7375p 0.0001154453u 136.75p 0.0001143422u 136.7625p 0.0001131628u 136.775p 0.0001119082u 136.7875p 0.0001105791u 136.8p 0.0001091766u
+ 136.8125p 0.0001077018u 136.825p 0.0001061557u 136.8375p 0.0001045395u 136.85p 0.0001028544u 136.8625p 0.0001011015u 136.875p 9.928226e-05u 136.8875p 9.739787e-05u 136.9p 9.544972e-05u 136.9125p 9.343922e-05u 136.925p 9.13678e-05u 136.9375p 8.923696e-05u 136.95p 8.704821e-05u
+ 136.9625p 8.48031e-05u 136.975p 8.250324e-05u 136.9875p 8.015025e-05u 137p 7.774579e-05u 137.0125p 7.529156e-05u 137.025p 7.278929e-05u 137.0375p 7.024074e-05u 137.05p 6.764768e-05u 137.0625p 6.501194e-05u 137.075p 6.233536e-05u 137.0875p 5.961981e-05u 137.1p 5.686717e-05u
+ 137.1125p 5.407935e-05u 137.125p 5.12583e-05u 137.1375p 4.840597e-05u 137.15p 4.552433e-05u 137.1625p 4.261538e-05u 137.175p 3.968111e-05u 137.1875p 3.672356e-05u 137.2p 3.374475e-05u 137.2125p 3.074674e-05u 137.225p 2.773157e-05u 137.2375p 2.470132e-05u 137.25p 2.165806e-05u
+ 137.2625p 1.860387e-05u 137.275p 1.554083e-05u 137.2875p 1.247104e-05u 137.3p 9.396574e-06u 137.3125p 6.31953e-06u 137.325p 3.241997e-06u 137.3375p 1.660601e-07u 137.35p -2.906196e-06u 137.3625p -5.972694e-06u 137.375p -9.031363e-06u 137.3875p -1.208014e-05u 137.4p -1.511697e-05u
+ 137.4125p -1.81398e-05u 137.425p -2.114662e-05u 137.4375p -2.41354e-05u 137.45p -2.710413e-05u 137.4625p -3.005084e-05u 137.475p -3.297354e-05u 137.4875p -3.58703e-05u 137.5p -3.873917e-05u 137.5125p -4.157826e-05u 137.525p -4.438567e-05u 137.5375p -4.715955e-05u 137.55p -4.989804e-05u
+ 137.5625p -5.259935e-05u 137.575p -5.526169e-05u 137.5875p -5.78833e-05u 137.6p -6.046246e-05u 137.6125p -6.299747e-05u 137.625p -6.548668e-05u 137.6375p -6.792844e-05u 137.65p -7.032118e-05u 137.6625p -7.266332e-05u 137.675p -7.495335e-05u 137.6875p -7.718977e-05u 137.7p -7.937114e-05u
+ 137.7125p -8.149605e-05u 137.725p -8.356313e-05u 137.7375p -8.557106e-05u 137.75p -8.751854e-05u 137.7625p -8.940434e-05u 137.775p -9.122724e-05u 137.7875p -9.298611e-05u 137.8p -9.467981e-05u 137.8125p -9.63073e-05u 137.825p -9.786754e-05u 137.8375p -9.935956e-05u 137.85p -0.0001007824u
+ 137.8625p -0.0001021353u 137.875p -0.0001034173u 137.8875p -0.0001046277u 137.9p -0.0001057657u 137.9125p -0.0001068307u 137.925p -0.0001078221u 137.9375p -0.0001087391u 137.95p -0.0001095814u 137.9625p -0.0001103484u 137.975p -0.0001110398u 137.9875p -0.000111655u 138p -0.0001121939u
+ 138.0125p -0.0001126562u 138.025p -0.0001130416u 138.0375p -0.0001133499u 138.05p -0.0001135811u 138.0625p -0.000113735u 138.075p -0.0001138118u 138.0875p -0.0001138114u 138.1p -0.0001137339u 138.1125p -0.0001135794u 138.125p -0.0001133482u 138.1375p -0.0001130405u 138.15p -0.0001126567u
+ 138.1625p -0.000112197u 138.175p -0.0001116619u 138.1875p -0.0001110518u 138.2p -0.0001103672u 138.2125p -0.0001096088u 138.225p -0.000108777u 138.2375p -0.0001078726u 138.25p -0.0001068962u 138.2625p -0.0001058486u 138.275p -0.0001047306u 138.2875p -0.000103543u 138.3p -0.0001022868u
+ 138.3125p -0.0001009628u 138.325p -9.957202e-05u 138.3375p -9.811552e-05u 138.35p -9.659434e-05u 138.3625p -9.50096e-05u 138.375p -9.336244e-05u 138.3875p -9.165405e-05u 138.4p -8.988566e-05u 138.4125p -8.805855e-05u 138.425p -8.617402e-05u 138.4375p -8.423341e-05u 138.45p -8.223811e-05u
+ 138.4625p -8.018954e-05u 138.475p -7.808914e-05u 138.4875p -7.59384e-05u 138.5p -7.373883e-05u 138.5125p -7.149199e-05u 138.525p -6.919946e-05u 138.5375p -6.686283e-05u 138.55p -6.448374e-05u 138.5625p -6.206386e-05u 138.575p -5.960487e-05u 138.5875p -5.710848e-05u 138.6p -5.457643e-05u
+ 138.6125p -5.201048e-05u 138.625p -4.941239e-05u 138.6375p -4.678398e-05u 138.65p -4.412704e-05u 138.6625p -4.144342e-05u 138.675p -3.873497e-05u 138.6875p -3.600354e-05u 138.7p -3.325102e-05u 138.7125p -3.047929e-05u 138.725p -2.769024e-05u 138.7375p -2.48858e-05u 138.75p -2.206787e-05u
+ 138.7625p -1.923837e-05u 138.775p -1.639924e-05u 138.7875p -1.355241e-05u 138.8p -1.069982e-05u 138.8125p -7.843396e-06u 138.825p -4.985082e-06u 138.8375p -2.126813e-06u 138.85p 7.294749e-07u 138.8625p 3.581852e-06u 138.875p 6.428394e-06u 138.8875p 9.267179e-06u 138.9p 1.20963e-05u
+ 138.9125p 1.491385e-05u 138.925p 1.771793e-05u 138.9375p 2.050667e-05u 138.95p 2.327819e-05u 138.9625p 2.603065e-05u 138.975p 2.87622e-05u 138.9875p 3.147101e-05u 139p 3.415529e-05u 139.0125p 3.681324e-05u 139.025p 3.944309e-05u 139.0375p 4.204311e-05u 139.05p 4.461156e-05u
+ 139.0625p 4.714675e-05u 139.075p 4.964699e-05u 139.0875p 5.211065e-05u 139.1p 5.453608e-05u 139.1125p 5.692171e-05u 139.125p 5.926595e-05u 139.1375p 6.156728e-05u 139.15p 6.382419e-05u 139.1625p 6.603519e-05u 139.175p 6.819886e-05u 139.1875p 7.031377e-05u 139.2p 7.237856e-05u
+ 139.2125p 7.439189e-05u 139.225p 7.635246e-05u 139.2375p 7.8259e-05u 139.25p 8.011028e-05u 139.2625p 8.190512e-05u 139.275p 8.364237e-05u 139.2875p 8.532092e-05u 139.3p 8.69397e-05u 139.3125p 8.849769e-05u 139.325p 8.999391e-05u 139.3375p 9.142741e-05u 139.35p 9.27973e-05u
+ 139.3625p 9.410273e-05u 139.375p 9.534288e-05u 139.3875p 9.6517e-05u 139.4p 9.762437e-05u 139.4125p 9.866432e-05u 139.425p 9.963621e-05u 139.4375p 0.0001005395u 139.45p 0.0001013736u 139.4625p 0.0001021381u 139.475p 0.0001028325u 139.4875p 0.0001034564u 139.5p 0.0001040095u
+ 139.5125p 0.0001044915u 139.525p 0.0001049022u 139.5375p 0.0001052414u 139.55p 0.0001055089u 139.5625p 0.0001057046u 139.575p 0.0001058284u 139.5875p 0.0001058805u 139.6p 0.0001058607u 139.6125p 0.0001057693u 139.625p 0.0001056064u 139.6375p 0.0001053721u 139.65p 0.0001050667u
+ 139.6625p 0.0001046905u 139.675p 0.0001042438u 139.6875p 0.0001037271u 139.7p 0.0001031406u 139.7125p 0.0001024851u 139.725p 0.0001017608u 139.7375p 0.0001009685u 139.75p 0.0001001087u 139.7625p 9.918206e-05u 139.775p 9.818935e-05u 139.7875p 9.713128e-05u 139.8p 9.600866e-05u
+ 139.8125p 9.482231e-05u 139.825p 9.357311e-05u 139.8375p 9.226198e-05u 139.85p 9.088989e-05u 139.8625p 8.945782e-05u 139.875p 8.796683e-05u 139.8875p 8.641798e-05u 139.9p 8.48124e-05u 139.9125p 8.315124e-05u 139.925p 8.143568e-05u 139.9375p 7.966696e-05u 139.95p 7.784633e-05u
+ 139.9625p 7.597509e-05u 139.975p 7.405455e-05u 139.9875p 7.208609e-05u 140p 7.007109e-05u 140.0125p 6.801096e-05u 140.025p 6.590716e-05u 140.0375p 6.376116e-05u 140.05p 6.157447e-05u 140.0625p 5.934861e-05u 140.075p 5.708513e-05u 140.0875p 5.478562e-05u 140.1p 5.245166e-05u
+ 140.1125p 5.00849e-05u 140.125p 4.768695e-05u 140.1375p 4.525949e-05u 140.15p 4.28042e-05u 140.1625p 4.032277e-05u 140.175p 3.781691e-05u 140.1875p 3.528834e-05u 140.2p 3.273882e-05u 140.2125p 3.017008e-05u 140.225p 2.75839e-05u 140.2375p 2.498204e-05u 140.25p 2.236629e-05u
+ 140.2625p 1.973843e-05u 140.275p 1.710026e-05u 140.2875p 1.445359e-05u 140.3p 1.18002e-05u 140.3125p 9.141916e-06u 140.325p 6.480537e-06u 140.3375p 3.817873e-06u 140.35p 1.155728e-06u 140.3625p -1.504092e-06u 140.375p -4.159789e-06u 140.3875p -6.809566e-06u 140.4p -9.451635e-06u
+ 140.4125p -1.208421e-05u 140.425p -1.470553e-05u 140.4375p -1.731381e-05u 140.45p -1.990732e-05u 140.4625p -2.24843e-05u 140.475p -2.504303e-05u 140.4875p -2.75818e-05u 140.5p -3.00989e-05u 140.5125p -3.259267e-05u 140.525p -3.506142e-05u 140.5375p -3.750352e-05u 140.55p -3.991735e-05u
+ 140.5625p -4.23013e-05u 140.575p -4.465378e-05u 140.5875p -4.697324e-05u 140.6p -4.925814e-05u 140.6125p -5.150698e-05u 140.625p -5.371827e-05u 140.6375p -5.589055e-05u 140.65p -5.80224e-05u 140.6625p -6.011242e-05u 140.675p -6.215924e-05u 140.6875p -6.416152e-05u 140.7p -6.611795e-05u
+ 140.7125p -6.802726e-05u 140.725p -6.988822e-05u 140.7375p -7.16996e-05u 140.75p -7.346025e-05u 140.7625p -7.516903e-05u 140.775p -7.682483e-05u 140.7875p -7.842661e-05u 140.8p -7.997332e-05u 140.8125p -8.146399e-05u 140.825p -8.289767e-05u 140.8375p -8.427345e-05u 140.85p -8.559048e-05u
+ 140.8625p -8.684791e-05u 140.875p -8.804498e-05u 140.8875p -8.918093e-05u 140.9p -9.025506e-05u 140.9125p -9.126673e-05u 140.925p -9.221531e-05u 140.9375p -9.310024e-05u 140.95p -9.392099e-05u 140.9625p -9.467707e-05u 140.975p -9.536805e-05u 140.9875p -9.599354e-05u 141p -9.655318e-05u
+ 141.0125p -9.704668e-05u 141.025p -9.747377e-05u 141.0375p -9.783424e-05u 141.05p -9.812793e-05u 141.0625p -9.835471e-05u 141.075p -9.851452e-05u 141.0875p -9.86073e-05u 141.1p -9.863309e-05u 141.1125p -9.859195e-05u 141.125p -9.848397e-05u 141.1375p -9.830931e-05u 141.15p -9.806817e-05u
+ 141.1625p -9.776078e-05u 141.175p -9.738744e-05u 141.1875p -9.694847e-05u 141.2p -9.644424e-05u 141.2125p -9.587518e-05u 141.225p -9.524175e-05u 141.2375p -9.454445e-05u 141.25p -9.378384e-05u 141.2625p -9.296049e-05u 141.275p -9.207504e-05u 141.2875p -9.112817e-05u 141.3p -9.012059e-05u
+ 141.3125p -8.905306e-05u 141.325p -8.792636e-05u 141.3375p -8.674134e-05u 141.35p -8.549887e-05u 141.3625p -8.419986e-05u 141.375p -8.284525e-05u 141.3875p -8.143602e-05u 141.4p -7.997321e-05u 141.4125p -7.845787e-05u 141.425p -7.689108e-05u 141.4375p -7.527398e-05u 141.45p -7.360771e-05u
+ 141.4625p -7.189346e-05u 141.475p -7.013246e-05u 141.4875p -6.832596e-05u 141.5p -6.647524e-05u 141.5125p -6.45816e-05u 141.525p -6.264638e-05u 141.5375p -6.067095e-05u 141.55p -5.865668e-05u 141.5625p -5.6605e-05u 141.575p -5.451735e-05u 141.5875p -5.239517e-05u 141.6p -5.023996e-05u
+ 141.6125p -4.805321e-05u 141.625p -4.583645e-05u 141.6375p -4.359122e-05u 141.65p -4.131907e-05u 141.6625p -3.902159e-05u 141.675p -3.670035e-05u 141.6875p -3.435697e-05u 141.7p -3.199305e-05u 141.7125p -2.961024e-05u 141.725p -2.721016e-05u 141.7375p -2.479448e-05u 141.75p -2.236484e-05u
+ 141.7625p -1.992292e-05u 141.775p -1.747039e-05u 141.7875p -1.500891e-05u 141.8p -1.254019e-05u 141.8125p -1.00659e-05u 141.825p -7.587718e-06u 141.8375p -5.107346e-06u 141.85p -2.626464e-06u 141.8625p -1.467583e-07u 141.875p 2.33009e-06u 141.8875p 4.802402e-06u 141.9p 7.268504e-06u
+ 141.9125p 9.726731e-06u 141.925p 1.217542e-05u 141.9375p 1.461293e-05u 141.95p 1.70376e-05u 141.9625p 1.944782e-05u 141.975p 2.184196e-05u 141.9875p 2.421842e-05u 142p 2.65756e-05u 142.0125p 2.891193e-05u 142.025p 3.122584e-05u 142.0375p 3.351579e-05u 142.05p 3.578026e-05u
+ 142.0625p 3.801774e-05u 142.075p 4.022674e-05u 142.0875p 4.24058e-05u 142.1p 4.455347e-05u 142.1125p 4.666833e-05u 142.125p 4.874899e-05u 142.1375p 5.079407e-05u 142.15p 5.280224e-05u 142.1625p 5.477217e-05u 142.175p 5.670256e-05u 142.1875p 5.859217e-05u 142.2p 6.043974e-05u
+ 142.2125p 6.224409e-05u 142.225p 6.400403e-05u 142.2375p 6.571843e-05u 142.25p 6.738618e-05u 142.2625p 6.90062e-05u 142.275p 7.057745e-05u 142.2875p 7.209892e-05u 142.3p 7.356964e-05u 142.3125p 7.498867e-05u 142.325p 7.635511e-05u 142.3375p 7.76681e-05u 142.35p 7.892681e-05u
+ 142.3625p 8.013045e-05u 142.375p 8.127828e-05u 142.3875p 8.236957e-05u 142.4p 8.340367e-05u 142.4125p 8.437993e-05u 142.425p 8.529776e-05u 142.4375p 8.615661e-05u 142.45p 8.695598e-05u 142.4625p 8.769538e-05u 142.475p 8.83744e-05u 142.4875p 8.899264e-05u 142.5p 8.954975e-05u
+ 142.5125p 9.004544e-05u 142.525p 9.047944e-05u 142.5375p 9.085154e-05u 142.55p 9.116154e-05u 142.5625p 9.140933e-05u 142.575p 9.159481e-05u 142.5875p 9.171793e-05u 142.6p 9.177867e-05u 142.6125p 9.177708e-05u 142.625p 9.171323e-05u 142.6375p 9.158725e-05u 142.65p 9.139928e-05u
+ 142.6625p 9.114954e-05u 142.675p 9.083828e-05u 142.6875p 9.046576e-05u 142.7p 9.003234e-05u 142.7125p 8.953836e-05u 142.725p 8.898425e-05u 142.7375p 8.837045e-05u 142.75p 8.769745e-05u 142.7625p 8.696577e-05u 142.775p 8.6176e-05u 142.7875p 8.532873e-05u 142.8p 8.442461e-05u
+ 142.8125p 8.346432e-05u 142.825p 8.244859e-05u 142.8375p 8.137816e-05u 142.85p 8.025383e-05u 142.8625p 7.907644e-05u 142.875p 7.784684e-05u 142.8875p 7.656594e-05u 142.9p 7.523466e-05u 142.9125p 7.385396e-05u 142.925p 7.242486e-05u 142.9375p 7.094837e-05u 142.95p 6.942555e-05u
+ 142.9625p 6.78575e-05u 142.975p 6.624533e-05u 142.9875p 6.459019e-05u 143p 6.289326e-05u 143.0125p 6.115574e-05u 143.025p 5.937885e-05u 143.0375p 5.756385e-05u 143.05p 5.571202e-05u 143.0625p 5.382466e-05u 143.075p 5.190309e-05u 143.0875p 4.994865e-05u 143.1p 4.796272e-05u
+ 143.1125p 4.594668e-05u 143.125p 4.390193e-05u 143.1375p 4.18299e-05u 143.15p 3.973202e-05u 143.1625p 3.760974e-05u 143.175p 3.546454e-05u 143.1875p 3.32979e-05u 143.2p 3.111132e-05u 143.2125p 2.89063e-05u 143.225p 2.668435e-05u 143.2375p 2.444702e-05u 143.25p 2.219582e-05u
+ 143.2625p 1.993232e-05u 143.275p 1.765805e-05u 143.2875p 1.537457e-05u 143.3p 1.308344e-05u 143.3125p 1.078622e-05u 143.325p 8.484484e-06u 143.3375p 6.179792e-06u 143.35p 3.87371e-06u 143.3625p 1.567804e-06u 143.375p -7.363633e-07u 143.3875p -3.037232e-06u 143.4p -5.333245e-06u
+ 143.4125p -7.622854e-06u 143.425p -9.904513e-06u 143.4375p -1.217669e-05u 143.45p -1.443784e-05u 143.4625p -1.668647e-05u 143.475p -1.892104e-05u 143.4875p -2.114008e-05u 143.5p -2.33421e-05u 143.5125p -2.552561e-05u 143.525p -2.768917e-05u 143.5375p -2.983133e-05u 143.55p -3.195067e-05u
+ 143.5625p -3.404578e-05u 143.575p -3.611527e-05u 143.5875p -3.815776e-05u 143.6p -4.017191e-05u 143.6125p -4.215638e-05u 143.625p -4.410987e-05u 143.6375p -4.603109e-05u 143.65p -4.791878e-05u 143.6625p -4.977169e-05u 143.675p -5.158862e-05u 143.6875p -5.336839e-05u 143.7p -5.510981e-05u
+ 143.7125p -5.681178e-05u 143.725p -5.847317e-05u 143.7375p -6.009292e-05u 143.75p -6.166997e-05u 143.7625p -6.320331e-05u 143.775p -6.469196e-05u 143.7875p -6.613496e-05u 143.8p -6.753138e-05u 143.8125p -6.888035e-05u 143.825p -7.018099e-05u 143.8375p -7.14325e-05u 143.85p -7.263407e-05u
+ 143.8625p -7.378497e-05u 143.875p -7.488446e-05u 143.8875p -7.593188e-05u 143.9p -7.692656e-05u 143.9125p -7.786791e-05u 143.925p -7.875535e-05u 143.9375p -7.958834e-05u 143.95p -8.036639e-05u 143.9625p -8.108903e-05u 143.975p -8.175585e-05u 143.9875p -8.236645e-05u 144p -8.29205e-05u
+ 144.0125p -8.341769e-05u 144.025p -8.385774e-05u 144.0375p -8.424044e-05u 144.05p -8.456559e-05u 144.0625p -8.483304e-05u 144.075p -8.504268e-05u 144.0875p -8.519444e-05u 144.1p -8.528829e-05u 144.1125p -8.532423e-05u 144.125p -8.53023e-05u 144.1375p -8.522261e-05u 144.15p -8.508525e-05u
+ 144.1625p -8.489041e-05u 144.175p -8.463829e-05u 144.1875p -8.432911e-05u 144.2p -8.396317e-05u 144.2125p -8.354078e-05u 144.225p -8.306228e-05u 144.2375p -8.252809e-05u 144.25p -8.193862e-05u 144.2625p -8.129433e-05u 144.275p -8.059575e-05u 144.2875p -7.984339e-05u 144.3p -7.903784e-05u
+ 144.3125p -7.817971e-05u 144.325p -7.726964e-05u 144.3375p -7.630831e-05u 144.35p -7.529644e-05u 144.3625p -7.423477e-05u 144.375p -7.312408e-05u 144.3875p -7.196518e-05u 144.4p -7.075891e-05u 144.4125p -6.950616e-05u 144.425p -6.820782e-05u 144.4375p -6.686483e-05u 144.45p -6.547815e-05u
+ 144.4625p -6.404877e-05u 144.475p -6.257772e-05u 144.4875p -6.106604e-05u 144.5p -5.95148e-05u 144.5125p -5.792511e-05u 144.525p -5.629808e-05u 144.5375p -5.463486e-05u 144.55p -5.293663e-05u 144.5625p -5.120456e-05u 144.575p -4.943989e-05u 144.5875p -4.764384e-05u 144.6p -4.581767e-05u
+ 144.6125p -4.396265e-05u 144.625p -4.208007e-05u 144.6375p -4.017124e-05u 144.65p -3.823749e-05u 144.6625p -3.628015e-05u 144.675p -3.430058e-05u 144.6875p -3.230014e-05u 144.7p -3.028022e-05u 144.7125p -2.824221e-05u 144.725p -2.618751e-05u 144.7375p -2.411752e-05u 144.75p -2.203368e-05u
+ 144.7625p -1.993741e-05u 144.775p -1.783015e-05u 144.7875p -1.571333e-05u 144.8p -1.35884e-05u 144.8125p -1.14568e-05u 144.825p -9.320001e-06u 144.8375p -7.179444e-06u 144.85p -5.036586e-06u 144.8625p -2.89288e-06u 144.875p -7.4978e-07u 144.8875p 1.391263e-06u 144.9p 3.528802e-06u
+ 144.9125p 5.661394e-06u 144.925p 7.787598e-06u 144.9375p 9.905984e-06u 144.95p 1.201513e-05u 144.9625p 1.41136e-05u 144.975p 1.620001e-05u 144.9875p 1.827295e-05u 145p 2.033104e-05u 145.0125p 2.237289e-05u 145.025p 2.439714e-05u 145.0375p 2.640244e-05u 145.05p 2.838746e-05u
+ 145.0625p 3.035088e-05u 145.075p 3.22914e-05u 145.0875p 3.420771e-05u 145.1p 3.609857e-05u 145.1125p 3.796271e-05u 145.125p 3.97989e-05u 145.1375p 4.160594e-05u 145.15p 4.338264e-05u 145.1625p 4.512783e-05u 145.175p 4.684035e-05u 145.1875p 4.851911e-05u 145.2p 5.016298e-05u
+ 145.2125p 5.177092e-05u 145.225p 5.334185e-05u 145.2375p 5.487478e-05u 145.25p 5.63687e-05u 145.2625p 5.782265e-05u 145.275p 5.923569e-05u 145.2875p 6.060691e-05u 145.3p 6.193544e-05u 145.3125p 6.322042e-05u 145.325p 6.446104e-05u 145.3375p 6.565651e-05u 145.35p 6.680607e-05u
+ 145.3625p 6.790899e-05u 145.375p 6.896459e-05u 145.3875p 6.997221e-05u 145.4p 7.093122e-05u 145.4125p 7.184103e-05u 145.425p 7.270108e-05u 145.4375p 7.351085e-05u 145.45p 7.426985e-05u 145.4625p 7.497763e-05u 145.475p 7.563375e-05u 145.4875p 7.623786e-05u 145.5p 7.678958e-05u
+ 145.5125p 7.728863e-05u 145.525p 7.773471e-05u 145.5375p 7.812758e-05u 145.55p 7.846706e-05u 145.5625p 7.875296e-05u 145.575p 7.898516e-05u 145.5875p 7.916356e-05u 145.6p 7.928811e-05u 145.6125p 7.935879e-05u 145.625p 7.93756e-05u 145.6375p 7.933862e-05u 145.65p 7.924791e-05u
+ 145.6625p 7.910362e-05u 145.675p 7.890589e-05u 145.6875p 7.865493e-05u 145.7p 7.835097e-05u 145.7125p 7.799427e-05u 145.725p 7.758515e-05u 145.7375p 7.712393e-05u 145.75p 7.661101e-05u 145.7625p 7.604677e-05u 145.775p 7.543167e-05u 145.7875p 7.476618e-05u 145.8p 7.405081e-05u
+ 145.8125p 7.328611e-05u 145.825p 7.247266e-05u 145.8375p 7.161105e-05u 145.85p 7.070194e-05u 145.8625p 6.974598e-05u 145.875p 6.87439e-05u 145.8875p 6.769641e-05u 145.9p 6.660429e-05u 145.9125p 6.546832e-05u 145.925p 6.428933e-05u 145.9375p 6.306817e-05u 145.95p 6.180571e-05u
+ 145.9625p 6.050285e-05u 145.975p 5.916054e-05u 145.9875p 5.777971e-05u 146p 5.636136e-05u 146.0125p 5.49065e-05u 146.025p 5.341614e-05u 146.0375p 5.189134e-05u 146.05p 5.033317e-05u 146.0625p 4.874273e-05u 146.075p 4.712114e-05u 146.0875p 4.546953e-05u 146.1p 4.378905e-05u
+ 146.1125p 4.208089e-05u 146.125p 4.034621e-05u 146.1375p 3.858625e-05u 146.15p 3.680221e-05u 146.1625p 3.499533e-05u 146.175p 3.316687e-05u 146.1875p 3.131809e-05u 146.2p 2.945026e-05u 146.2125p 2.756468e-05u 146.225p 2.566265e-05u 146.2375p 2.374546e-05u 146.25p 2.181445e-05u
+ 146.2625p 1.987093e-05u 146.275p 1.791623e-05u 146.2875p 1.59517e-05u 146.3p 1.397868e-05u 146.3125p 1.199851e-05u 146.325p 1.001254e-05u 146.3375p 8.022136e-06u 146.35p 6.02864e-06u 146.3625p 4.033411e-06u 146.375p 2.037803e-06u 146.3875p 4.316932e-08u 146.4p -1.94914e-06u
+ 146.4125p -3.937776e-06u 146.425p -5.921396e-06u 146.4375p -7.89866e-06u 146.45p -9.868237e-06u 146.4625p -1.18288e-05u 146.475p -1.377903e-05u 146.4875p -1.571762e-05u 146.5p -1.764326e-05u 146.5125p -1.955468e-05u 146.525p -2.145058e-05u 146.5375p -2.33297e-05u 146.55p -2.519079e-05u
+ 146.5625p -2.70326e-05u 146.575p -2.885392e-05u 146.5875p -3.065352e-05u 146.6p -3.243022e-05u 146.6125p -3.418284e-05u 146.625p -3.591021e-05u 146.6375p -3.76112e-05u 146.65p -3.928469e-05u 146.6625p -4.092956e-05u 146.675p -4.254475e-05u 146.6875p -4.412918e-05u 146.7p -4.568183e-05u
+ 146.7125p -4.720167e-05u 146.725p -4.868771e-05u 146.7375p -5.0139e-05u 146.75p -5.155457e-05u 146.7625p -5.293352e-05u 146.775p -5.427495e-05u 146.7875p -5.5578e-05u 146.8p -5.684183e-05u 146.8125p -5.806562e-05u 146.825p -5.924861e-05u 146.8375p -6.039002e-05u 146.85p -6.148913e-05u
+ 146.8625p -6.254526e-05u 146.875p -6.355773e-05u 146.8875p -6.452591e-05u 146.9p -6.54492e-05u 146.9125p -6.632701e-05u 146.925p -6.715882e-05u 146.9375p -6.79441e-05u 146.95p -6.868239e-05u 146.9625p -6.937323e-05u 146.975p -7.001621e-05u 146.9875p -7.061096e-05u 147p -7.115712e-05u
+ 147.0125p -7.165439e-05u 147.025p -7.210248e-05u 147.0375p -7.250115e-05u 147.05p -7.285018e-05u 147.0625p -7.31494e-05u 147.075p -7.339866e-05u 147.0875p -7.359785e-05u 147.1p -7.37469e-05u 147.1125p -7.384576e-05u 147.125p -7.389443e-05u 147.1375p -7.389293e-05u 147.15p -7.384132e-05u
+ 147.1625p -7.37397e-05u 147.175p -7.358819e-05u 147.1875p -7.338696e-05u 147.2p -7.31362e-05u 147.2125p -7.283613e-05u 147.225p -7.248703e-05u 147.2375p -7.208918e-05u 147.25p -7.164291e-05u 147.2625p -7.114859e-05u 147.275p -7.060659e-05u 147.2875p -7.001736e-05u 147.3p -6.938134e-05u
+ 147.3125p -6.869902e-05u 147.325p -6.797092e-05u 147.3375p -6.719758e-05u 147.35p -6.637958e-05u 147.3625p -6.551754e-05u 147.375p -6.461208e-05u 147.3875p -6.366388e-05u 147.4p -6.267362e-05u 147.4125p -6.164203e-05u 147.425p -6.056986e-05u 147.4375p -5.945787e-05u 147.45p -5.830689e-05u
+ 147.4625p -5.711772e-05u 147.475p -5.589123e-05u 147.4875p -5.462828e-05u 147.5p -5.332978e-05u 147.5125p -5.199666e-05u 147.525p -5.062985e-05u 147.5375p -4.923032e-05u 147.55p -4.779907e-05u 147.5625p -4.633709e-05u 147.575p -4.484543e-05u 147.5875p -4.332512e-05u 147.6p -4.177724e-05u
+ 147.6125p -4.020285e-05u 147.625p -3.860308e-05u 147.6375p -3.697902e-05u 147.65p -3.533181e-05u 147.6625p -3.366259e-05u 147.675p -3.197253e-05u 147.6875p -3.02628e-05u 147.7p -2.853457e-05u 147.7125p -2.678905e-05u 147.725p -2.502743e-05u 147.7375p -2.325093e-05u 147.75p -2.146078e-05u
+ 147.7625p -1.965821e-05u 147.775p -1.784444e-05u 147.7875p -1.602074e-05u 147.8p -1.418834e-05u 147.8125p -1.23485e-05u 147.825p -1.050248e-05u 147.8375p -8.651538e-06u 147.85p -6.796932e-06u 147.8625p -4.939927e-06u 147.875p -3.081786e-06u 147.8875p -1.223772e-06u 147.9p 6.328565e-07u
+ 147.9125p 2.48684e-06u 147.925p 4.336924e-06u 147.9375p 6.181859e-06u 147.95p 8.020398e-06u 147.9625p 9.851302e-06u 147.975p 1.167334e-05u 147.9875p 1.348528e-05u 148p 1.528591e-05u 148.0125p 1.707402e-05u 148.025p 1.884841e-05u 148.0375p 2.06079e-05u 148.05p 2.235131e-05u
+ 148.0625p 2.407747e-05u 148.075p 2.578524e-05u 148.0875p 2.747348e-05u 148.1p 2.914106e-05u 148.1125p 3.078688e-05u 148.125p 3.240985e-05u 148.1375p 3.400889e-05u 148.15p 3.558296e-05u 148.1625p 3.7131e-05u 148.175p 3.865201e-05u 148.1875p 4.014498e-05u 148.2p 4.160893e-05u
+ 148.2125p 4.304291e-05u 148.225p 4.444597e-05u 148.2375p 4.581721e-05u 148.25p 4.715573e-05u 148.2625p 4.846066e-05u 148.275p 4.973116e-05u 148.2875p 5.09664e-05u 148.3p 5.216559e-05u 148.3125p 5.332797e-05u 148.325p 5.445278e-05u 148.3375p 5.553931e-05u 148.35p 5.658686e-05u
+ 148.3625p 5.759478e-05u 148.375p 5.856242e-05u 148.3875p 5.948919e-05u 148.4p 6.037449e-05u 148.4125p 6.121779e-05u 148.425p 6.201855e-05u 148.4375p 6.277628e-05u 148.45p 6.349053e-05u 148.4625p 6.416086e-05u 148.475p 6.478687e-05u 148.4875p 6.536818e-05u 148.5p 6.590447e-05u
+ 148.5125p 6.639541e-05u 148.525p 6.684073e-05u 148.5375p 6.724018e-05u 148.55p 6.759355e-05u 148.5625p 6.790065e-05u 148.575p 6.816133e-05u 148.5875p 6.837547e-05u 148.6p 6.854298e-05u 148.6125p 6.86638e-05u 148.625p 6.873791e-05u 148.6375p 6.876532e-05u 148.65p 6.874605e-05u
+ 148.6625p 6.868018e-05u 148.675p 6.856782e-05u 148.6875p 6.840909e-05u 148.7p 6.820415e-05u 148.7125p 6.795321e-05u 148.725p 6.765649e-05u 148.7375p 6.731424e-05u 148.75p 6.692675e-05u 148.7625p 6.649435e-05u 148.775p 6.601737e-05u 148.7875p 6.549619e-05u 148.8p 6.493122e-05u
+ 148.8125p 6.43229e-05u 148.825p 6.36717e-05u 148.8375p 6.29781e-05u 148.85p 6.224263e-05u 148.8625p 6.146583e-05u 148.875p 6.064829e-05u 148.8875p 5.97906e-05u 148.9p 5.889341e-05u 148.9125p 5.795735e-05u 148.925p 5.698313e-05u 148.9375p 5.597144e-05u 148.95p 5.492301e-05u
+ 148.9625p 5.38386e-05u 148.975p 5.271899e-05u 148.9875p 5.156498e-05u 149p 5.037739e-05u 149.0125p 4.915708e-05u 149.025p 4.79049e-05u 149.0375p 4.662175e-05u 149.05p 4.530854e-05u 149.0625p 4.396618e-05u 149.075p 4.259563e-05u 149.0875p 4.119785e-05u 149.1p 3.977382e-05u
+ 149.1125p 3.832454e-05u 149.125p 3.685102e-05u 149.1375p 3.535429e-05u 149.15p 3.38354e-05u 149.1625p 3.229539e-05u 149.175p 3.073534e-05u 149.1875p 2.915633e-05u 149.2p 2.755946e-05u 149.2125p 2.594583e-05u 149.225p 2.431655e-05u 149.2375p 2.267275e-05u 149.25p 2.101555e-05u
+ 149.2625p 1.934611e-05u 149.275p 1.766557e-05u 149.2875p 1.597507e-05u 149.3p 1.427578e-05u 149.3125p 1.256886e-05u 149.325p 1.085548e-05u 149.3375p 9.136804e-06u 149.35p 7.414006e-06u 149.3625p 5.688259e-06u 149.375p 3.960737e-06u 149.3875p 2.232612e-06u 149.4p 5.050571e-07u
+ 149.4125p -1.220757e-06u 149.425p -2.943662e-06u 149.4375p -4.662495e-06u 149.45p -6.376094e-06u 149.4625p -8.083304e-06u 149.475p -9.782975e-06u 149.4875p -1.147397e-05u 149.5p -1.315514e-05u 149.5125p -1.482537e-05u 149.525p -1.648353e-05u 149.5375p -1.812852e-05u 149.55p -1.975924e-05u
+ 149.5625p -2.137459e-05u 149.575p -2.297351e-05u 149.5875p -2.455493e-05u 149.6p -2.611779e-05u 149.6125p -2.766107e-05u 149.625p -2.918373e-05u 149.6375p -3.068478e-05u 149.65p -3.216322e-05u 149.6625p -3.361807e-05u 149.675p -3.504837e-05u 149.6875p -3.64532e-05u 149.7p -3.783162e-05u
+ 149.7125p -3.918274e-05u 149.725p -4.050567e-05u 149.7375p -4.179954e-05u 149.75p -4.306352e-05u 149.7625p -4.429679e-05u 149.775p -4.549855e-05u 149.7875p -4.666801e-05u 149.8p -4.780444e-05u 149.8125p -4.890709e-05u 149.825p -4.997526e-05u 149.8375p -5.100827e-05u 149.85p -5.200545e-05u
+ 149.8625p -5.296619e-05u 149.875p -5.388987e-05u 149.8875p -5.47759e-05u 149.9p -5.562374e-05u 149.9125p -5.643286e-05u 149.925p -5.720275e-05u 149.9375p -5.793294e-05u 149.95p -5.862299e-05u 149.9625p -5.927246e-05u 149.975p -5.988098e-05u 149.9875p -6.044818e-05u 150p -6.097373e-05u
+ 150.0125p -6.145731e-05u 150.025p -6.189865e-05u 150.0375p -6.229751e-05u 150.05p -6.265367e-05u 150.0625p -6.296693e-05u 150.075p -6.323713e-05u 150.0875p -6.346414e-05u 150.1p -6.364787e-05u 150.1125p -6.378824e-05u 150.125p -6.38852e-05u 150.1375p -6.393875e-05u 150.15p -6.394889e-05u
+ 150.1625p -6.391568e-05u 150.175p -6.383919e-05u 150.1875p -6.371952e-05u 150.2p -6.355681e-05u 150.2125p -6.335122e-05u 150.225p -6.310293e-05u 150.2375p -6.281218e-05u 150.25p -6.24792e-05u 150.2625p -6.210428e-05u 150.275p -6.168771e-05u 150.2875p -6.122984e-05u 150.3p -6.073101e-05u
+ 150.3125p -6.019163e-05u 150.325p -5.96121e-05u 150.3375p -5.899286e-05u 150.35p -5.833438e-05u 150.3625p -5.763715e-05u 150.375p -5.69017e-05u 150.3875p -5.612857e-05u 150.4p -5.531833e-05u 150.4125p -5.447156e-05u 150.425p -5.35889e-05u 150.4375p -5.267097e-05u 150.45p -5.171845e-05u
+ 150.4625p -5.073202e-05u 150.475p -4.971239e-05u 150.4875p -4.866029e-05u 150.5p -4.757647e-05u 150.5125p -4.646171e-05u 150.525p -4.53168e-05u 150.5375p -4.414255e-05u 150.55p -4.293979e-05u 150.5625p -4.170938e-05u 150.575p -4.045217e-05u 150.5875p -3.916905e-05u 150.6p -3.786092e-05u
+ 150.6125p -3.65287e-05u 150.625p -3.517333e-05u 150.6375p -3.379574e-05u 150.65p -3.23969e-05u 150.6625p -3.097777e-05u 150.675p -2.953936e-05u 150.6875p -2.808264e-05u 150.7p -2.660865e-05u 150.7125p -2.511838e-05u 150.725p -2.361288e-05u 150.7375p -2.209317e-05u 150.75p -2.056032e-05u
+ 150.7625p -1.901536e-05u 150.775p -1.745937e-05u 150.7875p -1.589341e-05u 150.8p -1.431855e-05u 150.8125p -1.273588e-05u 150.825p -1.114647e-05u 150.8375p -9.551404e-06u 150.85p -7.951777e-06u 150.8625p -6.348677e-06u 150.875p -4.743192e-06u 150.8875p -3.136414e-06u 150.9p -1.529433e-06u
+ 150.9125p 7.666111e-08u 150.925p 1.680782e-06u 150.9375p 3.281844e-06u 150.95p 4.878767e-06u 150.9625p 6.470474e-06u 150.975p 8.055891e-06u 150.9875p 9.633953e-06u 151p 1.12036e-05u 151.0125p 1.276377e-05u 151.025p 1.431343e-05u 151.0375p 1.585154e-05u 151.05p 1.737706e-05u
+ 151.0625p 1.888899e-05u 151.075p 2.03863e-05u 151.0875p 2.186801e-05u 151.1p 2.333313e-05u 151.1125p 2.478069e-05u 151.125p 2.620972e-05u 151.1375p 2.761928e-05u 151.15p 2.900844e-05u 151.1625p 3.037628e-05u 151.175p 3.172189e-05u 151.1875p 3.304441e-05u 151.2p 3.434294e-05u
+ 151.2125p 3.561666e-05u 151.225p 3.686471e-05u 151.2375p 3.808629e-05u 151.25p 3.928059e-05u 151.2625p 4.044685e-05u 151.275p 4.158431e-05u 151.2875p 4.269223e-05u 151.3p 4.376989e-05u 151.3125p 4.48166e-05u 151.325p 4.583168e-05u 151.3375p 4.68145e-05u 151.35p 4.776441e-05u
+ 151.3625p 4.868082e-05u 151.375p 4.956314e-05u 151.3875p 5.041082e-05u 151.4p 5.122332e-05u 151.4125p 5.200014e-05u 151.425p 5.274079e-05u 151.4375p 5.344482e-05u 151.45p 5.411178e-05u 151.4625p 5.474127e-05u 151.475p 5.533291e-05u 151.4875p 5.588634e-05u 151.5p 5.640124e-05u
+ 151.5125p 5.68773e-05u 151.525p 5.731425e-05u 151.5375p 5.771182e-05u 151.55p 5.806981e-05u 151.5625p 5.838802e-05u 151.575p 5.866628e-05u 151.5875p 5.890444e-05u 151.6p 5.91024e-05u 151.6125p 5.926006e-05u 151.625p 5.937738e-05u 151.6375p 5.945431e-05u 151.65p 5.949085e-05u
+ 151.6625p 5.948703e-05u 151.675p 5.944289e-05u 151.6875p 5.935852e-05u 151.7p 5.923402e-05u 151.7125p 5.906953e-05u 151.725p 5.886519e-05u 151.7375p 5.86212e-05u 151.75p 5.833776e-05u 151.7625p 5.801513e-05u 151.775p 5.765356e-05u 151.7875p 5.725334e-05u 151.8p 5.68148e-05u
+ 151.8125p 5.633827e-05u 151.825p 5.582412e-05u 151.8375p 5.527274e-05u 151.85p 5.468456e-05u 151.8625p 5.406002e-05u 151.875p 5.339958e-05u 151.8875p 5.270373e-05u 151.9p 5.197298e-05u 151.9125p 5.120788e-05u 151.925p 5.040898e-05u 151.9375p 4.957687e-05u 151.95p 4.871214e-05u
+ 151.9625p 4.781542e-05u 151.975p 4.688736e-05u 151.9875p 4.592862e-05u 152p 4.493989e-05u 152.0125p 4.392188e-05u 152.025p 4.28753e-05u 152.0375p 4.180091e-05u 152.05p 4.069947e-05u 152.0625p 3.957174e-05u 152.075p 3.841854e-05u 152.0875p 3.724066e-05u 152.1p 3.603895e-05u
+ 152.1125p 3.481423e-05u 152.125p 3.356737e-05u 152.1375p 3.229924e-05u 152.15p 3.101072e-05u 152.1625p 2.970271e-05u 152.175p 2.837613e-05u 152.1875p 2.703189e-05u 152.2p 2.567092e-05u 152.2125p 2.429416e-05u 152.225p 2.290258e-05u 152.2375p 2.149712e-05u 152.25p 2.007876e-05u
+ 152.2625p 1.864848e-05u 152.275p 1.720725e-05u 152.2875p 1.575607e-05u 152.3p 1.429594e-05u 152.3125p 1.282784e-05u 152.325p 1.13528e-05u 152.3375p 9.871813e-06u 152.35p 8.385892e-06u 152.3625p 6.896052e-06u 152.375p 5.403306e-06u 152.3875p 3.908669e-06u 152.4p 2.413158e-06u
+ 152.4125p 9.177872e-07u 152.425p -5.764303e-07u 152.4375p -2.068483e-06u 152.45p -3.557362e-06u 152.4625p -5.042062e-06u 152.475p -6.521581e-06u 152.4875p -7.994923e-06u 152.5p -9.461096e-06u 152.5125p -1.091911e-05u 152.525p -1.2368e-05u 152.5375p -1.380678e-05u 152.55p -1.52345e-05u
+ 152.5625p -1.665019e-05u 152.575p -1.805291e-05u 152.5875p -1.944173e-05u 152.6p -2.081572e-05u 152.6125p -2.217397e-05u 152.625p -2.351557e-05u 152.6375p -2.483964e-05u 152.65p -2.61453e-05u 152.6625p -2.743169e-05u 152.675p -2.869795e-05u 152.6875p -2.994325e-05u 152.7p -3.116677e-05u
+ 152.7125p -3.236772e-05u 152.725p -3.354529e-05u 152.7375p -3.469872e-05u 152.75p -3.582726e-05u 152.7625p -3.693018e-05u 152.775p -3.800674e-05u 152.7875p -3.905626e-05u 152.8p -4.007806e-05u 152.8125p -4.107147e-05u 152.825p -4.203586e-05u 152.8375p -4.29706e-05u 152.85p -4.387511e-05u
+ 152.8625p -4.474879e-05u 152.875p -4.559109e-05u 152.8875p -4.640149e-05u 152.9p -4.717946e-05u 152.9125p -4.792453e-05u 152.925p -4.863621e-05u 152.9375p -4.931408e-05u 152.95p -4.995771e-05u 152.9625p -5.05667e-05u 152.975p -5.114069e-05u 152.9875p -5.167932e-05u 153p -5.218227e-05u
+ 153.0125p -5.264925e-05u 153.025p -5.307997e-05u 153.0375p -5.34742e-05u 153.05p -5.38317e-05u 153.0625p -5.415227e-05u 153.075p -5.443575e-05u 153.0875p -5.468199e-05u 153.1p -5.489085e-05u 153.1125p -5.506225e-05u 153.125p -5.519612e-05u 153.1375p -5.52924e-05u 153.15p -5.535107e-05u
+ 153.1625p -5.537215e-05u 153.175p -5.535565e-05u 153.1875p -5.530165e-05u 153.2p -5.521021e-05u 153.2125p -5.508144e-05u 153.225p -5.491548e-05u 153.2375p -5.471248e-05u 153.25p -5.447263e-05u 153.2625p -5.419612e-05u 153.275p -5.38832e-05u 153.2875p -5.353411e-05u 153.3p -5.314913e-05u
+ 153.3125p -5.272858e-05u 153.325p -5.227277e-05u 153.3375p -5.178206e-05u 153.35p -5.125683e-05u 153.3625p -5.069746e-05u 153.375p -5.010438e-05u 153.3875p -4.947803e-05u 153.4p -4.881888e-05u 153.4125p -4.81274e-05u 153.425p -4.740412e-05u 153.4375p -4.664955e-05u 153.45p -4.586425e-05u
+ 153.4625p -4.504878e-05u 153.475p -4.420374e-05u 153.4875p -4.332973e-05u 153.5p -4.242737e-05u 153.5125p -4.149732e-05u 153.525p -4.054024e-05u 153.5375p -3.955681e-05u 153.55p -3.854773e-05u 153.5625p -3.75137e-05u 153.575p -3.645548e-05u 153.5875p -3.537379e-05u 153.6p -3.42694e-05u
+ 153.6125p -3.314309e-05u 153.625p -3.199564e-05u 153.6375p -3.082787e-05u 153.65p -2.964058e-05u 153.6625p -2.843461e-05u 153.675p -2.721079e-05u 153.6875p -2.596998e-05u 153.7p -2.471304e-05u 153.7125p -2.344084e-05u 153.725p -2.215426e-05u 153.7375p -2.085418e-05u 153.75p -1.954152e-05u
+ 153.7625p -1.821717e-05u 153.775p -1.688205e-05u 153.7875p -1.553707e-05u 153.8p -1.418315e-05u 153.8125p -1.282124e-05u 153.825p -1.145225e-05u 153.8375p -1.007713e-05u 153.85p -8.696823e-06u 153.8625p -7.312261e-06u 153.875p -5.924392e-06u 153.8875p -4.534162e-06u 153.9p -3.142516e-06u
+ 153.9125p -1.7504e-06u 153.925p -3.58758e-07u 153.9375p 1.031466e-06u 153.95p 2.41933e-06u 153.9625p 3.803897e-06u 153.975p 5.184231e-06u 153.9875p 6.559401e-06u 154p 7.928481e-06u 154.0125p 9.290549e-06u 154.025p 1.064469e-05u 154.0375p 1.199e-05u 154.05p 1.332556e-05u
+ 154.0625p 1.46505e-05u 154.075p 1.596391e-05u 154.0875p 1.726494e-05u 154.1p 1.855269e-05u 154.1125p 1.982633e-05u 154.125p 2.108501e-05u 154.1375p 2.232787e-05u 154.15p 2.355412e-05u 154.1625p 2.476292e-05u 154.175p 2.595348e-05u 154.1875p 2.712503e-05u 154.2p 2.827677e-05u
+ 154.2125p 2.940797e-05u 154.225p 3.051787e-05u 154.2375p 3.160574e-05u 154.25p 3.267088e-05u 154.2625p 3.37126e-05u 154.275p 3.47302e-05u 154.2875p 3.572304e-05u 154.3p 3.669046e-05u 154.3125p 3.763185e-05u 154.325p 3.854659e-05u 154.3375p 3.943409e-05u 154.35p 4.029379e-05u
+ 154.3625p 4.112514e-05u 154.375p 4.192761e-05u 154.3875p 4.270068e-05u 154.4p 4.344387e-05u 154.4125p 4.415672e-05u 154.425p 4.483876e-05u 154.4375p 4.548958e-05u 154.45p 4.610878e-05u 154.4625p 4.669597e-05u 154.475p 4.725079e-05u 154.4875p 4.77729e-05u 154.5p 4.826199e-05u
+ 154.5125p 4.871777e-05u 154.525p 4.913997e-05u 154.5375p 4.952835e-05u 154.55p 4.988267e-05u 154.5625p 5.020274e-05u 154.575p 5.048838e-05u 154.5875p 5.073945e-05u 154.6p 5.095581e-05u 154.6125p 5.113736e-05u 154.625p 5.128401e-05u 154.6375p 5.139571e-05u 154.65p 5.147243e-05u
+ 154.6625p 5.151416e-05u 154.675p 5.15209e-05u 154.6875p 5.14927e-05u 154.7p 5.142962e-05u 154.7125p 5.133174e-05u 154.725p 5.119917e-05u 154.7375p 5.103204e-05u 154.75p 5.083051e-05u 154.7625p 5.059476e-05u 154.775p 5.032498e-05u 154.7875p 5.00214e-05u 154.8p 4.968427e-05u
+ 154.8125p 4.931385e-05u 154.825p 4.891044e-05u 154.8375p 4.847435e-05u 154.85p 4.800591e-05u 154.8625p 4.750549e-05u 154.875p 4.697346e-05u 154.8875p 4.641021e-05u 154.9p 4.581617e-05u 154.9125p 4.519178e-05u 154.925p 4.45375e-05u 154.9375p 4.38538e-05u 154.95p 4.314119e-05u
+ 154.9625p 4.240019e-05u 154.975p 4.163132e-05u 154.9875p 4.083515e-05u 155p 4.001225e-05u 155.0125p 3.916321e-05u 155.025p 3.828863e-05u 155.0375p 3.738914e-05u 155.05p 3.646538e-05u 155.0625p 3.551801e-05u 155.075p 3.454769e-05u 155.0875p 3.355511e-05u 155.1p 3.254097e-05u
+ 155.1125p 3.150599e-05u 155.125p 3.045089e-05u 155.1375p 2.937641e-05u 155.15p 2.828331e-05u 155.1625p 2.717234e-05u 155.175p 2.604428e-05u 155.1875p 2.489992e-05u 155.2p 2.374005e-05u 155.2125p 2.256547e-05u 155.225p 2.137701e-05u 155.2375p 2.017548e-05u 155.25p 1.896172e-05u
+ 155.2625p 1.773656e-05u 155.275p 1.650084e-05u 155.2875p 1.525542e-05u 155.3p 1.400116e-05u 155.3125p 1.273891e-05u 155.325p 1.146953e-05u 155.3375p 1.019391e-05u 155.35p 8.912907e-06u 155.3625p 7.627399e-06u 155.375p 6.338264e-06u 155.3875p 5.04638e-06u 155.4p 3.752627e-06u
+ 155.4125p 2.457883e-06u 155.425p 1.163027e-06u 155.4375p -1.310617e-07u 155.45p -1.423508e-06u 155.4625p -2.713437e-06u 155.475p -3.999977e-06u 155.4875p -5.28226e-06u 155.5p -6.559423e-06u 155.5125p -7.830605e-06u 155.525p -9.094951e-06u 155.5375p -1.035161e-05u 155.55p -1.159975e-05u
+ 155.5625p -1.283852e-05u 155.575p -1.406711e-05u 155.5875p -1.528468e-05u 155.6p -1.649042e-05u 155.6125p -1.768354e-05u 155.625p -1.886324e-05u 155.6375p -2.002873e-05u 155.65p -2.117925e-05u 155.6625p -2.231403e-05u 155.675p -2.343232e-05u 155.6875p -2.453338e-05u 155.7p -2.561648e-05u
+ 155.7125p -2.668093e-05u 155.725p -2.7726e-05u 155.7375p -2.875103e-05u 155.75p -2.975533e-05u 155.7625p -3.073826e-05u 155.775p -3.169917e-05u 155.7875p -3.263744e-05u 155.8p -3.355245e-05u 155.8125p -3.444363e-05u 155.825p -3.531038e-05u 155.8375p -3.615216e-05u 155.85p -3.696842e-05u
+ 155.8625p -3.775864e-05u 155.875p -3.852231e-05u 155.8875p -3.925895e-05u 155.9p -3.99681e-05u 155.9125p -4.06493e-05u 155.925p -4.130213e-05u 155.9375p -4.192618e-05u 155.95p -4.252106e-05u 155.9625p -4.30864e-05u 155.975p -4.362185e-05u 155.9875p -4.412709e-05u 156p -4.460182e-05u
+ 156.0125p -4.504573e-05u 156.025p -4.545858e-05u 156.0375p -4.584012e-05u 156.05p -4.619013e-05u 156.0625p -4.650841e-05u 156.075p -4.679478e-05u 156.0875p -4.704909e-05u 156.1p -4.727119e-05u 156.1125p -4.746099e-05u 156.125p -4.761839e-05u 156.1375p -4.774332e-05u 156.15p -4.783573e-05u
+ 156.1625p -4.789561e-05u 156.175p -4.792296e-05u 156.1875p -4.791778e-05u 156.2p -4.788013e-05u 156.2125p -4.781007e-05u 156.225p -4.770768e-05u 156.2375p -4.757308e-05u 156.25p -4.740639e-05u 156.2625p -4.720777e-05u 156.275p -4.697738e-05u 156.2875p -4.671543e-05u 156.3p -4.642212e-05u
+ 156.3125p -4.60977e-05u 156.325p -4.574242e-05u 156.3375p -4.535656e-05u 156.35p -4.494042e-05u 156.3625p -4.449432e-05u 156.375p -4.401859e-05u 156.3875p -4.351359e-05u 156.4p -4.29797e-05u 156.4125p -4.241731e-05u 156.425p -4.182685e-05u 156.4375p -4.120875e-05u 156.45p -4.056345e-05u
+ 156.4625p -3.989143e-05u 156.475p -3.919317e-05u 156.4875p -3.846919e-05u 156.5p -3.772e-05u 156.5125p -3.694613e-05u 156.525p -3.614815e-05u 156.5375p -3.532662e-05u 156.55p -3.448213e-05u 156.5625p -3.361528e-05u 156.575p -3.272668e-05u 156.5875p -3.181697e-05u 156.6p -3.088677e-05u
+ 156.6125p -2.993676e-05u 156.625p -2.896758e-05u 156.6375p -2.797994e-05u 156.65p -2.697451e-05u 156.6625p -2.5952e-05u 156.675p -2.491313e-05u 156.6875p -2.385861e-05u 156.7p -2.278918e-05u 156.7125p -2.170558e-05u 156.725p -2.060857e-05u 156.7375p -1.94989e-05u 156.75p -1.837735e-05u
+ 156.7625p -1.724468e-05u 156.775p -1.610168e-05u 156.7875p -1.494913e-05u 156.8p -1.378783e-05u 156.8125p -1.261857e-05u 156.825p -1.144215e-05u 156.8375p -1.025939e-05u 156.85p -9.071095e-06u 156.8625p -7.878069e-06u 156.875p -6.681131e-06u 156.8875p -5.481096e-06u 156.9p -4.278782e-06u
+ 156.9125p -3.075005e-06u 156.925p -1.870585e-06u 156.9375p -6.663377e-07u 156.95p 5.369209e-07u 156.9625p 1.738376e-06u 156.975p 2.937216e-06u 156.9875p 4.132631e-06u 157p 5.323815e-06u 157.0125p 6.509966e-06u 157.025p 7.690285e-06u 157.0375p 8.863981e-06u 157.05p 1.003026e-05u
+ 157.0625p 1.118835e-05u 157.075p 1.233748e-05u 157.0875p 1.347686e-05u 157.1p 1.460575e-05u 157.1125p 1.572339e-05u 157.125p 1.682903e-05u 157.1375p 1.792195e-05u 157.15p 1.900141e-05u 157.1625p 2.00667e-05u 157.175p 2.111711e-05u 157.1875p 2.215196e-05u 157.2p 2.317055e-05u
+ 157.2125p 2.417222e-05u 157.225p 2.515631e-05u 157.2375p 2.612218e-05u 157.25p 2.706918e-05u 157.2625p 2.79967e-05u 157.275p 2.890413e-05u 157.2875p 2.979089e-05u 157.3p 3.06564e-05u 157.3125p 3.15001e-05u 157.325p 3.232143e-05u 157.3375p 3.311987e-05u 157.35p 3.389491e-05u
+ 157.3625p 3.464605e-05u 157.375p 3.537281e-05u 157.3875p 3.607473e-05u 157.4p 3.675135e-05u 157.4125p 3.740225e-05u 157.425p 3.802703e-05u 157.4375p 3.862528e-05u 157.45p 3.919664e-05u 157.4625p 3.974074e-05u 157.475p 4.025726e-05u 157.4875p 4.074588e-05u 157.5p 4.120629e-05u
+ 157.5125p 4.163822e-05u 157.525p 4.204141e-05u 157.5375p 4.241562e-05u 157.55p 4.276064e-05u 157.5625p 4.307626e-05u 157.575p 4.33623e-05u 157.5875p 4.361862e-05u 157.6p 4.384505e-05u 157.6125p 4.40415e-05u 157.625p 4.420786e-05u 157.6375p 4.434406e-05u 157.65p 4.445004e-05u
+ 157.6625p 4.452576e-05u 157.675p 4.457121e-05u 157.6875p 4.458639e-05u 157.7p 4.457133e-05u 157.7125p 4.452608e-05u 157.725p 4.44507e-05u 157.7375p 4.434528e-05u 157.75p 4.420993e-05u 157.7625p 4.404477e-05u 157.775p 4.384995e-05u 157.7875p 4.362565e-05u 157.8p 4.337204e-05u
+ 157.8125p 4.308933e-05u 157.825p 4.277775e-05u 157.8375p 4.243755e-05u 157.85p 4.206898e-05u 157.8625p 4.167234e-05u 157.875p 4.124793e-05u 157.8875p 4.079606e-05u 157.9p 4.031708e-05u 157.9125p 3.981134e-05u 157.925p 3.927921e-05u 157.9375p 3.87211e-05u 157.95p 3.81374e-05u
+ 157.9625p 3.752855e-05u 157.975p 3.689499e-05u 157.9875p 3.623717e-05u 158p 3.555557e-05u 158.0125p 3.485069e-05u 158.025p 3.412302e-05u 158.0375p 3.337309e-05u 158.05p 3.260143e-05u 158.0625p 3.180859e-05u 158.075p 3.099513e-05u 158.0875p 3.016164e-05u 158.1p 2.930869e-05u
+ 158.1125p 2.843689e-05u 158.125p 2.754685e-05u 158.1375p 2.66392e-05u 158.15p 2.571458e-05u 158.1625p 2.477363e-05u 158.175p 2.3817e-05u 158.1875p 2.284537e-05u 158.2p 2.185941e-05u 158.2125p 2.085981e-05u 158.225p 1.984726e-05u 158.2375p 1.882246e-05u 158.25p 1.778613e-05u
+ 158.2625p 1.673897e-05u 158.275p 1.568171e-05u 158.2875p 1.461509e-05u 158.3p 1.353982e-05u 158.3125p 1.245666e-05u 158.325p 1.136635e-05u 158.3375p 1.026962e-05u 158.35p 9.167248e-06u 158.3625p 8.059971e-06u 158.375p 6.948549e-06u 158.3875p 5.833741e-06u 158.4p 4.716306e-06u
+ 158.4125p 3.597005e-06u 158.425p 2.476599e-06u 158.4375p 1.355848e-06u 158.45p 2.355135e-07u 158.4625p -8.836464e-07u 158.475p -2.000874e-06u 158.4875p -3.115415e-06u 158.5p -4.226517e-06u 158.5125p -5.33343e-06u 158.525p -6.435409e-06u 158.5375p -7.531713e-06u 158.55p -8.621606e-06u
+ 158.5625p -9.704356e-06u 158.575p -1.077924e-05u 158.5875p -1.184553e-05u 158.6p -1.290253e-05u 158.6125p -1.394952e-05u 158.625p -1.49858e-05u 158.6375p -1.60107e-05u 158.65p -1.702351e-05u 158.6625p -1.802359e-05u 158.675p -1.901025e-05u 158.6875p -1.998285e-05u 158.7p -2.094074e-05u
+ 158.7125p -2.18833e-05u 158.725p -2.28099e-05u 158.7375p -2.371994e-05u 158.75p -2.461281e-05u 158.7625p -2.548793e-05u 158.775p -2.634473e-05u 158.7875p -2.718265e-05u 158.8p -2.800114e-05u 158.8125p -2.879968e-05u 158.825p -2.957774e-05u 158.8375p -3.033482e-05u 158.85p -3.107044e-05u
+ 158.8625p -3.178412e-05u 158.875p -3.24754e-05u 158.8875p -3.314383e-05u 158.9p -3.378901e-05u 158.9125p -3.441051e-05u 158.925p -3.500794e-05u 158.9375p -3.558092e-05u 158.95p -3.61291e-05u 158.9625p -3.665213e-05u 158.975p -3.71497e-05u 158.9875p -3.762148e-05u 159p -3.80672e-05u
+ 159.0125p -3.848657e-05u 159.025p -3.887936e-05u 159.0375p -3.924532e-05u 159.05p -3.958424e-05u 159.0625p -3.989591e-05u 159.075p -4.018017e-05u 159.0875p -4.043685e-05u 159.1p -4.06658e-05u 159.1125p -4.086692e-05u 159.125p -4.104009e-05u 159.1375p -4.118522e-05u 159.15p -4.130226e-05u
+ 159.1625p -4.139117e-05u 159.175p -4.14519e-05u 159.1875p -4.148445e-05u 159.2p -4.148885e-05u 159.2125p -4.14651e-05u 159.225p -4.141328e-05u 159.2375p -4.133344e-05u 159.25p -4.122566e-05u 159.2625p -4.109007e-05u 159.275p -4.092678e-05u 159.2875p -4.073594e-05u 159.3p -4.05177e-05u
+ 159.3125p -4.027226e-05u 159.325p -3.99998e-05u 159.3375p -3.970055e-05u 159.35p -3.937474e-05u 159.3625p -3.902262e-05u 159.375p -3.864446e-05u 159.3875p -3.824055e-05u 159.4p -3.781119e-05u 159.4125p -3.735671e-05u 159.425p -3.687745e-05u 159.4375p -3.637375e-05u 159.45p -3.584599e-05u
+ 159.4625p -3.529456e-05u 159.475p -3.471985e-05u 159.4875p -3.412229e-05u 159.5p -3.350231e-05u 159.5125p -3.286035e-05u 159.525p -3.219687e-05u 159.5375p -3.151236e-05u 159.55p -3.080729e-05u 159.5625p -3.008218e-05u 159.575p -2.933754e-05u 159.5875p -2.857389e-05u 159.6p -2.779178e-05u
+ 159.6125p -2.699176e-05u 159.625p -2.61744e-05u 159.6375p -2.534026e-05u 159.65p -2.448993e-05u 159.6625p -2.362402e-05u 159.675p -2.274311e-05u 159.6875p -2.184784e-05u 159.7p -2.093883e-05u 159.7125p -2.00167e-05u 159.725p -1.90821e-05u 159.7375p -1.813567e-05u 159.75p -1.717808e-05u
+ 159.7625p -1.620999e-05u 159.775p -1.523205e-05u 159.7875p -1.424496e-05u 159.8p -1.324939e-05u 159.8125p -1.224602e-05u 159.825p -1.123555e-05u 159.8375p -1.021866e-05u 159.85p -9.196058e-06u 159.8625p -8.168442e-06u 159.875p -7.136514e-06u 159.8875p -6.100979e-06u 159.9p -5.062544e-06u
+ 159.9125p -4.021916e-06u 159.925p -2.979804e-06u 159.9375p -1.936915e-06u 159.95p -8.939581e-07u 159.9625p 1.483593e-07u 159.975p 1.189331e-06u 159.9875p 2.228254e-06u 160p 3.264425e-06u 160.0125p 4.297145e-06u 160.025p 5.325717e-06u 160.0375p 6.34945e-06u 160.05p 7.367655e-06u
+ 160.0625p 8.379648e-06u 160.075p 9.384751e-06u 160.0875p 1.038229e-05u 160.1p 1.13716e-05u 160.1125p 1.235201e-05u 160.125p 1.332288e-05u 160.1375p 1.428355e-05u 160.15p 1.523339e-05u 160.1625p 1.617177e-05u 160.175p 1.709806e-05u 160.1875p 1.801165e-05u 160.2p 1.891193e-05u
+ 160.2125p 1.979832e-05u 160.225p 2.067022e-05u 160.2375p 2.152707e-05u 160.25p 2.236829e-05u 160.2625p 2.319334e-05u 160.275p 2.400168e-05u 160.2875p 2.479278e-05u 160.3p 2.556612e-05u 160.3125p 2.632121e-05u 160.325p 2.705754e-05u 160.3375p 2.777465e-05u 160.35p 2.847206e-05u
+ 160.3625p 2.914934e-05u 160.375p 2.980604e-05u 160.3875p 3.044175e-05u 160.4p 3.105606e-05u 160.4125p 3.164857e-05u 160.425p 3.221892e-05u 160.4375p 3.276674e-05u 160.45p 3.329169e-05u 160.4625p 3.379343e-05u 160.475p 3.427166e-05u 160.4875p 3.472609e-05u 160.5p 3.515642e-05u
+ 160.5125p 3.55624e-05u 160.525p 3.594379e-05u 160.5375p 3.630034e-05u 160.55p 3.663186e-05u 160.5625p 3.693814e-05u 160.575p 3.721901e-05u 160.5875p 3.747431e-05u 160.6p 3.77039e-05u 160.6125p 3.790765e-05u 160.625p 3.808545e-05u 160.6375p 3.823721e-05u 160.65p 3.836287e-05u
+ 160.6625p 3.846236e-05u 160.675p 3.853566e-05u 160.6875p 3.858275e-05u 160.7p 3.860361e-05u 160.7125p 3.859828e-05u 160.725p 3.856678e-05u 160.7375p 3.850918e-05u 160.75p 3.842553e-05u 160.7625p 3.831593e-05u 160.775p 3.818048e-05u 160.7875p 3.801931e-05u 160.8p 3.783255e-05u
+ 160.8125p 3.762037e-05u 160.825p 3.738293e-05u 160.8375p 3.712043e-05u 160.85p 3.683308e-05u 160.8625p 3.65211e-05u 160.875p 3.618473e-05u 160.8875p 3.582423e-05u 160.9p 3.543987e-05u 160.9125p 3.503195e-05u 160.925p 3.460076e-05u 160.9375p 3.414663e-05u 160.95p 3.36699e-05u
+ 160.9625p 3.31709e-05u 160.975p 3.265002e-05u 160.9875p 3.210762e-05u 161p 3.15441e-05u 161.0125p 3.095987e-05u 161.025p 3.035535e-05u 161.0375p 2.973098e-05u 161.05p 2.908719e-05u 161.0625p 2.842446e-05u 161.075p 2.774325e-05u 161.0875p 2.704404e-05u 161.1p 2.632734e-05u
+ 161.1125p 2.559365e-05u 161.125p 2.484348e-05u 161.1375p 2.407737e-05u 161.15p 2.329585e-05u 161.1625p 2.249948e-05u 161.175p 2.168881e-05u 161.1875p 2.08644e-05u 161.2p 2.002683e-05u 161.2125p 1.91767e-05u 161.225p 1.831457e-05u 161.2375p 1.744107e-05u 161.25p 1.655679e-05u
+ 161.2625p 1.566234e-05u 161.275p 1.475834e-05u 161.2875p 1.384543e-05u 161.3p 1.292422e-05u 161.3125p 1.199535e-05u 161.325p 1.105946e-05u 161.3375p 1.01172e-05u 161.35p 9.169203e-06u 161.3625p 8.216129e-06u 161.375p 7.258626e-06u 161.3875p 6.29735e-06u 161.4p 5.332957e-06u
+ 161.4125p 4.366103e-06u 161.425p 3.397448e-06u 161.4375p 2.427651e-06u 161.45p 1.457369e-06u 161.4625p 4.872629e-07u 161.475p -4.820116e-07u 161.4875p -1.449798e-06u 161.5p -2.415442e-06u 161.5125p -3.378291e-06u 161.525p -4.337696e-06u 161.5375p -5.293011e-06u 161.55p -6.243593e-06u
+ 161.5625p -7.188803e-06u 161.575p -8.128007e-06u 161.5875p -9.060575e-06u 161.6p -9.985884e-06u 161.6125p -1.090331e-05u 161.625p -1.181225e-05u 161.6375p -1.271209e-05u 161.65p -1.360224e-05u 161.6625p -1.44821e-05u 161.675p -1.535109e-05u 161.6875p -1.620862e-05u 161.7p -1.705415e-05u
+ 161.7125p -1.788709e-05u 161.725p -1.870692e-05u 161.7375p -1.951308e-05u 161.75p -2.030504e-05u 161.7625p -2.10823e-05u 161.775p -2.184432e-05u 161.7875p -2.259063e-05u 161.8p -2.332073e-05u 161.8125p -2.403414e-05u 161.825p -2.473041e-05u 161.8375p -2.540908e-05u 161.85p -2.606971e-05u
+ 161.8625p -2.671187e-05u 161.875p -2.733516e-05u 161.8875p -2.793917e-05u 161.9p -2.852351e-05u 161.9125p -2.908782e-05u 161.925p -2.963173e-05u 161.9375p -3.015491e-05u 161.95p -3.065702e-05u 161.9625p -3.113774e-05u 161.975p -3.159678e-05u 161.9875p -3.203384e-05u 162p -3.244867e-05u
+ 162.0125p -3.284101e-05u 162.025p -3.321061e-05u 162.0375p -3.355725e-05u 162.05p -3.388074e-05u 162.0625p -3.418086e-05u 162.075p -3.445746e-05u 162.0875p -3.471036e-05u 162.1p -3.493944e-05u 162.1125p -3.514455e-05u 162.125p -3.532559e-05u 162.1375p -3.548247e-05u 162.15p -3.561511e-05u
+ 162.1625p -3.572344e-05u 162.175p -3.580743e-05u 162.1875p -3.586705e-05u 162.2p -3.590228e-05u 162.2125p -3.591312e-05u 162.225p -3.589961e-05u 162.2375p -3.586178e-05u 162.25p -3.579969e-05u 162.2625p -3.57134e-05u 162.275p -3.5603e-05u 162.2875p -3.54686e-05u 162.3p -3.531032e-05u
+ 162.3125p -3.512829e-05u 162.325p -3.492267e-05u 162.3375p -3.469362e-05u 162.35p -3.444132e-05u 162.3625p -3.416598e-05u 162.375p -3.386781e-05u 162.3875p -3.354703e-05u 162.4p -3.32039e-05u 162.4125p -3.283867e-05u 162.425p -3.245162e-05u 162.4375p -3.204303e-05u 162.45p -3.161321e-05u
+ 162.4625p -3.116247e-05u 162.475p -3.069115e-05u 162.4875p -3.019958e-05u 162.5p -2.968814e-05u 162.5125p -2.915718e-05u 162.525p -2.860709e-05u 162.5375p -2.803826e-05u 162.55p -2.745111e-05u 162.5625p -2.684606e-05u 162.575p -2.622353e-05u 162.5875p -2.558396e-05u 162.6p -2.492782e-05u
+ 162.6125p -2.425557e-05u 162.625p -2.356768e-05u 162.6375p -2.286464e-05u 162.65p -2.214693e-05u 162.6625p -2.141508e-05u 162.675p -2.066958e-05u 162.6875p -1.991096e-05u 162.7p -1.913975e-05u 162.7125p -1.835649e-05u 162.725p -1.756173e-05u 162.7375p -1.675601e-05u 162.75p -1.593989e-05u
+ 162.7625p -1.511395e-05u 162.775p -1.427875e-05u 162.7875p -1.343487e-05u 162.8p -1.258289e-05u 162.8125p -1.17234e-05u 162.825p -1.085699e-05u 162.8375p -9.984259e-06u 162.85p -9.105803e-06u 162.8625p -8.222226e-06u 162.875p -7.334131e-06u 162.8875p -6.442127e-06u 162.9p -5.546823e-06u
+ 162.9125p -4.648829e-06u 162.925p -3.748758e-06u 162.9375p -2.847223e-06u 162.95p -1.944836e-06u 162.9625p -1.042209e-06u 162.975p -1.399556e-07u 162.9875p 7.613138e-07u 163p 1.660989e-06u 163.0125p 2.558463e-06u 163.025p 3.453129e-06u 163.0375p 4.344384e-06u 163.05p 5.231629e-06u
+ 163.0625p 6.114267e-06u 163.075p 6.991704e-06u 163.0875p 7.863352e-06u 163.1p 8.728628e-06u 163.1125p 9.586953e-06u 163.125p 1.043775e-05u 163.1375p 1.128046e-05u 163.15p 1.211451e-05u 163.1625p 1.293935e-05u 163.175p 1.375444e-05u 163.1875p 1.455923e-05u 163.2p 1.535318e-05u
+ 163.2125p 1.613578e-05u 163.225p 1.690651e-05u 163.2375p 1.766485e-05u 163.25p 1.841031e-05u 163.2625p 1.91424e-05u 163.275p 1.986064e-05u 163.2875p 2.056456e-05u 163.3p 2.12537e-05u 163.3125p 2.19276e-05u 163.325p 2.258584e-05u 163.3375p 2.322798e-05u 163.35p 2.38536e-05u
+ 163.3625p 2.446231e-05u 163.375p 2.505371e-05u 163.3875p 2.562741e-05u 163.4p 2.618306e-05u 163.4125p 2.67203e-05u 163.425p 2.723878e-05u 163.4375p 2.773818e-05u 163.45p 2.821818e-05u 163.4625p 2.867847e-05u 163.475p 2.911878e-05u 163.4875p 2.953882e-05u 163.5p 2.993833e-05u
+ 163.5125p 3.031707e-05u 163.525p 3.067481e-05u 163.5375p 3.101133e-05u 163.55p 3.132642e-05u 163.5625p 3.16199e-05u 163.575p 3.18916e-05u 163.5875p 3.214135e-05u 163.6p 3.236902e-05u 163.6125p 3.257447e-05u 163.625p 3.275759e-05u 163.6375p 3.291829e-05u 163.65p 3.305649e-05u
+ 163.6625p 3.317211e-05u 163.675p 3.326511e-05u 163.6875p 3.333544e-05u 163.7p 3.338309e-05u 163.7125p 3.340806e-05u 163.725p 3.341035e-05u 163.7375p 3.338999e-05u 163.75p 3.334702e-05u 163.7625p 3.32815e-05u 163.775p 3.319349e-05u 163.7875p 3.308309e-05u 163.8p 3.295039e-05u
+ 163.8125p 3.279551e-05u 163.825p 3.261859e-05u 163.8375p 3.241977e-05u 163.85p 3.219921e-05u 163.8625p 3.195708e-05u 163.875p 3.169358e-05u 163.8875p 3.140891e-05u 163.9p 3.110329e-05u 163.9125p 3.077695e-05u 163.925p 3.043014e-05u 163.9375p 3.006311e-05u 163.95p 2.967614e-05u
+ 163.9625p 2.926952e-05u 163.975p 2.884354e-05u 163.9875p 2.839851e-05u 164p 2.793477e-05u 164.0125p 2.745264e-05u 164.025p 2.695248e-05u 164.0375p 2.643465e-05u 164.05p 2.589951e-05u 164.0625p 2.534746e-05u 164.075p 2.477888e-05u 164.0875p 2.419419e-05u 164.1p 2.359379e-05u
+ 164.1125p 2.297811e-05u 164.125p 2.234759e-05u 164.1375p 2.170268e-05u 164.15p 2.104382e-05u 164.1625p 2.037149e-05u 164.175p 1.968614e-05u 164.1875p 1.898827e-05u 164.2p 1.827836e-05u 164.2125p 1.755691e-05u 164.225p 1.682442e-05u 164.2375p 1.60814e-05u 164.25p 1.532836e-05u
+ 164.2625p 1.456583e-05u 164.275p 1.379433e-05u 164.2875p 1.30144e-05u 164.3p 1.222659e-05u 164.3125p 1.143142e-05u 164.325p 1.062946e-05u 164.3375p 9.821241e-06u 164.35p 9.007333e-06u 164.3625p 8.18829e-06u 164.375p 7.364673e-06u 164.3875p 6.537047e-06u 164.4p 5.705977e-06u
+ 164.4125p 4.87203e-06u 164.425p 4.035775e-06u 164.4375p 3.197783e-06u 164.45p 2.358622e-06u 164.4625p 1.518864e-06u 164.475p 6.790776e-07u 164.4875p -1.60167e-07u 164.5p -9.983017e-07u 164.5125p -1.83476e-06u 164.525p -2.668976e-06u 164.5375p -3.500388e-06u 164.55p -4.328435e-06u
+ 164.5625p -5.15256e-06u 164.575p -5.972209e-06u 164.5875p -6.786832e-06u 164.6p -7.595882e-06u 164.6125p -8.398817e-06u 164.625p -9.195101e-06u 164.6375p -9.984202e-06u 164.65p -1.076559e-05u 164.6625p -1.153875e-05u 164.675p -1.230317e-05u 164.6875p -1.305833e-05u 164.7p -1.380374e-05u
+ 164.7125p -1.453891e-05u 164.725p -1.526334e-05u 164.7375p -1.597656e-05u 164.75p -1.66781e-05u 164.7625p -1.736749e-05u 164.775p -1.804429e-05u 164.7875p -1.870805e-05u 164.8p -1.935833e-05u 164.8125p -1.999472e-05u 164.825p -2.061679e-05u 164.8375p -2.122414e-05u 164.85p -2.181638e-05u
+ 164.8625p -2.239312e-05u 164.875p -2.2954e-05u 164.8875p -2.349864e-05u 164.9p -2.402671e-05u 164.9125p -2.453785e-05u 164.925p -2.503175e-05u 164.9375p -2.55081e-05u 164.95p -2.596658e-05u 164.9625p -2.640691e-05u 164.975p -2.682881e-05u 164.9875p -2.723203e-05u 165p -2.761629e-05u
+ 165.0125p -2.798138e-05u 165.025p -2.832707e-05u 165.0375p -2.865314e-05u 165.05p -2.895939e-05u 165.0625p -2.924564e-05u 165.075p -2.951173e-05u 165.0875p -2.975749e-05u 165.1p -2.998279e-05u 165.1125p -3.018749e-05u 165.125p -3.037148e-05u 165.1375p -3.053466e-05u 165.15p -3.067695e-05u
+ 165.1625p -3.079826e-05u 165.175p -3.089856e-05u 165.1875p -3.097778e-05u 165.2p -3.103591e-05u 165.2125p -3.107293e-05u 165.225p -3.108884e-05u 165.2375p -3.108366e-05u 165.25p -3.10574e-05u 165.2625p -3.101013e-05u 165.275p -3.094188e-05u 165.2875p -3.085274e-05u 165.3p -3.074279e-05u
+ 165.3125p -3.061213e-05u 165.325p -3.046087e-05u 165.3375p -3.028914e-05u 165.35p -3.009707e-05u 165.3625p -2.988484e-05u 165.375p -2.965259e-05u 165.3875p -2.940052e-05u 165.4p -2.912882e-05u 165.4125p -2.883769e-05u 165.425p -2.852736e-05u 165.4375p -2.819806e-05u 165.45p -2.785004e-05u
+ 165.4625p -2.748354e-05u 165.475p -2.709886e-05u 165.4875p -2.669626e-05u 165.5p -2.627604e-05u 165.5125p -2.58385e-05u 165.525p -2.538398e-05u 165.5375p -2.491278e-05u 165.55p -2.442526e-05u 165.5625p -2.392176e-05u 165.575p -2.340264e-05u 165.5875p -2.286827e-05u 165.6p -2.231904e-05u
+ 165.6125p -2.175533e-05u 165.625p -2.117754e-05u 165.6375p -2.058609e-05u 165.65p -1.998139e-05u 165.6625p -1.936386e-05u 165.675p -1.873393e-05u 165.6875p -1.809206e-05u 165.7p -1.743869e-05u 165.7125p -1.677428e-05u 165.725p -1.609929e-05u 165.7375p -1.541418e-05u 165.75p -1.471945e-05u
+ 165.7625p -1.401556e-05u 165.775p -1.330301e-05u 165.7875p -1.25823e-05u 165.8p -1.185391e-05u 165.8125p -1.111836e-05u 165.825p -1.037615e-05u 165.8375p -9.627784e-06u 165.85p -8.873788e-06u 165.8625p -8.114677e-06u 165.875p -7.35097e-06u 165.8875p -6.583191e-06u 165.9p -5.811865e-06u
+ 165.9125p -5.037521e-06u 165.925p -4.260686e-06u 165.9375p -3.48189e-06u 165.95p -2.701663e-06u 165.9625p -1.920537e-06u 165.975p -1.139041e-06u 165.9875p -3.577069e-07u 166p 4.229367e-07u 166.0125p 1.202361e-06u 166.025p 1.980039e-06u 166.0375p 2.755446e-06u 166.05p 3.528058e-06u
+ 166.0625p 4.297355e-06u 166.075p 5.062819e-06u 166.0875p 5.823937e-06u 166.1p 6.580196e-06u 166.1125p 7.331091e-06u 166.125p 8.076118e-06u 166.1375p 8.814779e-06u 166.15p 9.546581e-06u 166.1625p 1.027104e-05u 166.175p 1.098766e-05u 166.1875p 1.169598e-05u 166.2p 1.239553e-05u
+ 166.2125p 1.308583e-05u 166.225p 1.376644e-05u 166.2375p 1.443689e-05u 166.25p 1.509676e-05u 166.2625p 1.574561e-05u 166.275p 1.638301e-05u 166.2875p 1.700853e-05u 166.3p 1.762178e-05u 166.3125p 1.822234e-05u 166.325p 1.880983e-05u 166.3375p 1.938387e-05u 166.35p 1.994408e-05u
+ 166.3625p 2.04901e-05u 166.375p 2.102157e-05u 166.3875p 2.153816e-05u 166.4p 2.203952e-05u 166.4125p 2.252534e-05u 166.425p 2.299531e-05u 166.4375p 2.344913e-05u 166.45p 2.388651e-05u 166.4625p 2.430717e-05u 166.475p 2.471084e-05u 166.4875p 2.509728e-05u 166.5p 2.546624e-05u
+ 166.5125p 2.58175e-05u 166.525p 2.615083e-05u 166.5375p 2.646603e-05u 166.55p 2.676291e-05u 166.5625p 2.704129e-05u 166.575p 2.7301e-05u 166.5875p 2.75419e-05u 166.6p 2.776383e-05u 166.6125p 2.796668e-05u 166.625p 2.815032e-05u 166.6375p 2.831465e-05u 166.65p 2.845959e-05u
+ 166.6625p 2.858507e-05u 166.675p 2.869101e-05u 166.6875p 2.877737e-05u 166.7p 2.884412e-05u 166.7125p 2.889124e-05u 166.725p 2.891871e-05u 166.7375p 2.892654e-05u 166.75p 2.891475e-05u 166.7625p 2.888337e-05u 166.775p 2.883245e-05u 166.7875p 2.876204e-05u 166.8p 2.867221e-05u
+ 166.8125p 2.856305e-05u 166.825p 2.843466e-05u 166.8375p 2.828715e-05u 166.85p 2.812063e-05u 166.8625p 2.793524e-05u 166.875p 2.773114e-05u 166.8875p 2.750848e-05u 166.9p 2.726744e-05u 166.9125p 2.70082e-05u 166.925p 2.673096e-05u 166.9375p 2.643593e-05u 166.95p 2.612333e-05u
+ 166.9625p 2.579339e-05u 166.975p 2.544636e-05u 166.9875p 2.508249e-05u 167p 2.470205e-05u 167.0125p 2.430532e-05u 167.025p 2.389259e-05u 167.0375p 2.346415e-05u 167.05p 2.302032e-05u 167.0625p 2.256141e-05u 167.075p 2.208776e-05u 167.0875p 2.15997e-05u 167.1p 2.109758e-05u
+ 167.1125p 2.058175e-05u 167.125p 2.005259e-05u 167.1375p 1.951047e-05u 167.15p 1.895577e-05u 167.1625p 1.838888e-05u 167.175p 1.78102e-05u 167.1875p 1.722014e-05u 167.2p 1.661912e-05u 167.2125p 1.600754e-05u 167.225p 1.538585e-05u 167.2375p 1.475447e-05u 167.25p 1.411384e-05u
+ 167.2625p 1.346441e-05u 167.275p 1.280662e-05u 167.2875p 1.214095e-05u 167.3p 1.146784e-05u 167.3125p 1.078775e-05u 167.325p 1.010117e-05u 167.3375p 9.408569e-06u 167.35p 8.710413e-06u 167.3625p 8.007187e-06u 167.375p 7.299375e-06u 167.3875p 6.587461e-06u 167.4p 5.871933e-06u
+ 167.4125p 5.153281e-06u 167.425p 4.431995e-06u 167.4375p 3.708568e-06u 167.45p 2.983492e-06u 167.4625p 2.257262e-06u 167.475p 1.53037e-06u 167.4875p 8.033107e-07u 167.5p 7.657709e-08u 167.5125p -6.493388e-07u 167.525p -1.373946e-06u 167.5375p -2.096754e-06u 167.55p -2.817276e-06u
+ 167.5625p -3.535025e-06u 167.575p -4.249519e-06u 167.5875p -4.960277e-06u 167.6p -5.666821e-06u 167.6125p -6.368679e-06u 167.625p -7.065379e-06u 167.6375p -7.756455e-06u 167.65p -8.441446e-06u 167.6625p -9.119894e-06u 167.675p -9.791348e-06u 167.6875p -1.045536e-05u 167.7p -1.111149e-05u
+ 167.7125p -1.17593e-05u 167.725p -1.239837e-05u 167.7375p -1.302826e-05u 167.75p -1.364857e-05u 167.7625p -1.425888e-05u 167.775p -1.48588e-05u 167.7875p -1.544792e-05u 167.8p -1.602587e-05u 167.8125p -1.659226e-05u 167.825p -1.714673e-05u 167.8375p -1.768891e-05u 167.85p -1.821845e-05u
+ 167.8625p -1.8735e-05u 167.875p -1.923823e-05u 167.8875p -1.972782e-05u 167.9p -2.020346e-05u 167.9125p -2.066482e-05u 167.925p -2.111162e-05u 167.9375p -2.154358e-05u 167.95p -2.196042e-05u 167.9625p -2.236186e-05u 167.975p -2.274767e-05u 167.9875p -2.31176e-05u 168p -2.347141e-05u
+ 168.0125p -2.380889e-05u 168.025p -2.412982e-05u 168.0375p -2.443401e-05u 168.05p -2.472127e-05u 168.0625p -2.499143e-05u 168.075p -2.524433e-05u 168.0875p -2.547981e-05u 168.1p -2.569773e-05u 168.1125p -2.589797e-05u 168.125p -2.608042e-05u 168.1375p -2.624496e-05u 168.15p -2.639152e-05u
+ 168.1625p -2.652001e-05u 168.175p -2.663037e-05u 168.1875p -2.672254e-05u 168.2p -2.679649e-05u 168.2125p -2.685219e-05u 168.225p -2.688961e-05u 168.2375p -2.690876e-05u 168.25p -2.690964e-05u 168.2625p -2.689229e-05u 168.275p -2.685672e-05u 168.2875p -2.680298e-05u 168.3p -2.673115e-05u
+ 168.3125p -2.664127e-05u 168.325p -2.653345e-05u 168.3375p -2.640776e-05u 168.35p -2.626432e-05u 168.3625p -2.610325e-05u 168.375p -2.592468e-05u 168.3875p -2.572875e-05u 168.4p -2.55156e-05u 168.4125p -2.528542e-05u 168.425p -2.503837e-05u 168.4375p -2.477464e-05u 168.45p -2.449443e-05u
+ 168.4625p -2.419795e-05u 168.475p -2.388543e-05u 168.4875p -2.355708e-05u 168.5p -2.321316e-05u 168.5125p -2.285391e-05u 168.525p -2.24796e-05u 168.5375p -2.20905e-05u 168.55p -2.168688e-05u 168.5625p -2.126905e-05u 168.575p -2.08373e-05u 168.5875p -2.039194e-05u 168.6p -1.993329e-05u
+ 168.6125p -1.946167e-05u 168.625p -1.897743e-05u 168.6375p -1.84809e-05u 168.65p -1.797243e-05u 168.6625p -1.745239e-05u 168.675p -1.692114e-05u 168.6875p -1.637905e-05u 168.7p -1.582651e-05u 168.7125p -1.52639e-05u 168.725p -1.469162e-05u 168.7375p -1.411006e-05u 168.75p -1.351963e-05u
+ 168.7625p -1.292074e-05u 168.775p -1.231381e-05u 168.7875p -1.169925e-05u 168.8p -1.107751e-05u 168.8125p -1.044899e-05u 168.825p -9.814142e-06u 168.8375p -9.1734e-06u 168.85p -8.527207e-06u 168.8625p -7.876004e-06u 168.875p -7.220242e-06u 168.8875p -6.560369e-06u 168.9p -5.896837e-06u
+ 168.9125p -5.230102e-06u 168.925p -4.560618e-06u 168.9375p -3.888843e-06u 168.95p -3.215235e-06u 168.9625p -2.540253e-06u 168.975p -1.864355e-06u 168.9875p -1.188002e-06u 169p -5.116525e-07u 169.0125p 1.642353e-07u 169.025p 8.392038e-07u 169.0375p 1.512796e-06u 169.05p 2.184558e-06u
+ 169.0625p 2.854036e-06u 169.075p 3.520778e-06u 169.0875p 4.184337e-06u 169.1p 4.844265e-06u 169.1125p 5.500121e-06u 169.125p 6.151464e-06u 169.1375p 6.797858e-06u 169.15p 7.438871e-06u 169.1625p 8.074075e-06u 169.175p 8.703046e-06u 169.1875p 9.325365e-06u 169.2p 9.940618e-06u
+ 169.2125p 1.05484e-05u 169.225p 1.11483e-05u 169.2375p 1.173993e-05u 169.25p 1.232289e-05u 169.2625p 1.28968e-05u 169.275p 1.346128e-05u 169.2875p 1.401596e-05u 169.3p 1.456048e-05u 169.3125p 1.509447e-05u 169.325p 1.56176e-05u 169.3375p 1.612951e-05u 169.35p 1.662987e-05u
+ 169.3625p 1.711837e-05u 169.375p 1.759467e-05u 169.3875p 1.805848e-05u 169.4p 1.850949e-05u 169.4125p 1.894742e-05u 169.425p 1.937198e-05u 169.4375p 1.978289e-05u 169.45p 2.017991e-05u 169.4625p 2.056277e-05u 169.475p 2.093123e-05u 169.4875p 2.128507e-05u 169.5p 2.162405e-05u
+ 169.5125p 2.194797e-05u 169.525p 2.225662e-05u 169.5375p 2.254981e-05u 169.55p 2.282737e-05u 169.5625p 2.308912e-05u 169.575p 2.333491e-05u 169.5875p 2.356458e-05u 169.6p 2.377801e-05u 169.6125p 2.397506e-05u 169.625p 2.415562e-05u 169.6375p 2.431959e-05u 169.65p 2.446688e-05u
+ 169.6625p 2.459741e-05u 169.675p 2.47111e-05u 169.6875p 2.480791e-05u 169.7p 2.488778e-05u 169.7125p 2.495069e-05u 169.725p 2.499661e-05u 169.7375p 2.502553e-05u 169.75p 2.503745e-05u 169.7625p 2.503238e-05u 169.775p 2.501035e-05u 169.7875p 2.497139e-05u 169.8p 2.491555e-05u
+ 169.8125p 2.484288e-05u 169.825p 2.475346e-05u 169.8375p 2.464737e-05u 169.85p 2.452469e-05u 169.8625p 2.438554e-05u 169.875p 2.423002e-05u 169.8875p 2.405826e-05u 169.9p 2.38704e-05u 169.9125p 2.366658e-05u 169.925p 2.344696e-05u 169.9375p 2.321171e-05u 169.95p 2.2961e-05u
+ 169.9625p 2.269503e-05u 169.975p 2.241399e-05u 169.9875p 2.211809e-05u 170p 2.211809e-05u)
.tran 0.0125p 170p
.print P(B1|XREPLAY) V(B1|XREPLAY) I(B1|XREPLAY) P(B2|XREPLAY) V(B2|XREPLAY) I(B2|XREPLAY) P(B3|XREPLAY) V(B3|XREPLAY) I(B3|XREPLAY)
.print I(L1|XREPLAY) I(L2|XREPLAY) I(L3|XREPLAY) I(L4|XREPLAY) I(L5|XREPLAY) I(L6|XREPLAY) I(LB1|XREPLAY) I(LB2|XREPLAY) I(IB1|XREPLAY) I(IB2|XREPLAY) I(RB1|XREPLAY) I(RB2|XREPLAY) I(RB3|XREPLAY)
.print V(Q_REPLAY) I(R_LOAD)
.end
