* QB-Q1 logical0 + canonical READ: canonical BVM with frozen scaled QB.
.include jjmit.cir
.include bvm_cell.cir
.include bq_cell.cir

XBVM1 WL1 BL1 SE1 SL1 BVM
XBQ SL1 OUT_Q IBIAS BQ
R_LOAD OUT_Q 0 10

I_IBIAS 0 IBIAS pwl(0p 0 1p 35u 2p 35u 170p 35u)
I_WL1 0 WL1 pwl(0p 0 10p 0 11p -100u 20p -100u 21p 0 95p 0 96p 100u 105p 100u 106p 0 170p 0)
I_BL1 0 BL1 pwl(0p 0 10p 0 11p -100u 20p -100u 21p 0 170p 0)
I_SE1 0 SE1 pwl(0p 0 95p 0 96p 100u 105p 100u 106p 0 170p 0)

.tran 0.0125p 170p
.print P(BJs|XBQ) V(BJs|XBQ) I(BJs|XBQ)
.print P(BJL1|XBQ) V(BJL1|XBQ) I(BJL1|XBQ)
.print P(BJL2|XBQ) V(BJL2|XBQ) I(BJL2|XBQ)
.print I(Lin|XBQ) I(L0|XBQ) I(L1|XBQ) I(L2|XBQ) I(RB|XBQ) I(RJ1|XBQ) I(RJ2|XBQ)
.print V(SL1) I(Lin|XBQ) V(OUT_Q) I(R_LOAD)
.print V(N6|XBVM1) I(L_SL|XBVM1)
.print P(B_JM1|XBVM1) V(B_JM1|XBVM1) P(B_JM2|XBVM1) V(B_JM2|XBVM1)
.print P(B_JS1|XBVM1) V(B_JS1|XBVM1) P(B_JS2|XBVM1) V(B_JS2|XBVM1)
.print I(I_WL1) I(I_BL1) I(I_SE1)
.end
