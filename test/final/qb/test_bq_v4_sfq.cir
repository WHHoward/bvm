* BQ v4 S1.3 — SFQ 注入 (1.5mV + 3Ω, 2ps 脉冲) → BQ → Load JTL
* S1.5 — JTL B1 相位 ΔP/(2π) = 收到的 SFQ 数
* PASS 标准: JTL B1 net ≥ 1.0 SFQ (单脉冲 → 单 SFQ)
.include ../../../circuits/models/jjmit.cir
.include ../../../circuits/qb/bq_cell_v4.cir
.include ../../../circuits/standard/JTL.cir

V_IN IN1 0 pulse(0 1.5m 10p 1p 1p 2p 50p)
R_SRC IN1 IN1b 3
XBQ IN1b OUT1 IBIAS BQ
I_IBIAS 0 IBIAS pwl(0 0 1p 35u)
XJTL OUT1 JTLQ THmitll_JTL
R_JTLQ JTLQ 0 10

.tran 0.1p 300p
.print V(OUT1) V(JTLQ) P(BJS|XBQ) P(BJL1|XBQ) P(BJL2|XBQ) P(B1|XJTL) P(B2|XJTL)
.end
