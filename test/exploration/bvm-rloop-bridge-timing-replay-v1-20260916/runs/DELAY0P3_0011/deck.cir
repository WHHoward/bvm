* GENERATED ARRAY DECK: JM2-connected BVM vs 4-BVM shared-SL experiment
* source_class=HISTORICAL_BVMSIM_JM2_CONNECTED_VARIANT
* ARRAY: four identical historical JM2-connected BVMs share COMMON_SL; only FINAL READ mask differs.
* Registered history: WRITE0 -> ZERO_STATE_READ_CONTROL -> WRITE1 -> selective one-state READ -> TAIL.

.param L1_VALUE=1.4p
.param IB_VALUE=260u
.param RJ1_VALUE=32
.param RJ2_VALUE=12
.include ../../../bvm-qb-threshold-ordering-boundary-search-v1-20260911/inputs/jjmit.cir
.include ../../../bvm-qb-threshold-ordering-boundary-search-v1-20260911/inputs/BQ_parameterized_bjs400_rj2.cir
.include ../../../bvm-qb-threshold-ordering-boundary-search-v1-20260911/inputs/jtl2.cir

* BVM_REPLAY_1: canonical BVM body; only R_S/L_S3 are replaced by an ideal current replay.
.subckt BVM_REPLAY_1 WL BL SE SL

* === WL+BL merge at Node '2' ===
R_BL    BL      1       20.0
L_PBL   1       2       0.5P
R_WL    WL      13      20.0
L_PWL   13      2       0.5P

* === S-Loop ===

* Main branch: N1 → JM1 → LM1 → GND
B_JM1   2       7       jjmit area=1.2
R_JM1   2       7       8
L_M1    7       0       12.5P

* Stabilizer branch: N1 → LM2 → JM2 → N2
L_M2    2       3       24.5P
B_JM2   3       4       jjmit area=1.4
* R_JM2   3       4       8

* N2 → LM3 → N5 (shared path with R-Loop)
L_M3    4       8       8.5P

* N5 → LPM → GND (loop closure)
L_PM    8       0       0.5P

* === R-Loop upper branch: N2 → LS1 → JS1 → N3 ===
L_S1    4       5       0.5P
B_JS1   5       6       jjmit area=0.74
* R_JS1   5       6       15

* === SE into N3 ===
R_SE    SE      14      20.0
L_PSE   14      6       0.5P

* === R-Loop bridge network ===
* N3 → N4 (direct wire — 0V voltage source for current measurement)
* R_N3N4  N3      N4      1E-6
* N3 → RS → N6
I_BRIDGE_REPLAY 6 10 PWL(0 0 0.10000000000000001p -8.9008820000000002e-09 0.20000000000000001p -3.9475250000000001e-08 0.29999999999999999p -1.0436383000000001e-07 0.40000000000000002p -2.1400482e-07 0.5p -3.7563160000000002e-07 0.59999999999999998p -5.9266280000000001e-07 0.70000000000000007p -8.6422770000000002e-07 0.80000000000000004p -1.1848615999999999e-06 0.90000000000000002p -1.5445506999999999e-06 1p -1.9293096e-06 1.0999999999999999p -2.3134958e-06 1.2p -2.6664352000000002e-06 1.2999999999999998p -2.9583841000000003e-06 1.4000000000000001p -3.1645435000000002e-06 1.5p -3.2677285000000001e-06 1.6000000000000001p -3.2601032000000001e-06 1.7p -3.1440952620000001e-06 1.8p -2.9323975000000003e-06 1.8999999999999999p -2.6469257000000001e-06 2p -2.3167244999999997e-06 2.1000000000000001p -1.9749690000000004e-06 2.1999999999999997p -1.6553862e-06 2.2999999999999998p -1.3885445e-06 2.3999999999999999p -1.1985030999999999e-06 2.5p -1.1002760000000001e-06 2.5999999999999996p -1.0984302e-06 2.6999999999999997p -1.18695348e-06 2.8000000000000003p -1.3503549999999998e-06 2.9000000000000004p -1.5657659999999998e-06 3p -1.8057077999999998e-06 3.1000000000000001p -2.0411551000000002e-06 3.2000000000000002p -2.2445025e-06 3.3000000000000003p -2.3921261000000002e-06 3.3999999999999999p -2.4663391999999999e-06 3.5p -2.4565962999999996e-06 3.6000000000000001p -2.3599669660000001e-06 3.7000000000000002p -2.1809230000000002e-06 3.7999999999999998p -1.9305763999999997e-06 3.8999999999999999p -1.6254939e-06 4p -1.2862519999999998e-06 4.0999999999999996p -9.3583149999999992e-07 4.2000000000000002p -5.979741e-07 4.2999999999999998p -2.9555919999999999e-07 4.3999999999999995p -4.9073100000000024e-08 4.5p 1.247717e-07 4.5999999999999996p 2.1420513000000003e-07 4.7000000000000002p 2.1328515000000001e-07 4.7999999999999998p 1.2242501e-07 4.8999999999999995p -5.1501650000000008e-08 5p -2.9552488999999999e-07 5.0999999999999996p -5.9142100000000001e-07 5.1999999999999993p -9.169996e-07 5.2999999999999998p -1.2477521e-06 5.3999999999999995p -1.5587338999999999e-06 5.5p -1.8265247e-06 5.6000000000000005p -2.0310801000000002e-06 5.7000000000000002p -2.1573279000000001e-06 5.8000000000000007p -2.1963351999999998e-06 5.9000000000000004p -2.1459638699999999e-06 6p -2.0109537900000002e-06 6.1000000000000005p -1.8024263999999997e-06 6.2000000000000002p -1.5368755000000001e-06 6.2999999999999998p -1.2347399000000001e-06 6.4000000000000004p -9.1867920000000013e-07 6.5p -6.1172900000000006e-07 6.6000000000000005p -3.3546069999999996e-07 6.7000000000000002p -1.0832810000000006e-07 6.7999999999999998p 5.5699600000000034e-08 6.9000000000000004p 1.481022e-07 7p 1.66312544e-07 7.0999999999999996p 1.1373537e-07 7.2000000000000002p -7.0865999999999412e-10 7.2999999999999998p -1.63462887e-07 7.4000000000000004p -3.5756030000000001e-07 7.5p -5.6408909999999998e-07 7.5999999999999996p -7.6377870000000002e-07 7.7000000000000002p -9.385763e-07 7.7999999999999998p -1.0730905e-06 7.8999999999999995p -1.1557854e-06 8p -1.1798365000000002e-06 8.0999999999999996p -1.14358415e-06 8.1999999999999993p -1.05054502e-06 8.2999999999999989p -9.0901139999999995e-07 8.4000000000000004p -7.3124549999999997e-07 8.5p -5.3237030000000002e-07 8.5999999999999996p -3.2904359999999997e-07 8.6999999999999993p -1.3802780000000004e-07 8.7999999999999989p 2.521889999999999e-08 8.9000000000000004p 1.4781390000000001e-07 9p 2.2048087000000001e-07 9.0999999999999996p 2.382589e-07 9.1999999999999993p 2.0083745e-07 9.2999999999999989p 1.1249866000000002e-07 9.4000000000000004p -1.8321199999999993e-08 9.5p -1.798045e-07 9.5999999999999996p -3.57789e-07 9.6999999999999993p -5.3697630000000001e-07 9.7999999999999989p -7.022098e-07 9.8999999999999986p -8.3971520000000006e-07 10p -9.382017e-07 10.1p -9.8973940000000001e-07 10.199999999999999p -9.9034289000000001e-07 10.299999999999999p -9.4022258299999998e-07 10.399999999999999p -8.4368817999999997e-07 10.5p -7.0871980000000003e-07 10.6p -5.4624829999999993e-07 10.699999999999999p -3.6920969999999998e-07 10.799999999999999p -1.9145510000000001e-07 10.899999999999999p -2.6606900000000029e-08 11p 1.1304240000000001e-07 11.100000000000001p 2.1750100299999999e-07 11.200000000000001p 2.7984089999999998e-07 11.300000000000001p 2.9669419999999998e-07 11.4p 2.6844909999999996e-07 11.5p 1.9913331999999998e-07 11.600000000000001p 9.6002929999999987e-08 11.700000000000001p -3.1125100000000001e-08 11.800000000000001p -1.7073491000000002e-07 11.9p -3.1059465999999999e-07 12p -4.387762e-07 12.100000000000001p -5.4462639999999999e-07 12.200000000000001p -6.1961219999999996e-07 12.300000000000001p -6.5797159999999999e-07 12.4p -6.5712274999999997e-07 12.5p -6.1780045800000001e-07 12.6p -5.4391811999999997e-07 12.700000000000001p -4.4217020000000003e-07 12.800000000000001p -3.214149e-07 12.9p -1.9189210000000003e-07 13p -6.434570000000001e-08 13.1p 5.0876400000000007e-08 13.200000000000001p 1.4466953e-07 13.300000000000001p 2.0989874e-07 13.4p 2.4194650000000003e-07 13.5p 2.3904152999999999e-07 13.6p 2.02345e-07 13.700000000000001p 1.3579481e-07 13.800000000000001p 4.5722289999999997e-08 13.9p -5.971849000000001e-08 14p -1.7126166e-07 14.1p -2.7931559999999996e-07 14.199999999999999p -3.7476149999999999e-07 14.300000000000001p -4.4969499999999998e-07 14.4p -4.9805420000000003e-07 14.5p -5.1608273000000006e-07 14.6p -5.0259281999999996e-07 14.700000000000001p -4.5901338000000001e-07 14.900000000000002p -2.9916869999999999e-07 15p -1.9636449999999998e-07 15.100000000000001p -8.9214700000000019e-08 15.199999999999999p 1.3679600000000006e-08 15.300000000000001p 1.0423333999999999e-07 15.4p 1.755302e-07 15.500000000000002p 2.2236609999999999e-07 15.6p 2.416405e-07 15.700000000000001p 2.3256714e-07 15.799999999999999p 1.9669026800000002e-07 15.900000000000002p 1.3770873000000001e-07 16p 6.1127589999999985e-08 16.100000000000001p -2.6231869999999998e-08 16.199999999999999p -1.1681967999999999e-07 16.300000000000001p -2.0299166999999999e-07 16.399999999999999p -2.7763909999999995e-07 16.5p -3.3476010000000001e-07 16.599999999999998p -3.6992821999999998e-07 16.700000000000003p -3.8062174999999997e-07 16.800000000000001p -3.6638937999999996e-07 16.900000000000002p -3.2884207000000002e-07 17p -2.714759e-07 17.100000000000001p -1.9934355000000002e-07 17.199999999999999p -1.1860469999999999e-07 17.300000000000001p -3.5995499999999986e-08 17.399999999999999p 4.1738629999999995e-08 17.5p 1.0839837999999999e-07 17.599999999999998p 1.5882947999999999e-07 17.699999999999999p 1.8932477999999998e-07 17.800000000000001p 1.9789915000000001e-07 17.900000000000002p 1.8441606000000001e-07 18p 1.5056015999999999e-07 18.100000000000001p 9.9660109999999996e-08 18.199999999999999p 3.6379859999999994e-08 18.300000000000001p -3.3694010000000007e-08 18.399999999999999p -1.04531066e-07 18.5p -1.7016345999999999e-07 18.599999999999998p -2.2517660000000001e-07 18.699999999999999p -2.6514289000000001e-07 18.800000000000001p -2.8696675e-07 18.900000000000002p -2.8911189e-07 19p -2.7169524499999999e-07 19.100000000000001p -2.3644417999999999e-07 19.199999999999999p -1.8652062e-07 19.300000000000001p -1.2623129999999999e-07 19.399999999999999p -6.065032e-08 19.5p 4.8143099999999922e-09 19.599999999999998p 6.4872410000000005e-08 19.699999999999999p 1.1478437e-07 19.799999999999997p 1.5073927999999999e-07 19.900000000000002p 1.7014925999999999e-07 20p 1.7183711999999999e-07 20.100000000000001p 1.5610333700000001e-07 20.199999999999999p 1.2467150999999999e-07 20.300000000000001p 8.0516300000000007e-08 20.399999999999999p 2.7593719999999992e-08 20.5p -2.9505059999999998e-08 20.599999999999998p -8.5943972000000009e-08 20.699999999999999p -1.3704461999999999e-07 20.799999999999997p -1.7866748000000002e-07 20.899999999999999p -2.0754068999999998e-07 21p -2.2151086e-07 21.100000000000001p -2.1969608999999999e-07 21.199999999999999p -2.0253207049999999e-07 21.300000000000001p -1.7170818000000001e-07 21.399999999999999p -1.3000178e-07 21.5p -8.1027489999999992e-08 21.599999999999998p -2.892138e-08 21.699999999999999p 2.2009789999999996e-08 21.799999999999997p 6.7646530000000012e-08 21.899999999999999p 1.0439188000000001e-07 22p 1.2945617e-07 22.100000000000001p 1.4106972e-07 22.200000000000003p 1.3860675999999999e-07 22.300000000000001p 1.2261324839999999e-07 22.400000000000002p 9.4737060000000002e-08 22.5p 5.7569280000000001e-08 22.600000000000001p 1.4411220000000006e-08 22.699999999999999p -3.1012319999999996e-08 22.800000000000001p -7.4868525000000004e-08 22.899999999999999p -1.1353429000000001e-07 23p -1.4389019e-07 23.100000000000001p -1.6356673e-07 23.200000000000003p -1.7112377999999999e-07 23.300000000000001p -1.6614997000000001e-07 23.400000000000002p -1.49274879e-07 23.5p -1.2209570999999999e-07 23.600000000000001p -8.7025939999999995e-08 23.699999999999999p -4.7079589999999997e-08 23.800000000000001p -5.6104899999999993e-09 23.899999999999999p 3.3970400000000001e-08 24p 6.8477105999999999e-08 24.099999999999998p 9.5206070000000001e-08 24.200000000000003p 1.1214867e-07 24.300000000000001p 1.1814205e-07 24.400000000000002p 1.1294728999999999e-07 24.5p 9.7249975999999993e-08 24.600000000000001p 7.2584480000000004e-08 24.699999999999999p 4.1190450000000005e-08 24.800000000000001p 5.8136399999999994e-09 24.899999999999999p -3.0530180000000001e-08 25p -6.4808969000000002e-08 25.099999999999998p -9.4224089999999993e-08 25.199999999999999p -1.1643558e-07 25.300000000000001p -1.2974504000000001e-07 25.400000000000002p -1.3322195e-07 25.5p -1.2676413e-07 25.600000000000001p -1.11088862e-07 25.699999999999999p -8.7656739999999999e-08 25.800000000000001p -5.8536290000000002e-08 25.899999999999999p -2.6220619999999998e-08 26p 6.5861099999999989e-09 26.099999999999998p 3.7195659999999995e-08 26.199999999999999p 6.3156509999999997e-08 26.300000000000001p 8.2450520000000007e-08 26.400000000000002p 9.3649989999999998e-08 26.5p 9.6022570000000001e-08 26.600000000000001p 8.9577144000000002e-08 26.699999999999999p 7.5047494000000002e-08 26.800000000000001p 5.3816769999999998e-08 26.899999999999999p 2.7790170000000001e-08 27p -7.7277000000000249e-10 27.099999999999998p -2.9451460000000005e-08 27.199999999999999p -5.5866789999999999e-08 27.299999999999997p -7.7876009999999999e-08 27.400000000000002p -9.3744070000000011e-08 27.5p -1.0227789999999999e-07 27.600000000000001p -1.029132e-07 27.699999999999999p -9.5747788000000003e-08 27.800000000000001p -8.1519663e-08 27.899999999999999p -6.153296e-08 28p -3.7538810000000002e-08 28.099999999999998p -1.1581879999999999e-08 28.199999999999999p 1.4173949999999996e-08 28.299999999999997p 3.7626197000000002e-08 28.399999999999999p 5.6905430000000004e-08 28.5p 7.052428e-08 28.600000000000001p 7.7491880000000005e-08 28.699999999999999p 7.7385019999999994e-08 28.800000000000001p 7.0371129000000007e-08 28.899999999999999p 5.7182266000000001e-08 29p 3.9043009999999998e-08 29.099999999999998p 1.7559540000000002e-08 29.199999999999999p -5.4205299999999984e-09 29.299999999999997p -2.7965174000000002e-08 29.400000000000002p -4.82187e-08 29.5p -6.4552820000000005e-08 29.600000000000001p -7.569586e-08 29.699999999999999p -8.083001e-08 29.800000000000004p -7.9649056999999996e-08 29.900000000000002p -7.2373029800000008e-08 30p -5.971899000000001e-08 30.099999999999998p -4.2831730000000003e-08 30.200000000000003p -2.3180680000000001e-08 30.300000000000001p -2.4321600000000029e-09 30.399999999999999p 1.76918e-08 30.499999999999996p 3.5556335999999999e-08 30.600000000000001p 4.9746450000000005e-08 30.700000000000003p 5.9178839999999999e-08 30.800000000000001p 6.3184189999999993e-08 30.899999999999999p 6.1553565999999997e-08 31.000000000000004p 5.4546041999999998e-08 31.100000000000001p 4.2857624999999995e-08 31.199999999999999p 2.7554879999999999e-08 31.299999999999997p 9.9794799999999971e-09 31.400000000000002p -8.3680000000000025e-09 31.5p -2.5954785999999998e-08 31.599999999999998p -4.1342739999999998e-08 31.699999999999999p -5.3304739999999996e-08 31.800000000000004p -6.092126000000001e-08 31.900000000000002p -6.3649599999999996e-08 32p -6.1360726999999992e-08 32.099999999999994p -5.4341333e-08 32.200000000000003p -4.3261511999999997e-08 32.300000000000004p -2.9111699999999997e-08 32.399999999999999p -1.3114489999999998e-08 32.5p 3.3807199999999991e-09 32.600000000000001p 1.9011526e-08 32.700000000000003p 3.2514769999999996e-08 32.799999999999997p 4.2828459999999999e-08 32.899999999999999p 4.9174960000000002e-08 33p 5.1119090000000005e-08 33.100000000000001p 4.8596766000000006e-08 33.199999999999996p 4.1912605000000003e-08 33.299999999999997p 3.1707153999999997e-08 33.400000000000006p 1.8897280000000004e-08 33.5p 4.5949200000000001e-09 33.600000000000001p -9.9883600000000004e-09 33.699999999999996p -2.3643192e-08 33.800000000000004p -3.5261779999999998e-08 33.899999999999999p -4.392698e-08 34p -4.8983660000000001e-08 34.099999999999994p -5.0087295999999999e-08 34.200000000000003p -4.7225703000000003e-08 34.299999999999997p -4.0713193999999998e-08 34.399999999999999p -3.1157868000000004e-08 34.5p -1.9405539999999997e-08 34.600000000000001p -6.4651100000000006e-09 34.700000000000003p 6.5777399999999992e-09 34.799999999999997p 1.86515e-08 34.899999999999999p 2.8786687000000001e-08 35p 3.6193450000000003e-08 35.100000000000001p 4.0322790000000002e-08 35.199999999999996p 4.0906709e-08 35.299999999999997p 3.7974379999999995e-08 35.399999999999999p 3.1843526000000005e-08 35.5p 2.3088317999999997e-08 35.600000000000001p 1.2486700000000002e-08 35.699999999999996p 9.5221000000000162e-10 35.800000000000004p -1.0544084e-08 35.899999999999999p -2.1054605999999999e-08 36p -2.9732769999999998e-08 36.099999999999994p -3.5900519999999998e-08 36.200000000000003p -3.9100584e-08 36.299999999999997p -3.9129488000000003e-08 36.399999999999999p -3.60489866e-08 36.5p -3.0175431999999996e-08 36.600000000000001p -2.2048440999999998e-08 36.700000000000003p -1.2381780000000001e-08 36.799999999999997p -2.0010699999999983e-09 36.900000000000006p 8.2265739999999997e-09 37p 1.7464681999999999e-08 37.100000000000001p 2.4975689999999999e-08 37.199999999999996p 3.0179539999999995e-08 37.300000000000004p 3.2698101999999999e-08 37.399999999999999p 3.2382116999999999e-08 37.5p 2.931869674e-08 37.600000000000001p 2.3819184000000002e-08 37.700000000000003p 1.6388903000000001e-08 37.800000000000004p 7.6814999999999983e-09 37.899999999999999p -1.5579500000000004e-09 38p -1.0556113e-08 38.100000000000001p -1.8575718e-08 38.200000000000003p -2.4975390000000002e-08 38.299999999999997p -2.9260499999999999e-08 38.399999999999999p -3.1120767e-08 38.5p -3.0452002000000001e-08 38.600000000000001p -2.73603635e-08 38.700000000000003p -2.2149222e-08 38.799999999999997p -1.5290148000000001e-08 38.900000000000006p -7.3805400000000007e-09 39p 9.0809000000000115e-10 39.100000000000001p 8.8870169999999992e-09 39.199999999999996p 1.5907209000000002e-08 39.300000000000004p 2.141204e-08 39.399999999999999p 2.4981116999999998e-08 39.5p 2.6362013999999999e-08 39.599999999999994p 2.5487633000000002e-08 39.700000000000003p 2.2477828500000001e-08 39.800000000000004p 1.7625659000000002e-08 39.899999999999999p 1.1369706000000001e-08 40p 4.2549310000000002e-09 40.100000000000001p -3.1143489999999994e-09 40.200000000000003p -1.0125426e-08 40.299999999999997p -1.6207802999999999e-08 40.399999999999999p -2.0879220999999999e-08 40.5p -2.3783547999999998e-08 40.600000000000001p -2.471744e-08 40.699999999999996p -2.3643892000000002e-08 40.799999999999997p -2.0691845000000001e-08 40.900000000000006p -1.6142135e-08 41p -1.0401204999999999e-08 41.100000000000001p -3.965088000000001e-09 41.199999999999996p 2.6232860000000007e-09 41.300000000000004p 8.8196830000000004e-09 41.399999999999999p 1.4123435e-08 41.5p 1.8117640000000002e-08 41.599999999999994p 2.0501781e-08 41.700000000000003p 2.1113983000000001e-08 41.799999999999997p 1.9941486999999999e-08 41.899999999999999p 1.7118542999999999e-08 42p 1.2912360000000002e-08 42.100000000000001p 7.6983220000000006e-09 42.200000000000003p 1.9268859999999997e-09 42.299999999999997p -3.9150560000000011e-09 42.399999999999999p -9.3449706000000009e-09 42.5p -1.3924285000000001e-08 42.600000000000001p -1.7293548000000001e-08 42.699999999999996p -1.9200338000000002e-08 42.799999999999997p -1.9517812000000003e-08 42.899999999999999p -1.8252479699999999e-08 43p -1.5540933999999999e-08 43.100000000000001p -1.1635848e-08 43.199999999999996p -6.8828019999999992e-09 43.300000000000004p -1.6899069999999999e-09 43.399999999999999p 3.5070800000000003e-09 43.5p 8.2811792000000007e-09 43.599999999999994p 1.2249121e-08 43.700000000000003p 1.5101969999999999e-08 43.799999999999997p 1.6628981e-08 43.899999999999999p 1.6732862000000001e-08 44p 1.5435463000000001e-08 44.100000000000001p 1.2873421999999999e-08 44.200000000000003p 9.2845390000000004e-09 44.299999999999997p 4.9861209999999996e-09 44.400000000000006p 3.4718699999999979e-10 44.5p -4.2429800000000006e-09 44.600000000000001p -8.4072700000000005e-09 44.699999999999996p -1.1811531e-08 44.800000000000004p -1.4191167999999998e-08 44.899999999999999p -1.5371458e-08 45p -1.5280033999999999e-08 45.100000000000001p -1.3950732600000001e-08 45.200000000000003p -1.1518553e-08 45.300000000000004p -8.2064500000000003e-09 45.399999999999999p -4.3051530000000003e-09 45.5p -1.4780499999999978e-10 45.600000000000001p 3.9183310000000004e-09 45.700000000000003p 7.5607469999999994e-09 45.799999999999997p 1.0488751000000001e-08 45.899999999999999p 1.2476519999999999e-08 46p 1.3380342000000001e-08 46.100000000000001p 1.3148699999999999e-08 46.200000000000003p 1.18246471e-08 46.299999999999997p 9.5402459999999987e-09 46.400000000000006p 6.5038550000000008e-09 46.5p 2.981399000000001e-09 46.600000000000001p -7.2671900000000025e-10 46.699999999999996p -4.3110600000000006e-09 46.800000000000004p -7.4788109999999996e-09 46.899999999999999p -9.9775359999999994e-09 47p -1.1615116999999999e-08 47.099999999999994p -1.2274310000000001e-08 47.200000000000003p -1.1920844e-08 47.300000000000004p -1.0604515000000001e-08 47.399999999999999p -8.4533499999999987e-09 47.5p -5.6614339999999996e-09 47.600000000000001p -2.4715879999999999e-09 47.700000000000003p 8.4564300000000012e-10 47.799999999999997p 4.014824e-09 47.899999999999999p 6.7783929999999999e-09 48p 8.9174910000000007e-09 48.100000000000001p 1.0269166000000001e-08 48.199999999999996p 1.0738627e-08 48.299999999999997p 1.0305625000000001e-08 48.400000000000006p 9.0245822000000006e-09 48.5p 7.0185629999999995e-09 48.600000000000001p 4.4677289999999995e-09 48.699999999999996p 1.5933319999999997e-09 48.800000000000004p -1.3613370000000001e-09 48.899999999999999p -4.1514239999999997e-09 49p -6.5506810000000003e-09 49.099999999999994p -8.3696950000000002e-09 49.200000000000003p -9.4707050000000012e-09 49.299999999999997p -9.77786e-09 49.399999999999999p -9.2821747999999995e-09 49.5p -8.0408806000000007e-09 49.600000000000001p -6.1713420000000001e-09 49.700000000000003p -3.8401549999999998e-09 49.799999999999997p -1.2484219999999999e-09 49.899999999999999p 1.3855069999999996e-09 50p 3.8443503000000004e-09 50.100000000000001p -5.6630849999999998e-06 50.199999999999996p -1.0960864e-05 50.299999999999997p -1.5755084000000001e-05 50.399999999999999p -1.9933583000000002e-05 50.5p -2.3419452e-05 50.600000000000001p -2.6182544000000003e-05 50.699999999999996p -2.8245783e-05 50.800000000000004p -2.9685274999999997e-05 50.899999999999999p -3.0624647999999996e-05 51p -3.1224506999999998e-05 51.100000000000001p -2.5999512e-05 51.200000000000003p -2.1180014999999998e-05 51.299999999999997p -1.7085389000000001e-05 51.399999999999999p -1.3992943e-05 51.5p -1.2114588000000001e-05 51.600000000000001p -1.1577498e-05 51.700000000000003p -1.2412267999999999e-05 51.799999999999997p -1.4549187000000001e-05 51.900000000000006p -1.7822274999999999e-05 52p -2.1980831999999999e-05 52.100000000000001p -2.6707766999999998e-05 52.199999999999996p -3.1643914000000002e-05 52.300000000000004p -3.6416399999999999e-05 52.399999999999999p -4.0668925000000001e-05 52.5p -4.4090944000000002e-05 52.600000000000001p -4.6442954000000003e-05 52.700000000000003p -4.7575596999999997e-05 52.800000000000004p -4.7440654999999998e-05 52.899999999999999p -4.609328831e-05 53p -4.3685296999999998e-05 53.100000000000001p -4.0450339999999997e-05 53.200000000000003p -3.6682623000000003e-05 53.299999999999997p -3.2711240999999998e-05 53.399999999999999p -2.8872957000000002e-05 53.5p -2.5485834000000002e-05 53.600000000000001p -2.2826248e-05 53.700000000000003p -2.1110488000000001e-05 53.799999999999997p -2.0481995000000001e-05 53.900000000000006p -2.1004241e-05 54p -2.2659086699999998e-05 54.100000000000001p -2.5350319999999998e-05 54.199999999999996p -2.8911972999999996e-05 54.300000000000004p -3.3121028e-05 54.399999999999999p -3.7713626000000002e-05 54.5p -4.2403616999999995e-05 54.599999999999994p -4.6901608999999996e-05 54.700000000000003p -5.0932744000000001e-05 54.800000000000004p -5.4251976999999999e-05 54.899999999999999p -5.6657166000000004e-05 55p -5.8001473999999999e-05 55.100000000000001p -5.8206564999999997e-05 55.200000000000003p -5.7275363100000001e-05 55.299999999999997p -5.5300399000000001e-05 55.399999999999999p -5.2462671999999998e-05 55.5p -4.9018516000000002e-05 55.600000000000001p -4.5275981e-05 55.699999999999996p -4.1565057999999998e-05 55.799999999999997p -3.8207102000000001e-05 55.899999999999999p -3.5487588999999999e-05 56p -3.3634801000000001e-05 56.100000000000001p -3.2805145999999994e-05 56.199999999999996p -3.3074815000000005e-05 56.300000000000004p -3.4437098499999995e-05 56.399999999999999p -3.6804573000000003e-05 56.5p -4.0015852999999996e-05 56.599999999999994p -4.3846698999999999e-05 56.700000000000003p -4.8025385999999998e-05 56.799999999999997p -5.2251916000000004e-05 56.899999999999999p -5.6220154999999998e-05 57p -5.9641400999999997e-05 57.100000000000001p -6.2267227000000006e-05 57.200000000000003p -6.3909538000000006e-05 57.299999999999997p -6.4455584000000003e-05 57.399999999999999p -6.3876609999999998e-05 57.5p -6.2229116199999997e-05 57.600000000000001p -5.9648882000000008e-05 57.699999999999996p -5.6338325000000004e-05 57.799999999999997p -5.2548922000000001e-05 57.899999999999999p -4.8560287999999997e-05 58p -4.4658347000000001e-05 58.100000000000001p -4.1114305000000001e-05 58.199999999999996p -3.8166144999999997e-05 58.299999999999997p -3.6003539000000002e-05 58.399999999999999p -3.4756894000000003e-05 58.500000000000007p -3.4490338000000001e-05 58.599999999999994p -3.5198944e-05 58.700000000000003p -3.6809835299999998e-05 58.800000000000004p -3.9187282000000001e-05 58.899999999999999p -4.2141849000000004e-05 59p -4.5443329999999994e-05 59.099999999999994p -4.8837075000000005e-05 59.200000000000003p -5.2062930000000001e-05 59.300000000000004p -5.4875110999999996e-05 59.399999999999999p -5.7061597999999997e-05 59.5p -5.8460959999999999e-05 59.600000000000009p -5.8974979999999996e-05 59.699999999999996p -5.8575955e-05 59.800000000000004p -5.7307769700000004e-05 59.899999999999991p -5.5280863e-05 60p -5.2661727999999994e-05 60.100000000000001p -4.3989034000000002e-05 60.199999999999996p -3.5534330000000005e-05 60.300000000000004p -2.767313e-05 60.400000000000006p -2.0750450000000001e-05 60.5p -1.505296e-05 60.600000000000001p -1.0783934999999999e-05 60.699999999999996p -8.0446209999999983e-06 60.799999999999997p -6.8231470000000002e-06 60.900000000000006p -6.9915010000000001e-06 60.999999999999993p -8.3114763999999991e-06 61.100000000000001p -1.6119213999999998e-05 61.200000000000003p -2.3973289e-05 61.299999999999997p -3.1300000000000002e-05 61.400000000000006p -3.7549699999999997e-05 61.499999999999993p -4.2248045999999999e-05 61.600000000000001p -4.5041664000000001e-05 61.700000000000003p -4.5731070000000005e-05 61.799999999999997p -4.4288317000000001e-05 61.899999999999999p -4.0858887000000001e-05 62.000000000000007p -3.5748147999999995e-05 62.099999999999994p -2.9393888000000004e-05 62.200000000000003p -2.2327211000000002e-05 62.299999999999997p -1.5125769999999998e-05 62.399999999999999p -8.3643099999999995e-06 62.500000000000007p -2.567750000000001e-06 62.599999999999994p 1.8287559999999998e-06 62.700000000000003p 4.5100489999999999e-06 62.800000000000004p 5.3007023000000002e-06 62.899999999999999p 4.1742160000000002e-06 63p 1.2523150000000001e-06 63.099999999999994p -3.2054426999999997e-06 63.199999999999996p -8.8217200000000003e-06 63.300000000000004p -1.5130808999999999e-05 63.399999999999999p -2.1616062999999997e-05 63.5p -2.7752632999999999e-05 63.600000000000009p -3.3051388999999997e-05 63.699999999999996p -3.7099679999999998e-05 63.800000000000004p -3.9594719000000001e-05 63.899999999999991p -4.0366864999999999e-05 64p -3.9391063000000002e-05 64.100000000000009p -3.6785958999999998e-05 64.199999999999989p -3.2801076999999997e-05 64.299999999999997p -2.7792961999999999e-05 64.400000000000006p -2.2192720999999999e-05 64.5p -1.6467770999999999e-05 64.600000000000009p -1.1081951000000001e-05 64.699999999999989p -6.457861999999999e-06 64.799999999999997p -2.9449439999999999e-06 64.900000000000006p -7.9533700000000021e-07 65p -1.4836399999999999e-07 65.099999999999994p -1.023707e-06 65.200000000000003p -3.3227369999999999e-06 65.299999999999997p -6.837648e-06 65.400000000000006p -1.1268094e-05 65.5p -1.6244796999999999e-05 65.599999999999994p -2.1359037000000001e-05 65.700000000000003p -2.6195985e-05 65.799999999999997p -3.0368950999999999e-05 65.900000000000006p -3.3551357999999997e-05 66p -3.5503144999999999e-05 66.099999999999994p -3.6089483000000001e-05 66.200000000000003p -3.5290048000000001e-05 66.300000000000011p -3.31985759e-05 66.399999999999991p -3.0012858999999996e-05 66.5p -2.6016130000000002e-05 66.599999999999994p -2.1551643999999999e-05 66.700000000000003p -1.6992718999999999e-05 66.800000000000011p -1.2711116999999999e-05 66.899999999999991p -9.0467240000000016e-06 67p -6.2810890000000006e-06 67.100000000000009p -4.6169069999999989e-06 67.200000000000003p -4.1644649999999998e-06 67.299999999999997p -4.9355277999999996e-06 67.399999999999991p -6.8446577000000002e-06 67.5p -9.7175779999999997e-06 67.600000000000009p -1.3306022e-05 67.700000000000003p -1.7308182999999998e-05 67.799999999999997p -2.1393417000000001e-05 67.900000000000006p -2.5229376e-05 68p -2.8509242999999999e-05 68.100000000000009p -3.0976760000000002e-05 68.199999999999989p -3.2446707000000001e-05 68.299999999999997p -3.2819086999999997e-05 68.400000000000006p -3.2085869500000004e-05 68.5p -3.0329896800000001e-05 68.599999999999994p -2.7716070999999998e-05 68.700000000000003p -2.4475929e-05 68.799999999999997p -2.0886798999999999e-05 68.900000000000006p -1.7247860000000002e-05 69p -1.3854974000000001e-05 69.099999999999994p -1.0976822999999999e-05 69.200000000000003p -8.8341349999999997e-06 69.299999999999997p -7.5834520000000007e-06 69.400000000000006p -7.3065810000000002e-06 69.5p -8.0059543999999998e-06 69.599999999999994p -9.6061132999999998e-06 69.700000000000003p -1.1961041999999999e-05 69.799999999999997p -1.4866808e-05 69.900000000000006p -1.8078656999999999e-05 70p -2.1331251999999999e-05 70.099999999999994p -1.2432891e-05 70.200000000000003p -3.6079259999999992e-06 70.300000000000011p 5.212038e-06 70.399999999999991p 1.4064574799999999e-05 70.5p 2.2955234999999999e-05 70.599999999999994p 3.1866490000000003e-05 70.700000000000003p 4.076761e-05 70.799999999999997p 4.9622709999999996e-05 70.899999999999991p 5.839618e-05 71p 6.7055339999999998e-05 71.100000000000009p 6.3642838999999993e-05 71.200000000000003p 6.0596817800000002e-05 71.299999999999997p 5.8021910000000002e-05 71.399999999999991p 5.5998309e-05 71.5p 5.4575903000000002e-05 71.600000000000009p 5.3766163999999995e-05 71.699999999999989p 5.3539824000000004e-05 71.799999999999997p 5.3830652199999998e-05 71.900000000000006p 5.45436284e-05 72p 5.5565086999999999e-05 72.100000000000009p 5.6773030000000002e-05 72.199999999999989p 5.8046486999999998e-05 72.299999999999997p 5.9273320000000002e-05 72.400000000000006p 6.0356421000000001e-05 72.5p 6.1218480999999998e-05 72.599999999999994p 6.1805334000000002e-05 72.700000000000003p 6.2088348100000003e-05 72.799999999999997p 6.2065588200000001e-05 72.900000000000006p 6.1761870539999998e-05 73p 6.1227308099999996e-05 73.099999999999994p 6.05341151e-05 73.200000000000003p 5.9771329099999999e-05 73.299999999999997p 5.9037554e-05 73.400000000000006p 5.8431894000000002e-05 73.5p 5.8044097199999997e-05 73.599999999999994p 5.7944929199999997e-05 73.700000000000003p 5.81781543e-05 73.800000000000011p 5.8755293500000002e-05 73.899999999999991p 5.9653947000000003e-05 74p 6.0819782999999997e-05 74.099999999999994p 6.2171955000000004e-05 74.200000000000003p 6.3610970999999992e-05 74.300000000000011p 6.5028122999999998e-05 74.399999999999991p 6.6315405999999995e-05 74.5p 6.7374862000000007e-05 74.600000000000009p 6.8126621999999999e-05 74.700000000000003p 6.8514862999999996e-05 74.799999999999997p 6.8511270700000008e-05 74.899999999999991p 6.811563583e-05 75p 6.7353954e-05 75.100000000000009p 6.6274195000000003e-05 75.200000000000003p 6.4940782000000004e-05 75.299999999999997p 6.3428381999999995e-05 75.400000000000006p 6.1816130999999997e-05 75.5p 6.0182602999999997e-05 75.600000000000009p 5.8602144e-05 75.699999999999989p 5.7142405999999993e-05 75.799999999999997p 5.5862981000000005e-05 75.900000000000006p 5.4814738999999995e-05 76p 5.4039572e-05 76.099999999999994p 5.3570184e-05 76.200000000000003p 5.3429677499999996e-05 76.299999999999997p 5.3630816600000002e-05 76.400000000000006p 5.4174874600000001e-05 76.5p 5.50502751e-05 76.599999999999994p 5.6231089000000001e-05 76.700000000000003p 5.7675819e-05 76.799999999999997p 5.9326865999999996e-05 76.900000000000006p 6.1111106000000002e-05 77p 6.2942134999999997e-05 77.099999999999994p 6.4724332999999997e-05 77.200000000000003p 6.6358835000000001e-05 77.299999999999997p 6.7750922999999992e-05 77.400000000000006p 6.8818201000000001e-05 77.5p 6.9498338999999992e-05 77.599999999999994p 6.9755449000000007e-05 77.700000000000003p 6.9584226499999993e-05 77.800000000000011p 6.901101140000001e-05 77.899999999999991p 6.8091901499999998e-05 78p 6.6907863999999992e-05 78.099999999999994p 6.5557582999999997e-05 78.200000000000003p 6.4148528999999997e-05 78.299999999999997p 6.2787414999999989e-05 78.399999999999991p 6.1570782000000001e-05 78.5p 6.0576788999999996e-05 78.600000000000009p 5.9858987999999998e-05 78.700000000000003p 5.9442884999999999e-05 78.799999999999997p 5.9325349599999996e-05 78.899999999999991p 5.9477044599999997e-05 79p 5.9847276899999998e-05 79.100000000000009p 6.0370472100000002e-05 79.199999999999989p 6.0973499600000002e-05 79.299999999999997p 6.1582866900000008e-05 79.400000000000006p 6.2131035700000009e-05 79.5p 6.2561541200000003e-05 79.600000000000009p 6.2832624500000009e-05 79.699999999999989p 6.2919341800000004e-05 79.799999999999997p 6.2814370700000005e-05 79.900000000000006p 6.2527758999999996e-05 80p 6.2085618400000003e-05 80.099999999999994p 4.9600418000000003e-05 80.200000000000003p 3.7594530000000003e-05 80.299999999999997p 2.627076e-05 80.400000000000006p 1.5816569999999998e-05 80.5p 6.3867799999999999e-06 80.599999999999994p -1.9223100000000009e-06 80.700000000000003p -9.0968539999999984e-06 80.799999999999997p -1.5221139000000001e-05 80.900000000000006p -2.0480427999999998e-05 81p -2.5147049000000002e-05 81.099999999999994p -1.76218049e-05 81.200000000000003p -1.0711820999999999e-05 81.300000000000011p -4.8582500000000005e-06 81.399999999999991p -4.1041199999999982e-07 81.5p 2.4004590000000005e-06 81.599999999999994p 3.4746129999999999e-06 81.700000000000003p 2.8400395000000001e-06 81.800000000000011p 6.3637080000000002e-07 81.899999999999991p -2.9069020000000001e-06 82p -7.492561e-06 82.100000000000009p -1.2775316e-05 82.200000000000003p -1.8378784000000001e-05 82.299999999999997p -2.3911797999999998e-05 82.399999999999991p -2.8986987999999999e-05 82.5p -3.3243992e-05 82.600000000000009p -3.6376915000000002e-05 82.700000000000003p -3.8162511999999999e-05 82.799999999999997p -3.8483023e-05 82.900000000000006p -3.7337807000000006e-05 83p -3.4840650999999999e-05 83.100000000000009p -3.1203758999999995e-05 83.199999999999989p -2.6713060000000001e-05 83.299999999999997p -2.1700823000000004e-05 83.400000000000006p -1.6520343999999999e-05 83.5p -1.1525165999999998e-05 83.599999999999994p -7.0525339999999986e-06 83.700000000000003p -3.409275999999999e-06 83.799999999999997p -8.5765400000000028e-07 83.900000000000006p 4.0036299999999963e-07 84p 2.4085399999999968e-07 84.099999999999994p -1.36403152e-06 84.200000000000003p -4.3313179999999996e-06 84.299999999999997p -8.4608780000000004e-06 84.400000000000006p -1.3442648e-05 84.5p -1.8880130000000001e-05 84.599999999999994p -2.4328388e-05 84.700000000000003p -2.9340084999999999e-05 84.799999999999997p -3.3510704000000002e-05 84.900000000000006p -3.6515340999999998e-05 85p -3.8133103000000004e-05 85.099999999999994p -3.8259278999999997e-05 85.200000000000003p -3.6907727999999996e-05 85.300000000000011p -3.4206311999999998e-05 85.399999999999991p -3.0387026999999999e-05 85.5p -2.5770235000000002e-05 85.599999999999994p -2.0741795000000002e-05 85.700000000000003p -1.5721974000000002e-05 85.799999999999997p -1.1127477e-05 85.899999999999991p -7.3308490000000009e-06 86p -4.6235599999999998e-06 86.100000000000009p -3.1890750000000005e-06 86.200000000000003p -3.0899720000000006e-06 86.299999999999997p -4.2700231000000001e-06 86.399999999999991p -6.569081e-06 86.5p -9.7466420000000007e-06 86.600000000000009p -1.3509462999999999e-05 86.699999999999989p -1.7539211999999999e-05 86.799999999999997p -2.1517512000000001e-05 86.900000000000006p -2.5147379999999998e-05 87p -2.8170995000000001e-05 87.100000000000009p -3.0384555000000001e-05 87.199999999999989p -3.1650235e-05 87.299999999999997p -3.1904883e-05 87.400000000000006p -3.1164048799999999e-05 87.5p -2.9519698800000002e-05 87.599999999999994p -2.7130891999999999e-05 87.700000000000003p -2.420796e-05 87.799999999999997p -2.0992150000000002e-05 87.900000000000006p -1.7734036999999998e-05 88p -1.4673653999999999e-05 88.099999999999994p -1.2024393e-05 88.200000000000003p -9.9615480000000007e-06 88.299999999999997p -8.6148949999999991e-06 88.400000000000006p -8.0644190000000006e-06 88.5p -8.3377669999999998e-06 88.599999999999994p -9.4090848000000002e-06 88.700000000000003p -1.1199035e-05 88.800000000000011p -1.3576962e-05 88.899999999999991p -1.6366394e-05 89p -1.9355107e-05 89.099999999999994p -2.2310098e-05 89.200000000000003p -2.4996594000000001e-05 89.300000000000011p -2.7198910000000002e-05 89.399999999999991p -2.8740182e-05 89.5p -2.9498191e-05 89.600000000000009p -2.9415479000000002e-05 89.700000000000003p -2.8503135090000002e-05 89.799999999999997p -2.6838685999999999e-05 89.899999999999991p -2.455919e-05 90p -2.1850418999999999e-05 90.100000000000009p -1.3264034000000002e-05 90.200000000000003p -5.0788900000000008e-06 90.299999999999997p 2.32906e-06 90.400000000000006p 8.6250209999999987e-06 90.5p 1.3549008e-05 90.600000000000009p 1.6946508999999999e-05 90.699999999999989p 1.8788987e-05 90.799999999999997p 1.9180424999999999e-05 90.900000000000006p 1.8347929e-05 91p 1.6617723899999999e-05 91.099999999999994p 8.711676000000001e-06 91.200000000000003p 1.0856070000000011e-06 91.299999999999997p -5.717941999999999e-06 91.400000000000006p -1.1216066e-05 91.5p -1.5018504e-05 91.599999999999994p -1.6852944999999999e-05 91.700000000000003p -1.6581750000000001e-05 91.799999999999997p -1.421144687e-05 91.900000000000006p -9.8954759999999997e-06 92p -3.9289610000000008e-06 92.099999999999994p 3.2671280000000004e-06 92.200000000000003p 1.1174967900000001e-05 92.299999999999997p 1.9222172e-05 92.400000000000006p 2.6833320000000001e-05 92.5p 3.3483659999999996e-05 92.599999999999994p 3.8746080000000004e-05 92.700000000000003p 4.2324675999999999e-05 92.800000000000011p 4.4070998999999996e-05 92.899999999999991p 4.3983342000000004e-05 93p 4.2191586799999999e-05 93.099999999999994p 3.8933525000000004e-05 93.200000000000003p 3.4529467999999994e-05 93.299999999999997p 2.9360862999999997e-05 93.399999999999991p 2.3853392000000003e-05 93.5p 1.8459146e-05 93.600000000000009p 1.3631892000000002e-05 93.700000000000003p 9.7940999999999983e-06 93.799999999999997p 7.3003950000000009e-06 93.899999999999991p 6.4044909999999998e-06 94p 7.2353270000000005e-06 94.100000000000009p 9.785692e-06 94.199999999999989p 1.3913600999999999e-05 94.299999999999997p 1.9355700000000002e-05 94.400000000000006p 2.5750765999999998e-05 94.5p 3.2670959000000001e-05 94.600000000000009p 3.9657679999999997e-05 94.700000000000003p 4.6258590000000004e-05 94.799999999999997p 5.2062479999999997e-05 94.900000000000006p 5.6728992999999999e-05 95p 6.0010781999999995e-05 95.099999999999994p 6.1766707999999994e-05 95.200000000000003p 6.1965305000000008e-05 95.299999999999997p 6.06797298e-05 95.400000000000006p 5.8076848000000004e-05 95.5p 5.4402728000000003e-05 95.599999999999994p 4.9965958000000001e-05 95.700000000000003p 4.5117762e-05 95.799999999999997p 4.0228551999999998e-05 95.900000000000006p 3.5662026000000003e-05 96p 3.1749802000000004e-05 96.099999999999994p 2.8769781000000002e-05 96.200000000000003p 2.6930259e-05 96.300000000000011p 2.6360177999999999e-05 96.399999999999991p 2.7104959e-05 96.5p 2.9126668700000001e-05 96.599999999999994p 3.2307458e-05 96.700000000000003p 3.6456082999999998e-05 96.800000000000011p 4.1317198000000006e-05 96.899999999999991p 4.6584252000000003e-05 97p 5.1916283000000003e-05 97.100000000000009p 5.6958839000000001e-05 97.200000000000003p 6.1368461e-05 97.299999999999997p 6.4838808000000002e-05 97.399999999999991p 6.7125944999999997e-05 97.5p 6.8069329999999998e-05 97.600000000000009p 6.7605800000000002e-05 97.700000000000003p 6.5774612699999999e-05 97.799999999999997p 6.2713082000000005e-05 97.900000000000006p 5.8643866000000003e-05 98p 5.3855946e-05 98.100000000000009p 4.8681691000000001e-05 98.199999999999989p 4.3472690000000001e-05 98.299999999999997p 3.8576177000000002e-05 98.400000000000006p 3.4313615000000004e-05 98.5p 3.0962071e-05 98.599999999999994p 2.8738755000000004e-05 98.700000000000003p 2.7788801000000003e-05 98.799999999999997p 2.8176034000000002e-05 98.900000000000006p 2.9877134000000002e-05 99p 3.2779639e-05 99.099999999999994p 3.6684904000000003e-05 99.200000000000003p 4.1317247e-05 99.299999999999997p 4.6340290999999996e-05 99.400000000000006p 5.1380496999999999e-05 99.5p 5.6056361000000001e-05 99.599999999999994p 6.0010458000000003e-05 99.700000000000003p 6.2940543999999999e-05 99.799999999999997p 6.4625844000000001e-05 99.900000000000006p 6.4945900000000004e-05 100p 6.3889994199999993e-05 100.09999999999999p 5.5887767999999996e-05 100.2p 4.7177203000000001e-05 100.30000000000001p 3.8175550000000004e-05 100.39999999999999p 2.9338010000000003e-05 100.5p 2.1117469999999997e-05 100.59999999999999p 1.3923879999999999e-05 100.7p 8.0887799999999998e-06 100.8p 3.837751e-06 100.89999999999999p 1.2715280000000004e-06 101p 3.5670699999999946e-07 101.10000000000001p 6.5958819999999997e-06 101.2p 1.3662206999999999e-05 101.3p 2.1034487000000001e-05 101.39999999999999p 2.8148210000000003e-05 101.5p 3.4447779999999998e-05 101.60000000000001p 3.9439284999999999e-05 101.69999999999999p 4.2735703999999996e-05 101.8p 4.4090654000000002e-05 101.90000000000001p 4.3418619999999999e-05 102p 4.08010636e-05 102.10000000000001p 3.6478294000000003e-05 102.2p 3.0827599e-05 102.3p 2.4329087999999998e-05 102.40000000000001p 1.7522481999999998e-05 102.5p 1.0959350000000002e-05 102.59999999999999p 5.1562799999999987e-06 102.7p 5.539610000000001e-07 102.8p -2.5144050000000004e-06 102.90000000000001p -3.8440660000000005e-06 103p -3.3689628e-06 103.09999999999999p -1.1622411000000001e-06 103.2p 2.5721147999999998e-06 103.3p 7.5159140000000003e-06 103.40000000000001p 1.3261168e-05 103.5p 1.9341466000000001e-05 103.59999999999999p 2.5268670999999998e-05 103.7p 3.0572318000000001e-05 103.80000000000001p 3.4838147000000003e-05 103.89999999999999p 3.7742171e-05 104p 3.9076823000000001e-05 104.09999999999999p 3.8766687e-05 104.2p 3.6872551199999999e-05 104.30000000000001p 3.3583317000000001e-05 104.39999999999999p 2.9196940999999997e-05 104.5p 2.4092298000000001e-05 104.60000000000001p 1.8695178000000003e-05 104.7p 1.3442003999999999e-05 104.8p 8.744803999999999e-06 104.89999999999999p 4.9604899999999995e-06 105p 2.3660919999999999e-06 105.10000000000001p 1.141093e-06 105.2p 1.3567820000000002e-06 105.3p 2.9727878299999998e-06 105.40000000000001p 5.8407879999999997e-06 105.5p 9.7156480000000003e-06 105.60000000000001p 1.4274118e-05 105.69999999999999p 1.9140486999999999e-05 105.8p 2.3917588999999999e-05 105.90000000000001p 2.8220258e-05 106p 3.1707849000000002e-05 106.09999999999999p 3.4112381000000004e-05 106.2p 3.5259614999999998e-05 106.3p 3.5081535999999998e-05 106.40000000000001p 3.3619715200000004e-05 106.5p 3.1019702000000003e-05 106.59999999999999p 2.7517151000000001e-05 106.7p 2.3416788999999999e-05 106.8p 1.9065895999999999e-05 106.90000000000001p 1.4824457999999999e-05 107p 1.1034839e-05 107.09999999999999p 7.9937919999999994e-06 107.2p 5.9293720000000004e-06 107.3p 4.9845679999999996e-06 107.40000000000001p 5.2086200000000001e-06 107.5p 6.5560518000000003e-06 107.59999999999999p 8.8930490000000001e-06 107.7p 1.2010273e-05 107.80000000000001p 1.5640991e-05 107.89999999999999p 1.9483209000000001e-05 108p 2.3224103000000002e-05 108.09999999999999p 2.6565128000000001e-05 108.2p 2.9245684e-05 108.3p 3.1063529000000004e-05 108.39999999999999p 3.1890315000000003e-05 108.5p 3.1680799999999997e-05 108.60000000000001p 3.0475021699999997e-05 108.7p 2.8393174e-05 108.8p 2.5623868000000003e-05 108.89999999999999p 2.2406744e-05 109p 1.9011408999999997e-05 109.10000000000001p 1.5714574000000003e-05 109.19999999999999p 1.2777751000000001e-05 109.3p 1.0427033000000001e-05 109.40000000000001p 8.8367090000000009e-06 109.5p 8.1173290000000004e-06 109.60000000000001p 8.3088650000000003e-06 109.7p 9.3791367000000011e-06 109.8p 1.1227356999999999e-05 109.90000000000001p 1.3692703e-05 110p 1.6567411e-05 110.09999999999999p 1.6567411e-05 110.2p 1.6567411e-05 110.3p 1.6567411e-05 110.40000000000001p 1.9469879000000001e-05 110.5p 2.2308399000000002e-05 110.59999999999999p 2.4797559999999998e-05 110.7p 2.6695331999999999e-05 110.8p 2.7821876e-05 110.90000000000001p 2.8068626999999998e-05 111p 2.74021328e-05 111.09999999999999p 2.58636039e-05 111.2p 2.3563727999999999e-05 111.30000000000001p 2.0672522999999999e-05 111.39999999999999p 1.7548317999999999e-05 111.5p 1.4275192e-05 111.59999999999999p 1.1146625000000001e-05 111.7p 8.4276750000000006e-06 111.8p 6.3341800000000006e-06 111.89999999999999p 5.0208359999999996e-06 112p 4.5734920000000001e-06 112.10000000000001p 5.0051039999999998e-06 112.2p 6.2560497000000002e-06 112.3p 8.1993800000000001e-06 112.39999999999999p 1.0651145e-05 112.5p 1.3385243999999999e-05 112.60000000000001p 1.6151683999999999e-05 112.7p 1.8696794000000001e-05 112.8p 2.0783727999999999e-05 112.90000000000001p 2.2211764000000001e-05 113p 2.2833244000000001e-05 113.10000000000001p 2.2566935000000001e-05 113.19999999999999p 2.14071975e-05 113.3p 1.9427686000000002e-05 113.40000000000001p 1.6778378999999998e-05 113.5p 1.3674817999999999e-05 113.59999999999999p 1.0380184000000001e-05 113.7p 7.1824400000000003e-06 113.8p 4.3699400000000005e-06 113.90000000000001p 2.2081129999999998e-06 114p 9.1830899999999978e-07 114.09999999999999p 6.5930500000000012e-07 114.2p 1.5119952e-06 114.3p 3.4684419999999996e-06 114.40000000000001p 6.4267900000000002e-06 114.5p 1.0193589999999999e-05 114.59999999999999p 1.4494578e-05 114.7p 1.8994053e-05 114.8p 2.3321558000000002e-05 114.90000000000001p 2.7103424000000001e-05 115p 2.9995837e-05 115.09999999999999p 3.1716778000000001e-05 115.2p 3.2073626000000002e-05 115.30000000000001p 3.0983338500000001e-05 115.39999999999999p 2.8482285000000002e-05 115.5p 2.4724184999999998e-05 115.59999999999999p 1.9965904000000002e-05 115.7p 1.454281e-05 115.8p 8.8363919999999987e-06 115.89999999999999p 3.238525999999999e-06 116p -1.882429000000001e-06 116.10000000000001p -6.2084759999999993e-06 116.2p -9.4890229999999997e-06 116.3p -1.1550301e-05 116.39999999999999p -1.230261e-05 116.50000000000001p -1.1746342e-05 116.59999999999999p -9.9703747000000004e-06 116.69999999999999p -7.1373530000000002e-06 116.8p -3.4589839999999998e-06 116.90000000000001p 8.3027899999999954e-07 117.00000000000001p 5.493907e-06 117.09999999999999p 1.0305613000000001e-05 117.19999999999999p 1.5054130000000001e-05 117.3p 1.9543037e-05 117.40000000000001p 2.3588688000000001e-05 117.50000000000001p 2.7019023999999999e-05 117.60000000000001p 2.9675439000000001e-05 117.69999999999999p 3.1418244000000004e-05 117.8p 3.2135341999999999e-05 117.90000000000001p 3.1752752000000001e-05 118p 3.0244798e-05 118.10000000000001p 2.7642093000000002e-05 118.19999999999999p 2.4036052000000001e-05 118.3p 1.9579814999999999e-05 118.40000000000001p 1.4485881000000001e-05 118.5p 9.020086999999998e-06 118.60000000000001p 3.4916679999999999e-06 118.69999999999999p -1.7610499999999999e-06 118.8p -6.3898779999999994e-06 118.89999999999999p -1.0062106999999999e-05 119p -1.2491666e-05 119.10000000000001p -1.3472820000000001e-05 119.20000000000002p -1.2909574e-05 119.3p -1.08334513e-05 119.39999999999999p -7.4060009999999993e-06 119.5p -2.90633e-06 119.60000000000001p 2.2966379999999999e-06 119.70000000000002p 7.7876210000000006e-06 119.79999999999998p 1.315761e-05 119.89999999999999p 1.8052144999999999e-05 120p 2.2202909000000002e-05 120.10000000000001p 2.5438453000000002e-05 120.2p 2.7678041e-05 120.29999999999998p 2.8916417e-05 120.39999999999999p 2.9350472e-05 120.5p 2.8920897700000003e-05 120.60000000000001p 2.7804075399999998e-05 120.7p 2.6182740000000002e-05 120.80000000000001p 2.4229029000000001e-05 120.89999999999999p 2.2089949000000001e-05 121p 1.9872644e-05 121.09999999999999p 1.7634947000000001e-05 121.2p 1.5386992000000002e-05 121.30000000000001p 1.3106024999999998e-05 121.39999999999999p 1.0617238000000001e-05 121.5p 8.0655409999999981e-06 121.59999999999999p 5.4362120000000009e-06 121.7p 2.7892360000000005e-06 121.80000000000001p 2.6865499999999989e-07 121.89999999999999p -1.9048320000000004e-06 121.99999999999999p -3.4537004999999998e-06 122.09999999999999p -4.0761889999999999e-06 122.2p -3.4917178000000002e-06 122.30000000000001p -1.4948099999999999e-06 122.40000000000001p 1.9929260000000003e-06 122.49999999999999p 6.8873680000000003e-06 122.59999999999999p 1.2935804e-05 122.7p 1.9743971e-05 122.80000000000001p 2.6827729999999999e-05 122.90000000000001p 3.3672869999999999e-05 122.99999999999999p 3.9786919999999998e-05 123.09999999999999p 4.4735414000000004e-05 123.2p 4.8163288000000001e-05 123.3p 4.9808049000000002e-05 123.40000000000001p 4.9510907999999996e-05 123.49999999999999p 4.7229243199999999e-05 123.59999999999999p 4.3049539000000002e-05 123.7p 3.7194979000000001e-05 123.8p 3.0019562999999998e-05 123.90000000000001p 2.198224e-05 124.00000000000001p 1.360254e-05 124.09999999999999p 5.4078999999999978e-06 124.19999999999999p -2.1135600000000001e-06 124.3p -8.5446579999999998e-06 124.40000000000001p -1.3552569e-05 124.50000000000001p -1.6888638e-05 124.59999999999999p -1.838246e-05 124.69999999999999p -1.7937615e-05 124.8p -1.5534239199999998e-05 124.90000000000001p -1.1240073e-05 125.00000000000001p -5.2273729999999996e-06 125.10000000000001p 2.2105909999999992e-06 125.19999999999999p 1.0652849799999999e-05 125.3p 1.9563246999999998e-05 125.40000000000001p 2.8326669999999999e-05 125.5p 3.630492e-05 125.60000000000001p 4.2900990000000001e-05 125.69999999999999p 4.7617639999999999e-05 125.8p 5.0100550999999999e-05 125.90000000000001p 5.0163073e-05 126p 4.7794796200000004e-05 126.10000000000001p 4.3158506e-05 126.19999999999999p 3.6578533999999995e-05 126.3p 2.852114e-05 126.39999999999999p 1.9565179999999999e-05 126.5p 1.0361770000000001e-05 126.60000000000001p 1.5838200000000014e-06 126.70000000000002p -6.1293650000000002e-06 126.8p -1.222546546e-05 126.89999999999999p -1.6282977e-05 127p -1.8041381000000001e-05 127.10000000000001p -1.7416373000000001e-05 127.20000000000002p -1.4501356399999999e-05 127.29999999999998p -9.5570679999999995e-06 127.39999999999999p -2.9906560000000005e-06 127.5p 4.6749789999999993e-06 127.60000000000001p 1.2840477000000001e-05 127.7p 2.0876041e-05 127.79999999999998p 2.8171109999999999e-05 127.89999999999999p 3.418298e-05 128p 3.8480153000000003e-05 128.09999999999999p 4.0775670999999997e-05 128.20000000000002p 4.0947639000000001e-05 128.30000000000001p 3.9045118199999996e-05 128.39999999999998p 3.5279138000000003e-05 128.5p 2.9999894000000001e-05 128.59999999999999p 2.3662782000000001e-05 128.70000000000002p 1.6787116000000001e-05 128.80000000000001p 9.9120500000000011e-06 128.89999999999998p 3.5544000000000011e-06 129p -1.8279990000000007e-06 129.09999999999999p -5.8651440000000003e-06 129.20000000000002p -8.2951560000000011e-06 129.30000000000001p -8.9764350000000001e-06 129.39999999999998p -7.8924980000000006e-06 129.5p -5.1502940000000007e-06 129.59999999999999p -9.7219600000000051e-07 129.69999999999999p 4.3185539999999996e-06 129.80000000000001p 1.0319296e-05 129.90000000000001p 1.6576159e-05 130p 2.2617798999999999e-05 130.09999999999999p 2.7992152000000001e-05 130.19999999999999p 3.2302811000000002e-05 130.30000000000001p 3.5241053000000002e-05 130.40000000000001p 3.6610394999999997e-05 130.5p 3.6341229000000003e-05 130.59999999999999p 3.4494435749999999e-05 130.69999999999999p 3.1253870999999996e-05 130.80000000000001p 2.6908822000000002e-05 130.90000000000001p 2.1828201999999998e-05 131p 1.6429058e-05 131.09999999999999p 1.1142482999999999e-05 131.19999999999999p 6.3799909999999986e-06 131.30000000000001p 2.5029489999999992e-06 131.40000000000001p -2.0291999999999991e-07 131.5p -1.5466289999999999e-06 131.59999999999999p -1.4441049000000001e-06 131.69999999999999p 7.7019699999999995e-08 131.80000000000001p 2.8803015000000001e-06 131.90000000000001p 6.7312489999999999e-06 132p 1.1315795000000001e-05 132.09999999999999p 1.6265554999999999e-05 132.19999999999999p 2.1187892999999998e-05 132.30000000000001p 2.5698036000000002e-05 132.40000000000001p 2.9450113999999999e-05 132.5p 3.2164303000000001e-05 132.60000000000002p 3.3647918000000003e-05 132.69999999999999p 3.3809167999999994e-05 132.79999999999998p 3.2662936200000004e-05 132.90000000000001p 3.0328182999999999e-05 133p 2.7017139999999999e-05 133.10000000000002p 2.3016667000000002e-05 133.19999999999999p 1.8663378999999997e-05 133.29999999999998p 1.4314507999999998e-05 133.40000000000001p 1.0317761000000001e-05 133.5p 6.9831619999999997e-06 133.60000000000002p 4.5596420000000002e-06 133.69999999999999p 3.2180789999999998e-06 133.79999999999998p 3.0414339999999999e-06 133.90000000000001p 4.0217922999999998e-06 134p 6.0637180000000001e-06 134.09999999999999p 8.9931959999999996e-06 134.20000000000002p 1.2571538e-05 134.29999999999998p 1.6513562999999999e-05 134.40000000000001p 2.0509256e-05 134.5p 2.4247645000000001e-05 134.59999999999999p 2.7441204000000002e-05 134.70000000000002p 2.9848697999999999e-05 134.79999999999998p 3.1294404999999997e-05 134.90000000000001p 3.1681655999999998e-05 135p 3.0999650399999997e-05 135.09999999999999p 2.93228724e-05 135.20000000000002p 2.6803402e-05 135.29999999999998p 2.3656991999999999e-05 135.40000000000001p 2.0144457999999998e-05 135.5p 1.6550085000000002e-05 135.59999999999999p 1.3158853999999999e-05 135.70000000000002p 1.0234429000000001e-05 135.80000000000001p 7.9994910000000006e-06 135.89999999999998p 6.6194990000000005e-06 136p 6.1911459999999999e-06 136.09999999999999p 6.7357721999999999e-06 136.20000000000002p 8.1984369999999988e-06 136.30000000000001p 1.0452604e-05 136.39999999999998p 1.3310359e-05 136.5p 1.653762e-05 136.59999999999999p 1.9873220999999999e-05 136.70000000000002p 2.3050476e-05 136.80000000000001p 2.5819116000000002e-05 136.89999999999998p 2.7965695999999998e-05 137p 2.9330672e-05 137.09999999999999p 2.9820573e-05 137.19999999999999p 2.9414432700000003e-05 137.30000000000001p 2.8164118599999999e-05 137.40000000000001p 2.6188640000000001e-05 137.5p 2.3663048000000002e-05 137.59999999999999p 2.0802982000000001e-05 137.69999999999999p 1.7846203e-05 137.80000000000001p 1.5032718999999998e-05 137.90000000000001p 1.2585307000000002e-05 138p 1.0692108000000001e-05 138.09999999999999p 9.492471e-06 138.19999999999999p 9.0672960000000012e-06 138.30000000000001p 9.434092800000001e-06 138.40000000000001p 1.0547270700000001e-05 138.5p 1.2303085999999999e-05 138.59999999999999p 1.4549079e-05 138.69999999999999p 1.7096963000000001e-05 138.80000000000001p 1.9738231000000002e-05 138.90000000000001p 2.2261002000000001e-05 139p 2.4466941999999999e-05 139.09999999999999p 2.6186976e-05 139.19999999999999p 2.7294304000000002e-05 139.30000000000001p 2.7713965e-05 139.40000000000001p 2.7427942100000002e-05 139.5p 2.64755151e-05 139.59999999999999p 2.4948821000000002e-05 139.69999999999999p 2.2984082999999999e-05 139.80000000000001p 2.0749291999999999e-05 139.90000000000001p 1.8429713e-05 140p 1.6212379e-05 140.10000000000002p 1.4271256999999999e-05 140.19999999999999p 1.2753927000000002e-05 140.29999999999998p 1.1771096000000001e-05 140.40000000000001p 1.1389100000000001e-05 140.5p 1.16260947e-05 140.60000000000002p 1.2451654100000001e-05 140.69999999999999p 1.3789978999999999e-05 140.79999999999998p 1.5526281999999998e-05 140.90000000000001p 1.7516125999999998e-05 141p 1.9597013000000001e-05 141.10000000000002p 2.1601489e-05 141.19999999999999p 2.3370698000000001e-05 141.29999999999998p 2.4767175000000001e-05 141.40000000000001p 2.5685808999999999e-05 141.5p 2.6062015999999999e-05 141.59999999999999p 2.5876350799999998e-05 141.70000000000002p 2.5155295500000001e-05 141.79999999999998p 2.3968225e-05 141.90000000000001p 2.2420975999999999e-05 142p 2.0646542000000001e-05 142.09999999999999p 1.8793705e-05 142.20000000000002p 1.7014689999999998e-05 142.29999999999998p 1.5452743e-05 142.40000000000001p 1.4230651999999999e-05 142.5p 1.3441148e-05 142.59999999999999p 1.3139974999999999e-05 142.70000000000002p 1.33420698e-05 142.79999999999998p 1.4021113399999999e-05 142.90000000000001p 1.51125212e-05 143p 1.6519450999999999e-05 143.09999999999999p 1.8121334000000002e-05 143.20000000000002p 1.9784217999999999e-05 143.30000000000001p 2.1371992000000003e-05 143.39999999999998p 2.2757489e-05 143.5p 2.3832730000000002e-05 143.59999999999999p 2.4517332000000001e-05 143.70000000000002p 2.4764431000000001e-05 143.80000000000001p 2.4563832699999999e-05 143.89999999999998p 2.3941980499999999e-05 144p 2.2959000600000001e-05 144.09999999999999p 2.1702911000000002e-05 144.20000000000002p 2.0281795999999999e-05 144.30000000000001p 1.8814415999999998e-05 144.39999999999998p 1.7420322999999999e-05 144.5p 1.6210163000000002e-05 144.59999999999999p 1.5277077e-05 144.69999999999999p 1.4689806000000001e-05 144.80000000000001p 1.4487896800000001e-05 144.90000000000001p 1.46794092e-05 145p 1.52410315e-05 145.09999999999999p 1.6120630899999999e-05 145.19999999999999p 1.7241909e-05 145.30000000000001p 1.8510848e-05 145.40000000000001p 1.9823424e-05 145.5p 2.107402e-05 145.59999999999999p 2.2163845000000003e-05 145.69999999999999p 2.3008788999999999e-05 145.80000000000001p 2.3545914000000003e-05 145.90000000000001p 2.3738231299999999e-05 146p 2.3577145000000001e-05 146.09999999999999p 2.30826752e-05 146.19999999999999p 2.23012403e-05 146.30000000000001p 2.1301339000000002e-05 146.40000000000001p 2.0167591000000002e-05 146.5p 1.8993608999999998e-05 146.59999999999999p 1.7874362999999998e-05 146.69999999999999p 1.6898565999999998e-05 146.80000000000001p 1.6141801000000001e-05 146.90000000000001p 1.5660768999999999e-05 147p 1.5489135699999997e-05 147.09999999999999p 1.5635187200000003e-05 147.19999999999999p 1.60815835e-05 147.30000000000001p 1.6787063599999999e-05 147.40000000000001p 1.7690132000000003e-05 147.5p 1.8714291e-05 147.60000000000002p 1.9774481e-05 147.69999999999999p 2.0784198000000001e-05 147.79999999999998p 2.1662599000000002e-05 147.90000000000001p 2.2341066999999998e-05 148p 2.2768618e-05 148.10000000000002p 2.2915801400000001e-05 148.19999999999999p 2.2776688800000002e-05 148.29999999999998p 2.23689312e-05 148.40000000000001p 2.17317425e-05 148.5p 2.0922285300000002e-05 148.60000000000002p 2.0010541e-05 148.69999999999999p 1.9073213000000001e-05 148.79999999999998p 1.8187293000000002e-05 148.90000000000001p 1.7423697000000002e-05 149p 1.6841606000000001e-05 149.09999999999999p 1.64839199e-05 149.20000000000002p 1.63742019e-05 149.29999999999998p 1.6515361099999999e-05 149.40000000000001p 1.6889916999999999e-05 149.5p 1.74620033e-05 149.59999999999999p 1.8180743800000001e-05 149.70000000000002p 1.8984746000000001e-05 149.79999999999998p 1.9807227999999999e-05 149.90000000000001p 2.0581522999999999e-05 150p 2.1246406e-05 150.09999999999999p 2.1750877000000003e-05 150.20000000000002p 2.2057995900000002e-05 150.29999999999998p 2.2147558099999998e-05 150.40000000000001p 2.2017299000000001e-05 150.5p 2.1682697900000001e-05 150.59999999999999p 2.1175316099999999e-05 150.70000000000002p 2.05398745e-05 150.80000000000001p 1.9830369600000001e-05 150.89999999999998p 1.9105537e-05 151p 1.8424085000000001e-05 151.09999999999999p 1.7839981999999999e-05 151.20000000000002p 1.7398369799999997e-05 151.30000000000001p 1.7132098599999999e-05 151.39999999999998p 1.70593891e-05 151.5p 1.7182660600000001e-05 151.59999999999999p 1.74885927e-05 151.70000000000002p 1.79494265e-05 151.80000000000001p 1.8525376800000001e-05 151.89999999999998p 1.91679898e-05 152p 1.9824202899999999e-05 152.09999999999999p 2.0440627999999999e-05 152.19999999999999p 2.0967972100000002e-05 152.30000000000001p 2.1364947299999999e-05 152.40000000000001p 2.1601546199999999e-05 152.5p 2.1661309300000002e-05 152.59999999999999p 2.1542462799999998e-05 152.69999999999999p 2.12578219e-05 152.80000000000001p 2.0833488499999998e-05 152.90000000000001p 2.0306483599999999e-05 153p 1.97215481e-05 153.09999999999999p 1.9127315499999998e-05 153.19999999999999p 1.8572332300000001e-05 153.30000000000001p 1.81010055e-05 153.40000000000001p 1.77501169e-05 153.5p 1.7545928299999999e-05 153.59999999999999p 1.7502235100000001e-05 153.69999999999999p 1.7619497590000001e-05 153.80000000000001p 1.78850183e-05 153.90000000000001p 1.8274330299999999e-05 154p 1.8753349400000003e-05 154.09999999999999p 1.92814447e-05 154.19999999999999p 1.9814855199999999e-05 154.30000000000001p 2.0310342000000003e-05 154.40000000000001p 2.0728731200000002e-05 154.5p 2.1037958799999999e-05 154.59999999999999p 2.1215571699999999e-05 154.69999999999999p 2.1250292899999998e-05 154.80000000000001p 2.114267878e-05 154.90000000000001p 2.0904809799999998e-05 155p 2.0558939699999999e-05 155.10000000000002p 2.0135520400000002e-05 155.19999999999999p 1.9670443400000001e-05 155.29999999999998p 1.9202027299999999e-05 155.40000000000001p 1.8767877000000001e-05 155.5p 1.84018796e-05 155.60000000000002p 1.8131580800000003e-05 155.69999999999999p 1.79762461e-05 155.79999999999998p 1.7945475800000001e-05 155.90000000000001p 1.8038781769999999e-05 156p 1.8245841300000001e-05 156.10000000000002p 1.8547545699999999e-05 156.19999999999999p 1.8917718999999999e-05 156.29999999999998p 1.9325325800000001e-05 156.40000000000001p 1.9737006299999999e-05 156.5p 2.0119761800000003e-05 156.59999999999999p 2.0443583799999998e-05 156.70000000000002p 2.0683748500000003e-05 156.79999999999998p 2.0822745700000001e-05 156.90000000000001p 2.0851492099999998e-05 157p 2.076996636e-05 157.09999999999999p 2.0587029099999999e-05 157.20000000000002p 2.0319536299999997e-05 157.29999999999998p 1.9990867000000002e-05 157.40000000000001p 1.96289263e-05 157.5p 1.9263797200000002e-05 157.59999999999999p 1.8925277e-05 157.70000000000002p 1.8640473000000002e-05 157.79999999999998p 1.8431646700000002e-05 157.90000000000001p 1.8314458699999999e-05 158p 1.8296811499999999e-05 158.09999999999999p 1.8378291140000003e-05 158.20000000000002p 1.8550395900000002e-05 158.30000000000001p 1.87972923e-05 158.39999999999998p 1.9097279300000002e-05 158.5p 1.9424704199999998e-05 158.59999999999999p 1.97520732e-05 158.70000000000002p 2.0052464699999998e-05 158.80000000000001p 2.0301655700000001e-05 158.89999999999998p 2.04801489e-05 159p 2.0574641999999999e-05 159.09999999999999p 2.0579028099999999e-05 159.20000000000002p 2.0494764960000001e-05 159.30000000000001p 2.0330576499999997e-05 159.39999999999998p 2.01015589e-05 159.5p 1.9827824300000001e-05 159.59999999999999p 1.95327286e-05 159.69999999999999p 1.9240848800000001e-05 159.80000000000001p 1.8975966799999999e-05 159.90000000000001p 1.8759114900000001e-05 160p 1.8606964800000001e-05 160.09999999999999p 1.8530510000000002e-05 160.19999999999999p 1.8534399899999998e-05 160.30000000000001p 1.8616649691e-05 160.40000000000001p 1.8769020400000001e-05 160.5p 1.8977778700000001e-05 160.59999999999999p 1.9225000700000001e-05 160.69999999999999p 1.9490059799999999e-05 160.80000000000001p 1.97513314e-05 160.90000000000001p 1.9987990199999998e-05 161p 2.0181633500000002e-05 161.09999999999999p 2.03176496e-05 161.19999999999999p 2.03863468e-05 161.30000000000001p 2.03836239e-05 161.40000000000001p 2.0311116033e-05 161.5p 2.0175986789999999e-05 161.59999999999999p 1.9990215800000001e-05 161.69999999999999p 1.9769577300000003e-05 161.80000000000001p 1.9532252899999999e-05 161.90000000000001p 1.9297419900000002e-05 162p 1.9083667400000001e-05 162.09999999999999p 1.8907555299999997e-05 162.19999999999999p 1.87823574e-05 162.30000000000001p 1.8717058499999997e-05 162.40000000000001p 1.87157296e-05 162.5p 1.877730796e-05 162.60000000000002p 1.8895701749999999e-05 162.69999999999999p 1.9060411599999998e-05 162.79999999999998p 1.9257412000000003e-05 162.90000000000001p 1.9470324699999999e-05 163p 1.9681771999999999e-05 163.10000000000002p 1.9874795099999999e-05 163.19999999999999p 2.0034223400000001e-05 163.29999999999998p 2.0147895800000003e-05 163.40000000000001p 2.0207558800000001e-05 163.5p 2.0209521000000001e-05 163.60000000000002p 2.0154868400000001e-05 163.69999999999999p 2.0049261970000001e-05 163.79999999999998p 1.99024292e-05 163.90000000000001p 1.97272695e-05 164p 1.9538713400000002e-05 164.09999999999999p 1.93524767e-05 164.20000000000002p 1.91837427e-05 164.29999999999998p 1.9045890399999999e-05 164.40000000000001p 1.8949463400000001e-05 164.5p 1.8901359599999999e-05 164.59999999999999p 1.8904305980000001e-05 164.70000000000002p 1.8956794265999999e-05 164.79999999999998p 1.9053252420000001e-05 164.90000000000001p 1.9184664600000001e-05 165p 1.9339352599999998e-05 165.09999999999999p 1.95040466e-05 165.20000000000002p 1.9664990900000003e-05 165.29999999999998p 1.9809092899999999e-05 165.40000000000001p 1.9924984100000001e-05 165.5p 2.0003886199999998e-05 165.59999999999999p 2.0040295199999998e-05 165.70000000000002p 2.003227036e-05 165.80000000000001p 1.9981577685000002e-05 165.89999999999998p 1.989338696e-05 166p 1.9775780300000001e-05 166.09999999999999p 1.9639050199999999e-05 166.20000000000002p 1.9494748799999999e-05 166.30000000000001p 1.9354815899999999e-05 166.39999999999998p 1.9230529899999999e-05 166.5p 1.9131661400000002e-05 166.59999999999999p 1.9065723399999999e-05 166.70000000000002p 1.9037418299999999e-05 166.80000000000001p 1.9048341179999998e-05 166.89999999999998p 1.9096894002000001e-05 167p 1.9178502230000001e-05 167.09999999999999p 1.9286003999999999e-05 167.19999999999999p 1.9410292500000002e-05 167.30000000000001p 1.9541064100000001e-05 167.40000000000001p 1.96676516e-05 167.5p 1.9779903000000002e-05 167.59999999999999p 1.9868948999999999e-05 167.69999999999999p 1.9927925399999998e-05 167.80000000000001p 1.9952497529999998e-05 167.90000000000001p 1.9941149430000001e-05 168p 1.9895299719999997e-05 168.09999999999999p 1.9819098569999999e-05 168.19999999999999p 1.9719114899999998e-05 168.30000000000001p 1.9603752600000002e-05 168.40000000000001p 1.94825337e-05 168.5p 1.9365321100000001e-05 168.59999999999999p 1.9261529600000001e-05 168.69999999999999p 1.9179345199999997e-05 168.80000000000001p 1.9125095700000002e-05 168.90000000000001p 1.9102736349999998e-05 169p 1.911358856e-05 169.09999999999999p 1.9156250429999997e-05 169.19999999999999p 1.9226754139999999e-05 169.30000000000001p 1.9318931900000002e-05 169.40000000000001p 1.94249711e-05 169.5p 1.9536081199999999e-05 169.59999999999999p 1.9643209600000003e-05 169.69999999999999p 1.9737820299999999e-05 169.80000000000001p 1.9812545300000002e-05 169.90000000000001p 1.9861820000000002e-05 170p 1.988226008e-05 170.10000000000002p 1.9872875290000001e-05 170.19999999999999p 1.9835132490999999e-05 170.29999999999998p 1.977276299e-05 170.40000000000001p 1.9691391539999999e-05 170.5p 1.95980132e-05 170.60000000000002p 1.9500431200000002e-05 170.69999999999999p 1.9406553900000001e-05 170.79999999999998p 1.9323802799999998e-05 170.90000000000001p 1.92584646e-05 171p 1.9215275499999998e-05 171.10000000000002p 1.919704686e-05 171.19999999999999p 1.920453643e-05 171.29999999999998p 1.9236406446999999e-05 171.40000000000001p 1.9289406220000001e-05 171.5p 1.9358738159999999e-05 171.59999999999999p 1.9438387200000001e-05 171.70000000000002p 1.9521706799999999e-05 171.79999999999998p 1.9601958600000001e-05 171.90000000000001p 1.96727982e-05 172p 1.9728824399999999e-05 172.09999999999999p 1.9765942599999998e-05 172.20000000000002p 1.9781672279999999e-05 172.29999999999998p 1.9775306269999999e-05 172.40000000000001p 1.9747918362999998e-05 172.5p 1.97022544e-05 172.59999999999999p 1.9642444190000001e-05 172.70000000000002p 1.9573670900000001e-05 172.79999999999998p 1.9501752999999998e-05 172.90000000000001p 1.94326008e-05 173p 1.9371816899999998e-05 173.09999999999999p 1.9324214239999998e-05 173.20000000000002p 1.9293432729999999e-05 173.30000000000001p 1.9281680089999999e-05 173.39999999999998p 1.928956831e-05 173.5p 1.9316104291999999e-05 173.59999999999999p 1.9358760099999997e-05 173.70000000000002p 1.941371679e-05 173.80000000000001p 1.9476215309999997e-05 173.89999999999998p 1.9540929099999999e-05 174p 1.9602444759999998e-05 174.09999999999999p 1.9655671280000001e-05 174.20000000000002p 1.9696311819999999e-05 174.30000000000001p 1.9721147630000001e-05 174.39999999999998p 1.9728358119999999e-05 174.5p 1.9717576060000002e-05 174.59999999999999p 1.968999052e-05 174.69999999999999p 1.9648122969999999e-05 174.80000000000001p 1.9595663320000003e-05 174.90000000000001p 1.9537132329999998e-05 175p 1.9477465450000001e-05 175.09999999999999p 1.9421620080000001e-05 175.19999999999999p 1.9374154300000001e-05 175.30000000000001p 1.9338860610000002e-05 175.40000000000001p 1.9318433210000001e-05 175.5p 1.93143428e-05 175.59999999999999p 1.9326648934999999e-05 175.69999999999999p 1.935407675e-05 175.80000000000001p 1.9394173369999998e-05 175.90000000000001p 1.9443468719999998e-05 176p 1.9497826599999999e-05 176.09999999999999p 1.9552793920000002e-05 176.19999999999999p 1.960394924e-05 176.30000000000001p 1.9647285450000002e-05 176.40000000000001p 1.9679495499999998e-05 176.5p 1.969823384e-05 176.59999999999999p 1.9702269980000001e-05 176.69999999999999p 1.9691593322000002e-05 176.80000000000001p 1.966733016e-05 176.90000000000001p 1.9631665139999999e-05 177p 1.9587618970000001e-05 177.09999999999999p 1.9538813619999998e-05 177.19999999999999p 1.948916385e-05 177.30000000000001p 1.944256211e-05 177.40000000000001p 1.9402570390000001e-05 177.5p 1.9372159990000001e-05 177.60000000000002p 1.935348727e-05 177.69999999999999p 1.9347760549999999e-05 177.79999999999998p 1.9355141829999998e-05 177.90000000000001p 1.9374764703e-05 178p 1.9404829669999999e-05 178.10000000000002p 1.944276715e-05 178.19999999999999p 1.9485429170000001e-05 178.29999999999998p 1.952936158e-05 178.40000000000001p 1.9571099910000001e-05 178.5p 1.9607404270000001e-05 178.60000000000002p 1.963553079e-05 178.69999999999999p 1.9653449539999999e-05 178.79999999999998p 1.965998174e-05 178.90000000000001p 1.9654901330000001e-05 179p 1.9638877891999998e-05 179.09999999999999p 1.96134997e-05 179.20000000000002p 1.9581036449999998e-05 179.29999999999998p 1.954430106e-05 179.40000000000001p 1.9506389509999998e-05 179.5p 1.9470416120000001e-05 179.59999999999999p 1.943928928e-05 179.70000000000002p 1.9415420640000001e-05 179.79999999999998p 1.9400577259999998e-05 179.90000000000001p 1.9395743979999999e-05 180p 1.9401040252000002e-05 180.09999999999999p 1.9415753816000001e-05 180.20000000000002p 1.9438382079999999e-05 180.29999999999998p 1.9466831510000001e-05 180.40000000000001p 1.9498545639999998e-05 180.5p 1.95307934e-05 180.59999999999999p 1.956082149e-05 180.70000000000002p 1.9586196759999998e-05 180.80000000000001p 1.960488742e-05 180.89999999999998p 1.9615494769999999e-05 181p 1.9617349309999998e-05 181.09999999999999p 1.9610507644000001e-05 181.20000000000002p 1.9595757826e-05 181.30000000000001p 1.9574531420000001e-05 181.39999999999998p 1.9548780829999999e-05 181.5p 1.9520749450000001e-05 181.59999999999999p 1.9492860880000003e-05 181.70000000000002p 1.9467431580000001e-05 181.80000000000001p 1.944653923e-05 181.90000000000001p 1.9431846710000003e-05 182p 1.9424459620000001e-05 182.09999999999999p 1.9424863429999999e-05 182.19999999999999p 1.94329147972e-05 182.30000000000001p 1.9447820959999998e-05 182.40000000000001p 1.9468270589999999e-05 182.5p 1.9492509700000003e-05 182.59999999999999p 1.9518516949999997e-05 182.69999999999999p 1.954417363e-05 182.80000000000001p 1.956738502e-05 182.90000000000001p 1.958632119e-05 183p 1.9599477109999999e-05 183.09999999999999p 1.9605873179999998e-05 183.19999999999999p 1.9605048969999997e-05 183.30000000000001p 1.95971338832e-05 183.40000000000001p 1.958281962e-05 183.5p 1.9563299479999998e-05 183.59999999999999p 1.9540160120000002e-05 183.69999999999999p 1.9515270749999998e-05 183.80000000000001p 1.9490624519999999e-05 183.90000000000001p 1.9468145520000002e-05 184p 1.944961412e-05 184.09999999999999p 1.9436441420000001e-05 184.19999999999999p 1.9429612699999998e-05 184.30000000000001p 1.9429607719999998e-05 184.40000000000001p 1.9436344958999999e-05 184.5p 1.9449215225999999e-05 184.59999999999999p 1.946712963e-05 184.69999999999999p 1.9488606380000002e-05 184.80000000000001p 1.95119009e-05 184.90000000000001p 1.9535164299999999e-05 185p 1.955655627e-05 185.10000000000002p 1.957442957e-05 185.19999999999999p 1.9587455089999997e-05 185.29999999999998p 1.9594708019999999e-05 185.40000000000001p 1.9595737260000003e-05 185.5p 1.9590611759000002e-05 185.60000000000002p 1.9579898516e-05 185.69999999999999p 1.9564577619999999e-05 185.79999999999998p 1.9545989949999999e-05 185.90000000000001p 1.9525692870000002e-05 186p 1.950533831e-05 186.10000000000002p 1.9486556540000001e-05 186.19999999999999p 1.9470757620000002e-05 186.29999999999998p 1.945912056e-05 186.40000000000001p 1.945239908e-05 186.5p 1.94509811e-05 186.59999999999999p 1.9454778270000001e-05 186.70000000000002p 1.9463300944999999e-05 186.79999999999998p 1.9475693820000001e-05 186.90000000000001p 1.9490817520000001e-05 187p 1.950737213e-05 187.09999999999999p 1.9523959290000001e-05 187.20000000000002p 1.9539250900000002e-05 187.29999999999998p 1.955206324e-05 187.40000000000001p 1.9561457139999999e-05 187.5p 1.9566795259999999e-05 187.59999999999999p 1.9567799003999998e-05 187.70000000000002p 1.9564528108e-05 187.79999999999998p 1.9557406242e-05 187.90000000000001p 1.9547166339999999e-05 188p 1.953472903e-05 188.09999999999999p 1.9521217299999997e-05 188.20000000000002p 1.9507769790000001e-05 188.30000000000001p 1.9495524549999999e-05 188.39999999999998p 1.9485454109999997e-05 188.5p 1.947836197e-05 188.59999999999999p 1.9474769720000001e-05 188.70000000000002p 1.947491326e-05 188.80000000000001p 1.9478706022e-05 188.89999999999998p 1.9485746523999997e-05 189p 1.949540734e-05 189.09999999999999p 1.9506802499999998e-05 189.20000000000002p 1.9518960420000001e-05 189.30000000000001p 1.9530819820000001e-05 189.40000000000001p 1.95413766e-05 189.5p 1.95497504e-05 189.59999999999999p 1.9555220139999998e-05 189.69999999999999p 1.9557349214000002e-05 189.80000000000001p 1.9555971175e-05 189.90000000000001p 1.9551218175000001e-05 190p 1.9543494627000002e-05 190.09999999999999p 1.9533469160000001e-05 190.19999999999999p 1.9521998050000001e-05 190.30000000000001p 1.9510033250000001e-05 190.40000000000001p 1.9498577640000003e-05 190.5p 1.9488599669999997e-05 190.59999999999999p 1.9480908640000003e-05 190.69999999999999p 1.9476140960000001e-05 190.80000000000001p 1.9474686777999999e-05 190.90000000000001p 1.9476635488999999e-05 191p 1.9481817743000002e-05 191.09999999999999p 1.9489801229000003e-05 191.19999999999999p 1.9499927e-05 191.30000000000001p 1.9511363230000002e-05 191.40000000000001p 1.9523173550000003e-05 191.5p 1.953442765e-05 191.59999999999999p 1.9544252479999999e-05 191.69999999999999p 1.955187347e-05 191.80000000000001p 1.9556735770000001e-05 191.90000000000001p 1.9558496637e-05 192p 1.9557070710999999e-05 192.09999999999999p 1.9552630432000002e-05 192.19999999999999p 1.9545554249000001e-05 192.30000000000001p 1.953645532e-05 192.40000000000001p 1.952606328e-05 192.5p 1.9515191169999998e-05 192.60000000000002p 1.9504689319999997e-05 192.69999999999999p 1.9495327060000002e-05 192.79999999999998p 1.9487792700000003e-05 192.90000000000001p 1.9482611409999998e-05 193p 1.9480100004000001e-05 193.10000000000002p 1.9480387289e-05 193.19999999999999p 1.9483368181199998e-05 193.29999999999998p 1.9488729575e-05 193.40000000000001p 1.9496006010000001e-05 193.5p 1.950459321e-05 193.60000000000002p 1.9513797800000001e-05 193.69999999999999p 1.9522911949999999e-05 193.79999999999998p 1.953123187e-05 193.90000000000001p 1.9538159829999999e-05 194p 1.9543199629999999e-05 194.09999999999999p 1.9546045975e-05 194.20000000000002p 1.9546548676000002e-05 194.29999999999998p 1.9544752954e-05 194.40000000000001p 1.9540877317999999e-05 194.5p 1.9535300767999999e-05 194.59999999999999p 1.9528541056000001e-05 194.70000000000002p 1.9521175690000002e-05 194.79999999999998p 1.9513807149999999e-05 194.90000000000001p 1.950706343e-05 195p 1.9501444710000001e-05 195.09999999999999p 1.9497386341999997e-05 195.20000000000002p 1.9495167902000001e-05 195.29999999999998p 1.9494897579e-05 195.40000000000001p 1.9496540628399999e-05 195.5p 1.9499870371999998e-05 195.59999999999999p 1.9504559935e-05 195.70000000000002p 1.9510142870999998e-05 195.80000000000001p 1.9516100917000001e-05 195.89999999999998p 1.9521907373000001e-05 196p 1.9527054991000002e-05 196.09999999999999p 1.9531097752e-05 196.20000000000002p 1.9533716468000001e-05 196.30000000000001p 1.9534708672999999e-05 196.39999999999998p 1.9534023801999999e-05 196.5p 1.9531755038299999e-05 196.59999999999999p 1.9528149496999998e-05 196.70000000000002p 1.952354851e-05 196.80000000000001p 1.9518389753000001e-05 196.90000000000001p 1.9513122718000002e-05 197p 1.9508238718000002e-05 197.09999999999999p 1.9504146156e-05 197.19999999999999p 1.9501221319000001e-05 197.30000000000001p 1.9499694449000001e-05 197.40000000000001p 1.9499710398999999e-05 197.5p 1.9501242810600001e-05 197.59999999999999p 1.9504170503000002e-05 197.69999999999999p 1.9508234595999999e-05 197.80000000000001p 1.9513104941e-05 197.90000000000001p 1.9518354515e-05 198p 1.9523570680999997e-05 198.09999999999999p 1.9528322531000002e-05 198.19999999999999p 1.9532213852000001e-05 198.30000000000001p 1.9534931662999999e-05 198.40000000000001p 1.9536260571999999e-05 198.5p 1.9536103565000001e-05 198.59999999999999p 1.9534460027600251e-05 198.69999999999999p 1.9531462027999999e-05 198.80000000000001p 1.9527329932000002e-05 198.90000000000001p 1.9522398456e-05 199p 1.9517044194999998e-05 199.09999999999999p 1.9511675497e-05 199.19999999999999p 1.9506695413000001e-05 199.30000000000001p 1.9502478159000002e-05 199.40000000000001p 1.9499339319999999e-05 199.5p 1.949751973e-05 199.59999999999999p 1.9497142701e-05 199.69999999999999p 1.9498214044999998e-05 199.80000000000001p 1.9500664128e-05 199.90000000000001p 1.9504271032e-05)
* N4 → LS3 → N7

* === R-Loop lower branch: N5 → LS2 → JS2 → N6 ===
L_S2    8       9       0.5P
B_JS2   9       10      jjmit area=0.74
* R_JS2   9       10      15

* === N6 → N7 (direct wire) ===
* R_N6N7  N6      N7      1E-6

* === Output chain: N7 → LPSL → RSL → N8 → LSL → DataOut ===
L_PSL   10      11      0.5P
R_SL    11      12      12.0
L_SL    12      SL      0.4P

.ends BVM_REPLAY_1

* BVM_REPLAY_2: canonical BVM body; only R_S/L_S3 are replaced by an ideal current replay.
.subckt BVM_REPLAY_2 WL BL SE SL

* === WL+BL merge at Node '2' ===
R_BL    BL      1       20.0
L_PBL   1       2       0.5P
R_WL    WL      13      20.0
L_PWL   13      2       0.5P

* === S-Loop ===

* Main branch: N1 → JM1 → LM1 → GND
B_JM1   2       7       jjmit area=1.2
R_JM1   2       7       8
L_M1    7       0       12.5P

* Stabilizer branch: N1 → LM2 → JM2 → N2
L_M2    2       3       24.5P
B_JM2   3       4       jjmit area=1.4
* R_JM2   3       4       8

* N2 → LM3 → N5 (shared path with R-Loop)
L_M3    4       8       8.5P

* N5 → LPM → GND (loop closure)
L_PM    8       0       0.5P

* === R-Loop upper branch: N2 → LS1 → JS1 → N3 ===
L_S1    4       5       0.5P
B_JS1   5       6       jjmit area=0.74
* R_JS1   5       6       15

* === SE into N3 ===
R_SE    SE      14      20.0
L_PSE   14      6       0.5P

* === R-Loop bridge network ===
* N3 → N4 (direct wire — 0V voltage source for current measurement)
* R_N3N4  N3      N4      1E-6
* N3 → RS → N6
I_BRIDGE_REPLAY 6 10 PWL(0 0 0.10000000000000001p -8.9008820000000002e-09 0.20000000000000001p -3.9475250000000001e-08 0.29999999999999999p -1.0436383000000001e-07 0.40000000000000002p -2.1400482e-07 0.5p -3.7563160000000002e-07 0.59999999999999998p -5.9266280000000001e-07 0.70000000000000007p -8.6422770000000002e-07 0.80000000000000004p -1.1848615999999999e-06 0.90000000000000002p -1.5445506999999999e-06 1p -1.9293096e-06 1.0999999999999999p -2.3134958e-06 1.2p -2.6664352000000002e-06 1.2999999999999998p -2.9583841000000003e-06 1.4000000000000001p -3.1645435000000002e-06 1.5p -3.2677285000000001e-06 1.6000000000000001p -3.2601032000000001e-06 1.7p -3.1440952620000001e-06 1.8p -2.9323975000000003e-06 1.8999999999999999p -2.6469257000000001e-06 2p -2.3167244999999997e-06 2.1000000000000001p -1.9749690000000004e-06 2.1999999999999997p -1.6553862e-06 2.2999999999999998p -1.3885445e-06 2.3999999999999999p -1.1985030999999999e-06 2.5p -1.1002760000000001e-06 2.5999999999999996p -1.0984302e-06 2.6999999999999997p -1.18695348e-06 2.8000000000000003p -1.3503549999999998e-06 2.9000000000000004p -1.5657659999999998e-06 3p -1.8057077999999998e-06 3.1000000000000001p -2.0411551000000002e-06 3.2000000000000002p -2.2445025e-06 3.3000000000000003p -2.3921261000000002e-06 3.3999999999999999p -2.4663391999999999e-06 3.5p -2.4565962999999996e-06 3.6000000000000001p -2.3599669660000001e-06 3.7000000000000002p -2.1809230000000002e-06 3.7999999999999998p -1.9305763999999997e-06 3.8999999999999999p -1.6254939e-06 4p -1.2862519999999998e-06 4.0999999999999996p -9.3583149999999992e-07 4.2000000000000002p -5.979741e-07 4.2999999999999998p -2.9555919999999999e-07 4.3999999999999995p -4.9073100000000024e-08 4.5p 1.247717e-07 4.5999999999999996p 2.1420513000000003e-07 4.7000000000000002p 2.1328515000000001e-07 4.7999999999999998p 1.2242501e-07 4.8999999999999995p -5.1501650000000008e-08 5p -2.9552488999999999e-07 5.0999999999999996p -5.9142100000000001e-07 5.1999999999999993p -9.169996e-07 5.2999999999999998p -1.2477521e-06 5.3999999999999995p -1.5587338999999999e-06 5.5p -1.8265247e-06 5.6000000000000005p -2.0310801000000002e-06 5.7000000000000002p -2.1573279000000001e-06 5.8000000000000007p -2.1963351999999998e-06 5.9000000000000004p -2.1459638699999999e-06 6p -2.0109537900000002e-06 6.1000000000000005p -1.8024263999999997e-06 6.2000000000000002p -1.5368755000000001e-06 6.2999999999999998p -1.2347399000000001e-06 6.4000000000000004p -9.1867920000000013e-07 6.5p -6.1172900000000006e-07 6.6000000000000005p -3.3546069999999996e-07 6.7000000000000002p -1.0832810000000006e-07 6.7999999999999998p 5.5699600000000034e-08 6.9000000000000004p 1.481022e-07 7p 1.66312544e-07 7.0999999999999996p 1.1373537e-07 7.2000000000000002p -7.0865999999999412e-10 7.2999999999999998p -1.63462887e-07 7.4000000000000004p -3.5756030000000001e-07 7.5p -5.6408909999999998e-07 7.5999999999999996p -7.6377870000000002e-07 7.7000000000000002p -9.385763e-07 7.7999999999999998p -1.0730905e-06 7.8999999999999995p -1.1557854e-06 8p -1.1798365000000002e-06 8.0999999999999996p -1.14358415e-06 8.1999999999999993p -1.05054502e-06 8.2999999999999989p -9.0901139999999995e-07 8.4000000000000004p -7.3124549999999997e-07 8.5p -5.3237030000000002e-07 8.5999999999999996p -3.2904359999999997e-07 8.6999999999999993p -1.3802780000000004e-07 8.7999999999999989p 2.521889999999999e-08 8.9000000000000004p 1.4781390000000001e-07 9p 2.2048087000000001e-07 9.0999999999999996p 2.382589e-07 9.1999999999999993p 2.0083745e-07 9.2999999999999989p 1.1249866000000002e-07 9.4000000000000004p -1.8321199999999993e-08 9.5p -1.798045e-07 9.5999999999999996p -3.57789e-07 9.6999999999999993p -5.3697630000000001e-07 9.7999999999999989p -7.022098e-07 9.8999999999999986p -8.3971520000000006e-07 10p -9.382017e-07 10.1p -9.8973940000000001e-07 10.199999999999999p -9.9034289000000001e-07 10.299999999999999p -9.4022258299999998e-07 10.399999999999999p -8.4368817999999997e-07 10.5p -7.0871980000000003e-07 10.6p -5.4624829999999993e-07 10.699999999999999p -3.6920969999999998e-07 10.799999999999999p -1.9145510000000001e-07 10.899999999999999p -2.6606900000000029e-08 11p 1.1304240000000001e-07 11.100000000000001p 2.1750100299999999e-07 11.200000000000001p 2.7984089999999998e-07 11.300000000000001p 2.9669419999999998e-07 11.4p 2.6844909999999996e-07 11.5p 1.9913331999999998e-07 11.600000000000001p 9.6002929999999987e-08 11.700000000000001p -3.1125100000000001e-08 11.800000000000001p -1.7073491000000002e-07 11.9p -3.1059465999999999e-07 12p -4.387762e-07 12.100000000000001p -5.4462639999999999e-07 12.200000000000001p -6.1961219999999996e-07 12.300000000000001p -6.5797159999999999e-07 12.4p -6.5712274999999997e-07 12.5p -6.1780045800000001e-07 12.6p -5.4391811999999997e-07 12.700000000000001p -4.4217020000000003e-07 12.800000000000001p -3.214149e-07 12.9p -1.9189210000000003e-07 13p -6.434570000000001e-08 13.1p 5.0876400000000007e-08 13.200000000000001p 1.4466953e-07 13.300000000000001p 2.0989874e-07 13.4p 2.4194650000000003e-07 13.5p 2.3904152999999999e-07 13.6p 2.02345e-07 13.700000000000001p 1.3579481e-07 13.800000000000001p 4.5722289999999997e-08 13.9p -5.971849000000001e-08 14p -1.7126166e-07 14.1p -2.7931559999999996e-07 14.199999999999999p -3.7476149999999999e-07 14.300000000000001p -4.4969499999999998e-07 14.4p -4.9805420000000003e-07 14.5p -5.1608273000000006e-07 14.6p -5.0259281999999996e-07 14.700000000000001p -4.5901338000000001e-07 14.900000000000002p -2.9916869999999999e-07 15p -1.9636449999999998e-07 15.100000000000001p -8.9214700000000019e-08 15.199999999999999p 1.3679600000000006e-08 15.300000000000001p 1.0423333999999999e-07 15.4p 1.755302e-07 15.500000000000002p 2.2236609999999999e-07 15.6p 2.416405e-07 15.700000000000001p 2.3256714e-07 15.799999999999999p 1.9669026800000002e-07 15.900000000000002p 1.3770873000000001e-07 16p 6.1127589999999985e-08 16.100000000000001p -2.6231869999999998e-08 16.199999999999999p -1.1681967999999999e-07 16.300000000000001p -2.0299166999999999e-07 16.399999999999999p -2.7763909999999995e-07 16.5p -3.3476010000000001e-07 16.599999999999998p -3.6992821999999998e-07 16.700000000000003p -3.8062174999999997e-07 16.800000000000001p -3.6638937999999996e-07 16.900000000000002p -3.2884207000000002e-07 17p -2.714759e-07 17.100000000000001p -1.9934355000000002e-07 17.199999999999999p -1.1860469999999999e-07 17.300000000000001p -3.5995499999999986e-08 17.399999999999999p 4.1738629999999995e-08 17.5p 1.0839837999999999e-07 17.599999999999998p 1.5882947999999999e-07 17.699999999999999p 1.8932477999999998e-07 17.800000000000001p 1.9789915000000001e-07 17.900000000000002p 1.8441606000000001e-07 18p 1.5056015999999999e-07 18.100000000000001p 9.9660109999999996e-08 18.199999999999999p 3.6379859999999994e-08 18.300000000000001p -3.3694010000000007e-08 18.399999999999999p -1.04531066e-07 18.5p -1.7016345999999999e-07 18.599999999999998p -2.2517660000000001e-07 18.699999999999999p -2.6514289000000001e-07 18.800000000000001p -2.8696675e-07 18.900000000000002p -2.8911189e-07 19p -2.7169524499999999e-07 19.100000000000001p -2.3644417999999999e-07 19.199999999999999p -1.8652062e-07 19.300000000000001p -1.2623129999999999e-07 19.399999999999999p -6.065032e-08 19.5p 4.8143099999999922e-09 19.599999999999998p 6.4872410000000005e-08 19.699999999999999p 1.1478437e-07 19.799999999999997p 1.5073927999999999e-07 19.900000000000002p 1.7014925999999999e-07 20p 1.7183711999999999e-07 20.100000000000001p 1.5610333700000001e-07 20.199999999999999p 1.2467150999999999e-07 20.300000000000001p 8.0516300000000007e-08 20.399999999999999p 2.7593719999999992e-08 20.5p -2.9505059999999998e-08 20.599999999999998p -8.5943972000000009e-08 20.699999999999999p -1.3704461999999999e-07 20.799999999999997p -1.7866748000000002e-07 20.899999999999999p -2.0754068999999998e-07 21p -2.2151086e-07 21.100000000000001p -2.1969608999999999e-07 21.199999999999999p -2.0253207049999999e-07 21.300000000000001p -1.7170818000000001e-07 21.399999999999999p -1.3000178e-07 21.5p -8.1027489999999992e-08 21.599999999999998p -2.892138e-08 21.699999999999999p 2.2009789999999996e-08 21.799999999999997p 6.7646530000000012e-08 21.899999999999999p 1.0439188000000001e-07 22p 1.2945617e-07 22.100000000000001p 1.4106972e-07 22.200000000000003p 1.3860675999999999e-07 22.300000000000001p 1.2261324839999999e-07 22.400000000000002p 9.4737060000000002e-08 22.5p 5.7569280000000001e-08 22.600000000000001p 1.4411220000000006e-08 22.699999999999999p -3.1012319999999996e-08 22.800000000000001p -7.4868525000000004e-08 22.899999999999999p -1.1353429000000001e-07 23p -1.4389019e-07 23.100000000000001p -1.6356673e-07 23.200000000000003p -1.7112377999999999e-07 23.300000000000001p -1.6614997000000001e-07 23.400000000000002p -1.49274879e-07 23.5p -1.2209570999999999e-07 23.600000000000001p -8.7025939999999995e-08 23.699999999999999p -4.7079589999999997e-08 23.800000000000001p -5.6104899999999993e-09 23.899999999999999p 3.3970400000000001e-08 24p 6.8477105999999999e-08 24.099999999999998p 9.5206070000000001e-08 24.200000000000003p 1.1214867e-07 24.300000000000001p 1.1814205e-07 24.400000000000002p 1.1294728999999999e-07 24.5p 9.7249975999999993e-08 24.600000000000001p 7.2584480000000004e-08 24.699999999999999p 4.1190450000000005e-08 24.800000000000001p 5.8136399999999994e-09 24.899999999999999p -3.0530180000000001e-08 25p -6.4808969000000002e-08 25.099999999999998p -9.4224089999999993e-08 25.199999999999999p -1.1643558e-07 25.300000000000001p -1.2974504000000001e-07 25.400000000000002p -1.3322195e-07 25.5p -1.2676413e-07 25.600000000000001p -1.11088862e-07 25.699999999999999p -8.7656739999999999e-08 25.800000000000001p -5.8536290000000002e-08 25.899999999999999p -2.6220619999999998e-08 26p 6.5861099999999989e-09 26.099999999999998p 3.7195659999999995e-08 26.199999999999999p 6.3156509999999997e-08 26.300000000000001p 8.2450520000000007e-08 26.400000000000002p 9.3649989999999998e-08 26.5p 9.6022570000000001e-08 26.600000000000001p 8.9577144000000002e-08 26.699999999999999p 7.5047494000000002e-08 26.800000000000001p 5.3816769999999998e-08 26.899999999999999p 2.7790170000000001e-08 27p -7.7277000000000249e-10 27.099999999999998p -2.9451460000000005e-08 27.199999999999999p -5.5866789999999999e-08 27.299999999999997p -7.7876009999999999e-08 27.400000000000002p -9.3744070000000011e-08 27.5p -1.0227789999999999e-07 27.600000000000001p -1.029132e-07 27.699999999999999p -9.5747788000000003e-08 27.800000000000001p -8.1519663e-08 27.899999999999999p -6.153296e-08 28p -3.7538810000000002e-08 28.099999999999998p -1.1581879999999999e-08 28.199999999999999p 1.4173949999999996e-08 28.299999999999997p 3.7626197000000002e-08 28.399999999999999p 5.6905430000000004e-08 28.5p 7.052428e-08 28.600000000000001p 7.7491880000000005e-08 28.699999999999999p 7.7385019999999994e-08 28.800000000000001p 7.0371129000000007e-08 28.899999999999999p 5.7182266000000001e-08 29p 3.9043009999999998e-08 29.099999999999998p 1.7559540000000002e-08 29.199999999999999p -5.4205299999999984e-09 29.299999999999997p -2.7965174000000002e-08 29.400000000000002p -4.82187e-08 29.5p -6.4552820000000005e-08 29.600000000000001p -7.569586e-08 29.699999999999999p -8.083001e-08 29.800000000000004p -7.9649056999999996e-08 29.900000000000002p -7.2373029800000008e-08 30p -5.971899000000001e-08 30.099999999999998p -4.2831730000000003e-08 30.200000000000003p -2.3180680000000001e-08 30.300000000000001p -2.4321600000000029e-09 30.399999999999999p 1.76918e-08 30.499999999999996p 3.5556335999999999e-08 30.600000000000001p 4.9746450000000005e-08 30.700000000000003p 5.9178839999999999e-08 30.800000000000001p 6.3184189999999993e-08 30.899999999999999p 6.1553565999999997e-08 31.000000000000004p 5.4546041999999998e-08 31.100000000000001p 4.2857624999999995e-08 31.199999999999999p 2.7554879999999999e-08 31.299999999999997p 9.9794799999999971e-09 31.400000000000002p -8.3680000000000025e-09 31.5p -2.5954785999999998e-08 31.599999999999998p -4.1342739999999998e-08 31.699999999999999p -5.3304739999999996e-08 31.800000000000004p -6.092126000000001e-08 31.900000000000002p -6.3649599999999996e-08 32p -6.1360726999999992e-08 32.099999999999994p -5.4341333e-08 32.200000000000003p -4.3261511999999997e-08 32.300000000000004p -2.9111699999999997e-08 32.399999999999999p -1.3114489999999998e-08 32.5p 3.3807199999999991e-09 32.600000000000001p 1.9011526e-08 32.700000000000003p 3.2514769999999996e-08 32.799999999999997p 4.2828459999999999e-08 32.899999999999999p 4.9174960000000002e-08 33p 5.1119090000000005e-08 33.100000000000001p 4.8596766000000006e-08 33.199999999999996p 4.1912605000000003e-08 33.299999999999997p 3.1707153999999997e-08 33.400000000000006p 1.8897280000000004e-08 33.5p 4.5949200000000001e-09 33.600000000000001p -9.9883600000000004e-09 33.699999999999996p -2.3643192e-08 33.800000000000004p -3.5261779999999998e-08 33.899999999999999p -4.392698e-08 34p -4.8983660000000001e-08 34.099999999999994p -5.0087295999999999e-08 34.200000000000003p -4.7225703000000003e-08 34.299999999999997p -4.0713193999999998e-08 34.399999999999999p -3.1157868000000004e-08 34.5p -1.9405539999999997e-08 34.600000000000001p -6.4651100000000006e-09 34.700000000000003p 6.5777399999999992e-09 34.799999999999997p 1.86515e-08 34.899999999999999p 2.8786687000000001e-08 35p 3.6193450000000003e-08 35.100000000000001p 4.0322790000000002e-08 35.199999999999996p 4.0906709e-08 35.299999999999997p 3.7974379999999995e-08 35.399999999999999p 3.1843526000000005e-08 35.5p 2.3088317999999997e-08 35.600000000000001p 1.2486700000000002e-08 35.699999999999996p 9.5221000000000162e-10 35.800000000000004p -1.0544084e-08 35.899999999999999p -2.1054605999999999e-08 36p -2.9732769999999998e-08 36.099999999999994p -3.5900519999999998e-08 36.200000000000003p -3.9100584e-08 36.299999999999997p -3.9129488000000003e-08 36.399999999999999p -3.60489866e-08 36.5p -3.0175431999999996e-08 36.600000000000001p -2.2048440999999998e-08 36.700000000000003p -1.2381780000000001e-08 36.799999999999997p -2.0010699999999983e-09 36.900000000000006p 8.2265739999999997e-09 37p 1.7464681999999999e-08 37.100000000000001p 2.4975689999999999e-08 37.199999999999996p 3.0179539999999995e-08 37.300000000000004p 3.2698101999999999e-08 37.399999999999999p 3.2382116999999999e-08 37.5p 2.931869674e-08 37.600000000000001p 2.3819184000000002e-08 37.700000000000003p 1.6388903000000001e-08 37.800000000000004p 7.6814999999999983e-09 37.899999999999999p -1.5579500000000004e-09 38p -1.0556113e-08 38.100000000000001p -1.8575718e-08 38.200000000000003p -2.4975390000000002e-08 38.299999999999997p -2.9260499999999999e-08 38.399999999999999p -3.1120767e-08 38.5p -3.0452002000000001e-08 38.600000000000001p -2.73603635e-08 38.700000000000003p -2.2149222e-08 38.799999999999997p -1.5290148000000001e-08 38.900000000000006p -7.3805400000000007e-09 39p 9.0809000000000115e-10 39.100000000000001p 8.8870169999999992e-09 39.199999999999996p 1.5907209000000002e-08 39.300000000000004p 2.141204e-08 39.399999999999999p 2.4981116999999998e-08 39.5p 2.6362013999999999e-08 39.599999999999994p 2.5487633000000002e-08 39.700000000000003p 2.2477828500000001e-08 39.800000000000004p 1.7625659000000002e-08 39.899999999999999p 1.1369706000000001e-08 40p 4.2549310000000002e-09 40.100000000000001p -3.1143489999999994e-09 40.200000000000003p -1.0125426e-08 40.299999999999997p -1.6207802999999999e-08 40.399999999999999p -2.0879220999999999e-08 40.5p -2.3783547999999998e-08 40.600000000000001p -2.471744e-08 40.699999999999996p -2.3643892000000002e-08 40.799999999999997p -2.0691845000000001e-08 40.900000000000006p -1.6142135e-08 41p -1.0401204999999999e-08 41.100000000000001p -3.965088000000001e-09 41.199999999999996p 2.6232860000000007e-09 41.300000000000004p 8.8196830000000004e-09 41.399999999999999p 1.4123435e-08 41.5p 1.8117640000000002e-08 41.599999999999994p 2.0501781e-08 41.700000000000003p 2.1113983000000001e-08 41.799999999999997p 1.9941486999999999e-08 41.899999999999999p 1.7118542999999999e-08 42p 1.2912360000000002e-08 42.100000000000001p 7.6983220000000006e-09 42.200000000000003p 1.9268859999999997e-09 42.299999999999997p -3.9150560000000011e-09 42.399999999999999p -9.3449706000000009e-09 42.5p -1.3924285000000001e-08 42.600000000000001p -1.7293548000000001e-08 42.699999999999996p -1.9200338000000002e-08 42.799999999999997p -1.9517812000000003e-08 42.899999999999999p -1.8252479699999999e-08 43p -1.5540933999999999e-08 43.100000000000001p -1.1635848e-08 43.199999999999996p -6.8828019999999992e-09 43.300000000000004p -1.6899069999999999e-09 43.399999999999999p 3.5070800000000003e-09 43.5p 8.2811792000000007e-09 43.599999999999994p 1.2249121e-08 43.700000000000003p 1.5101969999999999e-08 43.799999999999997p 1.6628981e-08 43.899999999999999p 1.6732862000000001e-08 44p 1.5435463000000001e-08 44.100000000000001p 1.2873421999999999e-08 44.200000000000003p 9.2845390000000004e-09 44.299999999999997p 4.9861209999999996e-09 44.400000000000006p 3.4718699999999979e-10 44.5p -4.2429800000000006e-09 44.600000000000001p -8.4072700000000005e-09 44.699999999999996p -1.1811531e-08 44.800000000000004p -1.4191167999999998e-08 44.899999999999999p -1.5371458e-08 45p -1.5280033999999999e-08 45.100000000000001p -1.3950732600000001e-08 45.200000000000003p -1.1518553e-08 45.300000000000004p -8.2064500000000003e-09 45.399999999999999p -4.3051530000000003e-09 45.5p -1.4780499999999978e-10 45.600000000000001p 3.9183310000000004e-09 45.700000000000003p 7.5607469999999994e-09 45.799999999999997p 1.0488751000000001e-08 45.899999999999999p 1.2476519999999999e-08 46p 1.3380342000000001e-08 46.100000000000001p 1.3148699999999999e-08 46.200000000000003p 1.18246471e-08 46.299999999999997p 9.5402459999999987e-09 46.400000000000006p 6.5038550000000008e-09 46.5p 2.981399000000001e-09 46.600000000000001p -7.2671900000000025e-10 46.699999999999996p -4.3110600000000006e-09 46.800000000000004p -7.4788109999999996e-09 46.899999999999999p -9.9775359999999994e-09 47p -1.1615116999999999e-08 47.099999999999994p -1.2274310000000001e-08 47.200000000000003p -1.1920844e-08 47.300000000000004p -1.0604515000000001e-08 47.399999999999999p -8.4533499999999987e-09 47.5p -5.6614339999999996e-09 47.600000000000001p -2.4715879999999999e-09 47.700000000000003p 8.4564300000000012e-10 47.799999999999997p 4.014824e-09 47.899999999999999p 6.7783929999999999e-09 48p 8.9174910000000007e-09 48.100000000000001p 1.0269166000000001e-08 48.199999999999996p 1.0738627e-08 48.299999999999997p 1.0305625000000001e-08 48.400000000000006p 9.0245822000000006e-09 48.5p 7.0185629999999995e-09 48.600000000000001p 4.4677289999999995e-09 48.699999999999996p 1.5933319999999997e-09 48.800000000000004p -1.3613370000000001e-09 48.899999999999999p -4.1514239999999997e-09 49p -6.5506810000000003e-09 49.099999999999994p -8.3696950000000002e-09 49.200000000000003p -9.4707050000000012e-09 49.299999999999997p -9.77786e-09 49.399999999999999p -9.2821747999999995e-09 49.5p -8.0408806000000007e-09 49.600000000000001p -6.1713420000000001e-09 49.700000000000003p -3.8401549999999998e-09 49.799999999999997p -1.2484219999999999e-09 49.899999999999999p 1.3855069999999996e-09 50p 3.8443503000000004e-09 50.100000000000001p -5.6630849999999998e-06 50.199999999999996p -1.0960864e-05 50.299999999999997p -1.5755084000000001e-05 50.399999999999999p -1.9933583000000002e-05 50.5p -2.3419452e-05 50.600000000000001p -2.6182544000000003e-05 50.699999999999996p -2.8245783e-05 50.800000000000004p -2.9685274999999997e-05 50.899999999999999p -3.0624647999999996e-05 51p -3.1224506999999998e-05 51.100000000000001p -2.5999512e-05 51.200000000000003p -2.1180014999999998e-05 51.299999999999997p -1.7085389000000001e-05 51.399999999999999p -1.3992943e-05 51.5p -1.2114588000000001e-05 51.600000000000001p -1.1577498e-05 51.700000000000003p -1.2412267999999999e-05 51.799999999999997p -1.4549187000000001e-05 51.900000000000006p -1.7822274999999999e-05 52p -2.1980831999999999e-05 52.100000000000001p -2.6707766999999998e-05 52.199999999999996p -3.1643914000000002e-05 52.300000000000004p -3.6416399999999999e-05 52.399999999999999p -4.0668925000000001e-05 52.5p -4.4090944000000002e-05 52.600000000000001p -4.6442954000000003e-05 52.700000000000003p -4.7575596999999997e-05 52.800000000000004p -4.7440654999999998e-05 52.899999999999999p -4.609328831e-05 53p -4.3685296999999998e-05 53.100000000000001p -4.0450339999999997e-05 53.200000000000003p -3.6682623000000003e-05 53.299999999999997p -3.2711240999999998e-05 53.399999999999999p -2.8872957000000002e-05 53.5p -2.5485834000000002e-05 53.600000000000001p -2.2826248e-05 53.700000000000003p -2.1110488000000001e-05 53.799999999999997p -2.0481995000000001e-05 53.900000000000006p -2.1004241e-05 54p -2.2659086699999998e-05 54.100000000000001p -2.5350319999999998e-05 54.199999999999996p -2.8911972999999996e-05 54.300000000000004p -3.3121028e-05 54.399999999999999p -3.7713626000000002e-05 54.5p -4.2403616999999995e-05 54.599999999999994p -4.6901608999999996e-05 54.700000000000003p -5.0932744000000001e-05 54.800000000000004p -5.4251976999999999e-05 54.899999999999999p -5.6657166000000004e-05 55p -5.8001473999999999e-05 55.100000000000001p -5.8206564999999997e-05 55.200000000000003p -5.7275363100000001e-05 55.299999999999997p -5.5300399000000001e-05 55.399999999999999p -5.2462671999999998e-05 55.5p -4.9018516000000002e-05 55.600000000000001p -4.5275981e-05 55.699999999999996p -4.1565057999999998e-05 55.799999999999997p -3.8207102000000001e-05 55.899999999999999p -3.5487588999999999e-05 56p -3.3634801000000001e-05 56.100000000000001p -3.2805145999999994e-05 56.199999999999996p -3.3074815000000005e-05 56.300000000000004p -3.4437098499999995e-05 56.399999999999999p -3.6804573000000003e-05 56.5p -4.0015852999999996e-05 56.599999999999994p -4.3846698999999999e-05 56.700000000000003p -4.8025385999999998e-05 56.799999999999997p -5.2251916000000004e-05 56.899999999999999p -5.6220154999999998e-05 57p -5.9641400999999997e-05 57.100000000000001p -6.2267227000000006e-05 57.200000000000003p -6.3909538000000006e-05 57.299999999999997p -6.4455584000000003e-05 57.399999999999999p -6.3876609999999998e-05 57.5p -6.2229116199999997e-05 57.600000000000001p -5.9648882000000008e-05 57.699999999999996p -5.6338325000000004e-05 57.799999999999997p -5.2548922000000001e-05 57.899999999999999p -4.8560287999999997e-05 58p -4.4658347000000001e-05 58.100000000000001p -4.1114305000000001e-05 58.199999999999996p -3.8166144999999997e-05 58.299999999999997p -3.6003539000000002e-05 58.399999999999999p -3.4756894000000003e-05 58.500000000000007p -3.4490338000000001e-05 58.599999999999994p -3.5198944e-05 58.700000000000003p -3.6809835299999998e-05 58.800000000000004p -3.9187282000000001e-05 58.899999999999999p -4.2141849000000004e-05 59p -4.5443329999999994e-05 59.099999999999994p -4.8837075000000005e-05 59.200000000000003p -5.2062930000000001e-05 59.300000000000004p -5.4875110999999996e-05 59.399999999999999p -5.7061597999999997e-05 59.5p -5.8460959999999999e-05 59.600000000000009p -5.8974979999999996e-05 59.699999999999996p -5.8575955e-05 59.800000000000004p -5.7307769700000004e-05 59.899999999999991p -5.5280863e-05 60p -5.2661727999999994e-05 60.100000000000001p -4.3989034000000002e-05 60.199999999999996p -3.5534330000000005e-05 60.300000000000004p -2.767313e-05 60.400000000000006p -2.0750450000000001e-05 60.5p -1.505296e-05 60.600000000000001p -1.0783934999999999e-05 60.699999999999996p -8.0446209999999983e-06 60.799999999999997p -6.8231470000000002e-06 60.900000000000006p -6.9915010000000001e-06 60.999999999999993p -8.3114763999999991e-06 61.100000000000001p -1.6119213999999998e-05 61.200000000000003p -2.3973289e-05 61.299999999999997p -3.1300000000000002e-05 61.400000000000006p -3.7549699999999997e-05 61.499999999999993p -4.2248045999999999e-05 61.600000000000001p -4.5041664000000001e-05 61.700000000000003p -4.5731070000000005e-05 61.799999999999997p -4.4288317000000001e-05 61.899999999999999p -4.0858887000000001e-05 62.000000000000007p -3.5748147999999995e-05 62.099999999999994p -2.9393888000000004e-05 62.200000000000003p -2.2327211000000002e-05 62.299999999999997p -1.5125769999999998e-05 62.399999999999999p -8.3643099999999995e-06 62.500000000000007p -2.567750000000001e-06 62.599999999999994p 1.8287559999999998e-06 62.700000000000003p 4.5100489999999999e-06 62.800000000000004p 5.3007023000000002e-06 62.899999999999999p 4.1742160000000002e-06 63p 1.2523150000000001e-06 63.099999999999994p -3.2054426999999997e-06 63.199999999999996p -8.8217200000000003e-06 63.300000000000004p -1.5130808999999999e-05 63.399999999999999p -2.1616062999999997e-05 63.5p -2.7752632999999999e-05 63.600000000000009p -3.3051388999999997e-05 63.699999999999996p -3.7099679999999998e-05 63.800000000000004p -3.9594719000000001e-05 63.899999999999991p -4.0366864999999999e-05 64p -3.9391063000000002e-05 64.100000000000009p -3.6785958999999998e-05 64.199999999999989p -3.2801076999999997e-05 64.299999999999997p -2.7792961999999999e-05 64.400000000000006p -2.2192720999999999e-05 64.5p -1.6467770999999999e-05 64.600000000000009p -1.1081951000000001e-05 64.699999999999989p -6.457861999999999e-06 64.799999999999997p -2.9449439999999999e-06 64.900000000000006p -7.9533700000000021e-07 65p -1.4836399999999999e-07 65.099999999999994p -1.023707e-06 65.200000000000003p -3.3227369999999999e-06 65.299999999999997p -6.837648e-06 65.400000000000006p -1.1268094e-05 65.5p -1.6244796999999999e-05 65.599999999999994p -2.1359037000000001e-05 65.700000000000003p -2.6195985e-05 65.799999999999997p -3.0368950999999999e-05 65.900000000000006p -3.3551357999999997e-05 66p -3.5503144999999999e-05 66.099999999999994p -3.6089483000000001e-05 66.200000000000003p -3.5290048000000001e-05 66.300000000000011p -3.31985759e-05 66.399999999999991p -3.0012858999999996e-05 66.5p -2.6016130000000002e-05 66.599999999999994p -2.1551643999999999e-05 66.700000000000003p -1.6992718999999999e-05 66.800000000000011p -1.2711116999999999e-05 66.899999999999991p -9.0467240000000016e-06 67p -6.2810890000000006e-06 67.100000000000009p -4.6169069999999989e-06 67.200000000000003p -4.1644649999999998e-06 67.299999999999997p -4.9355277999999996e-06 67.399999999999991p -6.8446577000000002e-06 67.5p -9.7175779999999997e-06 67.600000000000009p -1.3306022e-05 67.700000000000003p -1.7308182999999998e-05 67.799999999999997p -2.1393417000000001e-05 67.900000000000006p -2.5229376e-05 68p -2.8509242999999999e-05 68.100000000000009p -3.0976760000000002e-05 68.199999999999989p -3.2446707000000001e-05 68.299999999999997p -3.2819086999999997e-05 68.400000000000006p -3.2085869500000004e-05 68.5p -3.0329896800000001e-05 68.599999999999994p -2.7716070999999998e-05 68.700000000000003p -2.4475929e-05 68.799999999999997p -2.0886798999999999e-05 68.900000000000006p -1.7247860000000002e-05 69p -1.3854974000000001e-05 69.099999999999994p -1.0976822999999999e-05 69.200000000000003p -8.8341349999999997e-06 69.299999999999997p -7.5834520000000007e-06 69.400000000000006p -7.3065810000000002e-06 69.5p -8.0059543999999998e-06 69.599999999999994p -9.6061132999999998e-06 69.700000000000003p -1.1961041999999999e-05 69.799999999999997p -1.4866808e-05 69.900000000000006p -1.8078656999999999e-05 70p -2.1331251999999999e-05 70.099999999999994p -1.2432891e-05 70.200000000000003p -3.6079259999999992e-06 70.300000000000011p 5.212038e-06 70.399999999999991p 1.4064574799999999e-05 70.5p 2.2955234999999999e-05 70.599999999999994p 3.1866490000000003e-05 70.700000000000003p 4.076761e-05 70.799999999999997p 4.9622709999999996e-05 70.899999999999991p 5.839618e-05 71p 6.7055339999999998e-05 71.100000000000009p 6.3642838999999993e-05 71.200000000000003p 6.0596817800000002e-05 71.299999999999997p 5.8021910000000002e-05 71.399999999999991p 5.5998309e-05 71.5p 5.4575903000000002e-05 71.600000000000009p 5.3766163999999995e-05 71.699999999999989p 5.3539824000000004e-05 71.799999999999997p 5.3830652199999998e-05 71.900000000000006p 5.45436284e-05 72p 5.5565086999999999e-05 72.100000000000009p 5.6773030000000002e-05 72.199999999999989p 5.8046486999999998e-05 72.299999999999997p 5.9273320000000002e-05 72.400000000000006p 6.0356421000000001e-05 72.5p 6.1218480999999998e-05 72.599999999999994p 6.1805334000000002e-05 72.700000000000003p 6.2088348100000003e-05 72.799999999999997p 6.2065588200000001e-05 72.900000000000006p 6.1761870539999998e-05 73p 6.1227308099999996e-05 73.099999999999994p 6.05341151e-05 73.200000000000003p 5.9771329099999999e-05 73.299999999999997p 5.9037554e-05 73.400000000000006p 5.8431894000000002e-05 73.5p 5.8044097199999997e-05 73.599999999999994p 5.7944929199999997e-05 73.700000000000003p 5.81781543e-05 73.800000000000011p 5.8755293500000002e-05 73.899999999999991p 5.9653947000000003e-05 74p 6.0819782999999997e-05 74.099999999999994p 6.2171955000000004e-05 74.200000000000003p 6.3610970999999992e-05 74.300000000000011p 6.5028122999999998e-05 74.399999999999991p 6.6315405999999995e-05 74.5p 6.7374862000000007e-05 74.600000000000009p 6.8126621999999999e-05 74.700000000000003p 6.8514862999999996e-05 74.799999999999997p 6.8511270700000008e-05 74.899999999999991p 6.811563583e-05 75p 6.7353954e-05 75.100000000000009p 6.6274195000000003e-05 75.200000000000003p 6.4940782000000004e-05 75.299999999999997p 6.3428381999999995e-05 75.400000000000006p 6.1816130999999997e-05 75.5p 6.0182602999999997e-05 75.600000000000009p 5.8602144e-05 75.699999999999989p 5.7142405999999993e-05 75.799999999999997p 5.5862981000000005e-05 75.900000000000006p 5.4814738999999995e-05 76p 5.4039572e-05 76.099999999999994p 5.3570184e-05 76.200000000000003p 5.3429677499999996e-05 76.299999999999997p 5.3630816600000002e-05 76.400000000000006p 5.4174874600000001e-05 76.5p 5.50502751e-05 76.599999999999994p 5.6231089000000001e-05 76.700000000000003p 5.7675819e-05 76.799999999999997p 5.9326865999999996e-05 76.900000000000006p 6.1111106000000002e-05 77p 6.2942134999999997e-05 77.099999999999994p 6.4724332999999997e-05 77.200000000000003p 6.6358835000000001e-05 77.299999999999997p 6.7750922999999992e-05 77.400000000000006p 6.8818201000000001e-05 77.5p 6.9498338999999992e-05 77.599999999999994p 6.9755449000000007e-05 77.700000000000003p 6.9584226499999993e-05 77.800000000000011p 6.901101140000001e-05 77.899999999999991p 6.8091901499999998e-05 78p 6.6907863999999992e-05 78.099999999999994p 6.5557582999999997e-05 78.200000000000003p 6.4148528999999997e-05 78.299999999999997p 6.2787414999999989e-05 78.399999999999991p 6.1570782000000001e-05 78.5p 6.0576788999999996e-05 78.600000000000009p 5.9858987999999998e-05 78.700000000000003p 5.9442884999999999e-05 78.799999999999997p 5.9325349599999996e-05 78.899999999999991p 5.9477044599999997e-05 79p 5.9847276899999998e-05 79.100000000000009p 6.0370472100000002e-05 79.199999999999989p 6.0973499600000002e-05 79.299999999999997p 6.1582866900000008e-05 79.400000000000006p 6.2131035700000009e-05 79.5p 6.2561541200000003e-05 79.600000000000009p 6.2832624500000009e-05 79.699999999999989p 6.2919341800000004e-05 79.799999999999997p 6.2814370700000005e-05 79.900000000000006p 6.2527758999999996e-05 80p 6.2085618400000003e-05 80.099999999999994p 4.9600418000000003e-05 80.200000000000003p 3.7594530000000003e-05 80.299999999999997p 2.627076e-05 80.400000000000006p 1.5816569999999998e-05 80.5p 6.3867799999999999e-06 80.599999999999994p -1.9223100000000009e-06 80.700000000000003p -9.0968539999999984e-06 80.799999999999997p -1.5221139000000001e-05 80.900000000000006p -2.0480427999999998e-05 81p -2.5147049000000002e-05 81.099999999999994p -1.76218049e-05 81.200000000000003p -1.0711820999999999e-05 81.300000000000011p -4.8582500000000005e-06 81.399999999999991p -4.1041199999999982e-07 81.5p 2.4004590000000005e-06 81.599999999999994p 3.4746129999999999e-06 81.700000000000003p 2.8400395000000001e-06 81.800000000000011p 6.3637080000000002e-07 81.899999999999991p -2.9069020000000001e-06 82p -7.492561e-06 82.100000000000009p -1.2775316e-05 82.200000000000003p -1.8378784000000001e-05 82.299999999999997p -2.3911797999999998e-05 82.399999999999991p -2.8986987999999999e-05 82.5p -3.3243992e-05 82.600000000000009p -3.6376915000000002e-05 82.700000000000003p -3.8162511999999999e-05 82.799999999999997p -3.8483023e-05 82.900000000000006p -3.7337807000000006e-05 83p -3.4840650999999999e-05 83.100000000000009p -3.1203758999999995e-05 83.199999999999989p -2.6713060000000001e-05 83.299999999999997p -2.1700823000000004e-05 83.400000000000006p -1.6520343999999999e-05 83.5p -1.1525165999999998e-05 83.599999999999994p -7.0525339999999986e-06 83.700000000000003p -3.409275999999999e-06 83.799999999999997p -8.5765400000000028e-07 83.900000000000006p 4.0036299999999963e-07 84p 2.4085399999999968e-07 84.099999999999994p -1.36403152e-06 84.200000000000003p -4.3313179999999996e-06 84.299999999999997p -8.4608780000000004e-06 84.400000000000006p -1.3442648e-05 84.5p -1.8880130000000001e-05 84.599999999999994p -2.4328388e-05 84.700000000000003p -2.9340084999999999e-05 84.799999999999997p -3.3510704000000002e-05 84.900000000000006p -3.6515340999999998e-05 85p -3.8133103000000004e-05 85.099999999999994p -3.8259278999999997e-05 85.200000000000003p -3.6907727999999996e-05 85.300000000000011p -3.4206311999999998e-05 85.399999999999991p -3.0387026999999999e-05 85.5p -2.5770235000000002e-05 85.599999999999994p -2.0741795000000002e-05 85.700000000000003p -1.5721974000000002e-05 85.799999999999997p -1.1127477e-05 85.899999999999991p -7.3308490000000009e-06 86p -4.6235599999999998e-06 86.100000000000009p -3.1890750000000005e-06 86.200000000000003p -3.0899720000000006e-06 86.299999999999997p -4.2700231000000001e-06 86.399999999999991p -6.569081e-06 86.5p -9.7466420000000007e-06 86.600000000000009p -1.3509462999999999e-05 86.699999999999989p -1.7539211999999999e-05 86.799999999999997p -2.1517512000000001e-05 86.900000000000006p -2.5147379999999998e-05 87p -2.8170995000000001e-05 87.100000000000009p -3.0384555000000001e-05 87.199999999999989p -3.1650235e-05 87.299999999999997p -3.1904883e-05 87.400000000000006p -3.1164048799999999e-05 87.5p -2.9519698800000002e-05 87.599999999999994p -2.7130891999999999e-05 87.700000000000003p -2.420796e-05 87.799999999999997p -2.0992150000000002e-05 87.900000000000006p -1.7734036999999998e-05 88p -1.4673653999999999e-05 88.099999999999994p -1.2024393e-05 88.200000000000003p -9.9615480000000007e-06 88.299999999999997p -8.6148949999999991e-06 88.400000000000006p -8.0644190000000006e-06 88.5p -8.3377669999999998e-06 88.599999999999994p -9.4090848000000002e-06 88.700000000000003p -1.1199035e-05 88.800000000000011p -1.3576962e-05 88.899999999999991p -1.6366394e-05 89p -1.9355107e-05 89.099999999999994p -2.2310098e-05 89.200000000000003p -2.4996594000000001e-05 89.300000000000011p -2.7198910000000002e-05 89.399999999999991p -2.8740182e-05 89.5p -2.9498191e-05 89.600000000000009p -2.9415479000000002e-05 89.700000000000003p -2.8503135090000002e-05 89.799999999999997p -2.6838685999999999e-05 89.899999999999991p -2.455919e-05 90p -2.1850418999999999e-05 90.100000000000009p -1.3264034000000002e-05 90.200000000000003p -5.0788900000000008e-06 90.299999999999997p 2.32906e-06 90.400000000000006p 8.6250209999999987e-06 90.5p 1.3549008e-05 90.600000000000009p 1.6946508999999999e-05 90.699999999999989p 1.8788987e-05 90.799999999999997p 1.9180424999999999e-05 90.900000000000006p 1.8347929e-05 91p 1.6617723899999999e-05 91.099999999999994p 8.711676000000001e-06 91.200000000000003p 1.0856070000000011e-06 91.299999999999997p -5.717941999999999e-06 91.400000000000006p -1.1216066e-05 91.5p -1.5018504e-05 91.599999999999994p -1.6852944999999999e-05 91.700000000000003p -1.6581750000000001e-05 91.799999999999997p -1.421144687e-05 91.900000000000006p -9.8954759999999997e-06 92p -3.9289610000000008e-06 92.099999999999994p 3.2671280000000004e-06 92.200000000000003p 1.1174967900000001e-05 92.299999999999997p 1.9222172e-05 92.400000000000006p 2.6833320000000001e-05 92.5p 3.3483659999999996e-05 92.599999999999994p 3.8746080000000004e-05 92.700000000000003p 4.2324675999999999e-05 92.800000000000011p 4.4070998999999996e-05 92.899999999999991p 4.3983342000000004e-05 93p 4.2191586799999999e-05 93.099999999999994p 3.8933525000000004e-05 93.200000000000003p 3.4529467999999994e-05 93.299999999999997p 2.9360862999999997e-05 93.399999999999991p 2.3853392000000003e-05 93.5p 1.8459146e-05 93.600000000000009p 1.3631892000000002e-05 93.700000000000003p 9.7940999999999983e-06 93.799999999999997p 7.3003950000000009e-06 93.899999999999991p 6.4044909999999998e-06 94p 7.2353270000000005e-06 94.100000000000009p 9.785692e-06 94.199999999999989p 1.3913600999999999e-05 94.299999999999997p 1.9355700000000002e-05 94.400000000000006p 2.5750765999999998e-05 94.5p 3.2670959000000001e-05 94.600000000000009p 3.9657679999999997e-05 94.700000000000003p 4.6258590000000004e-05 94.799999999999997p 5.2062479999999997e-05 94.900000000000006p 5.6728992999999999e-05 95p 6.0010781999999995e-05 95.099999999999994p 6.1766707999999994e-05 95.200000000000003p 6.1965305000000008e-05 95.299999999999997p 6.06797298e-05 95.400000000000006p 5.8076848000000004e-05 95.5p 5.4402728000000003e-05 95.599999999999994p 4.9965958000000001e-05 95.700000000000003p 4.5117762e-05 95.799999999999997p 4.0228551999999998e-05 95.900000000000006p 3.5662026000000003e-05 96p 3.1749802000000004e-05 96.099999999999994p 2.8769781000000002e-05 96.200000000000003p 2.6930259e-05 96.300000000000011p 2.6360177999999999e-05 96.399999999999991p 2.7104959e-05 96.5p 2.9126668700000001e-05 96.599999999999994p 3.2307458e-05 96.700000000000003p 3.6456082999999998e-05 96.800000000000011p 4.1317198000000006e-05 96.899999999999991p 4.6584252000000003e-05 97p 5.1916283000000003e-05 97.100000000000009p 5.6958839000000001e-05 97.200000000000003p 6.1368461e-05 97.299999999999997p 6.4838808000000002e-05 97.399999999999991p 6.7125944999999997e-05 97.5p 6.8069329999999998e-05 97.600000000000009p 6.7605800000000002e-05 97.700000000000003p 6.5774612699999999e-05 97.799999999999997p 6.2713082000000005e-05 97.900000000000006p 5.8643866000000003e-05 98p 5.3855946e-05 98.100000000000009p 4.8681691000000001e-05 98.199999999999989p 4.3472690000000001e-05 98.299999999999997p 3.8576177000000002e-05 98.400000000000006p 3.4313615000000004e-05 98.5p 3.0962071e-05 98.599999999999994p 2.8738755000000004e-05 98.700000000000003p 2.7788801000000003e-05 98.799999999999997p 2.8176034000000002e-05 98.900000000000006p 2.9877134000000002e-05 99p 3.2779639e-05 99.099999999999994p 3.6684904000000003e-05 99.200000000000003p 4.1317247e-05 99.299999999999997p 4.6340290999999996e-05 99.400000000000006p 5.1380496999999999e-05 99.5p 5.6056361000000001e-05 99.599999999999994p 6.0010458000000003e-05 99.700000000000003p 6.2940543999999999e-05 99.799999999999997p 6.4625844000000001e-05 99.900000000000006p 6.4945900000000004e-05 100p 6.3889994199999993e-05 100.09999999999999p 5.5887767999999996e-05 100.2p 4.7177203000000001e-05 100.30000000000001p 3.8175550000000004e-05 100.39999999999999p 2.9338010000000003e-05 100.5p 2.1117469999999997e-05 100.59999999999999p 1.3923879999999999e-05 100.7p 8.0887799999999998e-06 100.8p 3.837751e-06 100.89999999999999p 1.2715280000000004e-06 101p 3.5670699999999946e-07 101.10000000000001p 6.5958819999999997e-06 101.2p 1.3662206999999999e-05 101.3p 2.1034487000000001e-05 101.39999999999999p 2.8148210000000003e-05 101.5p 3.4447779999999998e-05 101.60000000000001p 3.9439284999999999e-05 101.69999999999999p 4.2735703999999996e-05 101.8p 4.4090654000000002e-05 101.90000000000001p 4.3418619999999999e-05 102p 4.08010636e-05 102.10000000000001p 3.6478294000000003e-05 102.2p 3.0827599e-05 102.3p 2.4329087999999998e-05 102.40000000000001p 1.7522481999999998e-05 102.5p 1.0959350000000002e-05 102.59999999999999p 5.1562799999999987e-06 102.7p 5.539610000000001e-07 102.8p -2.5144050000000004e-06 102.90000000000001p -3.8440660000000005e-06 103p -3.3689628e-06 103.09999999999999p -1.1622411000000001e-06 103.2p 2.5721147999999998e-06 103.3p 7.5159140000000003e-06 103.40000000000001p 1.3261168e-05 103.5p 1.9341466000000001e-05 103.59999999999999p 2.5268670999999998e-05 103.7p 3.0572318000000001e-05 103.80000000000001p 3.4838147000000003e-05 103.89999999999999p 3.7742171e-05 104p 3.9076823000000001e-05 104.09999999999999p 3.8766687e-05 104.2p 3.6872551199999999e-05 104.30000000000001p 3.3583317000000001e-05 104.39999999999999p 2.9196940999999997e-05 104.5p 2.4092298000000001e-05 104.60000000000001p 1.8695178000000003e-05 104.7p 1.3442003999999999e-05 104.8p 8.744803999999999e-06 104.89999999999999p 4.9604899999999995e-06 105p 2.3660919999999999e-06 105.10000000000001p 1.141093e-06 105.2p 1.3567820000000002e-06 105.3p 2.9727878299999998e-06 105.40000000000001p 5.8407879999999997e-06 105.5p 9.7156480000000003e-06 105.60000000000001p 1.4274118e-05 105.69999999999999p 1.9140486999999999e-05 105.8p 2.3917588999999999e-05 105.90000000000001p 2.8220258e-05 106p 3.1707849000000002e-05 106.09999999999999p 3.4112381000000004e-05 106.2p 3.5259614999999998e-05 106.3p 3.5081535999999998e-05 106.40000000000001p 3.3619715200000004e-05 106.5p 3.1019702000000003e-05 106.59999999999999p 2.7517151000000001e-05 106.7p 2.3416788999999999e-05 106.8p 1.9065895999999999e-05 106.90000000000001p 1.4824457999999999e-05 107p 1.1034839e-05 107.09999999999999p 7.9937919999999994e-06 107.2p 5.9293720000000004e-06 107.3p 4.9845679999999996e-06 107.40000000000001p 5.2086200000000001e-06 107.5p 6.5560518000000003e-06 107.59999999999999p 8.8930490000000001e-06 107.7p 1.2010273e-05 107.80000000000001p 1.5640991e-05 107.89999999999999p 1.9483209000000001e-05 108p 2.3224103000000002e-05 108.09999999999999p 2.6565128000000001e-05 108.2p 2.9245684e-05 108.3p 3.1063529000000004e-05 108.39999999999999p 3.1890315000000003e-05 108.5p 3.1680799999999997e-05 108.60000000000001p 3.0475021699999997e-05 108.7p 2.8393174e-05 108.8p 2.5623868000000003e-05 108.89999999999999p 2.2406744e-05 109p 1.9011408999999997e-05 109.10000000000001p 1.5714574000000003e-05 109.19999999999999p 1.2777751000000001e-05 109.3p 1.0427033000000001e-05 109.40000000000001p 8.8367090000000009e-06 109.5p 8.1173290000000004e-06 109.60000000000001p 8.3088650000000003e-06 109.7p 9.3791367000000011e-06 109.8p 1.1227356999999999e-05 109.90000000000001p 1.3692703e-05 110p 1.6567411e-05 110.09999999999999p 1.6567411e-05 110.2p 1.6567411e-05 110.3p 1.6567411e-05 110.40000000000001p 1.9469879000000001e-05 110.5p 2.2308399000000002e-05 110.59999999999999p 2.4797559999999998e-05 110.7p 2.6695331999999999e-05 110.8p 2.7821876e-05 110.90000000000001p 2.8068626999999998e-05 111p 2.74021328e-05 111.09999999999999p 2.58636039e-05 111.2p 2.3563727999999999e-05 111.30000000000001p 2.0672522999999999e-05 111.39999999999999p 1.7548317999999999e-05 111.5p 1.4275192e-05 111.59999999999999p 1.1146625000000001e-05 111.7p 8.4276750000000006e-06 111.8p 6.3341800000000006e-06 111.89999999999999p 5.0208359999999996e-06 112p 4.5734920000000001e-06 112.10000000000001p 5.0051039999999998e-06 112.2p 6.2560497000000002e-06 112.3p 8.1993800000000001e-06 112.39999999999999p 1.0651145e-05 112.5p 1.3385243999999999e-05 112.60000000000001p 1.6151683999999999e-05 112.7p 1.8696794000000001e-05 112.8p 2.0783727999999999e-05 112.90000000000001p 2.2211764000000001e-05 113p 2.2833244000000001e-05 113.10000000000001p 2.2566935000000001e-05 113.19999999999999p 2.14071975e-05 113.3p 1.9427686000000002e-05 113.40000000000001p 1.6778378999999998e-05 113.5p 1.3674817999999999e-05 113.59999999999999p 1.0380184000000001e-05 113.7p 7.1824400000000003e-06 113.8p 4.3699400000000005e-06 113.90000000000001p 2.2081129999999998e-06 114p 9.1830899999999978e-07 114.09999999999999p 6.5930500000000012e-07 114.2p 1.5119952e-06 114.3p 3.4684419999999996e-06 114.40000000000001p 6.4267900000000002e-06 114.5p 1.0193589999999999e-05 114.59999999999999p 1.4494578e-05 114.7p 1.8994053e-05 114.8p 2.3321558000000002e-05 114.90000000000001p 2.7103424000000001e-05 115p 2.9995837e-05 115.09999999999999p 3.1716778000000001e-05 115.2p 3.2073626000000002e-05 115.30000000000001p 3.0983338500000001e-05 115.39999999999999p 2.8482285000000002e-05 115.5p 2.4724184999999998e-05 115.59999999999999p 1.9965904000000002e-05 115.7p 1.454281e-05 115.8p 8.8363919999999987e-06 115.89999999999999p 3.238525999999999e-06 116p -1.882429000000001e-06 116.10000000000001p -6.2084759999999993e-06 116.2p -9.4890229999999997e-06 116.3p -1.1550301e-05 116.39999999999999p -1.230261e-05 116.50000000000001p -1.1746342e-05 116.59999999999999p -9.9703747000000004e-06 116.69999999999999p -7.1373530000000002e-06 116.8p -3.4589839999999998e-06 116.90000000000001p 8.3027899999999954e-07 117.00000000000001p 5.493907e-06 117.09999999999999p 1.0305613000000001e-05 117.19999999999999p 1.5054130000000001e-05 117.3p 1.9543037e-05 117.40000000000001p 2.3588688000000001e-05 117.50000000000001p 2.7019023999999999e-05 117.60000000000001p 2.9675439000000001e-05 117.69999999999999p 3.1418244000000004e-05 117.8p 3.2135341999999999e-05 117.90000000000001p 3.1752752000000001e-05 118p 3.0244798e-05 118.10000000000001p 2.7642093000000002e-05 118.19999999999999p 2.4036052000000001e-05 118.3p 1.9579814999999999e-05 118.40000000000001p 1.4485881000000001e-05 118.5p 9.020086999999998e-06 118.60000000000001p 3.4916679999999999e-06 118.69999999999999p -1.7610499999999999e-06 118.8p -6.3898779999999994e-06 118.89999999999999p -1.0062106999999999e-05 119p -1.2491666e-05 119.10000000000001p -1.3472820000000001e-05 119.20000000000002p -1.2909574e-05 119.3p -1.08334513e-05 119.39999999999999p -7.4060009999999993e-06 119.5p -2.90633e-06 119.60000000000001p 2.2966379999999999e-06 119.70000000000002p 7.7876210000000006e-06 119.79999999999998p 1.315761e-05 119.89999999999999p 1.8052144999999999e-05 120p 2.2202909000000002e-05 120.10000000000001p 2.5438453000000002e-05 120.2p 2.7678041e-05 120.29999999999998p 2.8916417e-05 120.39999999999999p 2.9350472e-05 120.5p 2.8920897700000003e-05 120.60000000000001p 2.7804075399999998e-05 120.7p 2.6182740000000002e-05 120.80000000000001p 2.4229029000000001e-05 120.89999999999999p 2.2089949000000001e-05 121p 1.9872644e-05 121.09999999999999p 1.7634947000000001e-05 121.2p 1.5386992000000002e-05 121.30000000000001p 1.3106024999999998e-05 121.39999999999999p 1.0617238000000001e-05 121.5p 8.0655409999999981e-06 121.59999999999999p 5.4362120000000009e-06 121.7p 2.7892360000000005e-06 121.80000000000001p 2.6865499999999989e-07 121.89999999999999p -1.9048320000000004e-06 121.99999999999999p -3.4537004999999998e-06 122.09999999999999p -4.0761889999999999e-06 122.2p -3.4917178000000002e-06 122.30000000000001p -1.4948099999999999e-06 122.40000000000001p 1.9929260000000003e-06 122.49999999999999p 6.8873680000000003e-06 122.59999999999999p 1.2935804e-05 122.7p 1.9743971e-05 122.80000000000001p 2.6827729999999999e-05 122.90000000000001p 3.3672869999999999e-05 122.99999999999999p 3.9786919999999998e-05 123.09999999999999p 4.4735414000000004e-05 123.2p 4.8163288000000001e-05 123.3p 4.9808049000000002e-05 123.40000000000001p 4.9510907999999996e-05 123.49999999999999p 4.7229243199999999e-05 123.59999999999999p 4.3049539000000002e-05 123.7p 3.7194979000000001e-05 123.8p 3.0019562999999998e-05 123.90000000000001p 2.198224e-05 124.00000000000001p 1.360254e-05 124.09999999999999p 5.4078999999999978e-06 124.19999999999999p -2.1135600000000001e-06 124.3p -8.5446579999999998e-06 124.40000000000001p -1.3552569e-05 124.50000000000001p -1.6888638e-05 124.59999999999999p -1.838246e-05 124.69999999999999p -1.7937615e-05 124.8p -1.5534239199999998e-05 124.90000000000001p -1.1240073e-05 125.00000000000001p -5.2273729999999996e-06 125.10000000000001p 2.2105909999999992e-06 125.19999999999999p 1.0652849799999999e-05 125.3p 1.9563246999999998e-05 125.40000000000001p 2.8326669999999999e-05 125.5p 3.630492e-05 125.60000000000001p 4.2900990000000001e-05 125.69999999999999p 4.7617639999999999e-05 125.8p 5.0100550999999999e-05 125.90000000000001p 5.0163073e-05 126p 4.7794796200000004e-05 126.10000000000001p 4.3158506e-05 126.19999999999999p 3.6578533999999995e-05 126.3p 2.852114e-05 126.39999999999999p 1.9565179999999999e-05 126.5p 1.0361770000000001e-05 126.60000000000001p 1.5838200000000014e-06 126.70000000000002p -6.1293650000000002e-06 126.8p -1.222546546e-05 126.89999999999999p -1.6282977e-05 127p -1.8041381000000001e-05 127.10000000000001p -1.7416373000000001e-05 127.20000000000002p -1.4501356399999999e-05 127.29999999999998p -9.5570679999999995e-06 127.39999999999999p -2.9906560000000005e-06 127.5p 4.6749789999999993e-06 127.60000000000001p 1.2840477000000001e-05 127.7p 2.0876041e-05 127.79999999999998p 2.8171109999999999e-05 127.89999999999999p 3.418298e-05 128p 3.8480153000000003e-05 128.09999999999999p 4.0775670999999997e-05 128.20000000000002p 4.0947639000000001e-05 128.30000000000001p 3.9045118199999996e-05 128.39999999999998p 3.5279138000000003e-05 128.5p 2.9999894000000001e-05 128.59999999999999p 2.3662782000000001e-05 128.70000000000002p 1.6787116000000001e-05 128.80000000000001p 9.9120500000000011e-06 128.89999999999998p 3.5544000000000011e-06 129p -1.8279990000000007e-06 129.09999999999999p -5.8651440000000003e-06 129.20000000000002p -8.2951560000000011e-06 129.30000000000001p -8.9764350000000001e-06 129.39999999999998p -7.8924980000000006e-06 129.5p -5.1502940000000007e-06 129.59999999999999p -9.7219600000000051e-07 129.69999999999999p 4.3185539999999996e-06 129.80000000000001p 1.0319296e-05 129.90000000000001p 1.6576159e-05 130p 2.2617798999999999e-05 130.09999999999999p 2.7992152000000001e-05 130.19999999999999p 3.2302811000000002e-05 130.30000000000001p 3.5241053000000002e-05 130.40000000000001p 3.6610394999999997e-05 130.5p 3.6341229000000003e-05 130.59999999999999p 3.4494435749999999e-05 130.69999999999999p 3.1253870999999996e-05 130.80000000000001p 2.6908822000000002e-05 130.90000000000001p 2.1828201999999998e-05 131p 1.6429058e-05 131.09999999999999p 1.1142482999999999e-05 131.19999999999999p 6.3799909999999986e-06 131.30000000000001p 2.5029489999999992e-06 131.40000000000001p -2.0291999999999991e-07 131.5p -1.5466289999999999e-06 131.59999999999999p -1.4441049000000001e-06 131.69999999999999p 7.7019699999999995e-08 131.80000000000001p 2.8803015000000001e-06 131.90000000000001p 6.7312489999999999e-06 132p 1.1315795000000001e-05 132.09999999999999p 1.6265554999999999e-05 132.19999999999999p 2.1187892999999998e-05 132.30000000000001p 2.5698036000000002e-05 132.40000000000001p 2.9450113999999999e-05 132.5p 3.2164303000000001e-05 132.60000000000002p 3.3647918000000003e-05 132.69999999999999p 3.3809167999999994e-05 132.79999999999998p 3.2662936200000004e-05 132.90000000000001p 3.0328182999999999e-05 133p 2.7017139999999999e-05 133.10000000000002p 2.3016667000000002e-05 133.19999999999999p 1.8663378999999997e-05 133.29999999999998p 1.4314507999999998e-05 133.40000000000001p 1.0317761000000001e-05 133.5p 6.9831619999999997e-06 133.60000000000002p 4.5596420000000002e-06 133.69999999999999p 3.2180789999999998e-06 133.79999999999998p 3.0414339999999999e-06 133.90000000000001p 4.0217922999999998e-06 134p 6.0637180000000001e-06 134.09999999999999p 8.9931959999999996e-06 134.20000000000002p 1.2571538e-05 134.29999999999998p 1.6513562999999999e-05 134.40000000000001p 2.0509256e-05 134.5p 2.4247645000000001e-05 134.59999999999999p 2.7441204000000002e-05 134.70000000000002p 2.9848697999999999e-05 134.79999999999998p 3.1294404999999997e-05 134.90000000000001p 3.1681655999999998e-05 135p 3.0999650399999997e-05 135.09999999999999p 2.93228724e-05 135.20000000000002p 2.6803402e-05 135.29999999999998p 2.3656991999999999e-05 135.40000000000001p 2.0144457999999998e-05 135.5p 1.6550085000000002e-05 135.59999999999999p 1.3158853999999999e-05 135.70000000000002p 1.0234429000000001e-05 135.80000000000001p 7.9994910000000006e-06 135.89999999999998p 6.6194990000000005e-06 136p 6.1911459999999999e-06 136.09999999999999p 6.7357721999999999e-06 136.20000000000002p 8.1984369999999988e-06 136.30000000000001p 1.0452604e-05 136.39999999999998p 1.3310359e-05 136.5p 1.653762e-05 136.59999999999999p 1.9873220999999999e-05 136.70000000000002p 2.3050476e-05 136.80000000000001p 2.5819116000000002e-05 136.89999999999998p 2.7965695999999998e-05 137p 2.9330672e-05 137.09999999999999p 2.9820573e-05 137.19999999999999p 2.9414432700000003e-05 137.30000000000001p 2.8164118599999999e-05 137.40000000000001p 2.6188640000000001e-05 137.5p 2.3663048000000002e-05 137.59999999999999p 2.0802982000000001e-05 137.69999999999999p 1.7846203e-05 137.80000000000001p 1.5032718999999998e-05 137.90000000000001p 1.2585307000000002e-05 138p 1.0692108000000001e-05 138.09999999999999p 9.492471e-06 138.19999999999999p 9.0672960000000012e-06 138.30000000000001p 9.434092800000001e-06 138.40000000000001p 1.0547270700000001e-05 138.5p 1.2303085999999999e-05 138.59999999999999p 1.4549079e-05 138.69999999999999p 1.7096963000000001e-05 138.80000000000001p 1.9738231000000002e-05 138.90000000000001p 2.2261002000000001e-05 139p 2.4466941999999999e-05 139.09999999999999p 2.6186976e-05 139.19999999999999p 2.7294304000000002e-05 139.30000000000001p 2.7713965e-05 139.40000000000001p 2.7427942100000002e-05 139.5p 2.64755151e-05 139.59999999999999p 2.4948821000000002e-05 139.69999999999999p 2.2984082999999999e-05 139.80000000000001p 2.0749291999999999e-05 139.90000000000001p 1.8429713e-05 140p 1.6212379e-05 140.10000000000002p 1.4271256999999999e-05 140.19999999999999p 1.2753927000000002e-05 140.29999999999998p 1.1771096000000001e-05 140.40000000000001p 1.1389100000000001e-05 140.5p 1.16260947e-05 140.60000000000002p 1.2451654100000001e-05 140.69999999999999p 1.3789978999999999e-05 140.79999999999998p 1.5526281999999998e-05 140.90000000000001p 1.7516125999999998e-05 141p 1.9597013000000001e-05 141.10000000000002p 2.1601489e-05 141.19999999999999p 2.3370698000000001e-05 141.29999999999998p 2.4767175000000001e-05 141.40000000000001p 2.5685808999999999e-05 141.5p 2.6062015999999999e-05 141.59999999999999p 2.5876350799999998e-05 141.70000000000002p 2.5155295500000001e-05 141.79999999999998p 2.3968225e-05 141.90000000000001p 2.2420975999999999e-05 142p 2.0646542000000001e-05 142.09999999999999p 1.8793705e-05 142.20000000000002p 1.7014689999999998e-05 142.29999999999998p 1.5452743e-05 142.40000000000001p 1.4230651999999999e-05 142.5p 1.3441148e-05 142.59999999999999p 1.3139974999999999e-05 142.70000000000002p 1.33420698e-05 142.79999999999998p 1.4021113399999999e-05 142.90000000000001p 1.51125212e-05 143p 1.6519450999999999e-05 143.09999999999999p 1.8121334000000002e-05 143.20000000000002p 1.9784217999999999e-05 143.30000000000001p 2.1371992000000003e-05 143.39999999999998p 2.2757489e-05 143.5p 2.3832730000000002e-05 143.59999999999999p 2.4517332000000001e-05 143.70000000000002p 2.4764431000000001e-05 143.80000000000001p 2.4563832699999999e-05 143.89999999999998p 2.3941980499999999e-05 144p 2.2959000600000001e-05 144.09999999999999p 2.1702911000000002e-05 144.20000000000002p 2.0281795999999999e-05 144.30000000000001p 1.8814415999999998e-05 144.39999999999998p 1.7420322999999999e-05 144.5p 1.6210163000000002e-05 144.59999999999999p 1.5277077e-05 144.69999999999999p 1.4689806000000001e-05 144.80000000000001p 1.4487896800000001e-05 144.90000000000001p 1.46794092e-05 145p 1.52410315e-05 145.09999999999999p 1.6120630899999999e-05 145.19999999999999p 1.7241909e-05 145.30000000000001p 1.8510848e-05 145.40000000000001p 1.9823424e-05 145.5p 2.107402e-05 145.59999999999999p 2.2163845000000003e-05 145.69999999999999p 2.3008788999999999e-05 145.80000000000001p 2.3545914000000003e-05 145.90000000000001p 2.3738231299999999e-05 146p 2.3577145000000001e-05 146.09999999999999p 2.30826752e-05 146.19999999999999p 2.23012403e-05 146.30000000000001p 2.1301339000000002e-05 146.40000000000001p 2.0167591000000002e-05 146.5p 1.8993608999999998e-05 146.59999999999999p 1.7874362999999998e-05 146.69999999999999p 1.6898565999999998e-05 146.80000000000001p 1.6141801000000001e-05 146.90000000000001p 1.5660768999999999e-05 147p 1.5489135699999997e-05 147.09999999999999p 1.5635187200000003e-05 147.19999999999999p 1.60815835e-05 147.30000000000001p 1.6787063599999999e-05 147.40000000000001p 1.7690132000000003e-05 147.5p 1.8714291e-05 147.60000000000002p 1.9774481e-05 147.69999999999999p 2.0784198000000001e-05 147.79999999999998p 2.1662599000000002e-05 147.90000000000001p 2.2341066999999998e-05 148p 2.2768618e-05 148.10000000000002p 2.2915801400000001e-05 148.19999999999999p 2.2776688800000002e-05 148.29999999999998p 2.23689312e-05 148.40000000000001p 2.17317425e-05 148.5p 2.0922285300000002e-05 148.60000000000002p 2.0010541e-05 148.69999999999999p 1.9073213000000001e-05 148.79999999999998p 1.8187293000000002e-05 148.90000000000001p 1.7423697000000002e-05 149p 1.6841606000000001e-05 149.09999999999999p 1.64839199e-05 149.20000000000002p 1.63742019e-05 149.29999999999998p 1.6515361099999999e-05 149.40000000000001p 1.6889916999999999e-05 149.5p 1.74620033e-05 149.59999999999999p 1.8180743800000001e-05 149.70000000000002p 1.8984746000000001e-05 149.79999999999998p 1.9807227999999999e-05 149.90000000000001p 2.0581522999999999e-05 150p 2.1246406e-05 150.09999999999999p 2.1750877000000003e-05 150.20000000000002p 2.2057995900000002e-05 150.29999999999998p 2.2147558099999998e-05 150.40000000000001p 2.2017299000000001e-05 150.5p 2.1682697900000001e-05 150.59999999999999p 2.1175316099999999e-05 150.70000000000002p 2.05398745e-05 150.80000000000001p 1.9830369600000001e-05 150.89999999999998p 1.9105537e-05 151p 1.8424085000000001e-05 151.09999999999999p 1.7839981999999999e-05 151.20000000000002p 1.7398369799999997e-05 151.30000000000001p 1.7132098599999999e-05 151.39999999999998p 1.70593891e-05 151.5p 1.7182660600000001e-05 151.59999999999999p 1.74885927e-05 151.70000000000002p 1.79494265e-05 151.80000000000001p 1.8525376800000001e-05 151.89999999999998p 1.91679898e-05 152p 1.9824202899999999e-05 152.09999999999999p 2.0440627999999999e-05 152.19999999999999p 2.0967972100000002e-05 152.30000000000001p 2.1364947299999999e-05 152.40000000000001p 2.1601546199999999e-05 152.5p 2.1661309300000002e-05 152.59999999999999p 2.1542462799999998e-05 152.69999999999999p 2.12578219e-05 152.80000000000001p 2.0833488499999998e-05 152.90000000000001p 2.0306483599999999e-05 153p 1.97215481e-05 153.09999999999999p 1.9127315499999998e-05 153.19999999999999p 1.8572332300000001e-05 153.30000000000001p 1.81010055e-05 153.40000000000001p 1.77501169e-05 153.5p 1.7545928299999999e-05 153.59999999999999p 1.7502235100000001e-05 153.69999999999999p 1.7619497590000001e-05 153.80000000000001p 1.78850183e-05 153.90000000000001p 1.8274330299999999e-05 154p 1.8753349400000003e-05 154.09999999999999p 1.92814447e-05 154.19999999999999p 1.9814855199999999e-05 154.30000000000001p 2.0310342000000003e-05 154.40000000000001p 2.0728731200000002e-05 154.5p 2.1037958799999999e-05 154.59999999999999p 2.1215571699999999e-05 154.69999999999999p 2.1250292899999998e-05 154.80000000000001p 2.114267878e-05 154.90000000000001p 2.0904809799999998e-05 155p 2.0558939699999999e-05 155.10000000000002p 2.0135520400000002e-05 155.19999999999999p 1.9670443400000001e-05 155.29999999999998p 1.9202027299999999e-05 155.40000000000001p 1.8767877000000001e-05 155.5p 1.84018796e-05 155.60000000000002p 1.8131580800000003e-05 155.69999999999999p 1.79762461e-05 155.79999999999998p 1.7945475800000001e-05 155.90000000000001p 1.8038781769999999e-05 156p 1.8245841300000001e-05 156.10000000000002p 1.8547545699999999e-05 156.19999999999999p 1.8917718999999999e-05 156.29999999999998p 1.9325325800000001e-05 156.40000000000001p 1.9737006299999999e-05 156.5p 2.0119761800000003e-05 156.59999999999999p 2.0443583799999998e-05 156.70000000000002p 2.0683748500000003e-05 156.79999999999998p 2.0822745700000001e-05 156.90000000000001p 2.0851492099999998e-05 157p 2.076996636e-05 157.09999999999999p 2.0587029099999999e-05 157.20000000000002p 2.0319536299999997e-05 157.29999999999998p 1.9990867000000002e-05 157.40000000000001p 1.96289263e-05 157.5p 1.9263797200000002e-05 157.59999999999999p 1.8925277e-05 157.70000000000002p 1.8640473000000002e-05 157.79999999999998p 1.8431646700000002e-05 157.90000000000001p 1.8314458699999999e-05 158p 1.8296811499999999e-05 158.09999999999999p 1.8378291140000003e-05 158.20000000000002p 1.8550395900000002e-05 158.30000000000001p 1.87972923e-05 158.39999999999998p 1.9097279300000002e-05 158.5p 1.9424704199999998e-05 158.59999999999999p 1.97520732e-05 158.70000000000002p 2.0052464699999998e-05 158.80000000000001p 2.0301655700000001e-05 158.89999999999998p 2.04801489e-05 159p 2.0574641999999999e-05 159.09999999999999p 2.0579028099999999e-05 159.20000000000002p 2.0494764960000001e-05 159.30000000000001p 2.0330576499999997e-05 159.39999999999998p 2.01015589e-05 159.5p 1.9827824300000001e-05 159.59999999999999p 1.95327286e-05 159.69999999999999p 1.9240848800000001e-05 159.80000000000001p 1.8975966799999999e-05 159.90000000000001p 1.8759114900000001e-05 160p 1.8606964800000001e-05 160.09999999999999p 1.8530510000000002e-05 160.19999999999999p 1.8534399899999998e-05 160.30000000000001p 1.8616649691e-05 160.40000000000001p 1.8769020400000001e-05 160.5p 1.8977778700000001e-05 160.59999999999999p 1.9225000700000001e-05 160.69999999999999p 1.9490059799999999e-05 160.80000000000001p 1.97513314e-05 160.90000000000001p 1.9987990199999998e-05 161p 2.0181633500000002e-05 161.09999999999999p 2.03176496e-05 161.19999999999999p 2.03863468e-05 161.30000000000001p 2.03836239e-05 161.40000000000001p 2.0311116033e-05 161.5p 2.0175986789999999e-05 161.59999999999999p 1.9990215800000001e-05 161.69999999999999p 1.9769577300000003e-05 161.80000000000001p 1.9532252899999999e-05 161.90000000000001p 1.9297419900000002e-05 162p 1.9083667400000001e-05 162.09999999999999p 1.8907555299999997e-05 162.19999999999999p 1.87823574e-05 162.30000000000001p 1.8717058499999997e-05 162.40000000000001p 1.87157296e-05 162.5p 1.877730796e-05 162.60000000000002p 1.8895701749999999e-05 162.69999999999999p 1.9060411599999998e-05 162.79999999999998p 1.9257412000000003e-05 162.90000000000001p 1.9470324699999999e-05 163p 1.9681771999999999e-05 163.10000000000002p 1.9874795099999999e-05 163.19999999999999p 2.0034223400000001e-05 163.29999999999998p 2.0147895800000003e-05 163.40000000000001p 2.0207558800000001e-05 163.5p 2.0209521000000001e-05 163.60000000000002p 2.0154868400000001e-05 163.69999999999999p 2.0049261970000001e-05 163.79999999999998p 1.99024292e-05 163.90000000000001p 1.97272695e-05 164p 1.9538713400000002e-05 164.09999999999999p 1.93524767e-05 164.20000000000002p 1.91837427e-05 164.29999999999998p 1.9045890399999999e-05 164.40000000000001p 1.8949463400000001e-05 164.5p 1.8901359599999999e-05 164.59999999999999p 1.8904305980000001e-05 164.70000000000002p 1.8956794265999999e-05 164.79999999999998p 1.9053252420000001e-05 164.90000000000001p 1.9184664600000001e-05 165p 1.9339352599999998e-05 165.09999999999999p 1.95040466e-05 165.20000000000002p 1.9664990900000003e-05 165.29999999999998p 1.9809092899999999e-05 165.40000000000001p 1.9924984100000001e-05 165.5p 2.0003886199999998e-05 165.59999999999999p 2.0040295199999998e-05 165.70000000000002p 2.003227036e-05 165.80000000000001p 1.9981577685000002e-05 165.89999999999998p 1.989338696e-05 166p 1.9775780300000001e-05 166.09999999999999p 1.9639050199999999e-05 166.20000000000002p 1.9494748799999999e-05 166.30000000000001p 1.9354815899999999e-05 166.39999999999998p 1.9230529899999999e-05 166.5p 1.9131661400000002e-05 166.59999999999999p 1.9065723399999999e-05 166.70000000000002p 1.9037418299999999e-05 166.80000000000001p 1.9048341179999998e-05 166.89999999999998p 1.9096894002000001e-05 167p 1.9178502230000001e-05 167.09999999999999p 1.9286003999999999e-05 167.19999999999999p 1.9410292500000002e-05 167.30000000000001p 1.9541064100000001e-05 167.40000000000001p 1.96676516e-05 167.5p 1.9779903000000002e-05 167.59999999999999p 1.9868948999999999e-05 167.69999999999999p 1.9927925399999998e-05 167.80000000000001p 1.9952497529999998e-05 167.90000000000001p 1.9941149430000001e-05 168p 1.9895299719999997e-05 168.09999999999999p 1.9819098569999999e-05 168.19999999999999p 1.9719114899999998e-05 168.30000000000001p 1.9603752600000002e-05 168.40000000000001p 1.94825337e-05 168.5p 1.9365321100000001e-05 168.59999999999999p 1.9261529600000001e-05 168.69999999999999p 1.9179345199999997e-05 168.80000000000001p 1.9125095700000002e-05 168.90000000000001p 1.9102736349999998e-05 169p 1.911358856e-05 169.09999999999999p 1.9156250429999997e-05 169.19999999999999p 1.9226754139999999e-05 169.30000000000001p 1.9318931900000002e-05 169.40000000000001p 1.94249711e-05 169.5p 1.9536081199999999e-05 169.59999999999999p 1.9643209600000003e-05 169.69999999999999p 1.9737820299999999e-05 169.80000000000001p 1.9812545300000002e-05 169.90000000000001p 1.9861820000000002e-05 170p 1.988226008e-05 170.10000000000002p 1.9872875290000001e-05 170.19999999999999p 1.9835132490999999e-05 170.29999999999998p 1.977276299e-05 170.40000000000001p 1.9691391539999999e-05 170.5p 1.95980132e-05 170.60000000000002p 1.9500431200000002e-05 170.69999999999999p 1.9406553900000001e-05 170.79999999999998p 1.9323802799999998e-05 170.90000000000001p 1.92584646e-05 171p 1.9215275499999998e-05 171.10000000000002p 1.919704686e-05 171.19999999999999p 1.920453643e-05 171.29999999999998p 1.9236406446999999e-05 171.40000000000001p 1.9289406220000001e-05 171.5p 1.9358738159999999e-05 171.59999999999999p 1.9438387200000001e-05 171.70000000000002p 1.9521706799999999e-05 171.79999999999998p 1.9601958600000001e-05 171.90000000000001p 1.96727982e-05 172p 1.9728824399999999e-05 172.09999999999999p 1.9765942599999998e-05 172.20000000000002p 1.9781672279999999e-05 172.29999999999998p 1.9775306269999999e-05 172.40000000000001p 1.9747918362999998e-05 172.5p 1.97022544e-05 172.59999999999999p 1.9642444190000001e-05 172.70000000000002p 1.9573670900000001e-05 172.79999999999998p 1.9501752999999998e-05 172.90000000000001p 1.94326008e-05 173p 1.9371816899999998e-05 173.09999999999999p 1.9324214239999998e-05 173.20000000000002p 1.9293432729999999e-05 173.30000000000001p 1.9281680089999999e-05 173.39999999999998p 1.928956831e-05 173.5p 1.9316104291999999e-05 173.59999999999999p 1.9358760099999997e-05 173.70000000000002p 1.941371679e-05 173.80000000000001p 1.9476215309999997e-05 173.89999999999998p 1.9540929099999999e-05 174p 1.9602444759999998e-05 174.09999999999999p 1.9655671280000001e-05 174.20000000000002p 1.9696311819999999e-05 174.30000000000001p 1.9721147630000001e-05 174.39999999999998p 1.9728358119999999e-05 174.5p 1.9717576060000002e-05 174.59999999999999p 1.968999052e-05 174.69999999999999p 1.9648122969999999e-05 174.80000000000001p 1.9595663320000003e-05 174.90000000000001p 1.9537132329999998e-05 175p 1.9477465450000001e-05 175.09999999999999p 1.9421620080000001e-05 175.19999999999999p 1.9374154300000001e-05 175.30000000000001p 1.9338860610000002e-05 175.40000000000001p 1.9318433210000001e-05 175.5p 1.93143428e-05 175.59999999999999p 1.9326648934999999e-05 175.69999999999999p 1.935407675e-05 175.80000000000001p 1.9394173369999998e-05 175.90000000000001p 1.9443468719999998e-05 176p 1.9497826599999999e-05 176.09999999999999p 1.9552793920000002e-05 176.19999999999999p 1.960394924e-05 176.30000000000001p 1.9647285450000002e-05 176.40000000000001p 1.9679495499999998e-05 176.5p 1.969823384e-05 176.59999999999999p 1.9702269980000001e-05 176.69999999999999p 1.9691593322000002e-05 176.80000000000001p 1.966733016e-05 176.90000000000001p 1.9631665139999999e-05 177p 1.9587618970000001e-05 177.09999999999999p 1.9538813619999998e-05 177.19999999999999p 1.948916385e-05 177.30000000000001p 1.944256211e-05 177.40000000000001p 1.9402570390000001e-05 177.5p 1.9372159990000001e-05 177.60000000000002p 1.935348727e-05 177.69999999999999p 1.9347760549999999e-05 177.79999999999998p 1.9355141829999998e-05 177.90000000000001p 1.9374764703e-05 178p 1.9404829669999999e-05 178.10000000000002p 1.944276715e-05 178.19999999999999p 1.9485429170000001e-05 178.29999999999998p 1.952936158e-05 178.40000000000001p 1.9571099910000001e-05 178.5p 1.9607404270000001e-05 178.60000000000002p 1.963553079e-05 178.69999999999999p 1.9653449539999999e-05 178.79999999999998p 1.965998174e-05 178.90000000000001p 1.9654901330000001e-05 179p 1.9638877891999998e-05 179.09999999999999p 1.96134997e-05 179.20000000000002p 1.9581036449999998e-05 179.29999999999998p 1.954430106e-05 179.40000000000001p 1.9506389509999998e-05 179.5p 1.9470416120000001e-05 179.59999999999999p 1.943928928e-05 179.70000000000002p 1.9415420640000001e-05 179.79999999999998p 1.9400577259999998e-05 179.90000000000001p 1.9395743979999999e-05 180p 1.9401040252000002e-05 180.09999999999999p 1.9415753816000001e-05 180.20000000000002p 1.9438382079999999e-05 180.29999999999998p 1.9466831510000001e-05 180.40000000000001p 1.9498545639999998e-05 180.5p 1.95307934e-05 180.59999999999999p 1.956082149e-05 180.70000000000002p 1.9586196759999998e-05 180.80000000000001p 1.960488742e-05 180.89999999999998p 1.9615494769999999e-05 181p 1.9617349309999998e-05 181.09999999999999p 1.9610507644000001e-05 181.20000000000002p 1.9595757826e-05 181.30000000000001p 1.9574531420000001e-05 181.39999999999998p 1.9548780829999999e-05 181.5p 1.9520749450000001e-05 181.59999999999999p 1.9492860880000003e-05 181.70000000000002p 1.9467431580000001e-05 181.80000000000001p 1.944653923e-05 181.90000000000001p 1.9431846710000003e-05 182p 1.9424459620000001e-05 182.09999999999999p 1.9424863429999999e-05 182.19999999999999p 1.94329147972e-05 182.30000000000001p 1.9447820959999998e-05 182.40000000000001p 1.9468270589999999e-05 182.5p 1.9492509700000003e-05 182.59999999999999p 1.9518516949999997e-05 182.69999999999999p 1.954417363e-05 182.80000000000001p 1.956738502e-05 182.90000000000001p 1.958632119e-05 183p 1.9599477109999999e-05 183.09999999999999p 1.9605873179999998e-05 183.19999999999999p 1.9605048969999997e-05 183.30000000000001p 1.95971338832e-05 183.40000000000001p 1.958281962e-05 183.5p 1.9563299479999998e-05 183.59999999999999p 1.9540160120000002e-05 183.69999999999999p 1.9515270749999998e-05 183.80000000000001p 1.9490624519999999e-05 183.90000000000001p 1.9468145520000002e-05 184p 1.944961412e-05 184.09999999999999p 1.9436441420000001e-05 184.19999999999999p 1.9429612699999998e-05 184.30000000000001p 1.9429607719999998e-05 184.40000000000001p 1.9436344958999999e-05 184.5p 1.9449215225999999e-05 184.59999999999999p 1.946712963e-05 184.69999999999999p 1.9488606380000002e-05 184.80000000000001p 1.95119009e-05 184.90000000000001p 1.9535164299999999e-05 185p 1.955655627e-05 185.10000000000002p 1.957442957e-05 185.19999999999999p 1.9587455089999997e-05 185.29999999999998p 1.9594708019999999e-05 185.40000000000001p 1.9595737260000003e-05 185.5p 1.9590611759000002e-05 185.60000000000002p 1.9579898516e-05 185.69999999999999p 1.9564577619999999e-05 185.79999999999998p 1.9545989949999999e-05 185.90000000000001p 1.9525692870000002e-05 186p 1.950533831e-05 186.10000000000002p 1.9486556540000001e-05 186.19999999999999p 1.9470757620000002e-05 186.29999999999998p 1.945912056e-05 186.40000000000001p 1.945239908e-05 186.5p 1.94509811e-05 186.59999999999999p 1.9454778270000001e-05 186.70000000000002p 1.9463300944999999e-05 186.79999999999998p 1.9475693820000001e-05 186.90000000000001p 1.9490817520000001e-05 187p 1.950737213e-05 187.09999999999999p 1.9523959290000001e-05 187.20000000000002p 1.9539250900000002e-05 187.29999999999998p 1.955206324e-05 187.40000000000001p 1.9561457139999999e-05 187.5p 1.9566795259999999e-05 187.59999999999999p 1.9567799003999998e-05 187.70000000000002p 1.9564528108e-05 187.79999999999998p 1.9557406242e-05 187.90000000000001p 1.9547166339999999e-05 188p 1.953472903e-05 188.09999999999999p 1.9521217299999997e-05 188.20000000000002p 1.9507769790000001e-05 188.30000000000001p 1.9495524549999999e-05 188.39999999999998p 1.9485454109999997e-05 188.5p 1.947836197e-05 188.59999999999999p 1.9474769720000001e-05 188.70000000000002p 1.947491326e-05 188.80000000000001p 1.9478706022e-05 188.89999999999998p 1.9485746523999997e-05 189p 1.949540734e-05 189.09999999999999p 1.9506802499999998e-05 189.20000000000002p 1.9518960420000001e-05 189.30000000000001p 1.9530819820000001e-05 189.40000000000001p 1.95413766e-05 189.5p 1.95497504e-05 189.59999999999999p 1.9555220139999998e-05 189.69999999999999p 1.9557349214000002e-05 189.80000000000001p 1.9555971175e-05 189.90000000000001p 1.9551218175000001e-05 190p 1.9543494627000002e-05 190.09999999999999p 1.9533469160000001e-05 190.19999999999999p 1.9521998050000001e-05 190.30000000000001p 1.9510033250000001e-05 190.40000000000001p 1.9498577640000003e-05 190.5p 1.9488599669999997e-05 190.59999999999999p 1.9480908640000003e-05 190.69999999999999p 1.9476140960000001e-05 190.80000000000001p 1.9474686777999999e-05 190.90000000000001p 1.9476635488999999e-05 191p 1.9481817743000002e-05 191.09999999999999p 1.9489801229000003e-05 191.19999999999999p 1.9499927e-05 191.30000000000001p 1.9511363230000002e-05 191.40000000000001p 1.9523173550000003e-05 191.5p 1.953442765e-05 191.59999999999999p 1.9544252479999999e-05 191.69999999999999p 1.955187347e-05 191.80000000000001p 1.9556735770000001e-05 191.90000000000001p 1.9558496637e-05 192p 1.9557070710999999e-05 192.09999999999999p 1.9552630432000002e-05 192.19999999999999p 1.9545554249000001e-05 192.30000000000001p 1.953645532e-05 192.40000000000001p 1.952606328e-05 192.5p 1.9515191169999998e-05 192.60000000000002p 1.9504689319999997e-05 192.69999999999999p 1.9495327060000002e-05 192.79999999999998p 1.9487792700000003e-05 192.90000000000001p 1.9482611409999998e-05 193p 1.9480100004000001e-05 193.10000000000002p 1.9480387289e-05 193.19999999999999p 1.9483368181199998e-05 193.29999999999998p 1.9488729575e-05 193.40000000000001p 1.9496006010000001e-05 193.5p 1.950459321e-05 193.60000000000002p 1.9513797800000001e-05 193.69999999999999p 1.9522911949999999e-05 193.79999999999998p 1.953123187e-05 193.90000000000001p 1.9538159829999999e-05 194p 1.9543199629999999e-05 194.09999999999999p 1.9546045975e-05 194.20000000000002p 1.9546548676000002e-05 194.29999999999998p 1.9544752954e-05 194.40000000000001p 1.9540877317999999e-05 194.5p 1.9535300767999999e-05 194.59999999999999p 1.9528541056000001e-05 194.70000000000002p 1.9521175690000002e-05 194.79999999999998p 1.9513807149999999e-05 194.90000000000001p 1.950706343e-05 195p 1.9501444710000001e-05 195.09999999999999p 1.9497386341999997e-05 195.20000000000002p 1.9495167902000001e-05 195.29999999999998p 1.9494897579e-05 195.40000000000001p 1.9496540628399999e-05 195.5p 1.9499870371999998e-05 195.59999999999999p 1.9504559935e-05 195.70000000000002p 1.9510142870999998e-05 195.80000000000001p 1.9516100917000001e-05 195.89999999999998p 1.9521907373000001e-05 196p 1.9527054991000002e-05 196.09999999999999p 1.9531097752e-05 196.20000000000002p 1.9533716468000001e-05 196.30000000000001p 1.9534708672999999e-05 196.39999999999998p 1.9534023801999999e-05 196.5p 1.9531755038299999e-05 196.59999999999999p 1.9528149496999998e-05 196.70000000000002p 1.952354851e-05 196.80000000000001p 1.9518389753000001e-05 196.90000000000001p 1.9513122718000002e-05 197p 1.9508238718000002e-05 197.09999999999999p 1.9504146156e-05 197.19999999999999p 1.9501221319000001e-05 197.30000000000001p 1.9499694449000001e-05 197.40000000000001p 1.9499710398999999e-05 197.5p 1.9501242810600001e-05 197.59999999999999p 1.9504170503000002e-05 197.69999999999999p 1.9508234595999999e-05 197.80000000000001p 1.9513104941e-05 197.90000000000001p 1.9518354515e-05 198p 1.9523570680999997e-05 198.09999999999999p 1.9528322531000002e-05 198.19999999999999p 1.9532213852000001e-05 198.30000000000001p 1.9534931662999999e-05 198.40000000000001p 1.9536260571999999e-05 198.5p 1.9536103565000001e-05 198.59999999999999p 1.9534460027600953e-05 198.69999999999999p 1.9531462027999999e-05 198.80000000000001p 1.9527329932000002e-05 198.90000000000001p 1.9522398456e-05 199p 1.9517044194999998e-05 199.09999999999999p 1.9511675497e-05 199.19999999999999p 1.9506695413000001e-05 199.30000000000001p 1.9502478159000002e-05 199.40000000000001p 1.9499339319999999e-05 199.5p 1.949751973e-05 199.59999999999999p 1.9497142701e-05 199.69999999999999p 1.9498214044999998e-05 199.80000000000001p 1.9500664128e-05 199.90000000000001p 1.9504271032e-05)
* N4 → LS3 → N7

* === R-Loop lower branch: N5 → LS2 → JS2 → N6 ===
L_S2    8       9       0.5P
B_JS2   9       10      jjmit area=0.74
* R_JS2   9       10      15

* === N6 → N7 (direct wire) ===
* R_N6N7  N6      N7      1E-6

* === Output chain: N7 → LPSL → RSL → N8 → LSL → DataOut ===
L_PSL   10      11      0.5P
R_SL    11      12      12.0
L_SL    12      SL      0.4P

.ends BVM_REPLAY_2

* BVM_REPLAY_3: canonical BVM body; only R_S/L_S3 are replaced by an ideal current replay.
.subckt BVM_REPLAY_3 WL BL SE SL

* === WL+BL merge at Node '2' ===
R_BL    BL      1       20.0
L_PBL   1       2       0.5P
R_WL    WL      13      20.0
L_PWL   13      2       0.5P

* === S-Loop ===

* Main branch: N1 → JM1 → LM1 → GND
B_JM1   2       7       jjmit area=1.2
R_JM1   2       7       8
L_M1    7       0       12.5P

* Stabilizer branch: N1 → LM2 → JM2 → N2
L_M2    2       3       24.5P
B_JM2   3       4       jjmit area=1.4
* R_JM2   3       4       8

* N2 → LM3 → N5 (shared path with R-Loop)
L_M3    4       8       8.5P

* N5 → LPM → GND (loop closure)
L_PM    8       0       0.5P

* === R-Loop upper branch: N2 → LS1 → JS1 → N3 ===
L_S1    4       5       0.5P
B_JS1   5       6       jjmit area=0.74
* R_JS1   5       6       15

* === SE into N3 ===
R_SE    SE      14      20.0
L_PSE   14      6       0.5P

* === R-Loop bridge network ===
* N3 → N4 (direct wire — 0V voltage source for current measurement)
* R_N3N4  N3      N4      1E-6
* N3 → RS → N6
I_BRIDGE_REPLAY 6 10 PWL(0 0 0.10000000000000001p -8.9008820000000002e-09 0.20000000000000001p -3.9475250000000001e-08 0.29999999999999999p -1.0436383000000001e-07 0.40000000000000002p -2.1400482e-07 0.5p -3.7563160000000002e-07 0.59999999999999998p -5.9266280000000001e-07 0.70000000000000007p -8.6422770000000002e-07 0.80000000000000004p -1.1848615999999999e-06 0.90000000000000002p -1.5445506999999999e-06 1p -1.9293096e-06 1.0999999999999999p -2.3134958e-06 1.2p -2.6664352000000002e-06 1.2999999999999998p -2.9583841000000003e-06 1.4000000000000001p -3.1645435000000002e-06 1.5p -3.2677285000000001e-06 1.6000000000000001p -3.2601032000000001e-06 1.7p -3.1440952620000001e-06 1.8p -2.9323975000000003e-06 1.8999999999999999p -2.6469257000000001e-06 2p -2.3167244999999997e-06 2.1000000000000001p -1.9749690000000004e-06 2.1999999999999997p -1.6553862e-06 2.2999999999999998p -1.3885445e-06 2.3999999999999999p -1.1985030999999999e-06 2.5p -1.1002760000000001e-06 2.5999999999999996p -1.0984302e-06 2.6999999999999997p -1.18695348e-06 2.8000000000000003p -1.3503549999999998e-06 2.9000000000000004p -1.5657659999999998e-06 3p -1.8057077999999998e-06 3.1000000000000001p -2.0411551000000002e-06 3.2000000000000002p -2.2445025e-06 3.3000000000000003p -2.3921261000000002e-06 3.3999999999999999p -2.4663391999999999e-06 3.5p -2.4565962999999996e-06 3.6000000000000001p -2.3599669660000001e-06 3.7000000000000002p -2.1809230000000002e-06 3.7999999999999998p -1.9305763999999997e-06 3.8999999999999999p -1.6254939e-06 4p -1.2862519999999998e-06 4.0999999999999996p -9.3583149999999992e-07 4.2000000000000002p -5.979741e-07 4.2999999999999998p -2.9555919999999999e-07 4.3999999999999995p -4.9073100000000024e-08 4.5p 1.247717e-07 4.5999999999999996p 2.1420513000000003e-07 4.7000000000000002p 2.1328515000000001e-07 4.7999999999999998p 1.2242501e-07 4.8999999999999995p -5.1501650000000008e-08 5p -2.9552488999999999e-07 5.0999999999999996p -5.9142100000000001e-07 5.1999999999999993p -9.169996e-07 5.2999999999999998p -1.2477521e-06 5.3999999999999995p -1.5587338999999999e-06 5.5p -1.8265247e-06 5.6000000000000005p -2.0310801000000002e-06 5.7000000000000002p -2.1573279000000001e-06 5.8000000000000007p -2.1963351999999998e-06 5.9000000000000004p -2.1459638699999999e-06 6p -2.0109537900000002e-06 6.1000000000000005p -1.8024263999999997e-06 6.2000000000000002p -1.5368755000000001e-06 6.2999999999999998p -1.2347399000000001e-06 6.4000000000000004p -9.1867920000000013e-07 6.5p -6.1172900000000006e-07 6.6000000000000005p -3.3546069999999996e-07 6.7000000000000002p -1.0832810000000006e-07 6.7999999999999998p 5.5699600000000034e-08 6.9000000000000004p 1.481022e-07 7p 1.66312544e-07 7.0999999999999996p 1.1373537e-07 7.2000000000000002p -7.0865999999999412e-10 7.2999999999999998p -1.63462887e-07 7.4000000000000004p -3.5756030000000001e-07 7.5p -5.6408909999999998e-07 7.5999999999999996p -7.6377870000000002e-07 7.7000000000000002p -9.385763e-07 7.7999999999999998p -1.0730905e-06 7.8999999999999995p -1.1557854e-06 8p -1.1798365000000002e-06 8.0999999999999996p -1.14358415e-06 8.1999999999999993p -1.05054502e-06 8.2999999999999989p -9.0901139999999995e-07 8.4000000000000004p -7.3124549999999997e-07 8.5p -5.3237030000000002e-07 8.5999999999999996p -3.2904359999999997e-07 8.6999999999999993p -1.3802780000000004e-07 8.7999999999999989p 2.521889999999999e-08 8.9000000000000004p 1.4781390000000001e-07 9p 2.2048087000000001e-07 9.0999999999999996p 2.382589e-07 9.1999999999999993p 2.0083745e-07 9.2999999999999989p 1.1249866000000002e-07 9.4000000000000004p -1.8321199999999993e-08 9.5p -1.798045e-07 9.5999999999999996p -3.57789e-07 9.6999999999999993p -5.3697630000000001e-07 9.7999999999999989p -7.022098e-07 9.8999999999999986p -8.3971520000000006e-07 10p -9.382017e-07 10.1p -9.8973940000000001e-07 10.199999999999999p -9.9034289000000001e-07 10.299999999999999p -9.4022258299999998e-07 10.399999999999999p -8.4368817999999997e-07 10.5p -7.0871980000000003e-07 10.6p -5.4624829999999993e-07 10.699999999999999p -3.6920969999999998e-07 10.799999999999999p -1.9145510000000001e-07 10.899999999999999p -2.6606900000000029e-08 11p 1.1304240000000001e-07 11.100000000000001p 2.1750100299999999e-07 11.200000000000001p 2.7984089999999998e-07 11.300000000000001p 2.9669419999999998e-07 11.4p 2.6844909999999996e-07 11.5p 1.9913331999999998e-07 11.600000000000001p 9.6002929999999987e-08 11.700000000000001p -3.1125100000000001e-08 11.800000000000001p -1.7073491000000002e-07 11.9p -3.1059465999999999e-07 12p -4.387762e-07 12.100000000000001p -5.4462639999999999e-07 12.200000000000001p -6.1961219999999996e-07 12.300000000000001p -6.5797159999999999e-07 12.4p -6.5712274999999997e-07 12.5p -6.1780045800000001e-07 12.6p -5.4391811999999997e-07 12.700000000000001p -4.4217020000000003e-07 12.800000000000001p -3.214149e-07 12.9p -1.9189210000000003e-07 13p -6.434570000000001e-08 13.1p 5.0876400000000007e-08 13.200000000000001p 1.4466953e-07 13.300000000000001p 2.0989874e-07 13.4p 2.4194650000000003e-07 13.5p 2.3904152999999999e-07 13.6p 2.02345e-07 13.700000000000001p 1.3579481e-07 13.800000000000001p 4.5722289999999997e-08 13.9p -5.971849000000001e-08 14p -1.7126166e-07 14.1p -2.7931559999999996e-07 14.199999999999999p -3.7476149999999999e-07 14.300000000000001p -4.4969499999999998e-07 14.4p -4.9805420000000003e-07 14.5p -5.1608273000000006e-07 14.6p -5.0259281999999996e-07 14.700000000000001p -4.5901338000000001e-07 14.900000000000002p -2.9916869999999999e-07 15p -1.9636449999999998e-07 15.100000000000001p -8.9214700000000019e-08 15.199999999999999p 1.3679600000000006e-08 15.300000000000001p 1.0423333999999999e-07 15.4p 1.755302e-07 15.500000000000002p 2.2236609999999999e-07 15.6p 2.416405e-07 15.700000000000001p 2.3256714e-07 15.799999999999999p 1.9669026800000002e-07 15.900000000000002p 1.3770873000000001e-07 16p 6.1127589999999985e-08 16.100000000000001p -2.6231869999999998e-08 16.199999999999999p -1.1681967999999999e-07 16.300000000000001p -2.0299166999999999e-07 16.399999999999999p -2.7763909999999995e-07 16.5p -3.3476010000000001e-07 16.599999999999998p -3.6992821999999998e-07 16.700000000000003p -3.8062174999999997e-07 16.800000000000001p -3.6638937999999996e-07 16.900000000000002p -3.2884207000000002e-07 17p -2.714759e-07 17.100000000000001p -1.9934355000000002e-07 17.199999999999999p -1.1860469999999999e-07 17.300000000000001p -3.5995499999999986e-08 17.399999999999999p 4.1738629999999995e-08 17.5p 1.0839837999999999e-07 17.599999999999998p 1.5882947999999999e-07 17.699999999999999p 1.8932477999999998e-07 17.800000000000001p 1.9789915000000001e-07 17.900000000000002p 1.8441606000000001e-07 18p 1.5056015999999999e-07 18.100000000000001p 9.9660109999999996e-08 18.199999999999999p 3.6379859999999994e-08 18.300000000000001p -3.3694010000000007e-08 18.399999999999999p -1.04531066e-07 18.5p -1.7016345999999999e-07 18.599999999999998p -2.2517660000000001e-07 18.699999999999999p -2.6514289000000001e-07 18.800000000000001p -2.8696675e-07 18.900000000000002p -2.8911189e-07 19p -2.7169524499999999e-07 19.100000000000001p -2.3644417999999999e-07 19.199999999999999p -1.8652062e-07 19.300000000000001p -1.2623129999999999e-07 19.399999999999999p -6.065032e-08 19.5p 4.8143099999999922e-09 19.599999999999998p 6.4872410000000005e-08 19.699999999999999p 1.1478437e-07 19.799999999999997p 1.5073927999999999e-07 19.900000000000002p 1.7014925999999999e-07 20p 1.7183711999999999e-07 20.100000000000001p 1.5610333700000001e-07 20.199999999999999p 1.2467150999999999e-07 20.300000000000001p 8.0516300000000007e-08 20.399999999999999p 2.7593719999999992e-08 20.5p -2.9505059999999998e-08 20.599999999999998p -8.5943972000000009e-08 20.699999999999999p -1.3704461999999999e-07 20.799999999999997p -1.7866748000000002e-07 20.899999999999999p -2.0754068999999998e-07 21p -2.2151086e-07 21.100000000000001p -2.1969608999999999e-07 21.199999999999999p -2.0253207049999999e-07 21.300000000000001p -1.7170818000000001e-07 21.399999999999999p -1.3000178e-07 21.5p -8.1027489999999992e-08 21.599999999999998p -2.892138e-08 21.699999999999999p 2.2009789999999996e-08 21.799999999999997p 6.7646530000000012e-08 21.899999999999999p 1.0439188000000001e-07 22p 1.2945617e-07 22.100000000000001p 1.4106972e-07 22.200000000000003p 1.3860675999999999e-07 22.300000000000001p 1.2261324839999999e-07 22.400000000000002p 9.4737060000000002e-08 22.5p 5.7569280000000001e-08 22.600000000000001p 1.4411220000000006e-08 22.699999999999999p -3.1012319999999996e-08 22.800000000000001p -7.4868525000000004e-08 22.899999999999999p -1.1353429000000001e-07 23p -1.4389019e-07 23.100000000000001p -1.6356673e-07 23.200000000000003p -1.7112377999999999e-07 23.300000000000001p -1.6614997000000001e-07 23.400000000000002p -1.49274879e-07 23.5p -1.2209570999999999e-07 23.600000000000001p -8.7025939999999995e-08 23.699999999999999p -4.7079589999999997e-08 23.800000000000001p -5.6104899999999993e-09 23.899999999999999p 3.3970400000000001e-08 24p 6.8477105999999999e-08 24.099999999999998p 9.5206070000000001e-08 24.200000000000003p 1.1214867e-07 24.300000000000001p 1.1814205e-07 24.400000000000002p 1.1294728999999999e-07 24.5p 9.7249975999999993e-08 24.600000000000001p 7.2584480000000004e-08 24.699999999999999p 4.1190450000000005e-08 24.800000000000001p 5.8136399999999994e-09 24.899999999999999p -3.0530180000000001e-08 25p -6.4808969000000002e-08 25.099999999999998p -9.4224089999999993e-08 25.199999999999999p -1.1643558e-07 25.300000000000001p -1.2974504000000001e-07 25.400000000000002p -1.3322195e-07 25.5p -1.2676413e-07 25.600000000000001p -1.11088862e-07 25.699999999999999p -8.7656739999999999e-08 25.800000000000001p -5.8536290000000002e-08 25.899999999999999p -2.6220619999999998e-08 26p 6.5861099999999989e-09 26.099999999999998p 3.7195659999999995e-08 26.199999999999999p 6.3156509999999997e-08 26.300000000000001p 8.2450520000000007e-08 26.400000000000002p 9.3649989999999998e-08 26.5p 9.6022570000000001e-08 26.600000000000001p 8.9577144000000002e-08 26.699999999999999p 7.5047494000000002e-08 26.800000000000001p 5.3816769999999998e-08 26.899999999999999p 2.7790170000000001e-08 27p -7.7277000000000249e-10 27.099999999999998p -2.9451460000000005e-08 27.199999999999999p -5.5866789999999999e-08 27.299999999999997p -7.7876009999999999e-08 27.400000000000002p -9.3744070000000011e-08 27.5p -1.0227789999999999e-07 27.600000000000001p -1.029132e-07 27.699999999999999p -9.5747788000000003e-08 27.800000000000001p -8.1519663e-08 27.899999999999999p -6.153296e-08 28p -3.7538810000000002e-08 28.099999999999998p -1.1581879999999999e-08 28.199999999999999p 1.4173949999999996e-08 28.299999999999997p 3.7626197000000002e-08 28.399999999999999p 5.6905430000000004e-08 28.5p 7.052428e-08 28.600000000000001p 7.7491880000000005e-08 28.699999999999999p 7.7385019999999994e-08 28.800000000000001p 7.0371129000000007e-08 28.899999999999999p 5.7182266000000001e-08 29p 3.9043009999999998e-08 29.099999999999998p 1.7559540000000002e-08 29.199999999999999p -5.4205299999999984e-09 29.299999999999997p -2.7965174000000002e-08 29.400000000000002p -4.82187e-08 29.5p -6.4552820000000005e-08 29.600000000000001p -7.569586e-08 29.699999999999999p -8.083001e-08 29.800000000000004p -7.9649056999999996e-08 29.900000000000002p -7.2373029800000008e-08 30p -5.971899000000001e-08 30.099999999999998p -4.2831730000000003e-08 30.200000000000003p -2.3180680000000001e-08 30.300000000000001p -2.4321600000000029e-09 30.399999999999999p 1.76918e-08 30.499999999999996p 3.5556335999999999e-08 30.600000000000001p 4.9746450000000005e-08 30.700000000000003p 5.9178839999999999e-08 30.800000000000001p 6.3184189999999993e-08 30.899999999999999p 6.1553565999999997e-08 31.000000000000004p 5.4546041999999998e-08 31.100000000000001p 4.2857624999999995e-08 31.199999999999999p 2.7554879999999999e-08 31.299999999999997p 9.9794799999999971e-09 31.400000000000002p -8.3680000000000025e-09 31.5p -2.5954785999999998e-08 31.599999999999998p -4.1342739999999998e-08 31.699999999999999p -5.3304739999999996e-08 31.800000000000004p -6.092126000000001e-08 31.900000000000002p -6.3649599999999996e-08 32p -6.1360726999999992e-08 32.099999999999994p -5.4341333e-08 32.200000000000003p -4.3261511999999997e-08 32.300000000000004p -2.9111699999999997e-08 32.399999999999999p -1.3114489999999998e-08 32.5p 3.3807199999999991e-09 32.600000000000001p 1.9011526e-08 32.700000000000003p 3.2514769999999996e-08 32.799999999999997p 4.2828459999999999e-08 32.899999999999999p 4.9174960000000002e-08 33p 5.1119090000000005e-08 33.100000000000001p 4.8596766000000006e-08 33.199999999999996p 4.1912605000000003e-08 33.299999999999997p 3.1707153999999997e-08 33.400000000000006p 1.8897280000000004e-08 33.5p 4.5949200000000001e-09 33.600000000000001p -9.9883600000000004e-09 33.699999999999996p -2.3643192e-08 33.800000000000004p -3.5261779999999998e-08 33.899999999999999p -4.392698e-08 34p -4.8983660000000001e-08 34.099999999999994p -5.0087295999999999e-08 34.200000000000003p -4.7225703000000003e-08 34.299999999999997p -4.0713193999999998e-08 34.399999999999999p -3.1157868000000004e-08 34.5p -1.9405539999999997e-08 34.600000000000001p -6.4651100000000006e-09 34.700000000000003p 6.5777399999999992e-09 34.799999999999997p 1.86515e-08 34.899999999999999p 2.8786687000000001e-08 35p 3.6193450000000003e-08 35.100000000000001p 4.0322790000000002e-08 35.199999999999996p 4.0906709e-08 35.299999999999997p 3.7974379999999995e-08 35.399999999999999p 3.1843526000000005e-08 35.5p 2.3088317999999997e-08 35.600000000000001p 1.2486700000000002e-08 35.699999999999996p 9.5221000000000162e-10 35.800000000000004p -1.0544084e-08 35.899999999999999p -2.1054605999999999e-08 36p -2.9732769999999998e-08 36.099999999999994p -3.5900519999999998e-08 36.200000000000003p -3.9100584e-08 36.299999999999997p -3.9129488000000003e-08 36.399999999999999p -3.60489866e-08 36.5p -3.0175431999999996e-08 36.600000000000001p -2.2048440999999998e-08 36.700000000000003p -1.2381780000000001e-08 36.799999999999997p -2.0010699999999983e-09 36.900000000000006p 8.2265739999999997e-09 37p 1.7464681999999999e-08 37.100000000000001p 2.4975689999999999e-08 37.199999999999996p 3.0179539999999995e-08 37.300000000000004p 3.2698101999999999e-08 37.399999999999999p 3.2382116999999999e-08 37.5p 2.931869674e-08 37.600000000000001p 2.3819184000000002e-08 37.700000000000003p 1.6388903000000001e-08 37.800000000000004p 7.6814999999999983e-09 37.899999999999999p -1.5579500000000004e-09 38p -1.0556113e-08 38.100000000000001p -1.8575718e-08 38.200000000000003p -2.4975390000000002e-08 38.299999999999997p -2.9260499999999999e-08 38.399999999999999p -3.1120767e-08 38.5p -3.0452002000000001e-08 38.600000000000001p -2.73603635e-08 38.700000000000003p -2.2149222e-08 38.799999999999997p -1.5290148000000001e-08 38.900000000000006p -7.3805400000000007e-09 39p 9.0809000000000115e-10 39.100000000000001p 8.8870169999999992e-09 39.199999999999996p 1.5907209000000002e-08 39.300000000000004p 2.141204e-08 39.399999999999999p 2.4981116999999998e-08 39.5p 2.6362013999999999e-08 39.599999999999994p 2.5487633000000002e-08 39.700000000000003p 2.2477828500000001e-08 39.800000000000004p 1.7625659000000002e-08 39.899999999999999p 1.1369706000000001e-08 40p 4.2549310000000002e-09 40.100000000000001p -3.1143489999999994e-09 40.200000000000003p -1.0125426e-08 40.299999999999997p -1.6207802999999999e-08 40.399999999999999p -2.0879220999999999e-08 40.5p -2.3783547999999998e-08 40.600000000000001p -2.471744e-08 40.699999999999996p -2.3643892000000002e-08 40.799999999999997p -2.0691845000000001e-08 40.900000000000006p -1.6142135e-08 41p -1.0401204999999999e-08 41.100000000000001p -3.965088000000001e-09 41.199999999999996p 2.6232860000000007e-09 41.300000000000004p 8.8196830000000004e-09 41.399999999999999p 1.4123435e-08 41.5p 1.8117640000000002e-08 41.599999999999994p 2.0501781e-08 41.700000000000003p 2.1113983000000001e-08 41.799999999999997p 1.9941486999999999e-08 41.899999999999999p 1.7118542999999999e-08 42p 1.2912360000000002e-08 42.100000000000001p 7.6983220000000006e-09 42.200000000000003p 1.9268859999999997e-09 42.299999999999997p -3.9150560000000011e-09 42.399999999999999p -9.3449706000000009e-09 42.5p -1.3924285000000001e-08 42.600000000000001p -1.7293548000000001e-08 42.699999999999996p -1.9200338000000002e-08 42.799999999999997p -1.9517812000000003e-08 42.899999999999999p -1.8252479699999999e-08 43p -1.5540933999999999e-08 43.100000000000001p -1.1635848e-08 43.199999999999996p -6.8828019999999992e-09 43.300000000000004p -1.6899069999999999e-09 43.399999999999999p 3.5070800000000003e-09 43.5p 8.2811792000000007e-09 43.599999999999994p 1.2249121e-08 43.700000000000003p 1.5101969999999999e-08 43.799999999999997p 1.6628981e-08 43.899999999999999p 1.6732862000000001e-08 44p 1.5435463000000001e-08 44.100000000000001p 1.2873421999999999e-08 44.200000000000003p 9.2845390000000004e-09 44.299999999999997p 4.9861209999999996e-09 44.400000000000006p 3.4718699999999979e-10 44.5p -4.2429800000000006e-09 44.600000000000001p -8.4072700000000005e-09 44.699999999999996p -1.1811531e-08 44.800000000000004p -1.4191167999999998e-08 44.899999999999999p -1.5371458e-08 45p -1.5280033999999999e-08 45.100000000000001p -1.3950732600000001e-08 45.200000000000003p -1.1518553e-08 45.300000000000004p -8.2064500000000003e-09 45.399999999999999p -4.3051530000000003e-09 45.5p -1.4780499999999978e-10 45.600000000000001p 3.9183310000000004e-09 45.700000000000003p 7.5607469999999994e-09 45.799999999999997p 1.0488751000000001e-08 45.899999999999999p 1.2476519999999999e-08 46p 1.3380342000000001e-08 46.100000000000001p 1.3148699999999999e-08 46.200000000000003p 1.18246471e-08 46.299999999999997p 9.5402459999999987e-09 46.400000000000006p 6.5038550000000008e-09 46.5p 2.981399000000001e-09 46.600000000000001p -7.2671900000000025e-10 46.699999999999996p -4.3110600000000006e-09 46.800000000000004p -7.4788109999999996e-09 46.899999999999999p -9.9775359999999994e-09 47p -1.1615116999999999e-08 47.099999999999994p -1.2274310000000001e-08 47.200000000000003p -1.1920844e-08 47.300000000000004p -1.0604515000000001e-08 47.399999999999999p -8.4533499999999987e-09 47.5p -5.6614339999999996e-09 47.600000000000001p -2.4715879999999999e-09 47.700000000000003p 8.4564300000000012e-10 47.799999999999997p 4.014824e-09 47.899999999999999p 6.7783929999999999e-09 48p 8.9174910000000007e-09 48.100000000000001p 1.0269166000000001e-08 48.199999999999996p 1.0738627e-08 48.299999999999997p 1.0305625000000001e-08 48.400000000000006p 9.0245822000000006e-09 48.5p 7.0185629999999995e-09 48.600000000000001p 4.4677289999999995e-09 48.699999999999996p 1.5933319999999997e-09 48.800000000000004p -1.3613370000000001e-09 48.899999999999999p -4.1514239999999997e-09 49p -6.5506810000000003e-09 49.099999999999994p -8.3696950000000002e-09 49.200000000000003p -9.4707050000000012e-09 49.299999999999997p -9.77786e-09 49.399999999999999p -9.2821747999999995e-09 49.5p -8.0408806000000007e-09 49.600000000000001p -6.1713420000000001e-09 49.700000000000003p -3.8401549999999998e-09 49.799999999999997p -1.2484219999999999e-09 49.899999999999999p 1.3855069999999996e-09 50p 3.8443503000000004e-09 50.100000000000001p -5.6630849999999998e-06 50.199999999999996p -1.0960864e-05 50.299999999999997p -1.5755084000000001e-05 50.399999999999999p -1.9933583000000002e-05 50.5p -2.3419452e-05 50.600000000000001p -2.6182544000000003e-05 50.699999999999996p -2.8245783e-05 50.800000000000004p -2.9685274999999997e-05 50.899999999999999p -3.0624647999999996e-05 51p -3.1224506999999998e-05 51.100000000000001p -2.5999512e-05 51.200000000000003p -2.1180014999999998e-05 51.299999999999997p -1.7085389000000001e-05 51.399999999999999p -1.3992943e-05 51.5p -1.2114588000000001e-05 51.600000000000001p -1.1577498e-05 51.700000000000003p -1.2412267999999999e-05 51.799999999999997p -1.4549187000000001e-05 51.900000000000006p -1.7822274999999999e-05 52p -2.1980831999999999e-05 52.100000000000001p -2.6707766999999998e-05 52.199999999999996p -3.1643914000000002e-05 52.300000000000004p -3.6416399999999999e-05 52.399999999999999p -4.0668925000000001e-05 52.5p -4.4090944000000002e-05 52.600000000000001p -4.6442954000000003e-05 52.700000000000003p -4.7575596999999997e-05 52.800000000000004p -4.7440654999999998e-05 52.899999999999999p -4.609328831e-05 53p -4.3685296999999998e-05 53.100000000000001p -4.0450339999999997e-05 53.200000000000003p -3.6682623000000003e-05 53.299999999999997p -3.2711240999999998e-05 53.399999999999999p -2.8872957000000002e-05 53.5p -2.5485834000000002e-05 53.600000000000001p -2.2826248e-05 53.700000000000003p -2.1110488000000001e-05 53.799999999999997p -2.0481995000000001e-05 53.900000000000006p -2.1004241e-05 54p -2.2659086699999998e-05 54.100000000000001p -2.5350319999999998e-05 54.199999999999996p -2.8911972999999996e-05 54.300000000000004p -3.3121028e-05 54.399999999999999p -3.7713626000000002e-05 54.5p -4.2403616999999995e-05 54.599999999999994p -4.6901608999999996e-05 54.700000000000003p -5.0932744000000001e-05 54.800000000000004p -5.4251976999999999e-05 54.899999999999999p -5.6657166000000004e-05 55p -5.8001473999999999e-05 55.100000000000001p -5.8206564999999997e-05 55.200000000000003p -5.7275363100000001e-05 55.299999999999997p -5.5300399000000001e-05 55.399999999999999p -5.2462671999999998e-05 55.5p -4.9018516000000002e-05 55.600000000000001p -4.5275981e-05 55.699999999999996p -4.1565057999999998e-05 55.799999999999997p -3.8207102000000001e-05 55.899999999999999p -3.5487588999999999e-05 56p -3.3634801000000001e-05 56.100000000000001p -3.2805145999999994e-05 56.199999999999996p -3.3074815000000005e-05 56.300000000000004p -3.4437098499999995e-05 56.399999999999999p -3.6804573000000003e-05 56.5p -4.0015852999999996e-05 56.599999999999994p -4.3846698999999999e-05 56.700000000000003p -4.8025385999999998e-05 56.799999999999997p -5.2251916000000004e-05 56.899999999999999p -5.6220154999999998e-05 57p -5.9641400999999997e-05 57.100000000000001p -6.2267227000000006e-05 57.200000000000003p -6.3909538000000006e-05 57.299999999999997p -6.4455584000000003e-05 57.399999999999999p -6.3876609999999998e-05 57.5p -6.2229116199999997e-05 57.600000000000001p -5.9648882000000008e-05 57.699999999999996p -5.6338325000000004e-05 57.799999999999997p -5.2548922000000001e-05 57.899999999999999p -4.8560287999999997e-05 58p -4.4658347000000001e-05 58.100000000000001p -4.1114305000000001e-05 58.199999999999996p -3.8166144999999997e-05 58.299999999999997p -3.6003539000000002e-05 58.399999999999999p -3.4756894000000003e-05 58.500000000000007p -3.4490338000000001e-05 58.599999999999994p -3.5198944e-05 58.700000000000003p -3.6809835299999998e-05 58.800000000000004p -3.9187282000000001e-05 58.899999999999999p -4.2141849000000004e-05 59p -4.5443329999999994e-05 59.099999999999994p -4.8837075000000005e-05 59.200000000000003p -5.2062930000000001e-05 59.300000000000004p -5.4875110999999996e-05 59.399999999999999p -5.7061597999999997e-05 59.5p -5.8460959999999999e-05 59.600000000000009p -5.8974979999999996e-05 59.699999999999996p -5.8575955e-05 59.800000000000004p -5.7307769700000004e-05 59.899999999999991p -5.5280863e-05 60p -5.2661727999999994e-05 60.100000000000001p -4.3989034000000002e-05 60.199999999999996p -3.5534330000000005e-05 60.300000000000004p -2.767313e-05 60.400000000000006p -2.0750450000000001e-05 60.5p -1.505296e-05 60.600000000000001p -1.0783934999999999e-05 60.699999999999996p -8.0446209999999983e-06 60.799999999999997p -6.8231470000000002e-06 60.900000000000006p -6.9915010000000001e-06 60.999999999999993p -8.3114763999999991e-06 61.100000000000001p -1.6119213999999998e-05 61.200000000000003p -2.3973289e-05 61.299999999999997p -3.1300000000000002e-05 61.400000000000006p -3.7549699999999997e-05 61.499999999999993p -4.2248045999999999e-05 61.600000000000001p -4.5041664000000001e-05 61.700000000000003p -4.5731070000000005e-05 61.799999999999997p -4.4288317000000001e-05 61.899999999999999p -4.0858887000000001e-05 62.000000000000007p -3.5748147999999995e-05 62.099999999999994p -2.9393888000000004e-05 62.200000000000003p -2.2327211000000002e-05 62.299999999999997p -1.5125769999999998e-05 62.399999999999999p -8.3643099999999995e-06 62.500000000000007p -2.567750000000001e-06 62.599999999999994p 1.8287559999999998e-06 62.700000000000003p 4.5100489999999999e-06 62.800000000000004p 5.3007023000000002e-06 62.899999999999999p 4.1742160000000002e-06 63p 1.2523150000000001e-06 63.099999999999994p -3.2054426999999997e-06 63.199999999999996p -8.8217200000000003e-06 63.300000000000004p -1.5130808999999999e-05 63.399999999999999p -2.1616062999999997e-05 63.5p -2.7752632999999999e-05 63.600000000000009p -3.3051388999999997e-05 63.699999999999996p -3.7099679999999998e-05 63.800000000000004p -3.9594719000000001e-05 63.899999999999991p -4.0366864999999999e-05 64p -3.9391063000000002e-05 64.100000000000009p -3.6785958999999998e-05 64.199999999999989p -3.2801076999999997e-05 64.299999999999997p -2.7792961999999999e-05 64.400000000000006p -2.2192720999999999e-05 64.5p -1.6467770999999999e-05 64.600000000000009p -1.1081951000000001e-05 64.699999999999989p -6.457861999999999e-06 64.799999999999997p -2.9449439999999999e-06 64.900000000000006p -7.9533700000000021e-07 65p -1.4836399999999999e-07 65.099999999999994p -1.023707e-06 65.200000000000003p -3.3227369999999999e-06 65.299999999999997p -6.837648e-06 65.400000000000006p -1.1268094e-05 65.5p -1.6244796999999999e-05 65.599999999999994p -2.1359037000000001e-05 65.700000000000003p -2.6195985e-05 65.799999999999997p -3.0368950999999999e-05 65.900000000000006p -3.3551357999999997e-05 66p -3.5503144999999999e-05 66.099999999999994p -3.6089483000000001e-05 66.200000000000003p -3.5290048000000001e-05 66.300000000000011p -3.31985759e-05 66.399999999999991p -3.0012858999999996e-05 66.5p -2.6016130000000002e-05 66.599999999999994p -2.1551643999999999e-05 66.700000000000003p -1.6992718999999999e-05 66.800000000000011p -1.2711116999999999e-05 66.899999999999991p -9.0467240000000016e-06 67p -6.2810890000000006e-06 67.100000000000009p -4.6169069999999989e-06 67.200000000000003p -4.1644649999999998e-06 67.299999999999997p -4.9355277999999996e-06 67.399999999999991p -6.8446577000000002e-06 67.5p -9.7175779999999997e-06 67.600000000000009p -1.3306022e-05 67.700000000000003p -1.7308182999999998e-05 67.799999999999997p -2.1393417000000001e-05 67.900000000000006p -2.5229376e-05 68p -2.8509242999999999e-05 68.100000000000009p -3.0976760000000002e-05 68.199999999999989p -3.2446707000000001e-05 68.299999999999997p -3.2819086999999997e-05 68.400000000000006p -3.2085869500000004e-05 68.5p -3.0329896800000001e-05 68.599999999999994p -2.7716070999999998e-05 68.700000000000003p -2.4475929e-05 68.799999999999997p -2.0886798999999999e-05 68.900000000000006p -1.7247860000000002e-05 69p -1.3854974000000001e-05 69.099999999999994p -1.0976822999999999e-05 69.200000000000003p -8.8341349999999997e-06 69.299999999999997p -7.5834520000000007e-06 69.400000000000006p -7.3065810000000002e-06 69.5p -8.0059543999999998e-06 69.599999999999994p -9.6061132999999998e-06 69.700000000000003p -1.1961041999999999e-05 69.799999999999997p -1.4866808e-05 69.900000000000006p -1.8078656999999999e-05 70p -2.1331251999999999e-05 70.099999999999994p -1.2432891e-05 70.200000000000003p -3.6079259999999992e-06 70.300000000000011p 5.212038e-06 70.399999999999991p 1.4064574799999999e-05 70.5p 2.2955234999999999e-05 70.599999999999994p 3.1866490000000003e-05 70.700000000000003p 4.076761e-05 70.799999999999997p 4.9622709999999996e-05 70.899999999999991p 5.839618e-05 71p 6.7055339999999998e-05 71.100000000000009p 6.3642838999999993e-05 71.200000000000003p 6.0596817800000002e-05 71.299999999999997p 5.8021910000000002e-05 71.399999999999991p 5.5998309e-05 71.5p 5.4575903000000002e-05 71.600000000000009p 5.3766163999999995e-05 71.699999999999989p 5.3539824000000004e-05 71.799999999999997p 5.3830652199999998e-05 71.900000000000006p 5.45436284e-05 72p 5.5565086999999999e-05 72.100000000000009p 5.6773030000000002e-05 72.199999999999989p 5.8046486999999998e-05 72.299999999999997p 5.9273320000000002e-05 72.400000000000006p 6.0356421000000001e-05 72.5p 6.1218480999999998e-05 72.599999999999994p 6.1805334000000002e-05 72.700000000000003p 6.2088348100000003e-05 72.799999999999997p 6.2065588200000001e-05 72.900000000000006p 6.1761870539999998e-05 73p 6.1227308099999996e-05 73.099999999999994p 6.05341151e-05 73.200000000000003p 5.9771329099999999e-05 73.299999999999997p 5.9037554e-05 73.400000000000006p 5.8431894000000002e-05 73.5p 5.8044097199999997e-05 73.599999999999994p 5.7944929199999997e-05 73.700000000000003p 5.81781543e-05 73.800000000000011p 5.8755293500000002e-05 73.899999999999991p 5.9653947000000003e-05 74p 6.0819782999999997e-05 74.099999999999994p 6.2171955000000004e-05 74.200000000000003p 6.3610970999999992e-05 74.300000000000011p 6.5028122999999998e-05 74.399999999999991p 6.6315405999999995e-05 74.5p 6.7374862000000007e-05 74.600000000000009p 6.8126621999999999e-05 74.700000000000003p 6.8514862999999996e-05 74.799999999999997p 6.8511270700000008e-05 74.899999999999991p 6.811563583e-05 75p 6.7353954e-05 75.100000000000009p 6.6274195000000003e-05 75.200000000000003p 6.4940782000000004e-05 75.299999999999997p 6.3428381999999995e-05 75.400000000000006p 6.1816130999999997e-05 75.5p 6.0182602999999997e-05 75.600000000000009p 5.8602144e-05 75.699999999999989p 5.7142405999999993e-05 75.799999999999997p 5.5862981000000005e-05 75.900000000000006p 5.4814738999999995e-05 76p 5.4039572e-05 76.099999999999994p 5.3570184e-05 76.200000000000003p 5.3429677499999996e-05 76.299999999999997p 5.3630816600000002e-05 76.400000000000006p 5.4174874600000001e-05 76.5p 5.50502751e-05 76.599999999999994p 5.6231089000000001e-05 76.700000000000003p 5.7675819e-05 76.799999999999997p 5.9326865999999996e-05 76.900000000000006p 6.1111106000000002e-05 77p 6.2942134999999997e-05 77.099999999999994p 6.4724332999999997e-05 77.200000000000003p 6.6358835000000001e-05 77.299999999999997p 6.7750922999999992e-05 77.400000000000006p 6.8818201000000001e-05 77.5p 6.9498338999999992e-05 77.599999999999994p 6.9755449000000007e-05 77.700000000000003p 6.9584226499999993e-05 77.800000000000011p 6.901101140000001e-05 77.899999999999991p 6.8091901499999998e-05 78p 6.6907863999999992e-05 78.099999999999994p 6.5557582999999997e-05 78.200000000000003p 6.4148528999999997e-05 78.299999999999997p 6.2787414999999989e-05 78.399999999999991p 6.1570782000000001e-05 78.5p 6.0576788999999996e-05 78.600000000000009p 5.9858987999999998e-05 78.700000000000003p 5.9442884999999999e-05 78.799999999999997p 5.9325349599999996e-05 78.899999999999991p 5.9477044599999997e-05 79p 5.9847276899999998e-05 79.100000000000009p 6.0370472100000002e-05 79.199999999999989p 6.0973499600000002e-05 79.299999999999997p 6.1582866900000008e-05 79.400000000000006p 6.2131035700000009e-05 79.5p 6.2561541200000003e-05 79.600000000000009p 6.2832624500000009e-05 79.699999999999989p 6.2919341800000004e-05 79.799999999999997p 6.2814370700000005e-05 79.900000000000006p 6.2527758999999996e-05 80p 6.2085618400000003e-05 80.099999999999994p 4.9600418000000003e-05 80.200000000000003p 3.7594530000000003e-05 80.299999999999997p 2.627076e-05 80.400000000000006p 1.5816569999999998e-05 80.5p 6.3867799999999999e-06 80.599999999999994p -1.9223100000000009e-06 80.700000000000003p -9.0968539999999984e-06 80.799999999999997p -1.5221139000000001e-05 80.900000000000006p -2.0480427999999998e-05 81p -2.5147049000000002e-05 81.099999999999994p -1.76218049e-05 81.200000000000003p -1.0711820999999999e-05 81.300000000000011p -4.8582500000000005e-06 81.399999999999991p -4.1041199999999982e-07 81.5p 2.4004590000000005e-06 81.599999999999994p 3.4746129999999999e-06 81.700000000000003p 2.8400395000000001e-06 81.800000000000011p 6.3637080000000002e-07 81.899999999999991p -2.9069020000000001e-06 82p -7.492561e-06 82.100000000000009p -1.2775316e-05 82.200000000000003p -1.8378784000000001e-05 82.299999999999997p -2.3911797999999998e-05 82.399999999999991p -2.8986987999999999e-05 82.5p -3.3243992e-05 82.600000000000009p -3.6376915000000002e-05 82.700000000000003p -3.8162511999999999e-05 82.799999999999997p -3.8483023e-05 82.900000000000006p -3.7337807000000006e-05 83p -3.4840650999999999e-05 83.100000000000009p -3.1203758999999995e-05 83.199999999999989p -2.6713060000000001e-05 83.299999999999997p -2.1700823000000004e-05 83.400000000000006p -1.6520343999999999e-05 83.5p -1.1525165999999998e-05 83.599999999999994p -7.0525339999999986e-06 83.700000000000003p -3.409275999999999e-06 83.799999999999997p -8.5765400000000028e-07 83.900000000000006p 4.0036299999999963e-07 84p 2.4085399999999968e-07 84.099999999999994p -1.36403152e-06 84.200000000000003p -4.3313179999999996e-06 84.299999999999997p -8.4608780000000004e-06 84.400000000000006p -1.3442648e-05 84.5p -1.8880130000000001e-05 84.599999999999994p -2.4328388e-05 84.700000000000003p -2.9340084999999999e-05 84.799999999999997p -3.3510704000000002e-05 84.900000000000006p -3.6515340999999998e-05 85p -3.8133103000000004e-05 85.099999999999994p -3.8259278999999997e-05 85.200000000000003p -3.6907727999999996e-05 85.300000000000011p -3.4206311999999998e-05 85.399999999999991p -3.0387026999999999e-05 85.5p -2.5770235000000002e-05 85.599999999999994p -2.0741795000000002e-05 85.700000000000003p -1.5721974000000002e-05 85.799999999999997p -1.1127477e-05 85.899999999999991p -7.3308490000000009e-06 86p -4.6235599999999998e-06 86.100000000000009p -3.1890750000000005e-06 86.200000000000003p -3.0899720000000006e-06 86.299999999999997p -4.2700231000000001e-06 86.399999999999991p -6.569081e-06 86.5p -9.7466420000000007e-06 86.600000000000009p -1.3509462999999999e-05 86.699999999999989p -1.7539211999999999e-05 86.799999999999997p -2.1517512000000001e-05 86.900000000000006p -2.5147379999999998e-05 87p -2.8170995000000001e-05 87.100000000000009p -3.0384555000000001e-05 87.199999999999989p -3.1650235e-05 87.299999999999997p -3.1904883e-05 87.400000000000006p -3.1164048799999999e-05 87.5p -2.9519698800000002e-05 87.599999999999994p -2.7130891999999999e-05 87.700000000000003p -2.420796e-05 87.799999999999997p -2.0992150000000002e-05 87.900000000000006p -1.7734036999999998e-05 88p -1.4673653999999999e-05 88.099999999999994p -1.2024393e-05 88.200000000000003p -9.9615480000000007e-06 88.299999999999997p -8.6148949999999991e-06 88.400000000000006p -8.0644190000000006e-06 88.5p -8.3377669999999998e-06 88.599999999999994p -9.4090848000000002e-06 88.700000000000003p -1.1199035e-05 88.800000000000011p -1.3576962e-05 88.899999999999991p -1.6366394e-05 89p -1.9355107e-05 89.099999999999994p -2.2310098e-05 89.200000000000003p -2.4996594000000001e-05 89.300000000000011p -2.7198910000000002e-05 89.399999999999991p -2.8740182e-05 89.5p -2.9498191e-05 89.600000000000009p -2.9415479000000002e-05 89.700000000000003p -2.8503135090000002e-05 89.799999999999997p -2.6838685999999999e-05 89.899999999999991p -2.455919e-05 90p -2.1850418999999999e-05 90.100000000000009p -1.3264034000000002e-05 90.200000000000003p -5.0788900000000008e-06 90.299999999999997p 2.32906e-06 90.400000000000006p 8.6250209999999987e-06 90.5p 1.3549008e-05 90.600000000000009p 1.6946508999999999e-05 90.699999999999989p 1.8788987e-05 90.799999999999997p 1.9180424999999999e-05 90.900000000000006p 1.8347929e-05 91p 1.6617723899999999e-05 91.099999999999994p 8.711676000000001e-06 91.200000000000003p 1.0856070000000011e-06 91.299999999999997p -5.717941999999999e-06 91.400000000000006p -1.1216066e-05 91.5p -1.5018504e-05 91.599999999999994p -1.6852944999999999e-05 91.700000000000003p -1.6581750000000001e-05 91.799999999999997p -1.421144687e-05 91.900000000000006p -9.8954759999999997e-06 92p -3.9289610000000008e-06 92.099999999999994p 3.2671280000000004e-06 92.200000000000003p 1.1174967900000001e-05 92.299999999999997p 1.9222172e-05 92.400000000000006p 2.6833320000000001e-05 92.5p 3.3483659999999996e-05 92.599999999999994p 3.8746080000000004e-05 92.700000000000003p 4.2324675999999999e-05 92.800000000000011p 4.4070998999999996e-05 92.899999999999991p 4.3983342000000004e-05 93p 4.2191586799999999e-05 93.099999999999994p 3.8933525000000004e-05 93.200000000000003p 3.4529467999999994e-05 93.299999999999997p 2.9360862999999997e-05 93.399999999999991p 2.3853392000000003e-05 93.5p 1.8459146e-05 93.600000000000009p 1.3631892000000002e-05 93.700000000000003p 9.7940999999999983e-06 93.799999999999997p 7.3003950000000009e-06 93.899999999999991p 6.4044909999999998e-06 94p 7.2353270000000005e-06 94.100000000000009p 9.785692e-06 94.199999999999989p 1.3913600999999999e-05 94.299999999999997p 1.9355700000000002e-05 94.400000000000006p 2.5750765999999998e-05 94.5p 3.2670959000000001e-05 94.600000000000009p 3.9657679999999997e-05 94.700000000000003p 4.6258590000000004e-05 94.799999999999997p 5.2062479999999997e-05 94.900000000000006p 5.6728992999999999e-05 95p 6.0010781999999995e-05 95.099999999999994p 6.1766707999999994e-05 95.200000000000003p 6.1965305000000008e-05 95.299999999999997p 6.06797298e-05 95.400000000000006p 5.8076848000000004e-05 95.5p 5.4402728000000003e-05 95.599999999999994p 4.9965958000000001e-05 95.700000000000003p 4.5117762e-05 95.799999999999997p 4.0228551999999998e-05 95.900000000000006p 3.5662026000000003e-05 96p 3.1749802000000004e-05 96.099999999999994p 2.8769781000000002e-05 96.200000000000003p 2.6930259e-05 96.300000000000011p 2.6360177999999999e-05 96.399999999999991p 2.7104959e-05 96.5p 2.9126668700000001e-05 96.599999999999994p 3.2307458e-05 96.700000000000003p 3.6456082999999998e-05 96.800000000000011p 4.1317198000000006e-05 96.899999999999991p 4.6584252000000003e-05 97p 5.1916283000000003e-05 97.100000000000009p 5.6958839000000001e-05 97.200000000000003p 6.1368461e-05 97.299999999999997p 6.4838808000000002e-05 97.399999999999991p 6.7125944999999997e-05 97.5p 6.8069329999999998e-05 97.600000000000009p 6.7605800000000002e-05 97.700000000000003p 6.5774612699999999e-05 97.799999999999997p 6.2713082000000005e-05 97.900000000000006p 5.8643866000000003e-05 98p 5.3855946e-05 98.100000000000009p 4.8681691000000001e-05 98.199999999999989p 4.3472690000000001e-05 98.299999999999997p 3.8576177000000002e-05 98.400000000000006p 3.4313615000000004e-05 98.5p 3.0962071e-05 98.599999999999994p 2.8738755000000004e-05 98.700000000000003p 2.7788801000000003e-05 98.799999999999997p 2.8176034000000002e-05 98.900000000000006p 2.9877134000000002e-05 99p 3.2779639e-05 99.099999999999994p 3.6684904000000003e-05 99.200000000000003p 4.1317247e-05 99.299999999999997p 4.6340290999999996e-05 99.400000000000006p 5.1380496999999999e-05 99.5p 5.6056361000000001e-05 99.599999999999994p 6.0010458000000003e-05 99.700000000000003p 6.2940543999999999e-05 99.799999999999997p 6.4625844000000001e-05 99.900000000000006p 6.4945900000000004e-05 100p 6.3889994199999993e-05 100.09999999999999p 5.5887767999999996e-05 100.2p 4.7177203000000001e-05 100.30000000000001p 3.8175550000000004e-05 100.39999999999999p 2.9338010000000003e-05 100.5p 2.1117469999999997e-05 100.59999999999999p 1.3923879999999999e-05 100.7p 8.0887799999999998e-06 100.8p 3.837751e-06 100.89999999999999p 1.2715280000000004e-06 101p 3.5670699999999946e-07 101.10000000000001p 6.5958819999999997e-06 101.2p 1.3662206999999999e-05 101.3p 2.1034487000000001e-05 101.39999999999999p 2.8148210000000003e-05 101.5p 3.4447779999999998e-05 101.60000000000001p 3.9439284999999999e-05 101.69999999999999p 4.2735703999999996e-05 101.8p 4.4090654000000002e-05 101.90000000000001p 4.3418619999999999e-05 102p 4.08010636e-05 102.10000000000001p 3.6478294000000003e-05 102.2p 3.0827599e-05 102.3p 2.4329087999999998e-05 102.40000000000001p 1.7522481999999998e-05 102.5p 1.0959350000000002e-05 102.59999999999999p 5.1562799999999987e-06 102.7p 5.539610000000001e-07 102.8p -2.5144050000000004e-06 102.90000000000001p -3.8440660000000005e-06 103p -3.3689628e-06 103.09999999999999p -1.1622411000000001e-06 103.2p 2.5721147999999998e-06 103.3p 7.5159140000000003e-06 103.40000000000001p 1.3261168e-05 103.5p 1.9341466000000001e-05 103.59999999999999p 2.5268670999999998e-05 103.7p 3.0572318000000001e-05 103.80000000000001p 3.4838147000000003e-05 103.89999999999999p 3.7742171e-05 104p 3.9076823000000001e-05 104.09999999999999p 3.8766687e-05 104.2p 3.6872551199999999e-05 104.30000000000001p 3.3583317000000001e-05 104.39999999999999p 2.9196940999999997e-05 104.5p 2.4092298000000001e-05 104.60000000000001p 1.8695178000000003e-05 104.7p 1.3442003999999999e-05 104.8p 8.744803999999999e-06 104.89999999999999p 4.9604899999999995e-06 105p 2.3660919999999999e-06 105.10000000000001p 1.141093e-06 105.2p 1.3567820000000002e-06 105.3p 2.9727878299999998e-06 105.40000000000001p 5.8407879999999997e-06 105.5p 9.7156480000000003e-06 105.60000000000001p 1.4274118e-05 105.69999999999999p 1.9140486999999999e-05 105.8p 2.3917588999999999e-05 105.90000000000001p 2.8220258e-05 106p 3.1707849000000002e-05 106.09999999999999p 3.4112381000000004e-05 106.2p 3.5259614999999998e-05 106.3p 3.5081535999999998e-05 106.40000000000001p 3.3619715200000004e-05 106.5p 3.1019702000000003e-05 106.59999999999999p 2.7517151000000001e-05 106.7p 2.3416788999999999e-05 106.8p 1.9065895999999999e-05 106.90000000000001p 1.4824457999999999e-05 107p 1.1034839e-05 107.09999999999999p 7.9937919999999994e-06 107.2p 5.9293720000000004e-06 107.3p 4.9845679999999996e-06 107.40000000000001p 5.2086200000000001e-06 107.5p 6.5560518000000003e-06 107.59999999999999p 8.8930490000000001e-06 107.7p 1.2010273e-05 107.80000000000001p 1.5640991e-05 107.89999999999999p 1.9483209000000001e-05 108p 2.3224103000000002e-05 108.09999999999999p 2.6565128000000001e-05 108.2p 2.9245684e-05 108.3p 3.1063529000000004e-05 108.39999999999999p 3.1890315000000003e-05 108.5p 3.1680799999999997e-05 108.60000000000001p 3.0475021699999997e-05 108.7p 2.8393174e-05 108.8p 2.5623868000000003e-05 108.89999999999999p 2.2406744e-05 109p 1.9011408999999997e-05 109.10000000000001p 1.5714574000000003e-05 109.19999999999999p 1.2777751000000001e-05 109.3p 1.0427033000000001e-05 109.40000000000001p 8.8367090000000009e-06 109.5p 8.1173290000000004e-06 109.60000000000001p 8.3088650000000003e-06 109.7p 9.3791367000000011e-06 109.8p 1.1227356999999999e-05 109.90000000000001p 1.3692703e-05 110p 1.6567411e-05 110.09999999999999p 1.6567411e-05 110.2p 1.6567411e-05 110.3p 1.6567411e-05 110.40000000000001p 3.1684940000000002e-05 110.5p 4.617417e-05 110.59999999999999p 5.9712080000000006e-05 110.7p 7.2018020000000002e-05 110.8p 8.2877949999999998e-05 110.90000000000001p 9.2174250000000006e-05 111p 9.990457000000001e-05 111.09999999999999p 0.00010618481 111.2p 0.00011123656 111.30000000000001p 0.00011536045799999999 111.39999999999999p 0.00010682814400000001 111.5p 9.8607741000000007e-05 111.59999999999999p 9.1095142999999992e-05 111.7p 8.4610289999999998e-05 111.8p 7.9372321000000003e-05 111.89999999999999p 7.5476266000000001e-05 112p 7.2883737999999992e-05 112.10000000000001p 7.1429391999999989e-05 112.2p 7.0840220000000008e-05 112.3p 7.0763768000000008e-05 112.39999999999999p 7.0800941300000009e-05 112.5p 7.0539380599999999e-05 112.60000000000001p 6.9583551299999996e-05 112.7p 6.7579688e-05 112.8p 6.423563100000001e-05 112.90000000000001p 5.9338329000000007e-05 113p 5.2773382999999999e-05 113.10000000000001p 4.4551069999999999e-05 113.19999999999999p 3.4839689999999997e-05 113.3p 2.3998799999999998e-05 113.40000000000001p 1.2595069999999999e-05 113.5p 1.3790499999999983e-06 113.59999999999999p -8.7869599999999979e-06 113.7p -1.7035422e-05 113.8p -2.2601553000000002e-05 113.90000000000001p -2.4900227000000003e-05 114p -2.3556488000000001e-05 114.09999999999999p -1.8393884e-05 114.2p -9.3974300000000013e-06 114.3p 3.3275899999999994e-06 114.40000000000001p 1.95779966e-05 114.5p 3.9033060000000001e-05 114.59999999999999p 6.1175150000000007e-05 114.7p 8.5164139999999996e-05 114.8p 0.00010974311999999999 114.90000000000001p 0.00013329564999999999 115p 0.00015409833000000001 115.09999999999999p 0.00017065738999999999 115.2p 0.00018195918 115.30000000000001p 0.00018754654000000001 115.39999999999999p 0.00018744400000000002 115.5p 0.00018200460199999999 115.59999999999999p 0.00017174446200000001 115.7p 0.00015720729999999999 115.8p 0.0001388796 115.89999999999999p 0.00011716992 116p 9.2461219999999996e-05 116.10000000000001p 6.5238879999999995e-05 116.2p 3.626618e-05 116.3p 6.7300799999999971e-06 116.39999999999999p -2.1759610000000002e-05 116.50000000000001p -4.7366822999999998e-05 116.59999999999999p -6.8341909999999998e-05 116.69999999999999p -8.3306489999999999e-05 116.8p -9.141691999999999e-05 116.90000000000001p -9.2397280000000009e-05 117.00000000000001p -8.6479984000000008e-05 117.09999999999999p -7.4298149e-05 117.19999999999999p -5.676225e-05 117.3p -3.4941419999999992e-05 117.40000000000001p -9.9601700000000046e-06 117.50000000000001p 1.7083869999999999e-05 117.60000000000001p 4.5172378000000001e-05 117.69999999999999p 7.3371659999999991e-05 117.8p 0.00010077508999999999 117.90000000000001p 0.00012639904999999998 118p 0.00014910851 118.10000000000001p 0.00016767111000000001 118.19999999999999p 0.00018096225000000001 118.3p 0.00018822038000000001 118.40000000000001p 0.00018921121 118.5p 0.000184226876 118.60000000000001p 0.00017394127500000001 118.69999999999999p 0.00015919710999999999 118.8p 0.00014081308 118.89999999999999p 0.00011946677 119p 9.5679180000000002e-05 119.10000000000001p 6.9898700000000009e-05 119.20000000000002p 4.2663389999999995e-05 119.3p 1.4792549999999994e-05 119.39999999999999p -1.2490450000000002e-05 119.5p -3.7606320999999997e-05 119.60000000000001p -5.8853549999999998e-05 119.70000000000002p -7.4718369999999997e-05 119.79999999999998p -8.4121660000000009e-05 119.89999999999999p -8.6532150000000001e-05 120p -8.1954496999999988e-05 120.10000000000001p -7.0837837000000003e-05 120.2p -5.3951160000000003e-05 120.29999999999998p -3.2259160000000002e-05 120.39999999999999p -1.8889600000000003e-05 120.5p -2.2908599999999993e-06 120.60000000000001p 1.6569119999999998e-05 120.7p 3.6705258999999997e-05 120.80000000000001p 5.7025969999999997e-05 120.89999999999999p 7.622176e-05 121p 9.2752190000000009e-05 121.09999999999999p 0.00010501092 121.2p 0.00011161193 121.30000000000001p 0.00011164815 121.39999999999999p 0.000116887561 121.5p 0.000114988416 121.59999999999999p 0.00010662040699999999 121.7p 9.2788439999999997e-05 121.80000000000001p 7.4691269999999999e-05 121.89999999999999p 5.3620219999999993e-05 121.99999999999999p 3.0899060000000001e-05 122.09999999999999p 7.8590399999999965e-06 122.2p -1.4176409999999999e-05 122.30000000000001p -3.3926992e-05 122.40000000000001p -5.0222699999999996e-05 122.49999999999999p -6.2087679999999997e-05 122.59999999999999p -6.8814910000000005e-05 122.7p -7.0015850000000005e-05 122.80000000000001p -6.5647465000000002e-05 122.90000000000001p -5.6026643999999997e-05 122.99999999999999p -4.1835960000000001e-05 123.09999999999999p -2.4109959999999998e-05 123.2p -4.1822199999999967e-06 123.3p 1.6418260000000002e-05 123.40000000000001p 3.6111373000000001e-05 123.49999999999999p 5.342164e-05 123.59999999999999p 6.7114130000000004e-05 123.7p 7.6291449999999996e-05 123.8p 8.0448210000000001e-05 123.90000000000001p 7.9489940999999991e-05 124.00000000000001p 7.3724100500000006e-05 124.09999999999999p 6.3826015000000003e-05 124.19999999999999p 5.0777289999999998e-05 124.3p 3.5774730000000004e-05 124.40000000000001p 2.0115580000000003e-05 124.50000000000001p 5.0749399999999972e-06 124.59999999999999p -8.2043399999999998e-06 124.69999999999999p -1.87941e-05 124.8p -2.6030752e-05 124.90000000000001p -2.953756e-05 125.00000000000001p -2.9227896999999997e-05 125.10000000000001p -2.5296953500000001e-05 125.19999999999999p -1.8203535999999998e-05 125.3p -8.6389699999999994e-06 125.40000000000001p 2.5223400000000007e-06 125.5p 1.4293125999999998e-05 125.60000000000001p 2.565974e-05 125.69999999999999p 3.5674019999999999e-05 125.8p 4.35368e-05 125.90000000000001p 4.8662199999999996e-05 126p 5.0718019999999999e-05 126.10000000000001p 4.9641834999999999e-05 126.19999999999999p 4.5635465400000004e-05 126.3p 3.9139568e-05 126.39999999999999p 3.0789612e-05 126.5p 2.1355080000000004e-05 126.60000000000001p 1.1666519999999999e-05 126.70000000000002p 2.5386700000000012e-06 126.8p -5.3002349999999996e-06 126.89999999999999p -1.1264426e-05 127p -1.49475e-05 127.10000000000001p -1.6140416999999999e-05 127.20000000000002p -1.4834110000000002e-05 127.29999999999998p -1.1210273000000001e-05 127.39999999999999p -5.6226939999999998e-06 127.5p 1.430549e-06 127.60000000000001p 9.3445949999999999e-06 127.7p 1.7454781000000002e-05 127.79999999999998p 2.5090829999999999e-05 127.89999999999999p 3.1633459999999999e-05 128p 3.6567060000000002e-05 128.09999999999999p 3.9522401000000002e-05 128.20000000000002p 4.0304659000000002e-05 128.30000000000001p 3.8904663000000006e-05 128.39999999999998p 3.5493218000000004e-05 128.5p 3.0400059999999998e-05 128.59999999999999p 2.4080234999999999e-05 128.70000000000002p 1.7071573e-05 128.80000000000001p 9.94773e-06 128.89999999999998p 3.2714800000000011e-06 129p -2.4476020000000006e-06 129.09999999999999p -6.788090999999999e-06 129.20000000000002p -9.4426930000000011e-06 129.30000000000001p -1.0235066999999999e-05 129.39999999999998p -9.1278999999999995e-06 129.5p -6.2228500000000001e-06 129.59999999999999p -1.7525869999999994e-06 129.69999999999999p 3.9352579999999995e-06 129.80000000000001p 1.0402435999999999e-05 129.90000000000001p 1.7152290000000001e-05 130p 2.3668160000000002e-05 130.09999999999999p 2.9454869999999999e-05 130.19999999999999p 3.4079206e-05 130.30000000000001p 3.7205171000000002e-05 130.40000000000001p 3.8620342999999998e-05 130.5p 3.8251206e-05 130.59999999999999p 3.6166331299999999e-05 130.69999999999999p 3.2567828999999996e-05 130.80000000000001p 2.7772112000000004e-05 130.90000000000001p 2.2182059e-05 131p 1.6253124999999997e-05 131.09999999999999p 1.0456354999999999e-05 131.19999999999999p 5.2414939999999991e-06 131.30000000000001p 1.0031170000000004e-06 131.40000000000001p -1.9480589999999995e-06 131.5p -3.4067610000000001e-06 131.59999999999999p -3.2866914999999999e-06 131.69999999999999p -1.6252403e-06 131.80000000000001p 1.4210298000000001e-06 131.90000000000001p 5.5901109999999993e-06 132p 1.0536817e-05 132.09999999999999p 1.5861879000000001e-05 132.19999999999999p 2.1145166999999998e-05 132.30000000000001p 2.5979763e-05 132.40000000000001p 3.0003664e-05 132.5p 3.2926609999999998e-05 132.60000000000002p 3.4550498000000002e-05 132.69999999999999p 3.4782386999999999e-05 132.79999999999998p 3.3639820200000001e-05 132.90000000000001p 3.1247780000000001e-05 133p 2.7827351999999999e-05 133.10000000000002p 2.3676152000000001e-05 133.19999999999999p 1.9142042999999998e-05 133.29999999999998p 1.4592701999999999e-05 133.40000000000001p 1.0384604e-05 133.5p 6.8347309999999998e-06 133.60000000000002p 4.1979640000000001e-06 133.69999999999999p 2.6513719999999998e-06 133.79999999999998p 2.2855139999999999e-06 133.90000000000001p 3.1021154000000003e-06 134p 5.0170840000000002e-06 134.09999999999999p 7.8681369999999996e-06 134.20000000000002p 1.1426653e-05 134.29999999999998p 1.5413616000000001e-05 134.40000000000001p 1.9519447e-05 134.5p 2.3427004000000002e-05 134.59999999999999p 2.6836311999999999e-05 134.70000000000002p 2.9488803999999999e-05 134.79999999999998p 3.1188644000000002e-05 134.90000000000001p 3.1818674999999999e-05 135p 3.1349354999999999e-05 135.09999999999999p 2.9839960499999997e-05 135.20000000000002p 2.7432160000000002e-05 135.29999999999998p 2.4336779999999999e-05 135.40000000000001p 2.0815414999999998e-05 135.5p 1.7158339000000001e-05 135.59999999999999p 1.3660835999999998e-05 135.70000000000002p 1.0599697000000001e-05 135.80000000000001p 8.2118029999999998e-06 135.89999999999998p 6.6762560000000004e-06 136p 6.1013499999999996e-06 136.09999999999999p 6.5172420000000008e-06 136.20000000000002p 7.8747085999999992e-06 136.30000000000001p 1.0050059999999999e-05 136.39999999999998p 1.2855887999999999e-05 136.5p 1.6056869000000001e-05 136.59999999999999p 1.938944e-05 136.70000000000002p 2.2583778999999998e-05 136.80000000000001p 2.5386097999999999e-05 136.89999999999998p 2.7579354999999999e-05 137p 2.9000514e-05 137.09999999999999p 2.9552967999999999e-05 137.19999999999999p 2.9213106000000003e-05 137.30000000000001p 2.80306316e-05 137.40000000000001p 2.6122882000000001e-05 137.5p 2.3663472999999997e-05 137.59999999999999p 2.0866598000000002e-05 137.69999999999999p 1.7968228000000002e-05 137.80000000000001p 1.5206148000000001e-05 137.90000000000001p 1.2800397999999998e-05 138p 1.0936042999999999e-05 138.09999999999999p 9.7495100000000011e-06 138.19999999999999p 9.3193830000000011e-06 138.30000000000001p 9.662196300000001e-06 138.40000000000001p 1.0733086499999999e-05 138.5p 1.2431083e-05 138.59999999999999p 1.4608317e-05 138.69999999999999p 1.7082535e-05 138.80000000000001p 1.9651777000000001e-05 138.90000000000001p 2.2110419e-05 139p 2.4265266e-05 139.09999999999999p 2.5950640000000001e-05 139.19999999999999p 2.7041208e-05 139.30000000000001p 2.7461523000000001e-05 139.40000000000001p 2.7191343399999999e-05 139.5p 2.6266356800000002e-05 139.59999999999999p 2.4774056e-05 139.69999999999999p 2.2845467999999999e-05 139.80000000000001p 2.0643441999999998e-05 139.90000000000001p 1.8348771e-05 140p 1.6145523999999999e-05 140.10000000000002p 1.4206668999999999e-05 140.19999999999999p 1.2681210000000001e-05 140.29999999999998p 1.1683428000000001e-05 140.40000000000001p 1.128488e-05 140.5p 1.1509462799999999e-05 140.60000000000002p 1.2331883799999999e-05 140.69999999999999p 1.3679725999999998e-05 140.79999999999998p 1.5439141000000001e-05 140.90000000000001p 1.7463927000000001e-05 141p 1.9587599999999999e-05 141.10000000000002p 2.1637210000000001e-05 141.19999999999999p 2.3448017999999999e-05 141.29999999999998p 2.487725e-05 141.40000000000001p 2.5815887000000002e-05 141.5p 2.6197235999999999e-05 141.59999999999999p 2.6001681700000001e-05 141.70000000000002p 2.52573048e-05 141.79999999999998p 2.4036496999999998e-05 141.90000000000001p 2.2448978999999997e-05 142p 2.0631944999999998e-05 142.09999999999999p 1.8738129000000002e-05 142.20000000000002p 1.6922971000000001e-05 142.29999999999998p 1.5331733999999997e-05 142.40000000000001p 1.4087976000000001e-05 142.5p 1.3283933000000002e-05 142.59999999999999p 1.2973985e-05 142.70000000000002p 1.3171212e-05 142.79999999999998p 1.3847535799999999e-05 142.90000000000001p 1.49371246e-05 143p 1.6342713000000001e-05 143.09999999999999p 1.7944241999999998e-05 143.20000000000002p 1.9609033999999998e-05 143.30000000000001p 2.1202774000000002e-05 143.39999999999998p 2.2600168e-05 143.5p 2.3694771999999999e-05 143.59999999999999p 2.440697e-05 143.70000000000002p 2.4689668000000001e-05 143.80000000000001p 2.4531234100000001e-05 143.89999999999998p 2.3955618099999999e-05 144p 2.3019537300000001e-05 144.09999999999999p 2.1807135000000002e-05 144.20000000000002p 2.0422558000000002e-05 144.30000000000001p 1.8981112e-05 144.39999999999998p 1.75998e-05 144.5p 1.6387977999999999e-05 144.59999999999999p 1.5438908000000001e-05 144.69999999999999p 1.4822831999999999e-05 144.80000000000001p 1.4582025999999998e-05 144.90000000000001p 1.4728088200000001e-05 145p 1.5241661999999999e-05 145.09999999999999p 1.6074529899999997e-05 145.19999999999999p 1.7153859999999999e-05 145.30000000000001p 1.8388303e-05 145.40000000000001p 1.9675572000000002e-05 145.5p 2.0910733e-05 145.59999999999999p 2.1994771999999998e-05 145.69999999999999p 2.2842517e-05 145.80000000000001p 2.3389403999999998e-05 145.90000000000001p 2.3596410899999998e-05 146p 2.34529284e-05 146.09999999999999p 2.2977049800000001e-05 146.19999999999999p 2.2213714599999998e-05 146.30000000000001p 2.1230516999999999e-05 146.40000000000001p 2.0111859000000001e-05 146.5p 1.8951756e-05 146.59999999999999p 1.7846068999999997e-05 146.69999999999999p 1.6884609999999998e-05 146.80000000000001p 1.6143905999999999e-05 146.90000000000001p 1.5681135e-05 147p 1.5529700400000001e-05 147.09999999999999p 1.5696821100000001e-05 147.19999999999999p 1.6163360999999998e-05 147.30000000000001p 1.6885860900000002e-05 147.40000000000001p 1.7800539e-05 147.5p 1.8829004999999999e-05 147.60000000000002p 1.9885063999999999e-05 147.69999999999999p 2.0881991e-05 147.79999999999998p 2.1739755999999998e-05 147.90000000000001p 2.2391369999999998e-05 148p 2.2788164000000001e-05 148.10000000000002p 2.29032628e-05 148.19999999999999p 2.2733325300000001e-05 148.29999999999998p 2.22981988e-05 148.40000000000001p 2.16388054e-05 148.5p 2.0813279399999998e-05 148.60000000000002p 1.9891826999999999e-05 148.69999999999999p 1.8950677999999998e-05 148.79999999999998p 1.8065756000000002e-05 148.90000000000001p 1.7306589000000001e-05 149p 1.6730857000000002e-05 149.09999999999999p 1.63801938e-05 149.20000000000002p 1.6277368099999998e-05 149.29999999999998p 1.64250075e-05 149.40000000000001p 1.68060192e-05 149.5p 1.7385386100000001e-05 149.59999999999999p 1.8113346200000001e-05 149.70000000000002p 1.8929523000000002e-05 149.79999999999998p 1.9767873e-05 149.90000000000001p 2.0561836999999998e-05 150p 2.1249640999999999e-05 150.09999999999999p 2.1778961999999999e-05 150.20000000000002p 2.2111030400000001e-05 150.29999999999998p 2.2223473800000001e-05 150.40000000000001p 2.2111838299999999e-05 150.5p 2.17897131e-05 150.59999999999999p 2.1287303499999998e-05 150.70000000000002p 2.0648711400000001e-05 150.80000000000001p 1.99280795e-05 150.89999999999998p 1.9185087000000001e-05 151p 1.8479978999999998e-05 151.09999999999999p 1.7868700000000001e-05 151.20000000000002p 1.7398492699999999e-05 151.30000000000001p 1.7104284299999999e-05 151.39999999999998p 1.70060942e-05 151.5p 1.71077144e-05 151.59999999999999p 1.73966905e-05 151.70000000000002p 1.7845652599999999e-05 151.80000000000001p 1.84147482e-05 151.89999999999998p 1.9055140299999997e-05 152p 1.9713124399999998e-05 152.09999999999999p 2.0334629999999999e-05 152.19999999999999p 2.0869667299999999e-05 152.30000000000001p 2.1276385499999999e-05 152.40000000000001p 2.1524370799999998e-05 152.5p 2.15969388e-05 152.59999999999999p 2.14922242e-05 152.69999999999999p 2.1223022300000002e-05 152.80000000000001p 2.0815434099999999e-05 152.90000000000001p 2.03063316e-05 153p 1.9740116200000001e-05 153.09999999999999p 1.9164847999999998e-05 153.19999999999999p 1.8628172999999998e-05 153.30000000000001p 1.8173419800000003e-05 153.40000000000001p 1.78361446e-05 153.5p 1.76414249e-05 153.59999999999999p 1.7602051699999999e-05 153.69999999999999p 1.7717815209999999e-05 153.80000000000001p 1.79758387e-05 153.90000000000001p 1.8351962299999997e-05 154p 1.8812941700000001e-05 154.09999999999999p 1.9319378299999998e-05 154.19999999999999p 1.98290494e-05 154.30000000000001p 2.03003542e-05 154.40000000000001p 2.06956988e-05 154.5p 2.09844119e-05 154.59999999999999p 2.1145107100000003e-05 154.69999999999999p 2.11671766e-05 154.80000000000001p 2.1051442030000001e-05 154.90000000000001p 2.0809837300000001e-05 155p 2.0464227900000001e-05 155.10000000000002p 2.0044359800000001e-05 155.19999999999999p 1.9585410300000003e-05 155.29999999999998p 1.9124947200000002e-05 155.40000000000001p 1.8699982799999997e-05 155.5p 1.83440075e-05 155.60000000000002p 1.8084425499999999e-05 155.69999999999999p 1.79404947e-05 155.79999999999998p 1.79220032e-05 155.90000000000001p 1.8028585210000001e-05 156p 1.8249919899999999e-05 156.10000000000002p 1.8566680600000001e-05 156.19999999999999p 1.8952185500000002e-05 156.29999999999998p 1.9374581099999999e-05 156.40000000000001p 1.97995044e-05 156.5p 2.0192876800000002e-05 156.59999999999999p 2.05236541e-05 156.70000000000002p 2.07663308e-05 156.79999999999998p 2.0902928700000001e-05 156.90000000000001p 2.0924342900000002e-05 157p 2.0830960189999998e-05 157.09999999999999p 2.06324075e-05 157.20000000000002p 2.0346652200000001e-05 157.29999999999998p 1.99983298e-05 157.40000000000001p 1.9616656999999997e-05 157.5p 1.9232923499999998e-05 157.59999999999999p 1.88779516e-05 157.70000000000002p 1.8579592599999999e-05 157.79999999999998p 1.8360537799999999e-05 157.90000000000001p 1.82366099e-05 158p 1.8215594800000002e-05 158.09999999999999p 1.829681452e-05 158.20000000000002p 1.8471344400000001e-05 158.30000000000001p 1.8722948800000001e-05 158.39999999999998p 1.90295265e-05 158.5p 1.9365108299999999e-05 158.59999999999999p 1.9702015999999999e-05 158.70000000000002p 2.0013165000000001e-05 158.80000000000001p 2.0274220600000001e-05 158.89999999999998p 2.0465561300000001e-05 159p 2.0573688100000001e-05 159.09999999999999p 2.0592160999999999e-05 159.20000000000002p 2.0521963489999998e-05 159.30000000000001p 2.0371204460000002e-05 159.39999999999998p 2.01542547e-05 159.5p 1.9890463499999999e-05 159.59999999999999p 1.9602464800000002e-05 159.69999999999999p 1.9314240199999998e-05 159.80000000000001p 1.9049160800000001e-05 159.90000000000001p 1.8828142600000001e-05 160p 1.8667976999999999e-05 160.09999999999999p 1.8580151499999999e-05 160.19999999999999p 1.85699562e-05 160.30000000000001p 1.8636315670000003e-05 160.40000000000001p 1.8771959360000001e-05 160.5p 1.8964144299999999e-05 160.59999999999999p 1.9195887499999999e-05 160.69999999999999p 1.9447318400000002e-05 160.80000000000001p 1.9697441499999999e-05 160.90000000000001p 1.9925811800000001e-05 161p 2.01141823e-05 161.09999999999999p 2.02479266e-05 161.19999999999999p 2.0317180400000001e-05 161.30000000000001p 2.0317498399999997e-05 161.40000000000001p 2.025018717e-05 161.5p 2.0122015989999999e-05 161.59999999999999p 1.99446117e-05 161.69999999999999p 1.9733424200000002e-05 161.80000000000001p 1.9506407999999999e-05 161.90000000000001p 1.92825143e-05 162p 1.9080150099999999e-05 162.09999999999999p 1.89156455e-05 162.19999999999999p 1.88019958e-05 162.30000000000001p 1.8747819999999998e-05 162.40000000000001p 1.875676197e-05 162.5p 1.8827188544000001e-05 162.60000000000002p 1.895247715e-05 162.69999999999999p 1.9121610299999999e-05 162.79999999999998p 1.9320121000000002e-05 162.90000000000001p 1.95313871e-05 163p 1.9737977699999998e-05 163.10000000000002p 1.9923118899999999e-05 163.19999999999999p 2.0072059300000003e-05 163.29999999999998p 2.0173229899999999e-05 163.40000000000001p 2.02191628e-05 163.5p 2.020696303e-05 163.60000000000002p 2.0138522375999999e-05 163.69999999999999p 2.0020269869999999e-05 163.79999999999998p 1.9862528800000001e-05 163.90000000000001p 1.96786495e-05 164p 1.94838244e-05 164.09999999999999p 1.9293871999999998e-05 164.20000000000002p 1.9123899600000002e-05 164.29999999999998p 1.8987118699999997e-05 164.40000000000001p 1.8893804100000001e-05 164.5p 1.8850554800000002e-05 164.59999999999999p 1.8859829810000001e-05 164.70000000000002p 1.8919844686000002e-05 164.79999999999998p 1.9024805889999999e-05 164.90000000000001p 1.9165479500000002e-05 165p 1.93300112e-05 165.09999999999999p 1.9504900299999998e-05 165.20000000000002p 1.9676117199999999e-05 165.29999999999998p 1.9830263899999999e-05 165.40000000000001p 1.99555766e-05 165.5p 2.0042850900000002e-05 165.59999999999999p 2.00860902e-05 165.70000000000002p 2.008295546e-05 165.80000000000001p 2.0034825902e-05 165.89999999999998p 1.994663338e-05 166p 1.9826377699999999e-05 166.09999999999999p 1.9684420600000002e-05 166.20000000000002p 1.9532594099999998e-05 166.30000000000001p 1.93832107e-05 166.39999999999998p 1.9248098200000001e-05 166.5p 1.91376487e-05 166.59999999999999p 1.9060001900000001e-05 166.70000000000002p 1.90204926e-05 166.80000000000001p 1.9021253959999998e-05 166.89999999999998p 1.9061139238999998e-05 167p 1.913591258e-05 167.09999999999999p 1.9238626e-05 167.19999999999999p 1.93602306e-05 167.30000000000001p 1.94904038e-05 167.40000000000001p 1.9618376199999999e-05 167.5p 1.9733792599999998e-05 167.59999999999999p 1.98275743e-05 167.69999999999999p 1.9892612600000002e-05 167.80000000000001p 1.99243279e-05 167.90000000000001p 1.992096221e-05 168p 1.9883664596999998e-05 168.09999999999999p 1.9816368550000002e-05 168.19999999999999p 1.972537139e-05 168.30000000000001p 1.96187965e-05 168.40000000000001p 1.95058567e-05 168.5p 1.9396112899999999e-05 168.59999999999999p 1.9298624199999997e-05 168.69999999999999p 1.92212692e-05 168.80000000000001p 1.9170077600000001e-05 168.90000000000001p 1.9148795719999999e-05 169p 1.9158588520000001e-05 169.09999999999999p 1.9198068458999999e-05 169.19999999999999p 1.9263364199999997e-05 169.30000000000001p 1.9348552410000001e-05 169.40000000000001p 1.9446184999999999e-05 169.5p 1.95479075e-05 169.59999999999999p 1.96451575e-05 169.69999999999999p 1.9729940400000001e-05 169.80000000000001p 1.97953832e-05 169.90000000000001p 1.9836359e-05 170p 1.9849838530000002e-05 170.10000000000002p 1.9835124230000001e-05 170.19999999999999p 1.9793836399999998e-05 170.29999999999998p 1.9729745720000003e-05 170.40000000000001p 1.9648447060000001e-05 170.5p 1.9556819299999999e-05 170.60000000000002p 1.9462493e-05 170.69999999999999p 1.93731828e-05 170.79999999999998p 1.9296066e-05 170.90000000000001p 1.9237221500000002e-05 171p 1.9201157089999999e-05 171.10000000000002p 1.9190466379999999e-05 171.19999999999999p 1.9205661749999998e-05 171.29999999999998p 1.92451859e-05 171.40000000000001p 1.930554192e-05 171.5p 1.9381641e-05 171.59999999999999p 1.9467217800000002e-05 171.70000000000002p 1.9555335400000001e-05 171.79999999999998p 1.9638994599999999e-05 171.90000000000001p 1.9711649e-05 172p 1.97677483e-05 172.09999999999999p 1.9803143590000001e-05 172.20000000000002p 1.981539886e-05 172.29999999999998p 1.980396092e-05 172.40000000000001p 1.9770133690000001e-05 172.5p 1.9717014419999999e-05 172.59999999999999p 1.964910145e-05 172.70000000000002p 1.9572011999999998e-05 172.79999999999998p 1.94919764e-05 172.90000000000001p 1.9415301900000001e-05 173p 1.9347934699999999e-05 173.09999999999999p 1.9294944299999999e-05 173.20000000000002p 1.9260169019999997e-05 173.30000000000001p 1.9245927650000001e-05 173.39999999999998p 1.9252866900000001e-05 173.5p 1.9279942092999999e-05 173.59999999999999p 1.9324535340000001e-05 173.70000000000002p 1.9382684609999999e-05 173.80000000000001p 1.9449476939999999e-05 173.89999999999998p 1.9519390400000001e-05 174p 1.9586802300000001e-05 174.09999999999999p 1.96464239e-05 174.20000000000002p 1.969372841e-05 174.30000000000001p 1.9725281139999998e-05 174.39999999999998p 1.9739027669999997e-05 174.5p 1.9734379339999999e-05 174.59999999999999p 1.9712248443000002e-05 174.69999999999999p 1.967495834e-05 174.80000000000001p 1.9625994250000001e-05 174.90000000000001p 1.9569670179999998e-05 175p 1.9510815950000001e-05 175.09999999999999p 1.9454315270000001e-05 175.19999999999999p 1.9404722550000001e-05 175.30000000000001p 1.936590177e-05 175.40000000000001p 1.934073646e-05 175.5p 1.9330895559999998e-05 175.59999999999999p 1.9336726329999999e-05 175.69999999999999p 1.9357282229000002e-05 175.80000000000001p 1.9390432319999999e-05 175.90000000000001p 1.9433047500000002e-05 176p 1.9481309940000001e-05 176.09999999999999p 1.953102374e-05 176.19999999999999p 1.957797746e-05 176.30000000000001p 1.961832287e-05 176.40000000000001p 1.9648827899999999e-05 176.5p 1.9667175779999998e-05 176.59999999999999p 1.9672105929999999e-05 176.69999999999999p 1.9663494830000002e-05 176.80000000000001p 1.9642367649999999e-05 176.90000000000001p 1.9610722250000001e-05 177p 1.957143765e-05 177.09999999999999p 1.9527928120000001e-05 177.19999999999999p 1.9483912590000001e-05 177.30000000000001p 1.9443076740000002e-05 177.40000000000001p 1.9408792379999998e-05 177.5p 1.9383815479999998e-05 177.60000000000002p 1.937011157e-05 177.69999999999999p 1.9368683830000002e-05 177.79999999999998p 1.9379517045e-05 177.90000000000001p 1.9401598639999997e-05 178p 1.943299682e-05 178.10000000000002p 1.9471055549999998e-05 178.19999999999999p 1.951260639e-05 178.29999999999998p 1.9554218750000003e-05 178.40000000000001p 1.9592531570000001e-05 178.5p 1.962444214e-05 178.60000000000002p 1.9647430260000002e-05 178.69999999999999p 1.9659718730000001e-05 178.79999999999998p 1.9660383790000002e-05 178.90000000000001p 1.9649481469000002e-05 179p 1.9627977510000001e-05 179.09999999999999p 1.9597669859999997e-05 179.20000000000002p 1.9561073190000001e-05 179.29999999999998p 1.9521144560000003e-05 179.40000000000001p 1.9481088579999999e-05 179.5p 1.944408873e-05 179.59999999999999p 1.9413039360000002e-05 179.70000000000002p 1.9390310309999998e-05 179.79999999999998p 1.9377583640000001e-05 179.90000000000001p 1.9375738980000002e-05 180p 1.9384751909999998e-05 180.09999999999999p 1.9403747710000002e-05 180.20000000000002p 1.9431061859999999e-05 180.29999999999998p 1.9464427849999999e-05 180.40000000000001p 1.9501093650000002e-05 180.5p 1.9538148870000001e-05 180.59999999999999p 1.9572686750000002e-05 180.70000000000002p 1.9602067059999999e-05 180.80000000000001p 1.9624118609999999e-05 180.89999999999998p 1.9637292649999999e-05 181p 1.964078068e-05 181.09999999999999p 1.9634592445999999e-05 181.20000000000002p 1.9619461169999998e-05 181.30000000000001p 1.9596824339999998e-05 181.39999999999998p 1.9568678180000001e-05 181.5p 1.9537393690000003e-05 181.59999999999999p 1.9505520919999997e-05 181.70000000000002p 1.947558633e-05 181.80000000000001p 1.9449856150000002e-05 181.90000000000001p 1.9430236149999998e-05 182p 1.941805636e-05 182.09999999999999p 1.9414016760000001e-05 182.19999999999999p 1.9418148975999999e-05 182.30000000000001p 1.9429847413000001e-05 182.40000000000001p 1.9447913069999998e-05 182.5p 1.9470683289999998e-05 182.59999999999999p 1.9496151320000002e-05 182.69999999999999p 1.9522200519999999e-05 182.80000000000001p 1.9546709550000002e-05 182.90000000000001p 1.9567746399999998e-05 183p 1.958372086e-05 183.09999999999999p 1.959351649e-05 183.19999999999999p 1.9596535050000003e-05 183.30000000000001p 1.9592737147000001e-05 183.40000000000001p 1.958267419e-05 183.5p 1.9567357170000001e-05 183.59999999999999p 1.9548237830000001e-05 183.69999999999999p 1.9527017669999999e-05 183.80000000000001p 1.9505529330000002e-05 183.90000000000001p 1.9485604099999998e-05 184p 1.9468887639999999e-05 184.09999999999999p 1.9456724949999999e-05 184.19999999999999p 1.9450053729999997e-05 184.30000000000001p 1.9449334160000001e-05 184.40000000000001p 1.9454511547999998e-05 184.5p 1.9465047670999998e-05 184.59999999999999p 1.9479945619999999e-05 184.69999999999999p 1.9497872949999999e-05 184.80000000000001p 1.9517238009999997e-05 184.90000000000001p 1.9536364819999999e-05 185p 1.9553612990000001e-05 185.10000000000002p 1.956753022e-05 185.19999999999999p 1.957694646e-05 185.29999999999998p 1.9581090370000001e-05 185.40000000000001p 1.9579650297999999e-05 185.5p 1.9572792966e-05 185.60000000000002p 1.9561114588999999e-05 185.69999999999999p 1.9545639350000002e-05 185.79999999999998p 1.9527690560000002e-05 185.90000000000001p 1.9508769490000002e-05 186p 1.9490466060000002e-05 186.10000000000002p 1.947429464e-05 186.19999999999999p 1.946156662e-05 186.29999999999998p 1.945332023e-05 186.40000000000001p 1.9450186259999999e-05 186.5p 1.9452397306000002e-05 186.59999999999999p 1.9459736881000003e-05 186.70000000000002p 1.9471564049999999e-05 186.79999999999998p 1.9486898899999997e-05 186.90000000000001p 1.9504504239999999e-05 187p 1.9522949310000001e-05 187.09999999999999p 1.954078209e-05 187.20000000000002p 1.9556607939999998e-05 187.29999999999998p 1.9569223389999998e-05 187.40000000000001p 1.9577695140000001e-05 187.5p 1.958141577e-05 187.59999999999999p 1.9580178305999999e-05 187.70000000000002p 1.9574143084599998e-05 187.79999999999998p 1.9563880377000002e-05 187.90000000000001p 1.9550222820000001e-05 188p 1.953428131e-05 188.09999999999999p 1.9517327740000001e-05 188.20000000000002p 1.9500647259999998e-05 188.30000000000001p 1.9485501709999999e-05 188.39999999999998p 1.9473015490000001e-05 188.5p 1.9464073410000001e-05 188.59999999999999p 1.9459269890000002e-05 188.70000000000002p 1.9458867679999999e-05 188.80000000000001p 1.9462783597000002e-05 188.89999999999998p 1.9470618678e-05 189p 1.9481679419999999e-05 189.09999999999999p 1.949502713e-05 189.20000000000002p 1.9509572299999999e-05 189.30000000000001p 1.952418158e-05 189.40000000000001p 1.9537725310000001e-05 189.5p 1.9549184280000001e-05 189.59999999999999p 1.9557735489999998e-05 189.69999999999999p 1.9562817189999998e-05 189.80000000000001p 1.9564134523000003e-05 189.90000000000001p 1.9561727876e-05 190p 1.9555896413e-05 190.09999999999999p 1.9547239861999997e-05 190.19999999999999p 1.9536551629999997e-05 190.30000000000001p 1.952476622e-05 190.40000000000001p 1.9512863690000001e-05 190.5p 1.9501842939999999e-05 190.59999999999999p 1.9492555459999999e-05 190.69999999999999p 1.9485699669999998e-05 190.80000000000001p 1.948175542e-05 190.90000000000001p 1.9480947351999998e-05 191p 1.9483214998e-05 191.09999999999999p 1.9488246825000001e-05 191.19999999999999p 1.9495525385e-05 191.30000000000001p 1.9504320439999999e-05 191.40000000000001p 1.9513847309999999e-05 191.5p 1.952323804e-05 191.59999999999999p 1.9531683800000001e-05 191.69999999999999p 1.9538497690000003e-05 191.80000000000001p 1.954311791e-05 191.90000000000001p 1.9545212143000002e-05 192p 1.9544674924e-05 192.09999999999999p 1.9541609890300001e-05 192.19999999999999p 1.9536359662000002e-05 192.30000000000001p 1.9529435848e-05 192.40000000000001p 1.9521481760000001e-05 192.5p 1.9513200000000001e-05 192.60000000000002p 1.9505336629999999e-05 192.69999999999999p 1.9498563070000001e-05 192.79999999999998p 1.949345593e-05 192.90000000000001p 1.9490444781000003e-05 193p 1.9489776693999998e-05 193.10000000000002p 1.9491476337999999e-05 193.19999999999999p 1.9495399690999999e-05 193.29999999999998p 1.950120942e-05 193.40000000000001p 1.9508409868e-05 193.5p 1.9516399660000001e-05 193.60000000000002p 1.9524510280000002e-05 193.69999999999999p 1.9532079230000001e-05 193.79999999999998p 1.9538477030000003e-05 193.90000000000001p 1.954319745e-05 194p 1.9545841373000002e-05 194.09999999999999p 1.9546194669000001e-05 194.20000000000002p 1.95442212249e-05 194.29999999999998p 1.9540082437999999e-05 194.40000000000001p 1.9534084798999999e-05 194.5p 1.9526707276999997e-05 194.59999999999999p 1.9518530239999997e-05 194.70000000000002p 1.951018754e-05 194.79999999999998p 1.9502323079999999e-05 194.90000000000001p 1.9495562990000002e-05 195p 1.9490423900000003e-05 195.09999999999999p 1.9487297599e-05 195.20000000000002p 1.9486401549e-05 195.29999999999998p 1.9487814556000001e-05 195.40000000000001p 1.9491406273e-05 195.5p 1.9496878982e-05 195.59999999999999p 1.9503799864000002e-05 195.70000000000002p 1.9511621949999999e-05 195.80000000000001p 1.951974202e-05 195.89999999999998p 1.9527533959999999e-05 196p 1.9534406579999997e-05 196.09999999999999p 1.9539865079999999e-05 196.20000000000002p 1.9543526382999999e-05 196.30000000000001p 1.9545128480000002e-05 196.39999999999998p 1.9544625010000001e-05 196.5p 1.9542106284200001e-05 196.59999999999999p 1.9537798482000001e-05 196.70000000000002p 1.9532102793999999e-05 196.80000000000001p 1.9525496275000001e-05 196.90000000000001p 1.9518495990000002e-05 197p 1.9511667699999999e-05 197.09999999999999p 1.950550995e-05 197.19999999999999p 1.9500463819000002e-05 197.30000000000001p 1.9496888250999999e-05 197.40000000000001p 1.9494990304999998e-05 197.5p 1.9494829245999999e-05 197.59999999999999p 1.9496363220299999e-05 197.69999999999999p 1.9499376995000001e-05 197.80000000000001p 1.9503579285e-05 197.90000000000001p 1.9508578256999999e-05 198p 1.9513954049000003e-05 198.09999999999999p 1.9519257423000001e-05 198.19999999999999p 1.9524074033999998e-05 198.30000000000001p 1.9528054170000002e-05 198.40000000000001p 1.9530918196000001e-05 198.5p 1.9532488231e-05 198.59999999999999p 1.9532706880999998e-05 198.69999999999999p 1.9531624014000001e-05 198.80000000000001p 1.9529382680999999e-05 198.90000000000001p 1.9526225292e-05 199p 1.9522481092999999e-05 199.09999999999999p 1.9518465859000002e-05 199.19999999999999p 1.9514554516000002e-05 199.30000000000001p 1.9511067149e-05 199.40000000000001p 1.9508298643000002e-05 199.5p 1.9506471859999999e-05 199.59999999999999p 1.9505704067999998e-05 199.69999999999999p 1.9506046053000002e-05 199.80000000000001p 1.9507423170899999e-05 199.90000000000001p 1.9509707477e-05)
* N4 → LS3 → N7

* === R-Loop lower branch: N5 → LS2 → JS2 → N6 ===
L_S2    8       9       0.5P
B_JS2   9       10      jjmit area=0.74
* R_JS2   9       10      15

* === N6 → N7 (direct wire) ===
* R_N6N7  N6      N7      1E-6

* === Output chain: N7 → LPSL → RSL → N8 → LSL → DataOut ===
L_PSL   10      11      0.5P
R_SL    11      12      12.0
L_SL    12      SL      0.4P

.ends BVM_REPLAY_3

* BVM_REPLAY_4: canonical BVM body; only R_S/L_S3 are replaced by an ideal current replay.
.subckt BVM_REPLAY_4 WL BL SE SL

* === WL+BL merge at Node '2' ===
R_BL    BL      1       20.0
L_PBL   1       2       0.5P
R_WL    WL      13      20.0
L_PWL   13      2       0.5P

* === S-Loop ===

* Main branch: N1 → JM1 → LM1 → GND
B_JM1   2       7       jjmit area=1.2
R_JM1   2       7       8
L_M1    7       0       12.5P

* Stabilizer branch: N1 → LM2 → JM2 → N2
L_M2    2       3       24.5P
B_JM2   3       4       jjmit area=1.4
* R_JM2   3       4       8

* N2 → LM3 → N5 (shared path with R-Loop)
L_M3    4       8       8.5P

* N5 → LPM → GND (loop closure)
L_PM    8       0       0.5P

* === R-Loop upper branch: N2 → LS1 → JS1 → N3 ===
L_S1    4       5       0.5P
B_JS1   5       6       jjmit area=0.74
* R_JS1   5       6       15

* === SE into N3 ===
R_SE    SE      14      20.0
L_PSE   14      6       0.5P

* === R-Loop bridge network ===
* N3 → N4 (direct wire — 0V voltage source for current measurement)
* R_N3N4  N3      N4      1E-6
* N3 → RS → N6
I_BRIDGE_REPLAY 6 10 PWL(0 0 0.10000000000000001p -8.9008820000000002e-09 0.20000000000000001p -3.9475250000000001e-08 0.29999999999999999p -1.0436383000000001e-07 0.40000000000000002p -2.1400482e-07 0.5p -3.7563160000000002e-07 0.59999999999999998p -5.9266280000000001e-07 0.70000000000000007p -8.6422770000000002e-07 0.80000000000000004p -1.1848615999999999e-06 0.90000000000000002p -1.5445506999999999e-06 1p -1.9293096e-06 1.0999999999999999p -2.3134958e-06 1.2p -2.6664352000000002e-06 1.2999999999999998p -2.9583841000000003e-06 1.4000000000000001p -3.1645435000000002e-06 1.5p -3.2677285000000001e-06 1.6000000000000001p -3.2601032000000001e-06 1.7p -3.1440952620000001e-06 1.8p -2.9323975000000003e-06 1.8999999999999999p -2.6469257000000001e-06 2p -2.3167244999999997e-06 2.1000000000000001p -1.9749690000000004e-06 2.1999999999999997p -1.6553862e-06 2.2999999999999998p -1.3885445e-06 2.3999999999999999p -1.1985030999999999e-06 2.5p -1.1002760000000001e-06 2.5999999999999996p -1.0984302e-06 2.6999999999999997p -1.18695348e-06 2.8000000000000003p -1.3503549999999998e-06 2.9000000000000004p -1.5657659999999998e-06 3p -1.8057077999999998e-06 3.1000000000000001p -2.0411551000000002e-06 3.2000000000000002p -2.2445025e-06 3.3000000000000003p -2.3921261000000002e-06 3.3999999999999999p -2.4663391999999999e-06 3.5p -2.4565962999999996e-06 3.6000000000000001p -2.3599669660000001e-06 3.7000000000000002p -2.1809230000000002e-06 3.7999999999999998p -1.9305763999999997e-06 3.8999999999999999p -1.6254939e-06 4p -1.2862519999999998e-06 4.0999999999999996p -9.3583149999999992e-07 4.2000000000000002p -5.979741e-07 4.2999999999999998p -2.9555919999999999e-07 4.3999999999999995p -4.9073100000000024e-08 4.5p 1.247717e-07 4.5999999999999996p 2.1420513000000003e-07 4.7000000000000002p 2.1328515000000001e-07 4.7999999999999998p 1.2242501e-07 4.8999999999999995p -5.1501650000000008e-08 5p -2.9552488999999999e-07 5.0999999999999996p -5.9142100000000001e-07 5.1999999999999993p -9.169996e-07 5.2999999999999998p -1.2477521e-06 5.3999999999999995p -1.5587338999999999e-06 5.5p -1.8265247e-06 5.6000000000000005p -2.0310801000000002e-06 5.7000000000000002p -2.1573279000000001e-06 5.8000000000000007p -2.1963351999999998e-06 5.9000000000000004p -2.1459638699999999e-06 6p -2.0109537900000002e-06 6.1000000000000005p -1.8024263999999997e-06 6.2000000000000002p -1.5368755000000001e-06 6.2999999999999998p -1.2347399000000001e-06 6.4000000000000004p -9.1867920000000013e-07 6.5p -6.1172900000000006e-07 6.6000000000000005p -3.3546069999999996e-07 6.7000000000000002p -1.0832810000000006e-07 6.7999999999999998p 5.5699600000000034e-08 6.9000000000000004p 1.481022e-07 7p 1.66312544e-07 7.0999999999999996p 1.1373537e-07 7.2000000000000002p -7.0865999999999412e-10 7.2999999999999998p -1.63462887e-07 7.4000000000000004p -3.5756030000000001e-07 7.5p -5.6408909999999998e-07 7.5999999999999996p -7.6377870000000002e-07 7.7000000000000002p -9.385763e-07 7.7999999999999998p -1.0730905e-06 7.8999999999999995p -1.1557854e-06 8p -1.1798365000000002e-06 8.0999999999999996p -1.14358415e-06 8.1999999999999993p -1.05054502e-06 8.2999999999999989p -9.0901139999999995e-07 8.4000000000000004p -7.3124549999999997e-07 8.5p -5.3237030000000002e-07 8.5999999999999996p -3.2904359999999997e-07 8.6999999999999993p -1.3802780000000004e-07 8.7999999999999989p 2.521889999999999e-08 8.9000000000000004p 1.4781390000000001e-07 9p 2.2048087000000001e-07 9.0999999999999996p 2.382589e-07 9.1999999999999993p 2.0083745e-07 9.2999999999999989p 1.1249866000000002e-07 9.4000000000000004p -1.8321199999999993e-08 9.5p -1.798045e-07 9.5999999999999996p -3.57789e-07 9.6999999999999993p -5.3697630000000001e-07 9.7999999999999989p -7.022098e-07 9.8999999999999986p -8.3971520000000006e-07 10p -9.382017e-07 10.1p -9.8973940000000001e-07 10.199999999999999p -9.9034289000000001e-07 10.299999999999999p -9.4022258299999998e-07 10.399999999999999p -8.4368817999999997e-07 10.5p -7.0871980000000003e-07 10.6p -5.4624829999999993e-07 10.699999999999999p -3.6920969999999998e-07 10.799999999999999p -1.9145510000000001e-07 10.899999999999999p -2.6606900000000029e-08 11p 1.1304240000000001e-07 11.100000000000001p 2.1750100299999999e-07 11.200000000000001p 2.7984089999999998e-07 11.300000000000001p 2.9669419999999998e-07 11.4p 2.6844909999999996e-07 11.5p 1.9913331999999998e-07 11.600000000000001p 9.6002929999999987e-08 11.700000000000001p -3.1125100000000001e-08 11.800000000000001p -1.7073491000000002e-07 11.9p -3.1059465999999999e-07 12p -4.387762e-07 12.100000000000001p -5.4462639999999999e-07 12.200000000000001p -6.1961219999999996e-07 12.300000000000001p -6.5797159999999999e-07 12.4p -6.5712274999999997e-07 12.5p -6.1780045800000001e-07 12.6p -5.4391811999999997e-07 12.700000000000001p -4.4217020000000003e-07 12.800000000000001p -3.214149e-07 12.9p -1.9189210000000003e-07 13p -6.434570000000001e-08 13.1p 5.0876400000000007e-08 13.200000000000001p 1.4466953e-07 13.300000000000001p 2.0989874e-07 13.4p 2.4194650000000003e-07 13.5p 2.3904152999999999e-07 13.6p 2.02345e-07 13.700000000000001p 1.3579481e-07 13.800000000000001p 4.5722289999999997e-08 13.9p -5.971849000000001e-08 14p -1.7126166e-07 14.1p -2.7931559999999996e-07 14.199999999999999p -3.7476149999999999e-07 14.300000000000001p -4.4969499999999998e-07 14.4p -4.9805420000000003e-07 14.5p -5.1608273000000006e-07 14.6p -5.0259281999999996e-07 14.700000000000001p -4.5901338000000001e-07 14.900000000000002p -2.9916869999999999e-07 15p -1.9636449999999998e-07 15.100000000000001p -8.9214700000000019e-08 15.199999999999999p 1.3679600000000006e-08 15.300000000000001p 1.0423333999999999e-07 15.4p 1.755302e-07 15.500000000000002p 2.2236609999999999e-07 15.6p 2.416405e-07 15.700000000000001p 2.3256714e-07 15.799999999999999p 1.9669026800000002e-07 15.900000000000002p 1.3770873000000001e-07 16p 6.1127589999999985e-08 16.100000000000001p -2.6231869999999998e-08 16.199999999999999p -1.1681967999999999e-07 16.300000000000001p -2.0299166999999999e-07 16.399999999999999p -2.7763909999999995e-07 16.5p -3.3476010000000001e-07 16.599999999999998p -3.6992821999999998e-07 16.700000000000003p -3.8062174999999997e-07 16.800000000000001p -3.6638937999999996e-07 16.900000000000002p -3.2884207000000002e-07 17p -2.714759e-07 17.100000000000001p -1.9934355000000002e-07 17.199999999999999p -1.1860469999999999e-07 17.300000000000001p -3.5995499999999986e-08 17.399999999999999p 4.1738629999999995e-08 17.5p 1.0839837999999999e-07 17.599999999999998p 1.5882947999999999e-07 17.699999999999999p 1.8932477999999998e-07 17.800000000000001p 1.9789915000000001e-07 17.900000000000002p 1.8441606000000001e-07 18p 1.5056015999999999e-07 18.100000000000001p 9.9660109999999996e-08 18.199999999999999p 3.6379859999999994e-08 18.300000000000001p -3.3694010000000007e-08 18.399999999999999p -1.04531066e-07 18.5p -1.7016345999999999e-07 18.599999999999998p -2.2517660000000001e-07 18.699999999999999p -2.6514289000000001e-07 18.800000000000001p -2.8696675e-07 18.900000000000002p -2.8911189e-07 19p -2.7169524499999999e-07 19.100000000000001p -2.3644417999999999e-07 19.199999999999999p -1.8652062e-07 19.300000000000001p -1.2623129999999999e-07 19.399999999999999p -6.065032e-08 19.5p 4.8143099999999922e-09 19.599999999999998p 6.4872410000000005e-08 19.699999999999999p 1.1478437e-07 19.799999999999997p 1.5073927999999999e-07 19.900000000000002p 1.7014925999999999e-07 20p 1.7183711999999999e-07 20.100000000000001p 1.5610333700000001e-07 20.199999999999999p 1.2467150999999999e-07 20.300000000000001p 8.0516300000000007e-08 20.399999999999999p 2.7593719999999992e-08 20.5p -2.9505059999999998e-08 20.599999999999998p -8.5943972000000009e-08 20.699999999999999p -1.3704461999999999e-07 20.799999999999997p -1.7866748000000002e-07 20.899999999999999p -2.0754068999999998e-07 21p -2.2151086e-07 21.100000000000001p -2.1969608999999999e-07 21.199999999999999p -2.0253207049999999e-07 21.300000000000001p -1.7170818000000001e-07 21.399999999999999p -1.3000178e-07 21.5p -8.1027489999999992e-08 21.599999999999998p -2.892138e-08 21.699999999999999p 2.2009789999999996e-08 21.799999999999997p 6.7646530000000012e-08 21.899999999999999p 1.0439188000000001e-07 22p 1.2945617e-07 22.100000000000001p 1.4106972e-07 22.200000000000003p 1.3860675999999999e-07 22.300000000000001p 1.2261324839999999e-07 22.400000000000002p 9.4737060000000002e-08 22.5p 5.7569280000000001e-08 22.600000000000001p 1.4411220000000006e-08 22.699999999999999p -3.1012319999999996e-08 22.800000000000001p -7.4868525000000004e-08 22.899999999999999p -1.1353429000000001e-07 23p -1.4389019e-07 23.100000000000001p -1.6356673e-07 23.200000000000003p -1.7112377999999999e-07 23.300000000000001p -1.6614997000000001e-07 23.400000000000002p -1.49274879e-07 23.5p -1.2209570999999999e-07 23.600000000000001p -8.7025939999999995e-08 23.699999999999999p -4.7079589999999997e-08 23.800000000000001p -5.6104899999999993e-09 23.899999999999999p 3.3970400000000001e-08 24p 6.8477105999999999e-08 24.099999999999998p 9.5206070000000001e-08 24.200000000000003p 1.1214867e-07 24.300000000000001p 1.1814205e-07 24.400000000000002p 1.1294728999999999e-07 24.5p 9.7249975999999993e-08 24.600000000000001p 7.2584480000000004e-08 24.699999999999999p 4.1190450000000005e-08 24.800000000000001p 5.8136399999999994e-09 24.899999999999999p -3.0530180000000001e-08 25p -6.4808969000000002e-08 25.099999999999998p -9.4224089999999993e-08 25.199999999999999p -1.1643558e-07 25.300000000000001p -1.2974504000000001e-07 25.400000000000002p -1.3322195e-07 25.5p -1.2676413e-07 25.600000000000001p -1.11088862e-07 25.699999999999999p -8.7656739999999999e-08 25.800000000000001p -5.8536290000000002e-08 25.899999999999999p -2.6220619999999998e-08 26p 6.5861099999999989e-09 26.099999999999998p 3.7195659999999995e-08 26.199999999999999p 6.3156509999999997e-08 26.300000000000001p 8.2450520000000007e-08 26.400000000000002p 9.3649989999999998e-08 26.5p 9.6022570000000001e-08 26.600000000000001p 8.9577144000000002e-08 26.699999999999999p 7.5047494000000002e-08 26.800000000000001p 5.3816769999999998e-08 26.899999999999999p 2.7790170000000001e-08 27p -7.7277000000000249e-10 27.099999999999998p -2.9451460000000005e-08 27.199999999999999p -5.5866789999999999e-08 27.299999999999997p -7.7876009999999999e-08 27.400000000000002p -9.3744070000000011e-08 27.5p -1.0227789999999999e-07 27.600000000000001p -1.029132e-07 27.699999999999999p -9.5747788000000003e-08 27.800000000000001p -8.1519663e-08 27.899999999999999p -6.153296e-08 28p -3.7538810000000002e-08 28.099999999999998p -1.1581879999999999e-08 28.199999999999999p 1.4173949999999996e-08 28.299999999999997p 3.7626197000000002e-08 28.399999999999999p 5.6905430000000004e-08 28.5p 7.052428e-08 28.600000000000001p 7.7491880000000005e-08 28.699999999999999p 7.7385019999999994e-08 28.800000000000001p 7.0371129000000007e-08 28.899999999999999p 5.7182266000000001e-08 29p 3.9043009999999998e-08 29.099999999999998p 1.7559540000000002e-08 29.199999999999999p -5.4205299999999984e-09 29.299999999999997p -2.7965174000000002e-08 29.400000000000002p -4.82187e-08 29.5p -6.4552820000000005e-08 29.600000000000001p -7.569586e-08 29.699999999999999p -8.083001e-08 29.800000000000004p -7.9649056999999996e-08 29.900000000000002p -7.2373029800000008e-08 30p -5.971899000000001e-08 30.099999999999998p -4.2831730000000003e-08 30.200000000000003p -2.3180680000000001e-08 30.300000000000001p -2.4321600000000029e-09 30.399999999999999p 1.76918e-08 30.499999999999996p 3.5556335999999999e-08 30.600000000000001p 4.9746450000000005e-08 30.700000000000003p 5.9178839999999999e-08 30.800000000000001p 6.3184189999999993e-08 30.899999999999999p 6.1553565999999997e-08 31.000000000000004p 5.4546041999999998e-08 31.100000000000001p 4.2857624999999995e-08 31.199999999999999p 2.7554879999999999e-08 31.299999999999997p 9.9794799999999971e-09 31.400000000000002p -8.3680000000000025e-09 31.5p -2.5954785999999998e-08 31.599999999999998p -4.1342739999999998e-08 31.699999999999999p -5.3304739999999996e-08 31.800000000000004p -6.092126000000001e-08 31.900000000000002p -6.3649599999999996e-08 32p -6.1360726999999992e-08 32.099999999999994p -5.4341333e-08 32.200000000000003p -4.3261511999999997e-08 32.300000000000004p -2.9111699999999997e-08 32.399999999999999p -1.3114489999999998e-08 32.5p 3.3807199999999991e-09 32.600000000000001p 1.9011526e-08 32.700000000000003p 3.2514769999999996e-08 32.799999999999997p 4.2828459999999999e-08 32.899999999999999p 4.9174960000000002e-08 33p 5.1119090000000005e-08 33.100000000000001p 4.8596766000000006e-08 33.199999999999996p 4.1912605000000003e-08 33.299999999999997p 3.1707153999999997e-08 33.400000000000006p 1.8897280000000004e-08 33.5p 4.5949200000000001e-09 33.600000000000001p -9.9883600000000004e-09 33.699999999999996p -2.3643192e-08 33.800000000000004p -3.5261779999999998e-08 33.899999999999999p -4.392698e-08 34p -4.8983660000000001e-08 34.099999999999994p -5.0087295999999999e-08 34.200000000000003p -4.7225703000000003e-08 34.299999999999997p -4.0713193999999998e-08 34.399999999999999p -3.1157868000000004e-08 34.5p -1.9405539999999997e-08 34.600000000000001p -6.4651100000000006e-09 34.700000000000003p 6.5777399999999992e-09 34.799999999999997p 1.86515e-08 34.899999999999999p 2.8786687000000001e-08 35p 3.6193450000000003e-08 35.100000000000001p 4.0322790000000002e-08 35.199999999999996p 4.0906709e-08 35.299999999999997p 3.7974379999999995e-08 35.399999999999999p 3.1843526000000005e-08 35.5p 2.3088317999999997e-08 35.600000000000001p 1.2486700000000002e-08 35.699999999999996p 9.5221000000000162e-10 35.800000000000004p -1.0544084e-08 35.899999999999999p -2.1054605999999999e-08 36p -2.9732769999999998e-08 36.099999999999994p -3.5900519999999998e-08 36.200000000000003p -3.9100584e-08 36.299999999999997p -3.9129488000000003e-08 36.399999999999999p -3.60489866e-08 36.5p -3.0175431999999996e-08 36.600000000000001p -2.2048440999999998e-08 36.700000000000003p -1.2381780000000001e-08 36.799999999999997p -2.0010699999999983e-09 36.900000000000006p 8.2265739999999997e-09 37p 1.7464681999999999e-08 37.100000000000001p 2.4975689999999999e-08 37.199999999999996p 3.0179539999999995e-08 37.300000000000004p 3.2698101999999999e-08 37.399999999999999p 3.2382116999999999e-08 37.5p 2.931869674e-08 37.600000000000001p 2.3819184000000002e-08 37.700000000000003p 1.6388903000000001e-08 37.800000000000004p 7.6814999999999983e-09 37.899999999999999p -1.5579500000000004e-09 38p -1.0556113e-08 38.100000000000001p -1.8575718e-08 38.200000000000003p -2.4975390000000002e-08 38.299999999999997p -2.9260499999999999e-08 38.399999999999999p -3.1120767e-08 38.5p -3.0452002000000001e-08 38.600000000000001p -2.73603635e-08 38.700000000000003p -2.2149222e-08 38.799999999999997p -1.5290148000000001e-08 38.900000000000006p -7.3805400000000007e-09 39p 9.0809000000000115e-10 39.100000000000001p 8.8870169999999992e-09 39.199999999999996p 1.5907209000000002e-08 39.300000000000004p 2.141204e-08 39.399999999999999p 2.4981116999999998e-08 39.5p 2.6362013999999999e-08 39.599999999999994p 2.5487633000000002e-08 39.700000000000003p 2.2477828500000001e-08 39.800000000000004p 1.7625659000000002e-08 39.899999999999999p 1.1369706000000001e-08 40p 4.2549310000000002e-09 40.100000000000001p -3.1143489999999994e-09 40.200000000000003p -1.0125426e-08 40.299999999999997p -1.6207802999999999e-08 40.399999999999999p -2.0879220999999999e-08 40.5p -2.3783547999999998e-08 40.600000000000001p -2.471744e-08 40.699999999999996p -2.3643892000000002e-08 40.799999999999997p -2.0691845000000001e-08 40.900000000000006p -1.6142135e-08 41p -1.0401204999999999e-08 41.100000000000001p -3.965088000000001e-09 41.199999999999996p 2.6232860000000007e-09 41.300000000000004p 8.8196830000000004e-09 41.399999999999999p 1.4123435e-08 41.5p 1.8117640000000002e-08 41.599999999999994p 2.0501781e-08 41.700000000000003p 2.1113983000000001e-08 41.799999999999997p 1.9941486999999999e-08 41.899999999999999p 1.7118542999999999e-08 42p 1.2912360000000002e-08 42.100000000000001p 7.6983220000000006e-09 42.200000000000003p 1.9268859999999997e-09 42.299999999999997p -3.9150560000000011e-09 42.399999999999999p -9.3449706000000009e-09 42.5p -1.3924285000000001e-08 42.600000000000001p -1.7293548000000001e-08 42.699999999999996p -1.9200338000000002e-08 42.799999999999997p -1.9517812000000003e-08 42.899999999999999p -1.8252479699999999e-08 43p -1.5540933999999999e-08 43.100000000000001p -1.1635848e-08 43.199999999999996p -6.8828019999999992e-09 43.300000000000004p -1.6899069999999999e-09 43.399999999999999p 3.5070800000000003e-09 43.5p 8.2811792000000007e-09 43.599999999999994p 1.2249121e-08 43.700000000000003p 1.5101969999999999e-08 43.799999999999997p 1.6628981e-08 43.899999999999999p 1.6732862000000001e-08 44p 1.5435463000000001e-08 44.100000000000001p 1.2873421999999999e-08 44.200000000000003p 9.2845390000000004e-09 44.299999999999997p 4.9861209999999996e-09 44.400000000000006p 3.4718699999999979e-10 44.5p -4.2429800000000006e-09 44.600000000000001p -8.4072700000000005e-09 44.699999999999996p -1.1811531e-08 44.800000000000004p -1.4191167999999998e-08 44.899999999999999p -1.5371458e-08 45p -1.5280033999999999e-08 45.100000000000001p -1.3950732600000001e-08 45.200000000000003p -1.1518553e-08 45.300000000000004p -8.2064500000000003e-09 45.399999999999999p -4.3051530000000003e-09 45.5p -1.4780499999999978e-10 45.600000000000001p 3.9183310000000004e-09 45.700000000000003p 7.5607469999999994e-09 45.799999999999997p 1.0488751000000001e-08 45.899999999999999p 1.2476519999999999e-08 46p 1.3380342000000001e-08 46.100000000000001p 1.3148699999999999e-08 46.200000000000003p 1.18246471e-08 46.299999999999997p 9.5402459999999987e-09 46.400000000000006p 6.5038550000000008e-09 46.5p 2.981399000000001e-09 46.600000000000001p -7.2671900000000025e-10 46.699999999999996p -4.3110600000000006e-09 46.800000000000004p -7.4788109999999996e-09 46.899999999999999p -9.9775359999999994e-09 47p -1.1615116999999999e-08 47.099999999999994p -1.2274310000000001e-08 47.200000000000003p -1.1920844e-08 47.300000000000004p -1.0604515000000001e-08 47.399999999999999p -8.4533499999999987e-09 47.5p -5.6614339999999996e-09 47.600000000000001p -2.4715879999999999e-09 47.700000000000003p 8.4564300000000012e-10 47.799999999999997p 4.014824e-09 47.899999999999999p 6.7783929999999999e-09 48p 8.9174910000000007e-09 48.100000000000001p 1.0269166000000001e-08 48.199999999999996p 1.0738627e-08 48.299999999999997p 1.0305625000000001e-08 48.400000000000006p 9.0245822000000006e-09 48.5p 7.0185629999999995e-09 48.600000000000001p 4.4677289999999995e-09 48.699999999999996p 1.5933319999999997e-09 48.800000000000004p -1.3613370000000001e-09 48.899999999999999p -4.1514239999999997e-09 49p -6.5506810000000003e-09 49.099999999999994p -8.3696950000000002e-09 49.200000000000003p -9.4707050000000012e-09 49.299999999999997p -9.77786e-09 49.399999999999999p -9.2821747999999995e-09 49.5p -8.0408806000000007e-09 49.600000000000001p -6.1713420000000001e-09 49.700000000000003p -3.8401549999999998e-09 49.799999999999997p -1.2484219999999999e-09 49.899999999999999p 1.3855069999999996e-09 50p 3.8443503000000004e-09 50.100000000000001p -5.6630849999999998e-06 50.199999999999996p -1.0960864e-05 50.299999999999997p -1.5755084000000001e-05 50.399999999999999p -1.9933583000000002e-05 50.5p -2.3419452e-05 50.600000000000001p -2.6182544000000003e-05 50.699999999999996p -2.8245783e-05 50.800000000000004p -2.9685274999999997e-05 50.899999999999999p -3.0624647999999996e-05 51p -3.1224506999999998e-05 51.100000000000001p -2.5999512e-05 51.200000000000003p -2.1180014999999998e-05 51.299999999999997p -1.7085389000000001e-05 51.399999999999999p -1.3992943e-05 51.5p -1.2114588000000001e-05 51.600000000000001p -1.1577498e-05 51.700000000000003p -1.2412267999999999e-05 51.799999999999997p -1.4549187000000001e-05 51.900000000000006p -1.7822274999999999e-05 52p -2.1980831999999999e-05 52.100000000000001p -2.6707766999999998e-05 52.199999999999996p -3.1643914000000002e-05 52.300000000000004p -3.6416399999999999e-05 52.399999999999999p -4.0668925000000001e-05 52.5p -4.4090944000000002e-05 52.600000000000001p -4.6442954000000003e-05 52.700000000000003p -4.7575596999999997e-05 52.800000000000004p -4.7440654999999998e-05 52.899999999999999p -4.609328831e-05 53p -4.3685296999999998e-05 53.100000000000001p -4.0450339999999997e-05 53.200000000000003p -3.6682623000000003e-05 53.299999999999997p -3.2711240999999998e-05 53.399999999999999p -2.8872957000000002e-05 53.5p -2.5485834000000002e-05 53.600000000000001p -2.2826248e-05 53.700000000000003p -2.1110488000000001e-05 53.799999999999997p -2.0481995000000001e-05 53.900000000000006p -2.1004241e-05 54p -2.2659086699999998e-05 54.100000000000001p -2.5350319999999998e-05 54.199999999999996p -2.8911972999999996e-05 54.300000000000004p -3.3121028e-05 54.399999999999999p -3.7713626000000002e-05 54.5p -4.2403616999999995e-05 54.599999999999994p -4.6901608999999996e-05 54.700000000000003p -5.0932744000000001e-05 54.800000000000004p -5.4251976999999999e-05 54.899999999999999p -5.6657166000000004e-05 55p -5.8001473999999999e-05 55.100000000000001p -5.8206564999999997e-05 55.200000000000003p -5.7275363100000001e-05 55.299999999999997p -5.5300399000000001e-05 55.399999999999999p -5.2462671999999998e-05 55.5p -4.9018516000000002e-05 55.600000000000001p -4.5275981e-05 55.699999999999996p -4.1565057999999998e-05 55.799999999999997p -3.8207102000000001e-05 55.899999999999999p -3.5487588999999999e-05 56p -3.3634801000000001e-05 56.100000000000001p -3.2805145999999994e-05 56.199999999999996p -3.3074815000000005e-05 56.300000000000004p -3.4437098499999995e-05 56.399999999999999p -3.6804573000000003e-05 56.5p -4.0015852999999996e-05 56.599999999999994p -4.3846698999999999e-05 56.700000000000003p -4.8025385999999998e-05 56.799999999999997p -5.2251916000000004e-05 56.899999999999999p -5.6220154999999998e-05 57p -5.9641400999999997e-05 57.100000000000001p -6.2267227000000006e-05 57.200000000000003p -6.3909538000000006e-05 57.299999999999997p -6.4455584000000003e-05 57.399999999999999p -6.3876609999999998e-05 57.5p -6.2229116199999997e-05 57.600000000000001p -5.9648882000000008e-05 57.699999999999996p -5.6338325000000004e-05 57.799999999999997p -5.2548922000000001e-05 57.899999999999999p -4.8560287999999997e-05 58p -4.4658347000000001e-05 58.100000000000001p -4.1114305000000001e-05 58.199999999999996p -3.8166144999999997e-05 58.299999999999997p -3.6003539000000002e-05 58.399999999999999p -3.4756894000000003e-05 58.500000000000007p -3.4490338000000001e-05 58.599999999999994p -3.5198944e-05 58.700000000000003p -3.6809835299999998e-05 58.800000000000004p -3.9187282000000001e-05 58.899999999999999p -4.2141849000000004e-05 59p -4.5443329999999994e-05 59.099999999999994p -4.8837075000000005e-05 59.200000000000003p -5.2062930000000001e-05 59.300000000000004p -5.4875110999999996e-05 59.399999999999999p -5.7061597999999997e-05 59.5p -5.8460959999999999e-05 59.600000000000009p -5.8974979999999996e-05 59.699999999999996p -5.8575955e-05 59.800000000000004p -5.7307769700000004e-05 59.899999999999991p -5.5280863e-05 60p -5.2661727999999994e-05 60.100000000000001p -4.3989034000000002e-05 60.199999999999996p -3.5534330000000005e-05 60.300000000000004p -2.767313e-05 60.400000000000006p -2.0750450000000001e-05 60.5p -1.505296e-05 60.600000000000001p -1.0783934999999999e-05 60.699999999999996p -8.0446209999999983e-06 60.799999999999997p -6.8231470000000002e-06 60.900000000000006p -6.9915010000000001e-06 60.999999999999993p -8.3114763999999991e-06 61.100000000000001p -1.6119213999999998e-05 61.200000000000003p -2.3973289e-05 61.299999999999997p -3.1300000000000002e-05 61.400000000000006p -3.7549699999999997e-05 61.499999999999993p -4.2248045999999999e-05 61.600000000000001p -4.5041664000000001e-05 61.700000000000003p -4.5731070000000005e-05 61.799999999999997p -4.4288317000000001e-05 61.899999999999999p -4.0858887000000001e-05 62.000000000000007p -3.5748147999999995e-05 62.099999999999994p -2.9393888000000004e-05 62.200000000000003p -2.2327211000000002e-05 62.299999999999997p -1.5125769999999998e-05 62.399999999999999p -8.3643099999999995e-06 62.500000000000007p -2.567750000000001e-06 62.599999999999994p 1.8287559999999998e-06 62.700000000000003p 4.5100489999999999e-06 62.800000000000004p 5.3007023000000002e-06 62.899999999999999p 4.1742160000000002e-06 63p 1.2523150000000001e-06 63.099999999999994p -3.2054426999999997e-06 63.199999999999996p -8.8217200000000003e-06 63.300000000000004p -1.5130808999999999e-05 63.399999999999999p -2.1616062999999997e-05 63.5p -2.7752632999999999e-05 63.600000000000009p -3.3051388999999997e-05 63.699999999999996p -3.7099679999999998e-05 63.800000000000004p -3.9594719000000001e-05 63.899999999999991p -4.0366864999999999e-05 64p -3.9391063000000002e-05 64.100000000000009p -3.6785958999999998e-05 64.199999999999989p -3.2801076999999997e-05 64.299999999999997p -2.7792961999999999e-05 64.400000000000006p -2.2192720999999999e-05 64.5p -1.6467770999999999e-05 64.600000000000009p -1.1081951000000001e-05 64.699999999999989p -6.457861999999999e-06 64.799999999999997p -2.9449439999999999e-06 64.900000000000006p -7.9533700000000021e-07 65p -1.4836399999999999e-07 65.099999999999994p -1.023707e-06 65.200000000000003p -3.3227369999999999e-06 65.299999999999997p -6.837648e-06 65.400000000000006p -1.1268094e-05 65.5p -1.6244796999999999e-05 65.599999999999994p -2.1359037000000001e-05 65.700000000000003p -2.6195985e-05 65.799999999999997p -3.0368950999999999e-05 65.900000000000006p -3.3551357999999997e-05 66p -3.5503144999999999e-05 66.099999999999994p -3.6089483000000001e-05 66.200000000000003p -3.5290048000000001e-05 66.300000000000011p -3.31985759e-05 66.399999999999991p -3.0012858999999996e-05 66.5p -2.6016130000000002e-05 66.599999999999994p -2.1551643999999999e-05 66.700000000000003p -1.6992718999999999e-05 66.800000000000011p -1.2711116999999999e-05 66.899999999999991p -9.0467240000000016e-06 67p -6.2810890000000006e-06 67.100000000000009p -4.6169069999999989e-06 67.200000000000003p -4.1644649999999998e-06 67.299999999999997p -4.9355277999999996e-06 67.399999999999991p -6.8446577000000002e-06 67.5p -9.7175779999999997e-06 67.600000000000009p -1.3306022e-05 67.700000000000003p -1.7308182999999998e-05 67.799999999999997p -2.1393417000000001e-05 67.900000000000006p -2.5229376e-05 68p -2.8509242999999999e-05 68.100000000000009p -3.0976760000000002e-05 68.199999999999989p -3.2446707000000001e-05 68.299999999999997p -3.2819086999999997e-05 68.400000000000006p -3.2085869500000004e-05 68.5p -3.0329896800000001e-05 68.599999999999994p -2.7716070999999998e-05 68.700000000000003p -2.4475929e-05 68.799999999999997p -2.0886798999999999e-05 68.900000000000006p -1.7247860000000002e-05 69p -1.3854974000000001e-05 69.099999999999994p -1.0976822999999999e-05 69.200000000000003p -8.8341349999999997e-06 69.299999999999997p -7.5834520000000007e-06 69.400000000000006p -7.3065810000000002e-06 69.5p -8.0059543999999998e-06 69.599999999999994p -9.6061132999999998e-06 69.700000000000003p -1.1961041999999999e-05 69.799999999999997p -1.4866808e-05 69.900000000000006p -1.8078656999999999e-05 70p -2.1331251999999999e-05 70.099999999999994p -1.2432891e-05 70.200000000000003p -3.6079259999999992e-06 70.300000000000011p 5.212038e-06 70.399999999999991p 1.4064574799999999e-05 70.5p 2.2955234999999999e-05 70.599999999999994p 3.1866490000000003e-05 70.700000000000003p 4.076761e-05 70.799999999999997p 4.9622709999999996e-05 70.899999999999991p 5.839618e-05 71p 6.7055339999999998e-05 71.100000000000009p 6.3642838999999993e-05 71.200000000000003p 6.0596817800000002e-05 71.299999999999997p 5.8021910000000002e-05 71.399999999999991p 5.5998309e-05 71.5p 5.4575903000000002e-05 71.600000000000009p 5.3766163999999995e-05 71.699999999999989p 5.3539824000000004e-05 71.799999999999997p 5.3830652199999998e-05 71.900000000000006p 5.45436284e-05 72p 5.5565086999999999e-05 72.100000000000009p 5.6773030000000002e-05 72.199999999999989p 5.8046486999999998e-05 72.299999999999997p 5.9273320000000002e-05 72.400000000000006p 6.0356421000000001e-05 72.5p 6.1218480999999998e-05 72.599999999999994p 6.1805334000000002e-05 72.700000000000003p 6.2088348100000003e-05 72.799999999999997p 6.2065588200000001e-05 72.900000000000006p 6.1761870539999998e-05 73p 6.1227308099999996e-05 73.099999999999994p 6.05341151e-05 73.200000000000003p 5.9771329099999999e-05 73.299999999999997p 5.9037554e-05 73.400000000000006p 5.8431894000000002e-05 73.5p 5.8044097199999997e-05 73.599999999999994p 5.7944929199999997e-05 73.700000000000003p 5.81781543e-05 73.800000000000011p 5.8755293500000002e-05 73.899999999999991p 5.9653947000000003e-05 74p 6.0819782999999997e-05 74.099999999999994p 6.2171955000000004e-05 74.200000000000003p 6.3610970999999992e-05 74.300000000000011p 6.5028122999999998e-05 74.399999999999991p 6.6315405999999995e-05 74.5p 6.7374862000000007e-05 74.600000000000009p 6.8126621999999999e-05 74.700000000000003p 6.8514862999999996e-05 74.799999999999997p 6.8511270700000008e-05 74.899999999999991p 6.811563583e-05 75p 6.7353954e-05 75.100000000000009p 6.6274195000000003e-05 75.200000000000003p 6.4940782000000004e-05 75.299999999999997p 6.3428381999999995e-05 75.400000000000006p 6.1816130999999997e-05 75.5p 6.0182602999999997e-05 75.600000000000009p 5.8602144e-05 75.699999999999989p 5.7142405999999993e-05 75.799999999999997p 5.5862981000000005e-05 75.900000000000006p 5.4814738999999995e-05 76p 5.4039572e-05 76.099999999999994p 5.3570184e-05 76.200000000000003p 5.3429677499999996e-05 76.299999999999997p 5.3630816600000002e-05 76.400000000000006p 5.4174874600000001e-05 76.5p 5.50502751e-05 76.599999999999994p 5.6231089000000001e-05 76.700000000000003p 5.7675819e-05 76.799999999999997p 5.9326865999999996e-05 76.900000000000006p 6.1111106000000002e-05 77p 6.2942134999999997e-05 77.099999999999994p 6.4724332999999997e-05 77.200000000000003p 6.6358835000000001e-05 77.299999999999997p 6.7750922999999992e-05 77.400000000000006p 6.8818201000000001e-05 77.5p 6.9498338999999992e-05 77.599999999999994p 6.9755449000000007e-05 77.700000000000003p 6.9584226499999993e-05 77.800000000000011p 6.901101140000001e-05 77.899999999999991p 6.8091901499999998e-05 78p 6.6907863999999992e-05 78.099999999999994p 6.5557582999999997e-05 78.200000000000003p 6.4148528999999997e-05 78.299999999999997p 6.2787414999999989e-05 78.399999999999991p 6.1570782000000001e-05 78.5p 6.0576788999999996e-05 78.600000000000009p 5.9858987999999998e-05 78.700000000000003p 5.9442884999999999e-05 78.799999999999997p 5.9325349599999996e-05 78.899999999999991p 5.9477044599999997e-05 79p 5.9847276899999998e-05 79.100000000000009p 6.0370472100000002e-05 79.199999999999989p 6.0973499600000002e-05 79.299999999999997p 6.1582866900000008e-05 79.400000000000006p 6.2131035700000009e-05 79.5p 6.2561541200000003e-05 79.600000000000009p 6.2832624500000009e-05 79.699999999999989p 6.2919341800000004e-05 79.799999999999997p 6.2814370700000005e-05 79.900000000000006p 6.2527758999999996e-05 80p 6.2085618400000003e-05 80.099999999999994p 4.9600418000000003e-05 80.200000000000003p 3.7594530000000003e-05 80.299999999999997p 2.627076e-05 80.400000000000006p 1.5816569999999998e-05 80.5p 6.3867799999999999e-06 80.599999999999994p -1.9223100000000009e-06 80.700000000000003p -9.0968539999999984e-06 80.799999999999997p -1.5221139000000001e-05 80.900000000000006p -2.0480427999999998e-05 81p -2.5147049000000002e-05 81.099999999999994p -1.76218049e-05 81.200000000000003p -1.0711820999999999e-05 81.300000000000011p -4.8582500000000005e-06 81.399999999999991p -4.1041199999999982e-07 81.5p 2.4004590000000005e-06 81.599999999999994p 3.4746129999999999e-06 81.700000000000003p 2.8400395000000001e-06 81.800000000000011p 6.3637080000000002e-07 81.899999999999991p -2.9069020000000001e-06 82p -7.492561e-06 82.100000000000009p -1.2775316e-05 82.200000000000003p -1.8378784000000001e-05 82.299999999999997p -2.3911797999999998e-05 82.399999999999991p -2.8986987999999999e-05 82.5p -3.3243992e-05 82.600000000000009p -3.6376915000000002e-05 82.700000000000003p -3.8162511999999999e-05 82.799999999999997p -3.8483023e-05 82.900000000000006p -3.7337807000000006e-05 83p -3.4840650999999999e-05 83.100000000000009p -3.1203758999999995e-05 83.199999999999989p -2.6713060000000001e-05 83.299999999999997p -2.1700823000000004e-05 83.400000000000006p -1.6520343999999999e-05 83.5p -1.1525165999999998e-05 83.599999999999994p -7.0525339999999986e-06 83.700000000000003p -3.409275999999999e-06 83.799999999999997p -8.5765400000000028e-07 83.900000000000006p 4.0036299999999963e-07 84p 2.4085399999999968e-07 84.099999999999994p -1.36403152e-06 84.200000000000003p -4.3313179999999996e-06 84.299999999999997p -8.4608780000000004e-06 84.400000000000006p -1.3442648e-05 84.5p -1.8880130000000001e-05 84.599999999999994p -2.4328388e-05 84.700000000000003p -2.9340084999999999e-05 84.799999999999997p -3.3510704000000002e-05 84.900000000000006p -3.6515340999999998e-05 85p -3.8133103000000004e-05 85.099999999999994p -3.8259278999999997e-05 85.200000000000003p -3.6907727999999996e-05 85.300000000000011p -3.4206311999999998e-05 85.399999999999991p -3.0387026999999999e-05 85.5p -2.5770235000000002e-05 85.599999999999994p -2.0741795000000002e-05 85.700000000000003p -1.5721974000000002e-05 85.799999999999997p -1.1127477e-05 85.899999999999991p -7.3308490000000009e-06 86p -4.6235599999999998e-06 86.100000000000009p -3.1890750000000005e-06 86.200000000000003p -3.0899720000000006e-06 86.299999999999997p -4.2700231000000001e-06 86.399999999999991p -6.569081e-06 86.5p -9.7466420000000007e-06 86.600000000000009p -1.3509462999999999e-05 86.699999999999989p -1.7539211999999999e-05 86.799999999999997p -2.1517512000000001e-05 86.900000000000006p -2.5147379999999998e-05 87p -2.8170995000000001e-05 87.100000000000009p -3.0384555000000001e-05 87.199999999999989p -3.1650235e-05 87.299999999999997p -3.1904883e-05 87.400000000000006p -3.1164048799999999e-05 87.5p -2.9519698800000002e-05 87.599999999999994p -2.7130891999999999e-05 87.700000000000003p -2.420796e-05 87.799999999999997p -2.0992150000000002e-05 87.900000000000006p -1.7734036999999998e-05 88p -1.4673653999999999e-05 88.099999999999994p -1.2024393e-05 88.200000000000003p -9.9615480000000007e-06 88.299999999999997p -8.6148949999999991e-06 88.400000000000006p -8.0644190000000006e-06 88.5p -8.3377669999999998e-06 88.599999999999994p -9.4090848000000002e-06 88.700000000000003p -1.1199035e-05 88.800000000000011p -1.3576962e-05 88.899999999999991p -1.6366394e-05 89p -1.9355107e-05 89.099999999999994p -2.2310098e-05 89.200000000000003p -2.4996594000000001e-05 89.300000000000011p -2.7198910000000002e-05 89.399999999999991p -2.8740182e-05 89.5p -2.9498191e-05 89.600000000000009p -2.9415479000000002e-05 89.700000000000003p -2.8503135090000002e-05 89.799999999999997p -2.6838685999999999e-05 89.899999999999991p -2.455919e-05 90p -2.1850418999999999e-05 90.100000000000009p -1.3264034000000002e-05 90.200000000000003p -5.0788900000000008e-06 90.299999999999997p 2.32906e-06 90.400000000000006p 8.6250209999999987e-06 90.5p 1.3549008e-05 90.600000000000009p 1.6946508999999999e-05 90.699999999999989p 1.8788987e-05 90.799999999999997p 1.9180424999999999e-05 90.900000000000006p 1.8347929e-05 91p 1.6617723899999999e-05 91.099999999999994p 8.711676000000001e-06 91.200000000000003p 1.0856070000000011e-06 91.299999999999997p -5.717941999999999e-06 91.400000000000006p -1.1216066e-05 91.5p -1.5018504e-05 91.599999999999994p -1.6852944999999999e-05 91.700000000000003p -1.6581750000000001e-05 91.799999999999997p -1.421144687e-05 91.900000000000006p -9.8954759999999997e-06 92p -3.9289610000000008e-06 92.099999999999994p 3.2671280000000004e-06 92.200000000000003p 1.1174967900000001e-05 92.299999999999997p 1.9222172e-05 92.400000000000006p 2.6833320000000001e-05 92.5p 3.3483659999999996e-05 92.599999999999994p 3.8746080000000004e-05 92.700000000000003p 4.2324675999999999e-05 92.800000000000011p 4.4070998999999996e-05 92.899999999999991p 4.3983342000000004e-05 93p 4.2191586799999999e-05 93.099999999999994p 3.8933525000000004e-05 93.200000000000003p 3.4529467999999994e-05 93.299999999999997p 2.9360862999999997e-05 93.399999999999991p 2.3853392000000003e-05 93.5p 1.8459146e-05 93.600000000000009p 1.3631892000000002e-05 93.700000000000003p 9.7940999999999983e-06 93.799999999999997p 7.3003950000000009e-06 93.899999999999991p 6.4044909999999998e-06 94p 7.2353270000000005e-06 94.100000000000009p 9.785692e-06 94.199999999999989p 1.3913600999999999e-05 94.299999999999997p 1.9355700000000002e-05 94.400000000000006p 2.5750765999999998e-05 94.5p 3.2670959000000001e-05 94.600000000000009p 3.9657679999999997e-05 94.700000000000003p 4.6258590000000004e-05 94.799999999999997p 5.2062479999999997e-05 94.900000000000006p 5.6728992999999999e-05 95p 6.0010781999999995e-05 95.099999999999994p 6.1766707999999994e-05 95.200000000000003p 6.1965305000000008e-05 95.299999999999997p 6.06797298e-05 95.400000000000006p 5.8076848000000004e-05 95.5p 5.4402728000000003e-05 95.599999999999994p 4.9965958000000001e-05 95.700000000000003p 4.5117762e-05 95.799999999999997p 4.0228551999999998e-05 95.900000000000006p 3.5662026000000003e-05 96p 3.1749802000000004e-05 96.099999999999994p 2.8769781000000002e-05 96.200000000000003p 2.6930259e-05 96.300000000000011p 2.6360177999999999e-05 96.399999999999991p 2.7104959e-05 96.5p 2.9126668700000001e-05 96.599999999999994p 3.2307458e-05 96.700000000000003p 3.6456082999999998e-05 96.800000000000011p 4.1317198000000006e-05 96.899999999999991p 4.6584252000000003e-05 97p 5.1916283000000003e-05 97.100000000000009p 5.6958839000000001e-05 97.200000000000003p 6.1368461e-05 97.299999999999997p 6.4838808000000002e-05 97.399999999999991p 6.7125944999999997e-05 97.5p 6.8069329999999998e-05 97.600000000000009p 6.7605800000000002e-05 97.700000000000003p 6.5774612699999999e-05 97.799999999999997p 6.2713082000000005e-05 97.900000000000006p 5.8643866000000003e-05 98p 5.3855946e-05 98.100000000000009p 4.8681691000000001e-05 98.199999999999989p 4.3472690000000001e-05 98.299999999999997p 3.8576177000000002e-05 98.400000000000006p 3.4313615000000004e-05 98.5p 3.0962071e-05 98.599999999999994p 2.8738755000000004e-05 98.700000000000003p 2.7788801000000003e-05 98.799999999999997p 2.8176034000000002e-05 98.900000000000006p 2.9877134000000002e-05 99p 3.2779639e-05 99.099999999999994p 3.6684904000000003e-05 99.200000000000003p 4.1317247e-05 99.299999999999997p 4.6340290999999996e-05 99.400000000000006p 5.1380496999999999e-05 99.5p 5.6056361000000001e-05 99.599999999999994p 6.0010458000000003e-05 99.700000000000003p 6.2940543999999999e-05 99.799999999999997p 6.4625844000000001e-05 99.900000000000006p 6.4945900000000004e-05 100p 6.3889994199999993e-05 100.09999999999999p 5.5887767999999996e-05 100.2p 4.7177203000000001e-05 100.30000000000001p 3.8175550000000004e-05 100.39999999999999p 2.9338010000000003e-05 100.5p 2.1117469999999997e-05 100.59999999999999p 1.3923879999999999e-05 100.7p 8.0887799999999998e-06 100.8p 3.837751e-06 100.89999999999999p 1.2715280000000004e-06 101p 3.5670699999999946e-07 101.10000000000001p 6.5958819999999997e-06 101.2p 1.3662206999999999e-05 101.3p 2.1034487000000001e-05 101.39999999999999p 2.8148210000000003e-05 101.5p 3.4447779999999998e-05 101.60000000000001p 3.9439284999999999e-05 101.69999999999999p 4.2735703999999996e-05 101.8p 4.4090654000000002e-05 101.90000000000001p 4.3418619999999999e-05 102p 4.08010636e-05 102.10000000000001p 3.6478294000000003e-05 102.2p 3.0827599e-05 102.3p 2.4329087999999998e-05 102.40000000000001p 1.7522481999999998e-05 102.5p 1.0959350000000002e-05 102.59999999999999p 5.1562799999999987e-06 102.7p 5.539610000000001e-07 102.8p -2.5144050000000004e-06 102.90000000000001p -3.8440660000000005e-06 103p -3.3689628e-06 103.09999999999999p -1.1622411000000001e-06 103.2p 2.5721147999999998e-06 103.3p 7.5159140000000003e-06 103.40000000000001p 1.3261168e-05 103.5p 1.9341466000000001e-05 103.59999999999999p 2.5268670999999998e-05 103.7p 3.0572318000000001e-05 103.80000000000001p 3.4838147000000003e-05 103.89999999999999p 3.7742171e-05 104p 3.9076823000000001e-05 104.09999999999999p 3.8766687e-05 104.2p 3.6872551199999999e-05 104.30000000000001p 3.3583317000000001e-05 104.39999999999999p 2.9196940999999997e-05 104.5p 2.4092298000000001e-05 104.60000000000001p 1.8695178000000003e-05 104.7p 1.3442003999999999e-05 104.8p 8.744803999999999e-06 104.89999999999999p 4.9604899999999995e-06 105p 2.3660919999999999e-06 105.10000000000001p 1.141093e-06 105.2p 1.3567820000000002e-06 105.3p 2.9727878299999998e-06 105.40000000000001p 5.8407879999999997e-06 105.5p 9.7156480000000003e-06 105.60000000000001p 1.4274118e-05 105.69999999999999p 1.9140486999999999e-05 105.8p 2.3917588999999999e-05 105.90000000000001p 2.8220258e-05 106p 3.1707849000000002e-05 106.09999999999999p 3.4112381000000004e-05 106.2p 3.5259614999999998e-05 106.3p 3.5081535999999998e-05 106.40000000000001p 3.3619715200000004e-05 106.5p 3.1019702000000003e-05 106.59999999999999p 2.7517151000000001e-05 106.7p 2.3416788999999999e-05 106.8p 1.9065895999999999e-05 106.90000000000001p 1.4824457999999999e-05 107p 1.1034839e-05 107.09999999999999p 7.9937919999999994e-06 107.2p 5.9293720000000004e-06 107.3p 4.9845679999999996e-06 107.40000000000001p 5.2086200000000001e-06 107.5p 6.5560518000000003e-06 107.59999999999999p 8.8930490000000001e-06 107.7p 1.2010273e-05 107.80000000000001p 1.5640991e-05 107.89999999999999p 1.9483209000000001e-05 108p 2.3224103000000002e-05 108.09999999999999p 2.6565128000000001e-05 108.2p 2.9245684e-05 108.3p 3.1063529000000004e-05 108.39999999999999p 3.1890315000000003e-05 108.5p 3.1680799999999997e-05 108.60000000000001p 3.0475021699999997e-05 108.7p 2.8393174e-05 108.8p 2.5623868000000003e-05 108.89999999999999p 2.2406744e-05 109p 1.9011408999999997e-05 109.10000000000001p 1.5714574000000003e-05 109.19999999999999p 1.2777751000000001e-05 109.3p 1.0427033000000001e-05 109.40000000000001p 8.8367090000000009e-06 109.5p 8.1173290000000004e-06 109.60000000000001p 8.3088650000000003e-06 109.7p 9.3791367000000011e-06 109.8p 1.1227356999999999e-05 109.90000000000001p 1.3692703e-05 110p 1.6567411e-05 110.09999999999999p 1.6567411e-05 110.2p 1.6567411e-05 110.3p 1.6567411e-05 110.40000000000001p 3.1684940000000002e-05 110.5p 4.617417e-05 110.59999999999999p 5.9712080000000006e-05 110.7p 7.2018020000000002e-05 110.8p 8.2877949999999998e-05 110.90000000000001p 9.2174250000000006e-05 111p 9.990457000000001e-05 111.09999999999999p 0.00010618481 111.2p 0.00011123656 111.30000000000001p 0.00011536045799999999 111.39999999999999p 0.00010682814400000001 111.5p 9.8607741000000007e-05 111.59999999999999p 9.1095142999999992e-05 111.7p 8.4610289999999998e-05 111.8p 7.9372321000000003e-05 111.89999999999999p 7.5476266000000001e-05 112p 7.2883737999999992e-05 112.10000000000001p 7.1429391999999989e-05 112.2p 7.0840220000000008e-05 112.3p 7.0763768000000008e-05 112.39999999999999p 7.0800941300000009e-05 112.5p 7.0539380599999999e-05 112.60000000000001p 6.9583551299999996e-05 112.7p 6.7579688e-05 112.8p 6.423563100000001e-05 112.90000000000001p 5.9338329000000007e-05 113p 5.2773382999999999e-05 113.10000000000001p 4.4551069999999999e-05 113.19999999999999p 3.4839689999999997e-05 113.3p 2.3998799999999998e-05 113.40000000000001p 1.2595069999999999e-05 113.5p 1.3790499999999983e-06 113.59999999999999p -8.7869599999999979e-06 113.7p -1.7035422e-05 113.8p -2.2601553000000002e-05 113.90000000000001p -2.4900227000000003e-05 114p -2.3556488000000001e-05 114.09999999999999p -1.8393884e-05 114.2p -9.3974300000000013e-06 114.3p 3.3275899999999994e-06 114.40000000000001p 1.95779966e-05 114.5p 3.9033060000000001e-05 114.59999999999999p 6.1175150000000007e-05 114.7p 8.5164139999999996e-05 114.8p 0.00010974311999999999 114.90000000000001p 0.00013329564999999999 115p 0.00015409833000000001 115.09999999999999p 0.00017065738999999999 115.2p 0.00018195918 115.30000000000001p 0.00018754654000000001 115.39999999999999p 0.00018744400000000002 115.5p 0.00018200460199999999 115.59999999999999p 0.00017174446200000001 115.7p 0.00015720729999999999 115.8p 0.0001388796 115.89999999999999p 0.00011716992 116p 9.2461219999999996e-05 116.10000000000001p 6.5238879999999995e-05 116.2p 3.626618e-05 116.3p 6.7300799999999971e-06 116.39999999999999p -2.1759610000000002e-05 116.50000000000001p -4.7366822999999998e-05 116.59999999999999p -6.8341909999999998e-05 116.69999999999999p -8.3306489999999999e-05 116.8p -9.141691999999999e-05 116.90000000000001p -9.2397280000000009e-05 117.00000000000001p -8.6479984000000008e-05 117.09999999999999p -7.4298149e-05 117.19999999999999p -5.676225e-05 117.3p -3.4941419999999992e-05 117.40000000000001p -9.9601700000000046e-06 117.50000000000001p 1.7083869999999999e-05 117.60000000000001p 4.5172378000000001e-05 117.69999999999999p 7.3371659999999991e-05 117.8p 0.00010077508999999999 117.90000000000001p 0.00012639904999999998 118p 0.00014910851 118.10000000000001p 0.00016767111000000001 118.19999999999999p 0.00018096225000000001 118.3p 0.00018822038000000001 118.40000000000001p 0.00018921121 118.5p 0.000184226876 118.60000000000001p 0.00017394127500000001 118.69999999999999p 0.00015919710999999999 118.8p 0.00014081308 118.89999999999999p 0.00011946677 119p 9.5679180000000002e-05 119.10000000000001p 6.9898700000000009e-05 119.20000000000002p 4.2663389999999995e-05 119.3p 1.4792549999999994e-05 119.39999999999999p -1.2490450000000002e-05 119.5p -3.7606320999999997e-05 119.60000000000001p -5.8853549999999998e-05 119.70000000000002p -7.4718369999999997e-05 119.79999999999998p -8.4121660000000009e-05 119.89999999999999p -8.6532150000000001e-05 120p -8.1954496999999988e-05 120.10000000000001p -7.0837837000000003e-05 120.2p -5.3951160000000003e-05 120.29999999999998p -3.2259160000000002e-05 120.39999999999999p -1.8889600000000003e-05 120.5p -2.2908599999999993e-06 120.60000000000001p 1.6569119999999998e-05 120.7p 3.6705258999999997e-05 120.80000000000001p 5.7025969999999997e-05 120.89999999999999p 7.622176e-05 121p 9.2752190000000009e-05 121.09999999999999p 0.00010501092 121.2p 0.00011161193 121.30000000000001p 0.00011164815 121.39999999999999p 0.000116887561 121.5p 0.000114988416 121.59999999999999p 0.00010662040699999999 121.7p 9.2788439999999997e-05 121.80000000000001p 7.4691269999999999e-05 121.89999999999999p 5.3620219999999993e-05 121.99999999999999p 3.0899060000000001e-05 122.09999999999999p 7.8590399999999965e-06 122.2p -1.4176409999999999e-05 122.30000000000001p -3.3926992e-05 122.40000000000001p -5.0222699999999996e-05 122.49999999999999p -6.2087679999999997e-05 122.59999999999999p -6.8814910000000005e-05 122.7p -7.0015850000000005e-05 122.80000000000001p -6.5647465000000002e-05 122.90000000000001p -5.6026643999999997e-05 122.99999999999999p -4.1835960000000001e-05 123.09999999999999p -2.4109959999999998e-05 123.2p -4.1822199999999967e-06 123.3p 1.6418260000000002e-05 123.40000000000001p 3.6111373000000001e-05 123.49999999999999p 5.342164e-05 123.59999999999999p 6.7114130000000004e-05 123.7p 7.6291449999999996e-05 123.8p 8.0448210000000001e-05 123.90000000000001p 7.9489940999999991e-05 124.00000000000001p 7.3724100500000006e-05 124.09999999999999p 6.3826015000000003e-05 124.19999999999999p 5.0777289999999998e-05 124.3p 3.5774730000000004e-05 124.40000000000001p 2.0115580000000003e-05 124.50000000000001p 5.0749399999999972e-06 124.59999999999999p -8.2043399999999998e-06 124.69999999999999p -1.87941e-05 124.8p -2.6030752e-05 124.90000000000001p -2.953756e-05 125.00000000000001p -2.9227896999999997e-05 125.10000000000001p -2.5296953500000001e-05 125.19999999999999p -1.8203535999999998e-05 125.3p -8.6389699999999994e-06 125.40000000000001p 2.5223400000000007e-06 125.5p 1.4293125999999998e-05 125.60000000000001p 2.565974e-05 125.69999999999999p 3.5674019999999999e-05 125.8p 4.35368e-05 125.90000000000001p 4.8662199999999996e-05 126p 5.0718019999999999e-05 126.10000000000001p 4.9641834999999999e-05 126.19999999999999p 4.5635465400000004e-05 126.3p 3.9139568e-05 126.39999999999999p 3.0789612e-05 126.5p 2.1355080000000004e-05 126.60000000000001p 1.1666519999999999e-05 126.70000000000002p 2.5386700000000012e-06 126.8p -5.3002349999999996e-06 126.89999999999999p -1.1264426e-05 127p -1.49475e-05 127.10000000000001p -1.6140416999999999e-05 127.20000000000002p -1.4834110000000002e-05 127.29999999999998p -1.1210273000000001e-05 127.39999999999999p -5.6226939999999998e-06 127.5p 1.430549e-06 127.60000000000001p 9.3445949999999999e-06 127.7p 1.7454781000000002e-05 127.79999999999998p 2.5090829999999999e-05 127.89999999999999p 3.1633459999999999e-05 128p 3.6567060000000002e-05 128.09999999999999p 3.9522401000000002e-05 128.20000000000002p 4.0304659000000002e-05 128.30000000000001p 3.8904663000000006e-05 128.39999999999998p 3.5493218000000004e-05 128.5p 3.0400059999999998e-05 128.59999999999999p 2.4080234999999999e-05 128.70000000000002p 1.7071573e-05 128.80000000000001p 9.94773e-06 128.89999999999998p 3.2714800000000011e-06 129p -2.4476020000000006e-06 129.09999999999999p -6.788090999999999e-06 129.20000000000002p -9.4426930000000011e-06 129.30000000000001p -1.0235066999999999e-05 129.39999999999998p -9.1278999999999995e-06 129.5p -6.2228500000000001e-06 129.59999999999999p -1.7525869999999994e-06 129.69999999999999p 3.9352579999999995e-06 129.80000000000001p 1.0402435999999999e-05 129.90000000000001p 1.7152290000000001e-05 130p 2.3668160000000002e-05 130.09999999999999p 2.9454869999999999e-05 130.19999999999999p 3.4079206e-05 130.30000000000001p 3.7205171000000002e-05 130.40000000000001p 3.8620342999999998e-05 130.5p 3.8251206e-05 130.59999999999999p 3.6166331299999999e-05 130.69999999999999p 3.2567828999999996e-05 130.80000000000001p 2.7772112000000004e-05 130.90000000000001p 2.2182059e-05 131p 1.6253124999999997e-05 131.09999999999999p 1.0456354999999999e-05 131.19999999999999p 5.2414939999999991e-06 131.30000000000001p 1.0031170000000004e-06 131.40000000000001p -1.9480589999999995e-06 131.5p -3.4067610000000001e-06 131.59999999999999p -3.2866914999999999e-06 131.69999999999999p -1.6252403e-06 131.80000000000001p 1.4210298000000001e-06 131.90000000000001p 5.5901109999999993e-06 132p 1.0536817e-05 132.09999999999999p 1.5861879000000001e-05 132.19999999999999p 2.1145166999999998e-05 132.30000000000001p 2.5979763e-05 132.40000000000001p 3.0003664e-05 132.5p 3.2926609999999998e-05 132.60000000000002p 3.4550498000000002e-05 132.69999999999999p 3.4782386999999999e-05 132.79999999999998p 3.3639820200000001e-05 132.90000000000001p 3.1247780000000001e-05 133p 2.7827351999999999e-05 133.10000000000002p 2.3676152000000001e-05 133.19999999999999p 1.9142042999999998e-05 133.29999999999998p 1.4592701999999999e-05 133.40000000000001p 1.0384604e-05 133.5p 6.8347309999999998e-06 133.60000000000002p 4.1979640000000001e-06 133.69999999999999p 2.6513719999999998e-06 133.79999999999998p 2.2855139999999999e-06 133.90000000000001p 3.1021154000000003e-06 134p 5.0170840000000002e-06 134.09999999999999p 7.8681369999999996e-06 134.20000000000002p 1.1426653e-05 134.29999999999998p 1.5413616000000001e-05 134.40000000000001p 1.9519447e-05 134.5p 2.3427004000000002e-05 134.59999999999999p 2.6836311999999999e-05 134.70000000000002p 2.9488803999999999e-05 134.79999999999998p 3.1188644000000002e-05 134.90000000000001p 3.1818674999999999e-05 135p 3.1349354999999999e-05 135.09999999999999p 2.9839960499999997e-05 135.20000000000002p 2.7432160000000002e-05 135.29999999999998p 2.4336779999999999e-05 135.40000000000001p 2.0815414999999998e-05 135.5p 1.7158339000000001e-05 135.59999999999999p 1.3660835999999998e-05 135.70000000000002p 1.0599697000000001e-05 135.80000000000001p 8.2118029999999998e-06 135.89999999999998p 6.6762560000000004e-06 136p 6.1013499999999996e-06 136.09999999999999p 6.5172420000000008e-06 136.20000000000002p 7.8747085999999992e-06 136.30000000000001p 1.0050059999999999e-05 136.39999999999998p 1.2855887999999999e-05 136.5p 1.6056869000000001e-05 136.59999999999999p 1.938944e-05 136.70000000000002p 2.2583778999999998e-05 136.80000000000001p 2.5386097999999999e-05 136.89999999999998p 2.7579354999999999e-05 137p 2.9000514e-05 137.09999999999999p 2.9552967999999999e-05 137.19999999999999p 2.9213106000000003e-05 137.30000000000001p 2.80306316e-05 137.40000000000001p 2.6122882000000001e-05 137.5p 2.3663472999999997e-05 137.59999999999999p 2.0866598000000002e-05 137.69999999999999p 1.7968228000000002e-05 137.80000000000001p 1.5206148000000001e-05 137.90000000000001p 1.2800397999999998e-05 138p 1.0936042999999999e-05 138.09999999999999p 9.7495100000000011e-06 138.19999999999999p 9.3193830000000011e-06 138.30000000000001p 9.662196300000001e-06 138.40000000000001p 1.0733086499999999e-05 138.5p 1.2431083e-05 138.59999999999999p 1.4608317e-05 138.69999999999999p 1.7082535e-05 138.80000000000001p 1.9651777000000001e-05 138.90000000000001p 2.2110419e-05 139p 2.4265266e-05 139.09999999999999p 2.5950640000000001e-05 139.19999999999999p 2.7041208e-05 139.30000000000001p 2.7461523000000001e-05 139.40000000000001p 2.7191343399999999e-05 139.5p 2.6266356800000002e-05 139.59999999999999p 2.4774056e-05 139.69999999999999p 2.2845467999999999e-05 139.80000000000001p 2.0643441999999998e-05 139.90000000000001p 1.8348771e-05 140p 1.6145523999999999e-05 140.10000000000002p 1.4206668999999999e-05 140.19999999999999p 1.2681210000000001e-05 140.29999999999998p 1.1683428000000001e-05 140.40000000000001p 1.128488e-05 140.5p 1.1509462799999999e-05 140.60000000000002p 1.2331883799999999e-05 140.69999999999999p 1.3679725999999998e-05 140.79999999999998p 1.5439141000000001e-05 140.90000000000001p 1.7463927000000001e-05 141p 1.9587599999999999e-05 141.10000000000002p 2.1637210000000001e-05 141.19999999999999p 2.3448017999999999e-05 141.29999999999998p 2.487725e-05 141.40000000000001p 2.5815887000000002e-05 141.5p 2.6197235999999999e-05 141.59999999999999p 2.6001681700000001e-05 141.70000000000002p 2.52573048e-05 141.79999999999998p 2.4036496999999998e-05 141.90000000000001p 2.2448978999999997e-05 142p 2.0631944999999998e-05 142.09999999999999p 1.8738129000000002e-05 142.20000000000002p 1.6922971000000001e-05 142.29999999999998p 1.5331733999999997e-05 142.40000000000001p 1.4087976000000001e-05 142.5p 1.3283933000000002e-05 142.59999999999999p 1.2973985e-05 142.70000000000002p 1.3171212e-05 142.79999999999998p 1.3847535799999999e-05 142.90000000000001p 1.49371246e-05 143p 1.6342713000000001e-05 143.09999999999999p 1.7944241999999998e-05 143.20000000000002p 1.9609033999999998e-05 143.30000000000001p 2.1202774000000002e-05 143.39999999999998p 2.2600168e-05 143.5p 2.3694771999999999e-05 143.59999999999999p 2.440697e-05 143.70000000000002p 2.4689668000000001e-05 143.80000000000001p 2.4531234100000001e-05 143.89999999999998p 2.3955618099999999e-05 144p 2.3019537300000001e-05 144.09999999999999p 2.1807135000000002e-05 144.20000000000002p 2.0422558000000002e-05 144.30000000000001p 1.8981112e-05 144.39999999999998p 1.75998e-05 144.5p 1.6387977999999999e-05 144.59999999999999p 1.5438908000000001e-05 144.69999999999999p 1.4822831999999999e-05 144.80000000000001p 1.4582025999999998e-05 144.90000000000001p 1.4728088200000001e-05 145p 1.5241661999999999e-05 145.09999999999999p 1.6074529899999997e-05 145.19999999999999p 1.7153859999999999e-05 145.30000000000001p 1.8388303e-05 145.40000000000001p 1.9675572000000002e-05 145.5p 2.0910733e-05 145.59999999999999p 2.1994771999999998e-05 145.69999999999999p 2.2842517e-05 145.80000000000001p 2.3389403999999998e-05 145.90000000000001p 2.3596410899999998e-05 146p 2.34529284e-05 146.09999999999999p 2.2977049800000001e-05 146.19999999999999p 2.2213714599999998e-05 146.30000000000001p 2.1230516999999999e-05 146.40000000000001p 2.0111859000000001e-05 146.5p 1.8951756e-05 146.59999999999999p 1.7846068999999997e-05 146.69999999999999p 1.6884609999999998e-05 146.80000000000001p 1.6143905999999999e-05 146.90000000000001p 1.5681135e-05 147p 1.5529700400000001e-05 147.09999999999999p 1.5696821100000001e-05 147.19999999999999p 1.6163360999999998e-05 147.30000000000001p 1.6885860900000002e-05 147.40000000000001p 1.7800539e-05 147.5p 1.8829004999999999e-05 147.60000000000002p 1.9885063999999999e-05 147.69999999999999p 2.0881991e-05 147.79999999999998p 2.1739755999999998e-05 147.90000000000001p 2.2391369999999998e-05 148p 2.2788164000000001e-05 148.10000000000002p 2.29032628e-05 148.19999999999999p 2.2733325300000001e-05 148.29999999999998p 2.22981988e-05 148.40000000000001p 2.16388054e-05 148.5p 2.0813279399999998e-05 148.60000000000002p 1.9891826999999999e-05 148.69999999999999p 1.8950677999999998e-05 148.79999999999998p 1.8065756000000002e-05 148.90000000000001p 1.7306589000000001e-05 149p 1.6730857000000002e-05 149.09999999999999p 1.63801938e-05 149.20000000000002p 1.6277368099999998e-05 149.29999999999998p 1.64250075e-05 149.40000000000001p 1.68060192e-05 149.5p 1.7385386100000001e-05 149.59999999999999p 1.8113346200000001e-05 149.70000000000002p 1.8929523000000002e-05 149.79999999999998p 1.9767873e-05 149.90000000000001p 2.0561836999999998e-05 150p 2.1249640999999999e-05 150.09999999999999p 2.1778961999999999e-05 150.20000000000002p 2.2111030400000001e-05 150.29999999999998p 2.2223473800000001e-05 150.40000000000001p 2.2111838299999999e-05 150.5p 2.17897131e-05 150.59999999999999p 2.1287303499999998e-05 150.70000000000002p 2.0648711400000001e-05 150.80000000000001p 1.99280795e-05 150.89999999999998p 1.9185087000000001e-05 151p 1.8479978999999998e-05 151.09999999999999p 1.7868700000000001e-05 151.20000000000002p 1.7398492699999999e-05 151.30000000000001p 1.7104284299999999e-05 151.39999999999998p 1.70060942e-05 151.5p 1.71077144e-05 151.59999999999999p 1.73966905e-05 151.70000000000002p 1.7845652599999999e-05 151.80000000000001p 1.84147482e-05 151.89999999999998p 1.9055140299999997e-05 152p 1.9713124399999998e-05 152.09999999999999p 2.0334629999999999e-05 152.19999999999999p 2.0869667299999999e-05 152.30000000000001p 2.1276385499999999e-05 152.40000000000001p 2.1524370799999998e-05 152.5p 2.15969388e-05 152.59999999999999p 2.14922242e-05 152.69999999999999p 2.1223022300000002e-05 152.80000000000001p 2.0815434099999999e-05 152.90000000000001p 2.03063316e-05 153p 1.9740116200000001e-05 153.09999999999999p 1.9164847999999998e-05 153.19999999999999p 1.8628172999999998e-05 153.30000000000001p 1.8173419800000003e-05 153.40000000000001p 1.78361446e-05 153.5p 1.76414249e-05 153.59999999999999p 1.7602051699999999e-05 153.69999999999999p 1.7717815209999999e-05 153.80000000000001p 1.79758387e-05 153.90000000000001p 1.8351962299999997e-05 154p 1.8812941700000001e-05 154.09999999999999p 1.9319378299999998e-05 154.19999999999999p 1.98290494e-05 154.30000000000001p 2.03003542e-05 154.40000000000001p 2.06956988e-05 154.5p 2.09844119e-05 154.59999999999999p 2.1145107100000003e-05 154.69999999999999p 2.11671766e-05 154.80000000000001p 2.1051442030000001e-05 154.90000000000001p 2.0809837300000001e-05 155p 2.0464227900000001e-05 155.10000000000002p 2.0044359800000001e-05 155.19999999999999p 1.9585410300000003e-05 155.29999999999998p 1.9124947200000002e-05 155.40000000000001p 1.8699982799999997e-05 155.5p 1.83440075e-05 155.60000000000002p 1.8084425499999999e-05 155.69999999999999p 1.79404947e-05 155.79999999999998p 1.79220032e-05 155.90000000000001p 1.8028585210000001e-05 156p 1.8249919899999999e-05 156.10000000000002p 1.8566680600000001e-05 156.19999999999999p 1.8952185500000002e-05 156.29999999999998p 1.9374581099999999e-05 156.40000000000001p 1.97995044e-05 156.5p 2.0192876800000002e-05 156.59999999999999p 2.05236541e-05 156.70000000000002p 2.07663308e-05 156.79999999999998p 2.0902928700000001e-05 156.90000000000001p 2.0924342900000002e-05 157p 2.0830960189999998e-05 157.09999999999999p 2.06324075e-05 157.20000000000002p 2.0346652200000001e-05 157.29999999999998p 1.99983298e-05 157.40000000000001p 1.9616656999999997e-05 157.5p 1.9232923499999998e-05 157.59999999999999p 1.88779516e-05 157.70000000000002p 1.8579592599999999e-05 157.79999999999998p 1.8360537799999999e-05 157.90000000000001p 1.82366099e-05 158p 1.8215594800000002e-05 158.09999999999999p 1.829681452e-05 158.20000000000002p 1.8471344400000001e-05 158.30000000000001p 1.8722948800000001e-05 158.39999999999998p 1.90295265e-05 158.5p 1.9365108299999999e-05 158.59999999999999p 1.9702015999999999e-05 158.70000000000002p 2.0013165000000001e-05 158.80000000000001p 2.0274220600000001e-05 158.89999999999998p 2.0465561300000001e-05 159p 2.0573688100000001e-05 159.09999999999999p 2.0592160999999999e-05 159.20000000000002p 2.0521963489999998e-05 159.30000000000001p 2.0371204460000002e-05 159.39999999999998p 2.01542547e-05 159.5p 1.9890463499999999e-05 159.59999999999999p 1.9602464800000002e-05 159.69999999999999p 1.9314240199999998e-05 159.80000000000001p 1.9049160800000001e-05 159.90000000000001p 1.8828142600000001e-05 160p 1.8667976999999999e-05 160.09999999999999p 1.8580151499999999e-05 160.19999999999999p 1.85699562e-05 160.30000000000001p 1.8636315670000003e-05 160.40000000000001p 1.8771959360000001e-05 160.5p 1.8964144299999999e-05 160.59999999999999p 1.9195887499999999e-05 160.69999999999999p 1.9447318400000002e-05 160.80000000000001p 1.9697441499999999e-05 160.90000000000001p 1.9925811800000001e-05 161p 2.01141823e-05 161.09999999999999p 2.02479266e-05 161.19999999999999p 2.0317180400000001e-05 161.30000000000001p 2.0317498399999997e-05 161.40000000000001p 2.025018717e-05 161.5p 2.0122015989999999e-05 161.59999999999999p 1.99446117e-05 161.69999999999999p 1.9733424200000002e-05 161.80000000000001p 1.9506407999999999e-05 161.90000000000001p 1.92825143e-05 162p 1.9080150099999999e-05 162.09999999999999p 1.89156455e-05 162.19999999999999p 1.88019958e-05 162.30000000000001p 1.8747819999999998e-05 162.40000000000001p 1.875676197e-05 162.5p 1.8827188544000001e-05 162.60000000000002p 1.895247715e-05 162.69999999999999p 1.9121610299999999e-05 162.79999999999998p 1.9320121000000002e-05 162.90000000000001p 1.95313871e-05 163p 1.9737977699999998e-05 163.10000000000002p 1.9923118899999999e-05 163.19999999999999p 2.0072059300000003e-05 163.29999999999998p 2.0173229899999999e-05 163.40000000000001p 2.02191628e-05 163.5p 2.020696303e-05 163.60000000000002p 2.0138522375999999e-05 163.69999999999999p 2.0020269869999999e-05 163.79999999999998p 1.9862528800000001e-05 163.90000000000001p 1.96786495e-05 164p 1.94838244e-05 164.09999999999999p 1.9293871999999998e-05 164.20000000000002p 1.9123899600000002e-05 164.29999999999998p 1.8987118699999997e-05 164.40000000000001p 1.8893804100000001e-05 164.5p 1.8850554800000002e-05 164.59999999999999p 1.8859829810000001e-05 164.70000000000002p 1.8919844686000002e-05 164.79999999999998p 1.9024805889999999e-05 164.90000000000001p 1.9165479500000002e-05 165p 1.93300112e-05 165.09999999999999p 1.9504900299999998e-05 165.20000000000002p 1.9676117199999999e-05 165.29999999999998p 1.9830263899999999e-05 165.40000000000001p 1.99555766e-05 165.5p 2.0042850900000002e-05 165.59999999999999p 2.00860902e-05 165.70000000000002p 2.008295546e-05 165.80000000000001p 2.0034825902e-05 165.89999999999998p 1.994663338e-05 166p 1.9826377699999999e-05 166.09999999999999p 1.9684420600000002e-05 166.20000000000002p 1.9532594099999998e-05 166.30000000000001p 1.93832107e-05 166.39999999999998p 1.9248098200000001e-05 166.5p 1.91376487e-05 166.59999999999999p 1.9060001900000001e-05 166.70000000000002p 1.90204926e-05 166.80000000000001p 1.9021253959999998e-05 166.89999999999998p 1.9061139238999998e-05 167p 1.913591258e-05 167.09999999999999p 1.9238626e-05 167.19999999999999p 1.93602306e-05 167.30000000000001p 1.94904038e-05 167.40000000000001p 1.9618376199999999e-05 167.5p 1.9733792599999998e-05 167.59999999999999p 1.98275743e-05 167.69999999999999p 1.9892612600000002e-05 167.80000000000001p 1.99243279e-05 167.90000000000001p 1.992096221e-05 168p 1.9883664596999998e-05 168.09999999999999p 1.9816368550000002e-05 168.19999999999999p 1.972537139e-05 168.30000000000001p 1.96187965e-05 168.40000000000001p 1.95058567e-05 168.5p 1.9396112899999999e-05 168.59999999999999p 1.9298624199999997e-05 168.69999999999999p 1.92212692e-05 168.80000000000001p 1.9170077600000001e-05 168.90000000000001p 1.9148795719999999e-05 169p 1.9158588520000001e-05 169.09999999999999p 1.9198068458999999e-05 169.19999999999999p 1.9263364199999997e-05 169.30000000000001p 1.9348552410000001e-05 169.40000000000001p 1.9446184999999999e-05 169.5p 1.95479075e-05 169.59999999999999p 1.96451575e-05 169.69999999999999p 1.9729940400000001e-05 169.80000000000001p 1.97953832e-05 169.90000000000001p 1.9836359e-05 170p 1.9849838520000003e-05 170.10000000000002p 1.9835124230000001e-05 170.19999999999999p 1.9793836399999998e-05 170.29999999999998p 1.9729745720000003e-05 170.40000000000001p 1.9648447060000001e-05 170.5p 1.9556819299999999e-05 170.60000000000002p 1.9462493e-05 170.69999999999999p 1.93731828e-05 170.79999999999998p 1.9296066e-05 170.90000000000001p 1.9237221500000002e-05 171p 1.9201157089999999e-05 171.10000000000002p 1.9190466379999999e-05 171.19999999999999p 1.9205661749999998e-05 171.29999999999998p 1.92451859e-05 171.40000000000001p 1.930554192e-05 171.5p 1.9381641e-05 171.59999999999999p 1.9467217800000002e-05 171.70000000000002p 1.9555335400000001e-05 171.79999999999998p 1.9638994599999999e-05 171.90000000000001p 1.9711649e-05 172p 1.97677483e-05 172.09999999999999p 1.9803143590000001e-05 172.20000000000002p 1.981539886e-05 172.29999999999998p 1.980396092e-05 172.40000000000001p 1.9770133690000001e-05 172.5p 1.9717014419999999e-05 172.59999999999999p 1.964910145e-05 172.70000000000002p 1.9572011999999998e-05 172.79999999999998p 1.94919764e-05 172.90000000000001p 1.9415301900000001e-05 173p 1.9347934699999999e-05 173.09999999999999p 1.9294944299999999e-05 173.20000000000002p 1.9260169019999997e-05 173.30000000000001p 1.9245927650000001e-05 173.39999999999998p 1.9252866900000001e-05 173.5p 1.9279942092999999e-05 173.59999999999999p 1.9324535340000001e-05 173.70000000000002p 1.9382684609999999e-05 173.80000000000001p 1.9449476939999999e-05 173.89999999999998p 1.9519390400000001e-05 174p 1.9586802300000001e-05 174.09999999999999p 1.96464239e-05 174.20000000000002p 1.969372841e-05 174.30000000000001p 1.9725281139999998e-05 174.39999999999998p 1.9739027669999997e-05 174.5p 1.9734379339999999e-05 174.59999999999999p 1.9712248443000002e-05 174.69999999999999p 1.967495834e-05 174.80000000000001p 1.9625994250000001e-05 174.90000000000001p 1.9569670179999998e-05 175p 1.9510815950000001e-05 175.09999999999999p 1.9454315270000001e-05 175.19999999999999p 1.9404722550000001e-05 175.30000000000001p 1.936590177e-05 175.40000000000001p 1.934073646e-05 175.5p 1.9330895559999998e-05 175.59999999999999p 1.9336726329999999e-05 175.69999999999999p 1.9357282229000002e-05 175.80000000000001p 1.9390432319999999e-05 175.90000000000001p 1.9433047500000002e-05 176p 1.9481309940000001e-05 176.09999999999999p 1.953102374e-05 176.19999999999999p 1.957797746e-05 176.30000000000001p 1.961832287e-05 176.40000000000001p 1.9648827899999999e-05 176.5p 1.9667175779999998e-05 176.59999999999999p 1.9672105929999999e-05 176.69999999999999p 1.9663494830000002e-05 176.80000000000001p 1.9642367649999999e-05 176.90000000000001p 1.9610722250000001e-05 177p 1.957143765e-05 177.09999999999999p 1.9527928120000001e-05 177.19999999999999p 1.9483912590000001e-05 177.30000000000001p 1.9443076740000002e-05 177.40000000000001p 1.9408792379999998e-05 177.5p 1.9383815479999998e-05 177.60000000000002p 1.937011157e-05 177.69999999999999p 1.9368683830000002e-05 177.79999999999998p 1.9379517044e-05 177.90000000000001p 1.9401598639999997e-05 178p 1.943299682e-05 178.10000000000002p 1.9471055549999998e-05 178.19999999999999p 1.951260639e-05 178.29999999999998p 1.9554218750000003e-05 178.40000000000001p 1.9592531570000001e-05 178.5p 1.962444214e-05 178.60000000000002p 1.9647430260000002e-05 178.69999999999999p 1.9659718730000001e-05 178.79999999999998p 1.9660383790000002e-05 178.90000000000001p 1.9649481469000002e-05 179p 1.9627977510000001e-05 179.09999999999999p 1.9597669859999997e-05 179.20000000000002p 1.9561073190000001e-05 179.29999999999998p 1.9521144560000003e-05 179.40000000000001p 1.9481088579999999e-05 179.5p 1.944408873e-05 179.59999999999999p 1.9413039360000002e-05 179.70000000000002p 1.9390310309999998e-05 179.79999999999998p 1.9377583640000001e-05 179.90000000000001p 1.9375738980000002e-05 180p 1.9384751909999998e-05 180.09999999999999p 1.9403747710000002e-05 180.20000000000002p 1.9431061859999999e-05 180.29999999999998p 1.9464427849999999e-05 180.40000000000001p 1.9501093650000002e-05 180.5p 1.9538148870000001e-05 180.59999999999999p 1.9572686750000002e-05 180.70000000000002p 1.9602067059999999e-05 180.80000000000001p 1.9624118609999999e-05 180.89999999999998p 1.9637292649999999e-05 181p 1.964078068e-05 181.09999999999999p 1.9634592444999999e-05 181.20000000000002p 1.9619461169999998e-05 181.30000000000001p 1.9596824339999998e-05 181.39999999999998p 1.9568678180000001e-05 181.5p 1.9537393690000003e-05 181.59999999999999p 1.9505520919999997e-05 181.70000000000002p 1.947558633e-05 181.80000000000001p 1.9449856150000002e-05 181.90000000000001p 1.9430236149999998e-05 182p 1.941805636e-05 182.09999999999999p 1.9414016760000001e-05 182.19999999999999p 1.9418148975999999e-05 182.30000000000001p 1.9429847413000001e-05 182.40000000000001p 1.9447913069999998e-05 182.5p 1.9470683289999998e-05 182.59999999999999p 1.9496151320000002e-05 182.69999999999999p 1.9522200519999999e-05 182.80000000000001p 1.9546709550000002e-05 182.90000000000001p 1.9567746399999998e-05 183p 1.958372086e-05 183.09999999999999p 1.959351649e-05 183.19999999999999p 1.9596535050000003e-05 183.30000000000001p 1.9592737147000001e-05 183.40000000000001p 1.958267419e-05 183.5p 1.9567357170000001e-05 183.59999999999999p 1.9548237830000001e-05 183.69999999999999p 1.9527017669999999e-05 183.80000000000001p 1.9505529330000002e-05 183.90000000000001p 1.9485604099999998e-05 184p 1.9468887639999999e-05 184.09999999999999p 1.9456724949999999e-05 184.19999999999999p 1.9450053729999997e-05 184.30000000000001p 1.9449334160000001e-05 184.40000000000001p 1.9454511547999998e-05 184.5p 1.9465047670999998e-05 184.59999999999999p 1.9479945619999999e-05 184.69999999999999p 1.9497872949999999e-05 184.80000000000001p 1.9517238009999997e-05 184.90000000000001p 1.9536364819999999e-05 185p 1.9553612990000001e-05 185.10000000000002p 1.956753022e-05 185.19999999999999p 1.957694646e-05 185.29999999999998p 1.9581090370000001e-05 185.40000000000001p 1.9579650297999999e-05 185.5p 1.9572792966e-05 185.60000000000002p 1.9561114588999999e-05 185.69999999999999p 1.9545639350000002e-05 185.79999999999998p 1.9527690560000002e-05 185.90000000000001p 1.9508769490000002e-05 186p 1.9490466060000002e-05 186.10000000000002p 1.947429464e-05 186.19999999999999p 1.946156662e-05 186.29999999999998p 1.945332023e-05 186.40000000000001p 1.9450186259999999e-05 186.5p 1.9452397306000002e-05 186.59999999999999p 1.9459736881000003e-05 186.70000000000002p 1.9471564049999999e-05 186.79999999999998p 1.9486898899999997e-05 186.90000000000001p 1.9504504239999999e-05 187p 1.9522949310000001e-05 187.09999999999999p 1.954078209e-05 187.20000000000002p 1.9556607939999998e-05 187.29999999999998p 1.9569223389999998e-05 187.40000000000001p 1.9577695140000001e-05 187.5p 1.958141577e-05 187.59999999999999p 1.9580178305999999e-05 187.70000000000002p 1.9574143084599998e-05 187.79999999999998p 1.9563880377000002e-05 187.90000000000001p 1.9550222820000001e-05 188p 1.953428131e-05 188.09999999999999p 1.9517327740000001e-05 188.20000000000002p 1.9500647259999998e-05 188.30000000000001p 1.9485501709999999e-05 188.39999999999998p 1.9473015490000001e-05 188.5p 1.9464073410000001e-05 188.59999999999999p 1.9459269890000002e-05 188.70000000000002p 1.9458867679999999e-05 188.80000000000001p 1.9462783597000002e-05 188.89999999999998p 1.9470618678e-05 189p 1.9481679419999999e-05 189.09999999999999p 1.949502713e-05 189.20000000000002p 1.9509572299999999e-05 189.30000000000001p 1.952418158e-05 189.40000000000001p 1.9537725310000001e-05 189.5p 1.9549184280000001e-05 189.59999999999999p 1.9557735489999998e-05 189.69999999999999p 1.9562817189999998e-05 189.80000000000001p 1.9564134523000003e-05 189.90000000000001p 1.9561727876e-05 190p 1.9555896413e-05 190.09999999999999p 1.9547239861999997e-05 190.19999999999999p 1.9536551629999997e-05 190.30000000000001p 1.952476622e-05 190.40000000000001p 1.9512863690000001e-05 190.5p 1.9501842939999999e-05 190.59999999999999p 1.9492555459999999e-05 190.69999999999999p 1.9485699669999998e-05 190.80000000000001p 1.948175542e-05 190.90000000000001p 1.9480947351999998e-05 191p 1.9483214998e-05 191.09999999999999p 1.9488246825000001e-05 191.19999999999999p 1.9495525385e-05 191.30000000000001p 1.9504320439999999e-05 191.40000000000001p 1.9513847309999999e-05 191.5p 1.952323804e-05 191.59999999999999p 1.9531683800000001e-05 191.69999999999999p 1.9538497690000003e-05 191.80000000000001p 1.954311791e-05 191.90000000000001p 1.9545212143000002e-05 192p 1.9544674923e-05 192.09999999999999p 1.95416098902e-05 192.19999999999999p 1.9536359662000002e-05 192.30000000000001p 1.9529435848e-05 192.40000000000001p 1.9521481760000001e-05 192.5p 1.9513200000000001e-05 192.60000000000002p 1.9505336629999999e-05 192.69999999999999p 1.9498563070000001e-05 192.79999999999998p 1.949345593e-05 192.90000000000001p 1.9490444781000003e-05 193p 1.9489776693999998e-05 193.10000000000002p 1.9491476337999999e-05 193.19999999999999p 1.9495399690000002e-05 193.29999999999998p 1.950120942e-05 193.40000000000001p 1.9508409868e-05 193.5p 1.9516399660000001e-05 193.60000000000002p 1.9524510280000002e-05 193.69999999999999p 1.9532079230000001e-05 193.79999999999998p 1.9538477030000003e-05 193.90000000000001p 1.954319745e-05 194p 1.9545841373000002e-05 194.09999999999999p 1.9546194669000001e-05 194.20000000000002p 1.9544221224799999e-05 194.29999999999998p 1.9540082437999999e-05 194.40000000000001p 1.9534084798999999e-05 194.5p 1.9526707276999997e-05 194.59999999999999p 1.9518530239999997e-05 194.70000000000002p 1.951018754e-05 194.79999999999998p 1.9502323079999999e-05 194.90000000000001p 1.9495562990000002e-05 195p 1.9490423900000003e-05 195.09999999999999p 1.9487297599e-05 195.20000000000002p 1.9486401549e-05 195.29999999999998p 1.9487814556000001e-05 195.40000000000001p 1.9491406273e-05 195.5p 1.9496878982e-05 195.59999999999999p 1.9503799863000001e-05 195.70000000000002p 1.9511621949999999e-05 195.80000000000001p 1.951974202e-05 195.89999999999998p 1.9527533959999999e-05 196p 1.9534406579999997e-05 196.09999999999999p 1.9539865079999999e-05 196.20000000000002p 1.9543526382999999e-05 196.30000000000001p 1.9545128480000002e-05 196.39999999999998p 1.9544625010000001e-05 196.5p 1.9542106284100001e-05 196.59999999999999p 1.9537798482000001e-05 196.70000000000002p 1.9532102793999999e-05 196.80000000000001p 1.9525496274e-05 196.90000000000001p 1.9518495990000002e-05 197p 1.9511667699999999e-05 197.09999999999999p 1.950550995e-05 197.19999999999999p 1.9500463819000002e-05 197.30000000000001p 1.9496888250999999e-05 197.40000000000001p 1.9494990303999998e-05 197.5p 1.9494829245999999e-05 197.59999999999999p 1.9496363220200002e-05 197.69999999999999p 1.9499376995000001e-05 197.80000000000001p 1.9503579285e-05 197.90000000000001p 1.9508578256999999e-05 198p 1.9513954049000003e-05 198.09999999999999p 1.9519257423000001e-05 198.19999999999999p 1.9524074033999998e-05 198.30000000000001p 1.9528054170000002e-05 198.40000000000001p 1.9530918196000001e-05 198.5p 1.9532488231e-05 198.59999999999999p 1.9532706880999998e-05 198.69999999999999p 1.9531624014000001e-05 198.80000000000001p 1.9529382680999999e-05 198.90000000000001p 1.9526225292e-05 199p 1.9522481091999999e-05 199.09999999999999p 1.9518465859000002e-05 199.19999999999999p 1.9514554516000002e-05 199.30000000000001p 1.9511067149e-05 199.40000000000001p 1.9508298643000002e-05 199.5p 1.9506471859999999e-05 199.59999999999999p 1.9505704067999998e-05 199.69999999999999p 1.9506046053000002e-05 199.80000000000001p 1.9507423170800001e-05 199.90000000000001p 1.9509707477e-05)
* N4 → LS3 → N7

* === R-Loop lower branch: N5 → LS2 → JS2 → N6 ===
L_S2    8       9       0.5P
B_JS2   9       10      jjmit area=0.74
* R_JS2   9       10      15

* === N6 → N7 (direct wire) ===
* R_N6N7  N6      N7      1E-6

* === Output chain: N7 → LPSL → RSL → N8 → LSL → DataOut ===
L_PSL   10      11      0.5P
R_SL    11      12      12.0
L_SL    12      SL      0.4P

.ends BVM_REPLAY_4

XBVM1 WL1 BL1 SE1 COMMON_SL BVM_REPLAY_1
XBVM2 WL2 BL2 SE2 COMMON_SL BVM_REPLAY_2
XBVM3 WL3 BL3 SE3 COMMON_SL BVM_REPLAY_3
XBVM4 WL4 BL4 SE4 COMMON_SL BVM_REPLAY_4

B_JSL1 COMMON_SL JSL_NODE1 jjmit area=5.0
B_JSL2 JSL_NODE1 JSL_NODE2 jjmit area=5.0
B_JSL3 JSL_NODE2 JSL_NODE3 jjmit area=5.0
B_JSL4 JSL_NODE3 JSL_NODE4 jjmit area=5.0
B_JSL5 JSL_NODE4 JSL_NODE5 jjmit area=5.0
B_JSL6 JSL_NODE5 JSL_NODE6 jjmit area=5.0
B_JSL7 JSL_NODE6 JSL_NODE7 jjmit area=5.0
B_JSL8 JSL_NODE7 QBIN jjmit area=5.0

* Frozen QB and six-stage JTL are byte-identical in both decks.
XBQ1 QBIN QBOUT BQ
XJTL1_1 QBOUT JTL1_OUT jtl
XJTL1_2 JTL1_OUT JTL2_OUT jtl
XJTL1_3 JTL2_OUT JTL3_OUT jtl
XJTL1_4 JTL3_OUT JTL4_OUT jtl
XJTL1_5 JTL4_OUT JTL5_OUT jtl
XJTL1_6 JTL5_OUT JTL6_OUT jtl
R_TERM JTL6_OUT 0 10

I_WL1 0 WL1 pwl(0 0 50p 0 51p -100u 60p -100u 61p 0 70p 0 71p +100u 80p +100u 81p 0 90p 0 91p +100u 100p +100u 101p 0 110p 0 111p 0 120p 0 121p 0 200p 0)
I_BL1 0 BL1 pwl(0 0 50p 0 51p -100u 60p -100u 61p 0 70p 0 71p 0 80p 0 81p 0 90p 0 91p +100u 100p +100u 101p 0 110p 0 111p 0 120p 0 121p 0 200p 0)
I_SE1 0 SE1 pwl(0 0 50p 0 51p 0 60p 0 61p 0 70p 0 71p +100u 80p +100u 81p 0 90p 0 91p 0 100p 0 101p 0 110p 0 111p 0 120p 0 121p 0 200p 0)
I_WL2 0 WL2 pwl(0 0 50p 0 51p -100u 60p -100u 61p 0 70p 0 71p +100u 80p +100u 81p 0 90p 0 91p +100u 100p +100u 101p 0 110p 0 111p 0 120p 0 121p 0 200p 0)
I_BL2 0 BL2 pwl(0 0 50p 0 51p -100u 60p -100u 61p 0 70p 0 71p 0 80p 0 81p 0 90p 0 91p +100u 100p +100u 101p 0 110p 0 111p 0 120p 0 121p 0 200p 0)
I_SE2 0 SE2 pwl(0 0 50p 0 51p 0 60p 0 61p 0 70p 0 71p +100u 80p +100u 81p 0 90p 0 91p 0 100p 0 101p 0 110p 0 111p 0 120p 0 121p 0 200p 0)
I_WL3 0 WL3 pwl(0 0 50p 0 51p -100u 60p -100u 61p 0 70p 0 71p +100u 80p +100u 81p 0 90p 0 91p +100u 100p +100u 101p 0 110p 0 111p +100u 120p +100u 121p 0 200p 0)
I_BL3 0 BL3 pwl(0 0 50p 0 51p -100u 60p -100u 61p 0 70p 0 71p 0 80p 0 81p 0 90p 0 91p +100u 100p +100u 101p 0 110p 0 111p 0 120p 0 121p 0 200p 0)
I_SE3 0 SE3 pwl(0 0 50p 0 51p 0 60p 0 61p 0 70p 0 71p +100u 80p +100u 81p 0 90p 0 91p 0 100p 0 101p 0 110p 0 111p +100u 120p +100u 121p 0 200p 0)
I_WL4 0 WL4 pwl(0 0 50p 0 51p -100u 60p -100u 61p 0 70p 0 71p +100u 80p +100u 81p 0 90p 0 91p +100u 100p +100u 101p 0 110p 0 111p +100u 120p +100u 121p 0 200p 0)
I_BL4 0 BL4 pwl(0 0 50p 0 51p -100u 60p -100u 61p 0 70p 0 71p 0 80p 0 81p 0 90p 0 91p +100u 100p +100u 101p 0 110p 0 111p 0 120p 0 121p 0 200p 0)
I_SE4 0 SE4 pwl(0 0 50p 0 51p 0 60p 0 61p 0 70p 0 71p +100u 80p +100u 81p 0 90p 0 91p 0 100p 0 101p 0 110p 0 111p +100u 120p +100u 121p 0 200p 0)

.tran 0.1p 200p

* Full probe is intentionally retained for every BVM and all eight shared/single JSL elements.
.print I(I_WL1) I(I_BL1) I(I_SE1) I(I_WL2) I(I_BL2) I(I_SE2) I(I_WL3) I(I_BL3) I(I_SE3) I(I_WL4) I(I_BL4) I(I_SE4)
.print P(B_JM1|XBVM1) V(B_JM1|XBVM1) I(B_JM1|XBVM1)
.print P(B_JM2|XBVM1) V(B_JM2|XBVM1) I(B_JM2|XBVM1)
.print P(B_JS1|XBVM1) V(B_JS1|XBVM1) I(B_JS1|XBVM1)
.print P(B_JS2|XBVM1) V(B_JS2|XBVM1) I(B_JS2|XBVM1)
.print I(L_M1|XBVM1) V(L_M1|XBVM1)
.print I(L_M2|XBVM1) V(L_M2|XBVM1)
.print I(L_M3|XBVM1) V(L_M3|XBVM1)
.print I(L_PM|XBVM1) V(L_PM|XBVM1)
.print I(R_JM1|XBVM1) V(R_JM1|XBVM1)
.print I(L_S1|XBVM1) V(L_S1|XBVM1)
.print I(L_S2|XBVM1) V(L_S2|XBVM1)
.print I(I_BRIDGE_REPLAY|XBVM1) V(6|XBVM1) V(10|XBVM1)
.print I(R_SE|XBVM1) V(R_SE|XBVM1)
.print I(L_PSE|XBVM1) V(L_PSE|XBVM1)
.print I(L_PSL|XBVM1) V(L_PSL|XBVM1)
.print I(R_SL|XBVM1) V(R_SL|XBVM1)
.print I(L_SL|XBVM1) V(L_SL|XBVM1)
.print P(B_JM1|XBVM2) V(B_JM1|XBVM2) I(B_JM1|XBVM2)
.print P(B_JM2|XBVM2) V(B_JM2|XBVM2) I(B_JM2|XBVM2)
.print P(B_JS1|XBVM2) V(B_JS1|XBVM2) I(B_JS1|XBVM2)
.print P(B_JS2|XBVM2) V(B_JS2|XBVM2) I(B_JS2|XBVM2)
.print I(L_M1|XBVM2) V(L_M1|XBVM2)
.print I(L_M2|XBVM2) V(L_M2|XBVM2)
.print I(L_M3|XBVM2) V(L_M3|XBVM2)
.print I(L_PM|XBVM2) V(L_PM|XBVM2)
.print I(R_JM1|XBVM2) V(R_JM1|XBVM2)
.print I(L_S1|XBVM2) V(L_S1|XBVM2)
.print I(L_S2|XBVM2) V(L_S2|XBVM2)
.print I(I_BRIDGE_REPLAY|XBVM2) V(6|XBVM2) V(10|XBVM2)
.print I(R_SE|XBVM2) V(R_SE|XBVM2)
.print I(L_PSE|XBVM2) V(L_PSE|XBVM2)
.print I(L_PSL|XBVM2) V(L_PSL|XBVM2)
.print I(R_SL|XBVM2) V(R_SL|XBVM2)
.print I(L_SL|XBVM2) V(L_SL|XBVM2)
.print P(B_JM1|XBVM3) V(B_JM1|XBVM3) I(B_JM1|XBVM3)
.print P(B_JM2|XBVM3) V(B_JM2|XBVM3) I(B_JM2|XBVM3)
.print P(B_JS1|XBVM3) V(B_JS1|XBVM3) I(B_JS1|XBVM3)
.print P(B_JS2|XBVM3) V(B_JS2|XBVM3) I(B_JS2|XBVM3)
.print I(L_M1|XBVM3) V(L_M1|XBVM3)
.print I(L_M2|XBVM3) V(L_M2|XBVM3)
.print I(L_M3|XBVM3) V(L_M3|XBVM3)
.print I(L_PM|XBVM3) V(L_PM|XBVM3)
.print I(R_JM1|XBVM3) V(R_JM1|XBVM3)
.print I(L_S1|XBVM3) V(L_S1|XBVM3)
.print I(L_S2|XBVM3) V(L_S2|XBVM3)
.print I(I_BRIDGE_REPLAY|XBVM3) V(6|XBVM3) V(10|XBVM3)
.print I(R_SE|XBVM3) V(R_SE|XBVM3)
.print I(L_PSE|XBVM3) V(L_PSE|XBVM3)
.print I(L_PSL|XBVM3) V(L_PSL|XBVM3)
.print I(R_SL|XBVM3) V(R_SL|XBVM3)
.print I(L_SL|XBVM3) V(L_SL|XBVM3)
.print P(B_JM1|XBVM4) V(B_JM1|XBVM4) I(B_JM1|XBVM4)
.print P(B_JM2|XBVM4) V(B_JM2|XBVM4) I(B_JM2|XBVM4)
.print P(B_JS1|XBVM4) V(B_JS1|XBVM4) I(B_JS1|XBVM4)
.print P(B_JS2|XBVM4) V(B_JS2|XBVM4) I(B_JS2|XBVM4)
.print I(L_M1|XBVM4) V(L_M1|XBVM4)
.print I(L_M2|XBVM4) V(L_M2|XBVM4)
.print I(L_M3|XBVM4) V(L_M3|XBVM4)
.print I(L_PM|XBVM4) V(L_PM|XBVM4)
.print I(R_JM1|XBVM4) V(R_JM1|XBVM4)
.print I(L_S1|XBVM4) V(L_S1|XBVM4)
.print I(L_S2|XBVM4) V(L_S2|XBVM4)
.print I(I_BRIDGE_REPLAY|XBVM4) V(6|XBVM4) V(10|XBVM4)
.print I(R_SE|XBVM4) V(R_SE|XBVM4)
.print I(L_PSE|XBVM4) V(L_PSE|XBVM4)
.print I(L_PSL|XBVM4) V(L_PSL|XBVM4)
.print I(R_SL|XBVM4) V(R_SL|XBVM4)
.print I(L_SL|XBVM4) V(L_SL|XBVM4)
.print V(COMMON_SL)
.print P(B_JSL1) V(B_JSL1) I(B_JSL1)
.print P(B_JSL2) V(B_JSL2) I(B_JSL2)
.print P(B_JSL3) V(B_JSL3) I(B_JSL3)
.print P(B_JSL4) V(B_JSL4) I(B_JSL4)
.print P(B_JSL5) V(B_JSL5) I(B_JSL5)
.print P(B_JSL6) V(B_JSL6) I(B_JSL6)
.print P(B_JSL7) V(B_JSL7) I(B_JSL7)
.print P(B_JSL8) V(B_JSL8) I(B_JSL8)
.print V(QBIN) V(QBOUT)
.print I(LIN|XBQ1) V(LIN|XBQ1) I(L1|XBQ1) V(L1|XBQ1) I(L2|XBQ1) V(L2|XBQ1) I(L3|XBQ1) V(L3|XBQ1)
.print I(RJ1|XBQ1) V(RJ1|XBQ1) I(RJ2|XBQ1) V(RJ2|XBQ1) I(IB|XBQ1) V(IB|XBQ1)
.print P(BJS|XBQ1) V(BJS|XBQ1) I(BJS|XBQ1)
.print P(BJ1|XBQ1) V(BJ1|XBQ1) I(BJ1|XBQ1)
.print P(BJ2|XBQ1) V(BJ2|XBQ1) I(BJ2|XBQ1)
.print P(B01|XJTL1_1) V(B01|XJTL1_1) I(B01|XJTL1_1) P(B02|XJTL1_1) V(B02|XJTL1_1) I(B02|XJTL1_1)
.print V(JTL1_OUT)
.print P(B01|XJTL1_2) V(B01|XJTL1_2) I(B01|XJTL1_2) P(B02|XJTL1_2) V(B02|XJTL1_2) I(B02|XJTL1_2)
.print V(JTL2_OUT)
.print P(B01|XJTL1_3) V(B01|XJTL1_3) I(B01|XJTL1_3) P(B02|XJTL1_3) V(B02|XJTL1_3) I(B02|XJTL1_3)
.print V(JTL3_OUT)
.print P(B01|XJTL1_4) V(B01|XJTL1_4) I(B01|XJTL1_4) P(B02|XJTL1_4) V(B02|XJTL1_4) I(B02|XJTL1_4)
.print V(JTL4_OUT)
.print P(B01|XJTL1_5) V(B01|XJTL1_5) I(B01|XJTL1_5) P(B02|XJTL1_5) V(B02|XJTL1_5) I(B02|XJTL1_5)
.print V(JTL5_OUT)
.print P(B01|XJTL1_6) V(B01|XJTL1_6) I(B01|XJTL1_6) P(B02|XJTL1_6) V(B02|XJTL1_6) I(B02|XJTL1_6)
.print V(JTL6_OUT)
.print I(R_TERM)
.end
