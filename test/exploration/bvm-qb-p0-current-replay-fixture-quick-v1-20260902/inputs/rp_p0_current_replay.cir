* BVM_QB_P0_CURRENT_REPLAY_FIXTURE_QUICK_V1: literal P0 current replay
* source raw: test/exploration/bvm-load-qb-matrix-v1-20260901/raw/physical/13ps/12x320/logical1_read/run-01.csv
* source signal: I(LIN|XBQ), occurrence 0
* every P0 timestamp/current pair is retained; no fit, scale, hold, resample, or interpolation
* verified P0 final JSL orientation: B_LD12 njsl11 IN jjmit area=3.2
* verified frozen QB input orientation: Lin IN 1 0.8p
.include jjmit.cir
.include bq_cell.cir
XBQ IN OUT IBIAS BQ
I_REPLAY 0 IN pwl(0p 0 0.012500000000000001p -2.160587e-10 0.025000000000000001p -9.9244579999999992e-10 0.037499999999999999p -2.7173249999999998e-09 0.050000000000000003p -5.7753910000000002e-09 0.0625p -1.0525179999999999e-08 0.074999999999999997p -1.728901e-08 0.087500000000000008p -2.634871e-08 0.10000000000000001p -3.7944180000000003e-08 0.1125p -5.2273049999999997e-08 0.125p -6.9491280000000007e-08 0.13749999999999998p -8.9714000000000005e-08 0.14999999999999999p -1.1301689999999999e-07 0.16249999999999998p -1.394377e-07 0.17500000000000002p -1.689782e-07 0.1875p -2.016061e-07 0.20000000000000001p -2.3725739999999999e-07 0.21249999999999999p -2.7583870000000001e-07
+ 0.22500000000000001p -3.172298e-07 0.23749999999999999p -3.6128639999999999e-07 0.25p -4.078424e-07 0.26250000000000001p -4.5671309999999999e-07 0.27499999999999997p -5.0769770000000005e-07 0.28749999999999998p -5.6058200000000001e-07 0.29999999999999999p -6.1514109999999995e-07 0.3125p -6.7114239999999998e-07 0.32499999999999996p -7.2834750000000002e-07 0.33749999999999997p -7.8651519999999998e-07 0.35000000000000003p -8.4540369999999996e-07 0.36250000000000004p -9.0477289999999995e-07 0.375p -9.6438619999999995e-07 0.38750000000000001p -1.024013e-06 0.40000000000000002p -1.0834300000000001e-06 0.41250000000000003p -1.1424230000000001e-06 0.42499999999999999p -1.2007880000000001e-06 0.4375p -1.258334e-06
+ 0.45000000000000001p -1.314882e-06 0.46250000000000002p -1.370268e-06 0.47499999999999998p -1.4243409999999999e-06 0.48749999999999999p -1.4769669999999999e-06 0.5p -1.5280259999999999e-06 0.51249999999999996p -1.5774159999999999e-06 0.52500000000000002p -1.62505e-06 0.53749999999999998p -1.670857e-06 0.54999999999999993p -1.7147840000000001e-06 0.5625p -1.756789e-06 0.57499999999999996p -1.796851e-06 0.58750000000000002p -1.8349589999999999e-06 0.59999999999999998p -1.8711190000000001e-06 0.61249999999999993p -1.9053500000000001e-06 0.625p -1.937682e-06 0.63749999999999996p -1.9681580000000002e-06 0.64999999999999991p -1.9968320000000001e-06 0.66249999999999998p -2.0237670000000002e-06
+ 0.67499999999999993p -2.0490370000000002e-06 0.6875p -2.0727219999999998e-06 0.70000000000000007p -2.0949079999999998e-06 0.71250000000000002p -2.1156889999999998e-06 0.72500000000000009p -2.1351640000000002e-06 0.73750000000000004p -2.1534349999999999e-06 0.75p -2.1706049999999999e-06 0.76250000000000007p -2.1867830000000001e-06 0.77500000000000002p -2.2020759999999998e-06 0.78749999999999998p -2.2165919999999999e-06 0.80000000000000004p -2.2304380000000001e-06 0.8125p -2.2437210000000002e-06 0.82500000000000007p -2.2565450000000001e-06 0.83750000000000002p -2.2690100000000001e-06 0.84999999999999998p -2.2812139999999998e-06 0.86250000000000004p -2.2932509999999998e-06 0.875p -2.3052110000000001e-06 0.88749999999999996p -2.317177e-06
+ 0.90000000000000002p -2.3292300000000001e-06 0.91249999999999998p -2.3414429999999999e-06 0.92500000000000004p -2.3538860000000001e-06 0.9375p -2.3666189999999998e-06 0.94999999999999996p -2.3797019999999999e-06 0.96250000000000002p -2.3931840000000002e-06 0.97499999999999998p -2.4071100000000001e-06 0.98749999999999993p -2.4215200000000002e-06 1p -2.4364480000000001e-06 1.0125p -2.4517050000000001e-06 1.0249999999999999p -2.466969e-06 1.0374999999999999p -2.4818699999999999e-06 1.05p -2.4960360000000001e-06 1.0625p -2.5091170000000001e-06 1.075p -2.5207930000000001e-06 1.0874999999999999p -2.5307819999999999e-06 1.0999999999999999p -2.5388409999999998e-06 1.1125p -2.544764e-06
+ 1.125p -2.5483860000000001e-06 1.1375p -2.5495779999999999e-06 1.1499999999999999p -2.5482489999999999e-06 1.1624999999999999p -2.5443450000000001e-06 1.175p -2.5378449999999998e-06 1.1875p -2.5287609999999998e-06 1.2p -2.5171360000000002e-06 1.2124999999999999p -2.5030419999999999e-06 1.2249999999999999p -2.4865779999999999e-06 1.2374999999999998p -2.4678649999999998e-06 1.25p -2.4470480000000001e-06 1.2625p -2.4242890000000001e-06 1.2749999999999999p -2.3997699999999999e-06 1.2874999999999999p -2.373683e-06 1.2999999999999998p -2.3462359999999998e-06 1.3125p -2.3176410000000001e-06 1.325p -2.2881219999999999e-06 1.3374999999999999p -2.2579020000000001e-06
+ 1.3499999999999999p -2.2272119999999999e-06 1.3624999999999998p -2.1962759999999998e-06 1.375p -2.165322e-06 1.3875000000000002p -2.1345699999999999e-06 1.4000000000000001p -2.1042359999999998e-06 1.4125000000000001p -2.0745249999999998e-06 1.425p -2.0456380000000001e-06 1.4375p -2.017761e-06 1.4500000000000002p -1.991072e-06 1.4625000000000001p -1.9657320000000001e-06 1.4750000000000001p -1.941893e-06 1.4875p -1.9196889999999999e-06 1.5p -1.8992420000000001e-06 1.5125000000000002p -1.880658e-06 1.5250000000000001p -1.8640249999999999e-06 1.5375000000000001p -1.8494199999999999e-06 1.55p -1.836902e-06 1.5625p -1.826514e-06
+ 1.575p -1.8182860000000001e-06 1.5875000000000001p -1.812231e-06 1.6000000000000001p -1.808351e-06 1.6125p -1.806632e-06 1.625p -1.8070490000000001e-06 1.6375p -1.809562e-06 1.6500000000000001p -1.8141239999999999e-06 1.6625000000000001p -1.8206730000000001e-06 1.675p -1.8291420000000001e-06 1.6875p -1.8394520000000001e-06 1.7p -1.8515190000000001e-06 1.7125000000000001p -1.8652500000000001e-06 1.7250000000000001p -1.8805480000000001e-06 1.7375p -1.8973100000000001e-06 1.75p -1.9154310000000001e-06 1.7625p -1.9348020000000001e-06 1.7749999999999999p -1.9553120000000001e-06 1.7875000000000001p -1.97685e-06
+ 1.8p -1.9993020000000001e-06 1.8125p -2.0225589999999998e-06 1.825p -2.0465100000000001e-06 1.8375000000000001p -2.0710460000000002e-06 1.8625000000000003p -2.1214569999999998e-06 1.875p -2.147131e-06 1.8875000000000002p -2.1729890000000001e-06 1.8999999999999999p -2.1989420000000001e-06 1.9125000000000001p -2.2249040000000002e-06 1.925p -2.250796e-06 1.9375000000000002p -2.276542e-06 1.95p -2.3020740000000001e-06 1.9625000000000001p -2.3273289999999999e-06 1.9749999999999999p -2.3522469999999999e-06 1.9875000000000003p -2.3767769999999998e-06 2p -2.4008719999999998e-06 2.0125000000000002p -2.424492e-06 2.0249999999999999p -2.4476000000000001e-06
+ 2.0375000000000001p -2.4701650000000002e-06 2.0499999999999998p -2.4921619999999998e-06 2.0625p -2.5135709999999998e-06 2.0749999999999997p -2.534374e-06 2.0875000000000004p -2.5545610000000001e-06 2.1000000000000001p -2.5741219999999998e-06 2.1125000000000003p -2.593053e-06 2.125p -2.6113540000000001e-06 2.1375000000000002p -2.6290250000000002e-06 2.1499999999999999p -2.6460709999999998e-06 2.1625000000000001p -2.6624990000000001e-06 2.1749999999999998p -2.6783179999999999e-06 2.1875p -2.6935370000000001e-06 2.1999999999999997p -2.708169e-06 2.2124999999999999p -2.7222259999999998e-06 2.2250000000000001p -2.7357220000000001e-06 2.2375000000000003p -2.7486700000000001e-06 2.25p -2.7610849999999999e-06
+ 2.2625000000000002p -2.7729799999999998e-06 2.2749999999999999p -2.78437e-06 2.2875000000000001p -2.7952669999999999e-06 2.2999999999999998p -2.8056849999999999e-06 2.3125p -2.8156339999999999e-06 2.3249999999999997p -2.8251260000000001e-06 2.3374999999999999p -2.8341710000000002e-06 2.3500000000000001p -2.8427770000000001e-06 2.3625000000000003p -2.8509519999999998e-06 2.375p -2.8586999999999998e-06 2.3875000000000002p -2.8660280000000001e-06 2.3999999999999999p -2.8729379999999998e-06 2.4125000000000001p -2.8794330000000002e-06 2.4249999999999998p -2.8855120000000001e-06 2.4375p -2.8911749999999999e-06 2.4499999999999997p -2.8964209999999999e-06 2.4624999999999999p -2.9012459999999999e-06 2.4749999999999996p -2.9056449999999999e-06
+ 2.4875000000000003p -2.909614e-06 2.5p -2.9131460000000001e-06 2.5125000000000002p -2.9162339999999998e-06 2.5249999999999999p -2.918871e-06 2.5375000000000001p -2.9210480000000001e-06 2.5499999999999998p -2.9227570000000001e-06 2.5625p -2.923988e-06 2.5749999999999997p -2.9247320000000002e-06 2.5874999999999999p -2.924979e-06 2.5999999999999996p -2.9247210000000001e-06 2.6124999999999998p -2.9239480000000001e-06 2.625p -2.9226499999999999e-06 2.6375000000000002p -2.9208200000000002e-06 2.6499999999999999p -2.91845e-06 2.6625000000000001p -2.9155310000000001e-06 2.6749999999999998p -2.9120569999999999e-06 2.6875p -2.9080209999999999e-06 2.6999999999999997p -2.9034189999999999e-06
+ 2.7124999999999999p -2.8982469999999999e-06 2.7249999999999996p -2.8924999999999998e-06 2.7374999999999998p -2.886177e-06 2.75p -2.8792759999999999e-06 2.7625000000000002p -2.8717980000000001e-06 2.7750000000000004p -2.8637429999999999e-06 2.7875000000000001p -2.8551130000000001e-06 2.8000000000000003p -2.8459120000000001e-06 2.8125p -2.836145e-06 2.8250000000000002p -2.8258160000000001e-06 2.8374999999999999p -2.8149330000000002e-06 2.8500000000000001p -2.8035049999999999e-06 2.8624999999999998p -2.7915389999999999e-06 2.875p -2.7790450000000002e-06 2.8875000000000002p -2.766036e-06 2.9000000000000004p -2.7525229999999999e-06 2.9125000000000001p -2.7385199999999998e-06 2.9250000000000003p -2.7240390000000001e-06
+ 2.9375p -2.7090950000000001e-06 2.9500000000000002p -2.6937050000000001e-06 2.9624999999999999p -2.6778840000000002e-06 2.9750000000000001p -2.6616489999999999e-06 2.9874999999999998p -2.6450169999999999e-06 3p -2.6280059999999998e-06 3.0124999999999997p -2.6106329999999999e-06 3.0250000000000004p -2.5929179999999998e-06 3.0375000000000001p -2.5748790000000002e-06 3.0500000000000003p -2.5565340000000001e-06 3.0625p -2.537904e-06 3.0750000000000002p -2.5190060000000001e-06 3.0874999999999999p -2.499861e-06 3.1000000000000001p -2.4804870000000001e-06 3.1124999999999998p -2.4609020000000001e-06 3.125p -2.4411269999999999e-06 3.1374999999999997p -2.4211789999999998e-06 3.1499999999999999p -2.4010770000000002e-06
+ 3.1625000000000001p -2.3808390000000002e-06 3.1750000000000003p -2.360482e-06 3.1875p -2.3400250000000001e-06 3.2000000000000002p -2.3194819999999999e-06 3.2124999999999999p -2.2988720000000002e-06 3.2250000000000001p -2.2782099999999999e-06 3.2374999999999998p -2.2575119999999999e-06 3.25p -2.2367929999999999e-06 3.2624999999999997p -2.216067e-06 3.2749999999999999p -2.195348e-06 3.2875000000000001p -2.1746509999999998e-06 3.3000000000000003p -2.1539869999999999e-06 3.3125p -2.133369e-06 3.3250000000000002p -2.1128100000000002e-06 3.3374999999999999p -2.0923209999999998e-06 3.3500000000000001p -2.0719119999999999e-06 3.3624999999999998p -2.0515939999999998e-06 3.375p -2.0313770000000002e-06
+ 3.3874999999999997p -2.0112700000000001e-06 3.3999999999999999p -1.9912830000000001e-06 3.4124999999999996p -1.9714229999999999e-06 3.4250000000000003p -1.9516990000000001e-06 3.4375p -1.932119e-06 3.4500000000000002p -1.9126889999999998e-06 3.4624999999999999p -1.893417e-06 3.4750000000000001p -1.874308e-06 3.4874999999999998p -1.8553700000000001e-06 3.5p -1.8366079999999999e-06 3.5124999999999997p -1.8180269999999999e-06 3.5249999999999999p -1.7996319999999999e-06 3.5374999999999996p -1.781429e-06 3.5499999999999998p -1.7634220000000001e-06 3.5625p -1.745614e-06 3.5750000000000002p -1.7280119999999999e-06 3.5874999999999999p -1.710617e-06 3.6000000000000001p -1.6934350000000001e-06
+ 3.6124999999999998p -1.6764670000000001e-06 3.625p -1.6597190000000001e-06 3.6374999999999997p -1.643191e-06 3.6499999999999999p -1.626889e-06 3.6624999999999996p -1.6108140000000001e-06 3.6750000000000003p -1.594969e-06 3.6875p -1.5793559999999999e-06 3.7000000000000002p -1.563977e-06 3.7124999999999999p -1.548836e-06 3.7250000000000005p -1.5339329999999999e-06 3.7375000000000003p -1.51927e-06 3.75p -1.5048500000000001e-06 3.7624999999999997p -1.4906740000000001e-06 3.7750000000000004p -1.4767439999999999e-06 3.7875000000000001p -1.46306e-06 3.7999999999999998p -1.4496230000000001e-06 3.8124999999999996p -1.4364360000000001e-06 3.8250000000000002p -1.423499e-06
+ 3.8375000000000004p -1.410812e-06 3.8500000000000001p -1.398377e-06 3.8624999999999998p -1.386193e-06 3.8750000000000004p -1.3742610000000001e-06 3.8875000000000002p -1.362582e-06 3.8999999999999999p -1.3511559999999999e-06 3.9124999999999996p -1.339982e-06 3.9250000000000003p -1.3290600000000001e-06 3.9375p -1.3183900000000001e-06 3.9499999999999997p -1.3079710000000001e-06 3.9624999999999999p -1.297803e-06 3.9750000000000005p -1.287886e-06 3.9875000000000003p -1.2782169999999999e-06 4p -1.2687959999999999e-06 4.0124999999999993p -1.2596219999999999e-06 4.0250000000000004p -1.250693e-06 4.0375000000000005p -1.2420079999999999e-06 4.0499999999999998p -1.233565e-06
+ 4.0625p -1.225362e-06 4.0750000000000002p -1.2173969999999999e-06 4.0875000000000004p -1.209669e-06 4.0999999999999996p -1.2021750000000001e-06 4.1124999999999998p -1.1949120000000001e-06 4.125p -1.1878779999999999e-06 4.1375000000000002p -1.1810710000000001e-06 4.1499999999999995p -1.174488e-06 4.1624999999999996p -1.168126e-06 4.1750000000000007p -1.161981e-06 4.1875p -1.156051e-06 4.2000000000000002p -1.1503339999999999e-06 4.2124999999999995p -1.1448240000000001e-06 4.2250000000000005p -1.13952e-06 4.2374999999999998p -1.1344169999999999e-06 4.25p -1.1295120000000001e-06 4.2624999999999993p -1.1248020000000001e-06 4.2750000000000004p -1.120282e-06
+ 4.2874999999999996p -1.1159500000000001e-06 4.2999999999999998p -1.1118000000000001e-06 4.3125p -1.107831e-06 4.3250000000000002p -1.1040360000000001e-06 4.3375000000000004p -1.100413e-06 4.3499999999999996p -1.0969579999999999e-06 4.3624999999999998p -1.0936659999999999e-06 4.375p -1.0905340000000001e-06 4.3875000000000002p -1.0875570000000001e-06 4.3999999999999995p -1.084731e-06 4.4124999999999996p -1.0820519999999999e-06 4.4249999999999998p -1.079516e-06 4.4375p -1.0771189999999999e-06 4.4500000000000002p -1.0748559999999999e-06 4.4624999999999995p -1.0727239999999999e-06 4.4750000000000005p -1.070717e-06 4.4874999999999998p -1.0688330000000001e-06 4.5p -1.067066e-06
+ 4.5124999999999993p -1.0654129999999999e-06 4.5250000000000004p -1.0638699999999999e-06 4.5374999999999996p -1.062431e-06 4.5499999999999998p -1.0610929999999999e-06 4.5625p -1.059852e-06 4.5750000000000002p -1.058703e-06 4.5875000000000004p -1.057643e-06 4.5999999999999996p -1.0566669999999999e-06 4.6125000000000007p -1.055771e-06 4.625p -1.054951e-06 4.6375000000000002p -1.0542030000000001e-06 4.6499999999999995p -1.0535219999999999e-06 4.6625000000000005p -1.052905e-06 4.6749999999999998p -1.0523479999999999e-06 4.6875p -1.051845e-06 4.7000000000000002p -1.0513940000000001e-06 4.7125000000000004p -1.0509909999999999e-06 4.7250000000000005p -1.0506299999999999e-06
+ 4.7374999999999998p -1.050309e-06 4.75p -1.0500229999999999e-06 4.7625000000000002p -1.0497680000000001e-06 4.7750000000000004p -1.0495399999999999e-06 4.7874999999999996p -1.049335e-06 4.7999999999999998p -1.0491499999999999e-06 4.8125p -1.0489799999999999e-06 4.8250000000000002p -1.048821e-06 4.8375000000000004p -1.04867e-06 4.8499999999999996p -1.048523e-06 4.8625000000000007p -1.0483749999999999e-06 4.875p -1.048224e-06 4.8875000000000002p -1.048064e-06 4.8999999999999995p -1.047893e-06 4.9125000000000005p -1.0477069999999999e-06 4.9249999999999998p -1.047501e-06 4.9375p -1.047273e-06 4.9499999999999993p -1.047018e-06
+ 4.9625000000000004p -1.0467329999999999e-06 4.9750000000000005p -1.046415e-06 4.9874999999999998p -1.046059e-06 5p -1.045662e-06 5.0125000000000002p -1.0452219999999999e-06 5.0250000000000004p -1.044733e-06 5.0374999999999996p -1.0441939999999999e-06 5.0499999999999998p -1.0436000000000001e-06 5.0625p -1.0429480000000001e-06 5.0750000000000002p -1.0422360000000001e-06 5.0874999999999995p -1.041459e-06 5.0999999999999996p -1.0406160000000001e-06 5.1125000000000007p -1.039702e-06 5.125p -1.0387150000000001e-06 5.1375000000000002p -1.037652e-06 5.1499999999999995p -1.036511e-06 5.1625000000000005p -1.0352869999999999e-06 5.1749999999999998p -1.033979e-06
+ 5.1875p -1.0325850000000001e-06 5.1999999999999993p -1.031101e-06 5.2125000000000004p -1.0295249999999999e-06 5.2249999999999996p -1.027855e-06 5.2374999999999998p -1.0260880000000001e-06 5.25p -1.0242230000000001e-06 5.2625000000000002p -1.022257e-06 5.2750000000000004p -1.0201889999999999e-06 5.2874999999999996p -1.0180160000000001e-06 5.2999999999999998p -1.015737e-06 5.3125p -1.013351e-06 5.3250000000000002p -1.0108539999999999e-06 5.3374999999999995p -1.008247e-06 5.3499999999999996p -1.0055280000000001e-06 5.3624999999999998p -1.002696e-06 5.375p -9.9974890000000008e-07 5.3875000000000002p -9.9668669999999995e-07 5.3999999999999995p -9.9350819999999999e-07
+ 5.4125000000000005p -9.9021279999999991e-07 5.4249999999999998p -9.8679979999999993e-07 5.4375p -9.8326880000000008e-07 5.4499999999999993p -9.7961939999999997e-07 5.4625000000000004p -9.7585139999999994e-07 5.4749999999999996p -9.7196460000000009e-07 5.4874999999999998p -9.679591999999999e-07 5.5p -9.6383519999999999e-07 5.5125000000000002p -9.5959289999999996e-07 5.5250000000000004p -9.5523270000000001e-07 5.5374999999999996p -9.5075519999999998e-07 5.5500000000000007p -9.4616089999999998e-07 5.5625p -9.4145080000000005e-07 5.5750000000000002p -9.3662570000000001e-07 5.5874999999999995p -9.3168670000000005e-07 5.6000000000000005p -9.2663490000000002e-07 5.6124999999999998p -9.2147170000000003e-07 5.625p -9.1619840000000003e-07
+ 5.6375000000000002p -9.108166e-07 5.6500000000000004p -9.0532799999999997e-07 5.6625000000000005p -8.9973450000000004e-07 5.6749999999999998p -8.9403780000000004e-07 5.6875p -8.8823999999999997e-07 5.7000000000000002p -8.823434e-07 5.7125000000000004p -8.7635010000000003e-07 5.7249999999999996p -8.7026260000000002e-07 5.7374999999999998p -8.640833e-07 5.75p -8.5781499999999996e-07 5.7625000000000002p -8.5146019999999996e-07 5.7750000000000004p -8.4502189999999999e-07 5.7874999999999996p -8.3850290000000004e-07 5.8000000000000007p -8.3190639999999995e-07 5.8125p -8.2523540000000004e-07 5.8250000000000002p -8.1849310000000004e-07 5.8374999999999995p -8.1168290000000001e-07 5.8500000000000005p -8.048082e-07
+ 5.8624999999999998p -7.978725e-07 5.875p -7.9087940000000005e-07 5.8874999999999993p -7.8383249999999996e-07 5.9000000000000004p -7.7673559999999998e-07 5.9125000000000005p -7.6959239999999997e-07 5.9249999999999998p -7.6240690000000004e-07 5.9375p -7.5518300000000005e-07 5.9500000000000002p -7.4792469999999999e-07 5.9625000000000004p -7.4063610000000003e-07 5.9749999999999996p -7.3332119999999996e-07 5.9874999999999998p -7.2598430000000003e-07 6p -7.1862949999999996e-07 6.0125000000000002p -7.112611e-07 6.0249999999999995p -7.0388339999999997e-07 6.0374999999999996p -6.9650059999999998e-07 6.0500000000000007p -6.8911720000000003e-07 6.0625p -6.8173740000000001e-07 6.0750000000000002p -6.7436570000000004e-07
+ 6.0874999999999995p -6.6700639999999995e-07 6.1000000000000005p -6.5966399999999997e-07 6.1124999999999998p -6.5234269999999998e-07 6.125p -6.4504719999999998e-07 6.1374999999999993p -6.3778160000000002e-07 6.1500000000000004p -6.3055040000000001e-07 6.1624999999999996p -6.233579e-07 6.1749999999999998p -6.1620850000000005e-07 6.1875p -6.0910660000000003e-07 6.2000000000000002p -6.0205619999999996e-07 6.2125000000000004p -5.9506179999999995e-07 6.2249999999999996p -5.881274e-07 6.2374999999999998p -5.8125729999999995e-07 6.25p -5.7445550000000001e-07 6.2625000000000002p -5.677261e-07 6.2749999999999995p -5.6107309999999995e-07 6.2874999999999996p -5.5450029999999997e-07 6.2999999999999998p -5.4801160000000003e-07
+ 6.3125p -5.4161080000000003e-07 6.3250000000000002p -5.3530150000000002e-07 6.3374999999999995p -5.2908739999999997e-07 6.3500000000000005p -5.2297190000000004e-07 6.3624999999999998p -5.169585e-07 6.375p -5.1105049999999997e-07 6.3875000000000002p -5.0525110000000002e-07 6.4000000000000004p -4.9956339999999995e-07 6.4124999999999996p -4.9399050000000001e-07 6.4249999999999998p -4.8853510000000002e-07 6.4375p -4.8320019999999997e-07 6.4500000000000002p -4.7798819999999999e-07 6.4625000000000004p -4.7290180000000002e-07 6.4749999999999996p -4.6794339999999999e-07 6.4875000000000007p -4.6311509999999999e-07 6.5p -4.584193e-07 6.5125000000000002p -4.5385769999999998e-07 6.5249999999999995p -4.4943239999999999e-07
+ 6.5375000000000005p -4.4514490000000001e-07 6.5499999999999998p -4.4099700000000001e-07 6.5625p -4.3699e-07 6.5750000000000002p -4.3312509999999997e-07 6.5875000000000004p -4.294036e-07 6.6000000000000005p -4.2582640000000001e-07 6.6124999999999998p -4.2239429999999999e-07 6.625p -4.191079e-07 6.6375000000000002p -4.1596789999999999e-07 6.6500000000000004p -4.1297459999999998e-07 6.6624999999999996p -4.1012810000000002e-07 6.6749999999999998p -4.074285e-07 6.6875p -4.0487569999999998e-07 6.7000000000000002p -4.0246950000000002e-07 6.7125000000000004p -4.0020930000000001e-07 6.7249999999999996p -3.980946e-07 6.7375000000000007p -3.9612480000000002e-07 6.75p -3.9429880000000002e-07
+ 6.7625000000000002p -3.926156e-07 6.7749999999999995p -3.9107400000000002e-07 6.7875000000000005p -3.8967270000000002e-07 6.7999999999999998p -3.8841010000000001e-07 6.8125p -3.8728460000000002e-07 6.8249999999999993p -3.8629440000000003e-07 6.8375000000000004p -3.8543750000000003e-07 6.8500000000000005p -3.8471180000000003e-07 6.8624999999999998p -3.8411509999999999e-07 6.875p -3.8364499999999999e-07 6.8875000000000002p -3.8329900000000002e-07 6.9000000000000004p -3.8307450000000002e-07 6.9124999999999996p -3.829686e-07 6.9249999999999998p -3.8297860000000001e-07 6.9375p -3.8310119999999999e-07 6.9500000000000002p -3.8333350000000002e-07 6.9624999999999995p -3.8367209999999999e-07 6.9749999999999996p -3.8411369999999999e-07
+ 6.9874999999999998p -3.8465479999999999e-07 7p -3.8529189999999999e-07 7.0125000000000002p -3.8602109999999998e-07 7.0249999999999995p -3.8683879999999998e-07 7.0375000000000005p -3.8774110000000002e-07 7.0499999999999998p -3.887241e-07 7.0625p -3.8978370000000002e-07 7.0749999999999993p -3.9091569999999998e-07 7.0875000000000004p -3.9211609999999998e-07 7.0999999999999996p -3.933806e-07 7.1124999999999998p -3.9470489999999999e-07 7.125p -3.960845e-07 7.1375000000000002p -3.9751519999999998e-07 7.1500000000000004p -3.9899240000000003e-07 7.1624999999999996p -4.005117e-07 7.1749999999999998p -4.020686e-07 7.1875p -4.0365840000000002e-07 7.2000000000000002p -4.0527659999999999e-07
+ 7.2124999999999995p -4.069186e-07 7.2249999999999996p -4.0857989999999998e-07 7.2374999999999998p -4.1025569999999999e-07 7.25p -4.1194150000000001e-07 7.2625000000000002p -4.1363269999999998e-07 7.2749999999999995p -4.1532469999999999e-07 7.2874999999999996p -4.1701289999999998e-07 7.2999999999999998p -4.1869279999999999e-07 7.3125000000000009p -4.203598e-07 7.3249999999999993p -4.2200949999999999e-07 7.3375000000000004p -4.2363739999999999e-07 7.3500000000000005p -4.2523909999999998e-07 7.3624999999999998p -4.2681030000000002e-07 7.375p -4.283466e-07 7.3874999999999993p -4.2984380000000001e-07 7.4000000000000004p -4.3129780000000002e-07 7.4125000000000005p -4.3270439999999998e-07 7.4249999999999998p -4.3405969999999998e-07
+ 7.4375p -4.3535959999999998e-07 7.4500000000000011p -4.366004e-07 7.4624999999999995p -4.3777830000000002e-07 7.4750000000000005p -4.3888960000000001e-07 7.4874999999999989p -4.3993069999999999e-07 7.5p -4.4089820000000002e-07 7.5125000000000002p -4.4178879999999998e-07 7.5249999999999995p -4.4259910000000002e-07 7.5375000000000005p -4.4332609999999997e-07 7.5500000000000007p -4.4396680000000001e-07 7.5625p -4.4451829999999999e-07 7.5750000000000002p -4.4497780000000002e-07 7.5874999999999995p -4.4534269999999999e-07 7.5999999999999996p -4.4561059999999998e-07 7.6125000000000007p -4.4577899999999998e-07 7.6249999999999991p -4.4584589999999999e-07 7.6375000000000002p -4.4580900000000002e-07 7.6500000000000004p -4.456665e-07
+ 7.6624999999999996p -4.4541670000000002e-07 7.6750000000000007p -4.450579e-07 7.6874999999999991p -4.445885e-07 7.7000000000000002p -4.4400740000000001e-07 7.7125000000000004p -4.4331330000000002e-07 7.7249999999999996p -4.4250520000000001e-07 7.7374999999999998p -4.4158229999999999e-07 7.7500000000000009p -4.4054390000000001e-07 7.7624999999999993p -4.3938940000000001e-07 7.7750000000000004p -4.3811839999999997e-07 7.7874999999999996p -4.3673080000000001e-07 7.7999999999999998p -4.3522639999999998e-07 7.8125000000000009p -4.3360540000000002e-07 7.8249999999999993p -4.3186800000000001e-07 7.8375000000000004p -4.3001459999999998e-07 7.8500000000000005p -4.2804569999999999e-07 7.8624999999999998p -4.2596220000000002e-07 7.875p -4.2376490000000002e-07
+ 7.8874999999999993p -4.2145470000000001e-07 7.8999999999999995p -4.1903299999999999e-07 7.9125000000000005p -4.1650099999999998e-07 7.9249999999999998p -4.1386020000000001e-07 7.9375p -4.1111220000000002e-07 7.9500000000000011p -4.0825880000000002e-07 7.9624999999999995p -4.0530190000000002e-07 7.9750000000000005p -4.0224360000000002e-07 7.9874999999999989p -3.99086e-07 8p -3.9583150000000001e-07 8.0125000000000011p -3.924824e-07 8.0249999999999986p -3.8904139999999999e-07 8.0374999999999996p -3.8551119999999997e-07 8.0500000000000007p -3.8189450000000001e-07 8.0625p -3.781944e-07 8.0750000000000011p -3.744137e-07 8.0874999999999986p -3.7055580000000002e-07 8.0999999999999996p -3.6662370000000001e-07
+ 8.1125000000000007p -3.6262089999999998e-07 8.125p -3.5855079999999998e-07 8.1374999999999993p -3.544169e-07 8.1500000000000004p -3.5022280000000001e-07 8.1624999999999996p -3.459723e-07 8.1750000000000007p -3.4166899999999999e-07 8.1875p -3.3731679999999999e-07 8.1999999999999993p -3.3291960000000002e-07 8.2125000000000004p -3.2848139999999998e-07 8.2249999999999996p -3.2400609999999999e-07 8.2375000000000007p -3.1949789999999997e-07 8.25p -3.1496070000000001e-07 8.2624999999999993p -3.1039880000000001e-07 8.2750000000000004p -3.0581629999999999e-07 8.2875000000000014p -3.0121739999999999e-07 8.2999999999999989p -2.9660640000000002e-07 8.3125p -2.9198730000000001e-07 8.3249999999999993p -2.8736460000000001e-07
+ 8.3375000000000004p -2.8274239999999997e-07 8.3500000000000014p -2.7812499999999998e-07 8.3624999999999989p -2.7351659999999998e-07 8.375p -2.6892149999999999e-07 8.3875000000000011p -2.6434380000000002e-07 8.4000000000000004p -2.5978769999999999e-07 8.4124999999999996p -2.5525740000000002e-07 8.4249999999999989p -2.5075689999999998e-07 8.4375p -2.4629049999999998e-07 8.4500000000000011p -2.4186210000000002e-07 8.4625000000000004p -2.3747560000000001e-07 8.4749999999999996p -2.3313509999999999e-07 8.4875000000000007p -2.2884430000000001e-07 8.5p -2.246072e-07 8.5125000000000011p -2.204273e-07 8.5249999999999986p -2.1630849999999999e-07 8.5374999999999996p -2.122542e-07 8.5500000000000007p -2.082679e-07
+ 8.5625p -2.043531e-07 8.5749999999999993p -2.0051299999999999e-07 8.5875000000000004p -1.9675089999999999e-07 8.5999999999999996p -1.930699e-07 8.6125000000000007p -1.8947299999999999e-07 8.625p -1.8596300000000001e-07 8.6374999999999993p -1.825429e-07 8.6500000000000004p -1.792151e-07 8.6624999999999996p -1.7598239999999999e-07 8.6750000000000007p -1.7284700000000001e-07 8.6875p -1.6981140000000001e-07 8.6999999999999993p -1.668776e-07 8.7125000000000004p -1.640478e-07 8.7249999999999996p -1.6132380000000001e-07 8.7375000000000007p -1.5870739999999999e-07 8.75p -1.5620019999999999e-07 8.7624999999999993p -1.5380369999999999e-07 8.7750000000000004p -1.515193e-07
+ 8.7875000000000014p -1.4934809999999999e-07 8.7999999999999989p -1.4729129999999999e-07 8.8125p -1.453498e-07 8.8249999999999993p -1.4352419999999999e-07 8.8375000000000004p -1.418154e-07 8.8499999999999996p -1.402236e-07 8.8624999999999989p -1.387493e-07 8.875p -1.373926e-07 8.8875000000000011p -1.3615359999999999e-07 8.9000000000000004p -1.350322e-07 8.9124999999999996p -1.3402799999999999e-07 8.9249999999999989p -1.3314059999999999e-07 8.9375p -1.3236959999999999e-07 8.9500000000000011p -1.317142e-07 8.9624999999999986p -1.3117349999999999e-07 8.9749999999999996p -1.307466e-07 8.9875000000000007p -1.3043229999999999e-07 9p -1.302293e-07
+ 9.0125000000000011p -1.301363e-07 9.0249999999999986p -1.301518e-07 9.0374999999999996p -1.302739e-07 9.0500000000000007p -1.3050100000000001e-07 9.0625p -1.3083099999999999e-07 9.0749999999999993p -1.31262e-07 9.0875000000000004p -1.3179169999999999e-07 9.0999999999999996p -1.324179e-07 9.1125000000000007p -1.331381e-07 9.125p -1.3394979999999999e-07 9.1374999999999993p -1.3485039999999999e-07 9.1500000000000004p -1.3583709999999999e-07 9.1624999999999996p -1.3690709999999999e-07 9.1750000000000007p -1.380574e-07 9.1875p -1.3928510000000001e-07 9.1999999999999993p -1.4058689999999999e-07 9.2125000000000004p -1.4195970000000001e-07 9.2250000000000014p -1.4340020000000001e-07
+ 9.2374999999999989p -1.449051e-07 9.25p -1.464709e-07 9.2624999999999993p -1.48094e-07 9.2750000000000004p -1.4977109999999999e-07 9.2875000000000014p -1.5149839999999999e-07 9.2999999999999989p -1.5327220000000001e-07 9.3125p -1.5508899999999999e-07 9.3250000000000011p -1.569448e-07 9.3375000000000004p -1.5883589999999999e-07 9.3499999999999996p -1.607586e-07 9.3624999999999989p -1.6270890000000001e-07 9.375p -1.6468299999999999e-07 9.3875000000000011p -1.6667690000000001e-07 9.4000000000000004p -1.6868689999999999e-07 9.4124999999999996p -1.707089e-07 9.4250000000000007p -1.7273920000000001e-07 9.4375p -1.747737e-07 9.4500000000000011p -1.768087e-07
+ 9.4624999999999986p -1.788401e-07 9.4749999999999996p -1.808643e-07 9.4875000000000007p -1.8287730000000001e-07 9.5p -1.8487539999999999e-07 9.5124999999999993p -1.868548e-07 9.5250000000000004p -1.888118e-07 9.5374999999999996p -1.907427e-07 9.5500000000000007p -1.926439e-07 9.5625p -1.9451170000000001e-07 9.5749999999999993p -1.9634279999999999e-07 9.5875000000000004p -1.981336e-07 9.5999999999999996p -1.998808e-07 9.6125000000000007p -2.015811e-07 9.625p -2.0323120000000001e-07 9.6374999999999993p -2.0482800000000001e-07 9.6500000000000004p -2.0636829999999999e-07 9.6624999999999996p -2.0784939999999999e-07 9.6750000000000007p -2.0926810000000001e-07
+ 9.6875p -2.106219e-07 9.6999999999999993p -2.119079e-07 9.7125000000000004p -2.131236e-07 9.7250000000000014p -2.1426650000000001e-07 9.7374999999999989p -2.153342e-07 9.75p -2.1632450000000001e-07 9.7624999999999993p -2.1723520000000001e-07 9.7750000000000004p -2.1806440000000001e-07 9.7874999999999996p -2.1881000000000001e-07 9.7999999999999989p -2.194703e-07 9.8125p -2.2004360000000001e-07 9.8250000000000011p -2.2052849999999999e-07 9.8375000000000004p -2.2092339999999999e-07 9.8499999999999996p -2.2122720000000001e-07 9.8624999999999989p -2.2143860000000001e-07 9.875p -2.2155660000000001e-07 9.8875000000000011p -2.215804e-07 9.8999999999999986p -2.2150909999999999e-07
+ 9.9124999999999996p -2.2134220000000001e-07 9.9250000000000007p -2.210792e-07 9.9375p -2.207198e-07 9.9500000000000011p -2.202636e-07 9.9624999999999986p -2.197107e-07 9.9749999999999996p -2.190611e-07 9.9875000000000007p -2.1831489999999999e-07 10p -2.1747260000000001e-07 10.012499999999999p 6.2677669999999995e-08 10.025p 3.2706280000000001e-07 10.0375p 5.741478e-07 10.050000000000001p 8.0335699999999999e-07 10.0625p 1.014532e-06 10.074999999999999p 1.207749e-06 10.0875p 1.3832529999999999e-06 10.1p 1.54143e-06 10.112500000000001p 1.682786e-06 10.125p 1.807942e-06
+ 10.137499999999999p 1.917614e-06 10.15p 2.0126079999999998e-06 10.162500000000001p 2.0938019999999998e-06 10.174999999999999p 2.1621379999999998e-06 10.1875p 2.2186100000000001e-06 10.199999999999999p 2.26425e-06 10.2125p 2.3001179999999999e-06 10.225000000000001p 2.3272930000000002e-06 10.237499999999999p 2.3468600000000001e-06 10.25p 2.3599000000000001e-06 10.262500000000001p 2.3674820000000001e-06 10.275p 2.370652e-06 10.2875p 2.370429e-06 10.299999999999999p 2.367791e-06 10.3125p 2.3636760000000001e-06 10.325000000000001p 2.3589699999999998e-06 10.3375p 2.3545029999999999e-06 10.35p 2.3510469999999998e-06
+ 10.362500000000001p 2.3493090000000001e-06 10.375p 2.349933e-06 10.387500000000001p 2.353491e-06 10.399999999999999p 2.360487e-06 10.4125p 2.3713550000000001e-06 10.425000000000001p 2.3864569999999998e-06 10.4375p 2.4060860000000002e-06 10.449999999999999p 2.4304660000000002e-06 10.4625p 2.4597520000000001e-06 10.475p 2.4940359999999999e-06 10.487500000000001p 2.533348e-06 10.5p 2.577656e-06 10.512499999999999p 2.6268750000000002e-06 10.525p 2.6808659999999999e-06 10.5375p 2.7394430000000001e-06 10.550000000000001p 2.8023759999999998e-06 10.5625p 2.8693950000000001e-06 10.574999999999999p 2.9401949999999999e-06
+ 10.5875p 3.014443e-06 10.6p 3.091776e-06 10.612500000000001p 3.171813e-06 10.625p 3.2541560000000002e-06 10.637499999999999p 3.3383939999999999e-06 10.65p 3.4241099999999998e-06 10.662500000000001p 3.5108820000000001e-06 10.674999999999999p 3.5982870000000002e-06 10.6875p 3.6859109999999998e-06 10.699999999999999p 3.7733419999999998e-06 10.7125p 3.8601840000000003e-06 10.725p 3.946053e-06 10.737499999999999p 4.0305809999999997e-06 10.75p 4.1134219999999996e-06 10.762500000000001p 4.1942490000000003e-06 10.775p 4.272761e-06 10.7875p 4.3486810000000001e-06 10.799999999999999p 4.4217590000000001e-06
+ 10.8125p 4.4917709999999998e-06 10.825000000000001p 4.5585230000000001e-06 10.837499999999999p 4.6218490000000002e-06 10.85p 4.6816129999999999e-06 10.862500000000001p 4.7377070000000004e-06 10.875p 4.79005e-06 10.887500000000001p 4.8385910000000001e-06 10.899999999999999p 4.8833070000000003e-06 10.9125p 4.924199e-06 10.925000000000001p 4.9612960000000001e-06 10.9375p 4.9946490000000003e-06 10.949999999999999p 5.0243320000000004e-06 10.9625p 5.0504419999999998e-06 10.975p 5.0730929999999998e-06 10.987500000000001p 5.092419e-06 11p 5.1085689999999999e-06 11.012499999999999p 4.8424959999999997e-06 11.025p 4.5894469999999999e-06
+ 11.0375p 4.3511450000000003e-06 11.050000000000001p 4.1283610000000001e-06 11.0625p 3.9214560000000001e-06 11.074999999999999p 3.7305629999999999e-06 11.0875p 3.5556470000000001e-06 11.100000000000001p 3.396537e-06 11.112499999999999p 3.2529400000000001e-06 11.125p 3.1244499999999998e-06 11.137499999999999p 3.0105580000000001e-06 11.15p 2.9106679999999999e-06 11.162500000000001p 2.824101e-06 11.174999999999999p 2.7501120000000001e-06 11.1875p 2.6878950000000002e-06 11.200000000000001p 2.6365960000000002e-06 11.2125p 2.5953259999999998e-06 11.225p 2.563167e-06 11.237499999999999p 2.539185e-06 11.25p 2.522438e-06
+ 11.262500000000001p 2.5119870000000001e-06 11.275p 2.5069000000000001e-06 11.2875p 2.5062670000000002e-06 11.300000000000001p 2.5092009999999999e-06 11.3125p 2.5148469999999999e-06 11.325000000000001p 2.5223910000000002e-06 11.337499999999999p 2.53106e-06 11.35p 2.5401309999999998e-06 11.362500000000001p 2.5489339999999999e-06 11.375p 2.5568549999999998e-06 11.387499999999999p 2.5633359999999998e-06 11.4p 2.5678819999999999e-06 11.4125p 2.5700610000000002e-06 11.425000000000001p 2.5695000000000001e-06 11.4375p 2.5658920000000001e-06 11.449999999999999p 2.5589900000000001e-06 11.4625p 2.5486110000000001e-06 11.475p 2.534629e-06
+ 11.487500000000001p 2.516976e-06 11.5p 2.4956420000000002e-06 11.512499999999999p 2.4706679999999999e-06 11.525p 2.4421439999999998e-06 11.5375p 2.410208e-06 11.550000000000001p 2.3750390000000001e-06 11.5625p 2.3368569999999999e-06 11.574999999999999p 2.2959159999999999e-06 11.5875p 2.2525009999999998e-06 11.600000000000001p 2.2069250000000001e-06 11.612499999999999p 2.1595229999999998e-06 11.625p 2.110649e-06 11.637499999999999p 2.0606720000000001e-06 11.65p 2.0099719999999999e-06 11.6625p 1.9589360000000001e-06 11.674999999999999p 1.907953e-06 11.6875p 1.8574119999999999e-06 11.700000000000001p 1.8077000000000001e-06
+ 11.7125p 1.7591950000000001e-06 11.725p 1.712266e-06 11.737499999999999p 1.6672690000000001e-06 11.75p 1.624545e-06 11.762500000000001p 1.5844170000000001e-06 11.774999999999999p 1.5471890000000001e-06 11.7875p 1.5131449999999999e-06 11.800000000000001p 1.4825439999999999e-06 11.8125p 1.4556230000000001e-06 11.825000000000001p 1.432592e-06 11.8375p 1.4136389999999999e-06 11.85p 1.398922e-06 11.862500000000001p 1.3885759999999999e-06 11.875p 1.3827070000000001e-06 11.887499999999999p 1.3813959999999999e-06 11.9p 1.384698e-06 11.9125p 1.3926429999999999e-06 11.925000000000001p 1.4052360000000001e-06
+ 11.9375p 1.4224590000000001e-06 11.949999999999999p 1.4442699999999999e-06 11.9625p 1.4706069999999999e-06 11.975p 1.5013849999999999e-06 11.987500000000001p 1.5365039999999999e-06 12p 1.5758419999999999e-06 12.012499999999999p 1.619264e-06 12.025p 1.6666169999999999e-06 12.037500000000001p 1.7177380000000001e-06 12.049999999999999p 1.7724500000000001e-06 12.0625p 1.830565e-06 12.074999999999999p 1.891889e-06 12.0875p 1.9562180000000001e-06 12.100000000000001p 2.0233429999999999e-06 12.112499999999999p 2.0930499999999998e-06 12.125p 2.165122e-06 12.137500000000001p 2.239341e-06 12.15p 2.315487e-06
+ 12.1625p 2.3933399999999999e-06 12.174999999999999p 2.472682e-06 12.1875p 2.5532980000000001e-06 12.200000000000001p 2.6349759999999999e-06 12.2125p 2.717506e-06 12.225p 2.8006860000000002e-06 12.237500000000001p 2.8843169999999999e-06 12.25p 2.9682070000000002e-06 12.262500000000001p 3.0521700000000002e-06 12.274999999999999p 3.1360269999999998e-06 12.2875p 3.219607e-06 12.300000000000001p 3.3027440000000001e-06 12.3125p 3.3852810000000001e-06 12.324999999999999p 3.467069e-06 12.3375p 3.5479649999999998e-06 12.35p 3.6278350000000001e-06 12.362500000000001p 3.7065520000000002e-06 12.375p 3.783996e-06
+ 12.387499999999999p 3.8600539999999997e-06 12.4p 3.9346200000000001e-06 12.4125p 4.0075939999999998e-06 12.425000000000001p 4.0788849999999998e-06 12.4375p 4.1484040000000001e-06 12.449999999999999p 4.2160720000000002e-06 12.4625p 4.2818110000000003e-06 12.475p 4.3455509999999997e-06 12.487500000000001p 4.4072269999999996e-06 12.5p 4.4667760000000003e-06 12.512499999999999p 4.5241410000000001e-06 12.525p 4.5792670000000001e-06 12.537500000000001p 4.6321049999999996e-06 12.549999999999999p 4.6826059999999996e-06 12.5625p 4.7307259999999997e-06 12.574999999999999p 4.7764230000000001e-06 12.5875p 4.8196560000000003e-06 12.6p 4.860389e-06
+ 12.612499999999999p 4.8985849999999998e-06 12.625p 4.93421e-06 12.637500000000001p 4.9672310000000003e-06 12.65p 4.9976170000000001e-06 12.6625p 5.025339e-06 12.674999999999999p 5.0503679999999999e-06 12.6875p 5.0726759999999999e-06 12.700000000000001p 5.0922390000000002e-06 12.712499999999999p 5.1090319999999997e-06 12.725p 5.1230309999999997e-06 12.737500000000001p 5.1342150000000001e-06 12.75p 5.1425630000000001e-06 12.762500000000001p 5.1480569999999998e-06 12.775p 5.15068e-06 12.7875p 5.1504169999999997e-06 12.800000000000001p 5.1472539999999998e-06 12.8125p 5.1411800000000003e-06 12.824999999999999p 5.132187e-06
+ 12.8375p 5.1202690000000001e-06 12.85p 5.1054210000000002e-06 12.862500000000001p 5.0876439999999997e-06 12.875p 5.0669380000000003e-06 12.887499999999999p 5.0433100000000003e-06 12.9p 5.0167679999999999e-06 12.9125p 4.9873240000000003e-06 12.925000000000001p 4.9549940000000003e-06 12.9375p 4.9197980000000003e-06 12.949999999999999p 4.8817579999999997e-06 12.9625p 4.8409020000000002e-06 12.975000000000001p 4.7972630000000003e-06 12.987499999999999p 4.7508749999999996e-06 13p 4.7017799999999999e-06 13.012499999999999p 4.6500210000000003e-06 13.025p 4.5956469999999999e-06 13.037500000000001p 4.5387119999999998e-06 13.049999999999999p 4.4792740000000002e-06
+ 13.0625p 4.4173939999999997e-06 13.075000000000001p 4.3531400000000001e-06 13.0875p 4.2865819999999997e-06 13.1p 4.2177950000000002e-06 13.112499999999999p 4.1468580000000002e-06 13.125p 4.0738550000000003e-06 13.137500000000001p 3.9988730000000003e-06 13.15p 3.9220020000000004e-06 13.1625p 3.8433369999999997e-06 13.175000000000001p 3.7629750000000002e-06 13.1875p 3.6810180000000001e-06 13.200000000000001p 3.5975689999999999e-06 13.212499999999999p 3.5127339999999999e-06 13.225p 3.4266229999999999e-06 13.237500000000001p 3.3393470000000002e-06 13.25p 3.2510190000000002e-06 13.262499999999999p 3.1617530000000001e-06 13.275p 3.0716649999999998e-06
+ 13.2875p 2.9808739999999998e-06 13.300000000000001p 2.8894970000000002e-06 13.3125p 2.7976530000000001e-06 13.324999999999999p 2.7054610000000002e-06 13.3375p 2.6130389999999998e-06 13.35p 2.5205069999999998e-06 13.362500000000001p 2.427983e-06 13.375p 2.3355829999999999e-06 13.387499999999999p 2.243425e-06 13.4p 2.151622e-06 13.4125p 2.0602880000000001e-06 13.425000000000001p 1.9695349999999999e-06 13.4375p 1.879472e-06 13.449999999999999p 1.790207e-06 13.4625p 1.7018430000000001e-06 13.475000000000001p 1.6144829999999999e-06 13.487499999999999p 1.5282259999999999e-06 13.5p 1.44317e-06
+ 13.512499999999999p 1.359406e-06 13.525p 1.2770260000000001e-06 13.5375p 1.1961169999999999e-06 13.549999999999999p 1.116761e-06 13.5625p 1.0390389999999999e-06 13.575000000000001p 9.6302900000000009e-07 13.5875p 8.8880270000000002e-07 13.6p 8.164302e-07 13.612499999999999p 7.4597770000000003e-07 13.625p 6.7750790000000004e-07 13.637500000000001p 6.1108000000000004e-07 13.649999999999999p 5.4674960000000003e-07 13.6625p 4.8456899999999998e-07 13.675000000000001p 4.2458709999999998e-07 13.6875p 3.6684950000000002e-07 13.700000000000001p 3.1139850000000001e-07 13.7125p 2.5827349999999999e-07 13.725p 2.0751059999999999e-07
+ 13.737500000000001p 1.591428e-07 13.75p 1.1320070000000001e-07 13.762499999999999p 6.971164e-08 13.775p 2.8700549999999999e-08 13.7875p -9.8103099999999994e-09 13.800000000000001p -4.5801130000000003e-08 13.8125p -7.9254489999999994e-08 13.824999999999999p -1.1015519999999999e-07 13.8375p -1.3849050000000001e-07 13.85p -1.6424930000000001e-07 13.862500000000001p -1.87423e-07 13.875p -2.0800459999999999e-07 13.887499999999999p -2.259893e-07 13.9p -2.4137370000000002e-07 13.912500000000001p -2.541566e-07 13.924999999999999p -2.6433819999999998e-07 13.9375p -2.7192060000000002e-07 13.949999999999999p -2.7690749999999999e-07
+ 13.9625p -2.7930420000000001e-07 13.975p -2.7911750000000001e-07 13.987499999999999p -2.7635610000000001e-07 14p -2.710302e-07 14.012500000000001p -2.631517e-07 14.025p -2.5273410000000001e-07 14.0375p -2.3979270000000001e-07 14.049999999999999p -2.2434440000000001e-07 14.0625p -2.0640819999999999e-07 14.075000000000001p -1.860047e-07 14.0875p -1.631565e-07 14.1p -1.3788820000000001e-07 14.112500000000001p -1.102265e-07 14.125p -8.0200099999999996e-08 14.137500000000001p -4.783999e-08 14.149999999999999p -1.317941e-08 14.1625p 2.3746059999999999e-08 14.175000000000001p 6.2898399999999994e-08
+ 14.1875p 1.042371e-07 14.199999999999999p 1.4771909999999999e-07 14.2125p 1.9329859999999999e-07 14.225p 2.4092740000000002e-07 14.237500000000001p 2.9055410000000001e-07 14.25p 3.4212489999999998e-07 14.262499999999999p 3.9558289999999998e-07 14.275p 4.5086850000000002e-07 14.2875p 5.0791900000000004e-07 14.300000000000001p 5.66669e-07 14.3125p 6.2705010000000004e-07 14.324999999999999p 6.8899079999999997e-07 14.3375p 7.5241689999999999e-07 14.35p 8.172512e-07 14.362500000000001p 8.8341390000000001e-07 14.375p 9.5082209999999998e-07 14.387499999999999p 1.0193900000000001e-06 14.4p 1.0890310000000001e-06
+ 14.412500000000001p 1.159652e-06 14.424999999999999p 1.231162e-06 14.4375p 1.303465e-06 14.449999999999999p 1.3764629999999999e-06 14.4625p 1.4500559999999999e-06 14.475p 1.5241430000000001e-06 14.487499999999999p 1.598621e-06 14.5p 1.6733839999999999e-06 14.512500000000001p 1.748327e-06 14.525p 1.8233420000000001e-06 14.5375p 1.89832e-06 14.549999999999999p 1.973152e-06 14.562500000000002p 2.0477279999999998e-06 14.574999999999999p 2.1219380000000002e-06 14.587499999999999p 2.1956720000000001e-06 14.6p 2.2688179999999998e-06 14.612500000000001p 2.3412679999999999e-06 14.625000000000002p 2.4129120000000001e-06
+ 14.637499999999999p 2.4836400000000001e-06 14.649999999999999p 2.5533460000000002e-06 14.6625p 2.621922e-06 14.675000000000001p 2.6892649999999999e-06 14.687500000000002p 2.7552700000000001e-06 14.700000000000001p 2.8198359999999998e-06 14.712499999999999p 2.8828639999999998e-06 14.725p 2.944258e-06 14.737500000000001p 3.0039210000000001e-06 14.75p 3.0617639999999999e-06 14.762500000000001p 3.1176980000000002e-06 14.774999999999999p 3.171636e-06 14.7875p 3.223496e-06 14.800000000000001p 3.2732010000000001e-06 14.8125p 3.3206730000000001e-06 14.825000000000001p 3.3658430000000002e-06 14.837499999999999p 3.408643e-06 14.85p 3.4490080000000001e-06
+ 14.862499999999999p 3.4868810000000001e-06 14.875p 3.522204e-06 14.887500000000001p 3.554928e-06 14.900000000000002p 3.585007e-06 14.9125p 3.6123979999999999e-06 14.924999999999999p 3.6370640000000001e-06 14.9375p 3.6589720000000001e-06 14.950000000000001p 3.6780939999999998e-06 14.962500000000002p 3.6944059999999999e-06 14.974999999999998p 3.7078899999999998e-06 14.987499999999999p 3.7185320000000001e-06 15p 3.726322e-06 15.012500000000001p 3.731255e-06 15.025p 3.7333310000000001e-06 15.037499999999998p 3.7325560000000001e-06 15.049999999999999p 3.728937e-06 15.0625p 3.7224889999999998e-06 15.075000000000001p 3.713229e-06
+ 15.0875p 3.7011809999999999e-06 15.100000000000001p 3.686372e-06 15.112499999999999p 3.668832e-06 15.125p 3.6485969999999998e-06 15.137499999999999p 3.6257080000000001e-06 15.15p 3.600206e-06 15.162500000000001p 3.572142e-06 15.174999999999999p 3.5415650000000002e-06 15.1875p 3.5085310000000002e-06 15.199999999999999p 3.473099e-06 15.2125p 3.4353310000000002e-06 15.225000000000001p 3.3952929999999999e-06 15.237499999999999p 3.353055e-06 15.249999999999998p 3.3086879999999999e-06 15.262499999999999p 3.2622669999999998e-06 15.275p 3.2138710000000001e-06 15.287500000000001p 3.16358e-06 15.300000000000001p 3.1114770000000002e-06
+ 15.312499999999998p 3.057649e-06 15.324999999999999p 3.002183e-06 15.3375p 2.945169e-06 15.350000000000001p 2.8866999999999998e-06 15.362500000000001p 2.8268690000000002e-06 15.374999999999998p 2.7657730000000002e-06 15.387499999999999p 2.703507e-06 15.4p 2.6401700000000002e-06 15.4125p 2.575862e-06 15.425000000000001p 2.5106830000000001e-06 15.437499999999998p 2.444735e-06 15.449999999999999p 2.378119e-06 15.4625p 2.310938e-06 15.475p 2.2432949999999998e-06 15.487500000000001p 2.1752919999999999e-06 15.500000000000002p 2.1070319999999999e-06 15.512499999999999p 2.0386179999999999e-06 15.524999999999999p 1.970153e-06
+ 15.5375p 1.9017379999999999e-06 15.550000000000001p 1.833474e-06 15.562500000000002p 1.7654620000000001e-06 15.574999999999999p 1.6978019999999999e-06 15.587499999999999p 1.63059e-06 15.6p 1.563925e-06 15.612500000000001p 1.4979019999999999e-06 15.625000000000002p 1.432615e-06 15.637500000000001p 1.3681559999999999e-06 15.649999999999999p 1.304617e-06 15.6625p 1.242086e-06 15.675000000000001p 1.1806490000000001e-06 15.6875p 1.1203910000000001e-06 15.700000000000001p 1.061395e-06 15.712499999999999p 1.0037400000000001e-06 15.725p 9.4750409999999998e-07 15.737500000000001p 8.927628e-07 15.75p 8.3958840000000004e-07
+ 15.762500000000001p 7.8805079999999996e-07 15.774999999999999p 7.3821729999999995e-07 15.7875p 6.9015250000000004e-07 15.799999999999999p 6.439181e-07 15.8125p 5.9957309999999998e-07 15.825000000000001p 5.571734e-07 15.837500000000002p 5.1677229999999997e-07 15.85p 4.7841999999999997e-07 15.862499999999999p 4.421638e-07 15.875p 4.0804819999999999e-07 15.887500000000001p 3.7611460000000001e-07 15.900000000000002p 3.4640150000000002e-07 15.912499999999998p 3.189443e-07 15.924999999999999p 2.9377579999999999e-07 15.9375p 2.7092549999999999e-07 15.950000000000001p 2.5042020000000003e-07 15.9625p 2.3228369999999999e-07 15.974999999999998p 2.1653690000000001e-07
+ 15.987499999999999p 2.0319799999999999e-07 16p 1.92282e-07 16.012499999999999p 1.8380139999999999e-07 16.025000000000002p 1.777657e-07 16.037500000000001p 1.741816e-07 16.049999999999997p 1.7305319999999999e-07 16.0625p 1.7438149999999999e-07 16.074999999999999p 1.7816519999999999e-07 16.087500000000002p 1.844001e-07 16.100000000000001p 1.930791e-07 16.112499999999997p 2.041927e-07 16.125p 2.177287e-07 16.137499999999999p 2.3367230000000001e-07 16.150000000000002p 2.520058e-07 16.162500000000001p 2.7270920000000002e-07 16.174999999999997p 2.9575980000000001e-07 16.1875p 3.2113239999999999e-07 16.199999999999999p 3.4879900000000003e-07
+ 16.212499999999999p 3.7872930000000001e-07 16.225000000000001p 4.1089040000000002e-07 16.237500000000001p 4.4524669999999999e-07 16.25p 4.8176040000000002e-07 16.262499999999999p 5.2039090000000005e-07 16.274999999999999p 5.6109539999999995e-07 16.287500000000001p 6.0382840000000005e-07 16.300000000000001p 6.4854209999999995e-07 16.3125p 6.9518629999999999e-07 16.324999999999999p 7.4370830000000001e-07 16.337499999999999p 7.9405330000000005e-07 16.350000000000001p 8.4616389999999996e-07 16.362500000000001p 8.9998070000000004e-07 16.375p 9.554418e-07 16.387499999999999p 1.012483e-06 16.399999999999999p 1.071039e-06 16.412500000000001p 1.1310419999999999e-06 16.425000000000001p 1.1924199999999999e-06
+ 16.4375p 1.2551029999999999e-06 16.449999999999999p 1.319016e-06 16.462499999999999p 1.384084e-06 16.475000000000001p 1.4502290000000001e-06 16.487500000000001p 1.517373e-06 16.5p 1.585436e-06 16.512499999999999p 1.6543350000000001e-06 16.524999999999999p 1.723989e-06 16.537500000000001p 1.794312e-06 16.550000000000001p 1.8652210000000001e-06 16.5625p 1.9366280000000002e-06 16.575000000000003p 2.0084480000000002e-06 16.587499999999999p 2.0805930000000001e-06 16.599999999999998p 2.1529740000000001e-06 16.612500000000001p 2.225505e-06 16.625p 2.298096e-06 16.637500000000003p 2.3706580000000001e-06 16.649999999999999p 2.4431040000000001e-06
+ 16.662499999999998p 2.5153439999999998e-06 16.675000000000001p 2.5872899999999999e-06 16.6875p 2.6588540000000001e-06 16.700000000000003p 2.7299490000000002e-06 16.712499999999999p 2.800487e-06 16.724999999999998p 2.8703829999999998e-06 16.737500000000001p 2.9395509999999999e-06 16.75p 3.007907e-06 16.762499999999999p 3.075367e-06 16.775000000000002p 3.141849e-06 16.787499999999998p 3.2072719999999998e-06 16.800000000000001p 3.271555e-06 16.8125p 3.334622e-06 16.824999999999999p 3.396394e-06 16.837500000000002p 3.4567969999999998e-06 16.849999999999998p 3.5157559999999999e-06 16.862500000000001p 3.5731999999999999e-06 16.875p 3.629059e-06
+ 16.887499999999999p 3.683265e-06 16.900000000000002p 3.7357500000000002e-06 16.912499999999998p 3.786452e-06 16.925000000000001p 3.8353070000000003e-06 16.9375p 3.8822559999999997e-06 16.949999999999999p 3.9272420000000002e-06 16.962500000000002p 3.9702079999999999e-06 16.975000000000001p 4.0111030000000003e-06 16.987499999999997p 4.0498749999999999e-06 17p 4.0864770000000002e-06 17.012499999999999p 4.1208639999999996e-06 17.025000000000002p 4.1529919999999997e-06 17.037500000000001p 4.1828230000000004e-06 17.049999999999997p 4.2103199999999999e-06 17.0625p 4.2354479999999998e-06 17.074999999999999p 4.2581769999999997e-06 17.087500000000002p 4.2784789999999998e-06 17.100000000000001p 4.296329e-06
+ 17.112499999999997p 4.3117069999999997e-06 17.125p 4.3245930000000001e-06 17.137499999999999p 4.3349720000000001e-06 17.149999999999999p 4.3428339999999998e-06 17.162500000000001p 4.348171e-06 17.175000000000001p 4.3509769999999999e-06 17.1875p 4.3512519999999997e-06 17.199999999999999p 4.3489979999999997e-06 17.212499999999999p 4.3442209999999998e-06 17.225000000000001p 4.3369309999999997e-06 17.237500000000001p 4.3271410000000001e-06 17.25p 4.3148679999999999e-06 17.262499999999999p 4.3001319999999997e-06 17.274999999999999p 4.2829570000000002e-06 17.287500000000001p 4.2633700000000001e-06 17.300000000000001p 4.2414029999999996e-06 17.3125p 4.21709e-06 17.324999999999999p 4.1904679999999999e-06
+ 17.337499999999999p 4.1615800000000004e-06 17.350000000000001p 4.1304679999999996e-06 17.362500000000001p 4.097181e-06 17.375p 4.061769e-06 17.387499999999999p 4.0242850000000004e-06 17.399999999999999p 3.9847869999999998e-06 17.412500000000001p 3.9433330000000003e-06 17.425000000000001p 3.8999849999999997e-06 17.4375p 3.8548080000000001e-06 17.449999999999999p 3.8078670000000001e-06 17.462499999999999p 3.759232e-06 17.475000000000001p 3.7089740000000001e-06 17.487500000000001p 3.657165e-06 17.5p 3.6038799999999998e-06 17.512500000000003p 3.5491949999999999e-06 17.524999999999999p 3.4931859999999999e-06 17.537499999999998p 3.4359340000000001e-06 17.550000000000001p 3.3775179999999999e-06
+ 17.5625p 3.3180170000000001e-06 17.575000000000003p 3.2575149999999999e-06 17.587499999999999p 3.196092e-06 17.599999999999998p 3.1338310000000002e-06 17.612500000000001p 3.0708139999999999e-06 17.625p 3.0071239999999998e-06 17.637500000000003p 2.9428450000000002e-06 17.649999999999999p 2.8780569999999999e-06 17.662499999999998p 2.8128430000000001e-06 17.675000000000001p 2.7472839999999999e-06 17.6875p 2.6814610000000001e-06 17.699999999999999p 2.6154540000000002e-06 17.712500000000002p 2.549343e-06 17.724999999999998p 2.4832039999999999e-06 17.737500000000001p 2.4171149999999999e-06 17.75p 2.351152e-06 17.762499999999999p 2.2853879999999998e-06 17.775000000000002p 2.2198969999999998e-06
+ 17.787499999999998p 2.1547509999999998e-06 17.800000000000001p 2.090018e-06 17.8125p 2.0257669999999999e-06 17.824999999999999p 1.9620640000000001e-06 17.837500000000002p 1.8989750000000001e-06 17.849999999999998p 1.836563e-06 17.862500000000001p 1.774887e-06 17.875p 1.7140090000000001e-06 17.887499999999999p 1.653985e-06 17.900000000000002p 1.594872e-06 17.912500000000001p 1.536722e-06 17.924999999999997p 1.4795880000000001e-06 17.9375p 1.423521e-06 17.949999999999999p 1.3685670000000001e-06 17.962500000000002p 1.314775e-06 17.975000000000001p 1.262187e-06 17.987499999999997p 1.210848e-06 18p 1.1607979999999999e-06
+ 18.012499999999999p 1.1120769999999999e-06 18.025000000000002p 1.0647219999999999e-06 18.037500000000001p 1.0187680000000001e-06 18.049999999999997p 9.7425079999999997e-07 18.0625p 9.3120220000000001e-07 18.074999999999999p 8.8965319999999999e-07 18.087499999999999p 8.4963320000000003e-07 18.100000000000001p 8.1116990000000004e-07 18.112500000000001p 7.742898e-07 18.125p 7.3901760000000004e-07 18.137499999999999p 7.053764e-07 18.149999999999999p 6.7338819999999995e-07 18.162500000000001p 6.4307329999999995e-07 18.175000000000001p 6.1445059999999995e-07 18.1875p 5.8753760000000001e-07 18.199999999999999p 5.6235030000000003e-07 18.212499999999999p 5.3890339999999999e-07 18.225000000000001p 5.172101e-07
+ 18.237500000000001p 4.9728230000000005e-07 18.25p 4.7913010000000002e-07 18.262499999999999p 4.627626e-07 18.274999999999999p 4.481872e-07 18.287500000000001p 4.3540980000000002e-07 18.300000000000001p 4.2443489999999998e-07 18.3125p 4.1526550000000002e-07 18.324999999999999p 4.0790300000000002e-07 18.337499999999999p 4.0234710000000001e-07 18.350000000000001p 3.9859610000000002e-07 18.362500000000001p 3.966465e-07 18.375p 3.9649319999999999e-07 18.387499999999999p 3.9812940000000003e-07 18.399999999999999p 4.015465e-07 18.412500000000001p 4.0673399999999999e-07 18.425000000000001p 4.1367989999999999e-07 18.4375p 4.223699e-07 18.450000000000003p 4.3278829999999997e-07
+ 18.462499999999999p 4.4491690000000002e-07 18.474999999999998p 4.5873609999999998e-07 18.487500000000001p 4.7422379999999999e-07 18.5p 4.9135620000000001e-07 18.512500000000003p 5.1010740000000005e-07 18.524999999999999p 5.3044930000000004e-07 18.537499999999998p 5.5235179999999996e-07 18.550000000000001p 5.7578260000000005e-07 18.5625p 6.0070730000000004e-07 18.575000000000003p 6.2708959999999996e-07 18.587499999999999p 6.5489070000000001e-07 18.599999999999998p 6.8406999999999996e-07 18.612500000000001p 7.1458460000000005e-07 18.625p 7.4638960000000003e-07 18.637499999999999p 7.7943789999999995e-07 18.650000000000002p 8.1368050000000003e-07 18.662499999999998p 8.4906640000000004e-07 18.675000000000001p 8.8554250000000004e-07
+ 18.6875p 9.2305380000000002e-07 18.699999999999999p 9.615436e-07 18.712500000000002p 1.000953e-06 18.724999999999998p 1.0412230000000001e-06 18.737500000000001p 1.0822889999999999e-06 18.75p 1.1240899999999999e-06 18.762499999999999p 1.1665589999999999e-06 18.775000000000002p 1.209631e-06 18.787499999999998p 1.2532379999999999e-06 18.800000000000001p 1.2973099999999999e-06 18.8125p 1.341778e-06 18.824999999999999p 1.38657e-06 18.837500000000002p 1.431615e-06 18.850000000000001p 1.47684e-06 18.862499999999997p 1.5221720000000001e-06 18.875p 1.567536e-06 18.887499999999999p 1.61286e-06 18.900000000000002p 1.658068e-06
+ 18.912500000000001p 1.7030869999999999e-06 18.924999999999997p 1.7478419999999999e-06 18.9375p 1.7922580000000001e-06 18.949999999999999p 1.8362629999999999e-06 18.962500000000002p 1.8797829999999999e-06 18.975000000000001p 1.922745e-06 18.987499999999997p 1.965077e-06 19p 2.0067089999999998e-06 19.012499999999999p 2.0475700000000001e-06 19.024999999999999p 2.0875930000000002e-06 19.037500000000001p 2.1267080000000001e-06 19.050000000000001p 2.1648509999999999e-06 19.0625p 2.2019570000000001e-06 19.074999999999999p 2.237963e-06 19.087499999999999p 2.2728090000000001e-06 19.100000000000001p 2.306435e-06 19.112500000000001p 2.3387839999999999e-06 19.125p 2.3698019999999998e-06
+ 19.137499999999999p 2.399436e-06 19.149999999999999p 2.4276350000000002e-06 19.162500000000001p 2.4543529999999999e-06 19.175000000000001p 2.4795429999999999e-06 19.1875p 2.5031639999999999e-06 19.199999999999999p 2.5251740000000001e-06 19.212499999999999p 2.545537e-06 19.225000000000001p 2.5642189999999998e-06 19.237500000000001p 2.5811869999999998e-06 19.25p 2.596413e-06 19.262499999999999p 2.609871e-06 19.274999999999999p 2.6215370000000002e-06 19.287500000000001p 2.6313929999999999e-06 19.300000000000001p 2.639421e-06 19.3125p 2.6456079999999999e-06 19.324999999999999p 2.6499420000000001e-06 19.337499999999999p 2.652415e-06 19.350000000000001p 2.6530240000000001e-06
+ 19.362500000000001p 2.6517649999999998e-06 19.375p 2.6486400000000002e-06 19.387500000000003p 2.6436540000000002e-06 19.399999999999999p 2.636813e-06 19.412499999999998p 2.6281279999999998e-06 19.425000000000001p 2.6176109999999998e-06 19.4375p 2.6052769999999999e-06 19.450000000000003p 2.5911460000000001e-06 19.462499999999999p 2.5752380000000001e-06 19.474999999999998p 2.5575769999999999e-06 19.487500000000001p 2.5381899999999998e-06 19.5p 2.5171040000000001e-06 19.512500000000003p 2.4943520000000002e-06 19.524999999999999p 2.469968e-06 19.537499999999998p 2.4439859999999998e-06 19.550000000000001p 2.416445e-06 19.5625p 2.387385e-06 19.574999999999999p 2.3568480000000001e-06
+ 19.587500000000002p 2.324879e-06 19.599999999999998p 2.291523e-06 19.612500000000001p 2.2568269999999998e-06 19.625p 2.2208410000000001e-06 19.637499999999999p 2.1836160000000002e-06 19.650000000000002p 2.1452030000000001e-06 19.662499999999998p 2.1056560000000001e-06 19.675000000000001p 2.0650300000000001e-06 19.6875p 2.023379e-06 19.699999999999999p 1.9807610000000001e-06 19.712500000000002p 1.9372319999999999e-06 19.724999999999998p 1.8928520000000001e-06 19.737500000000001p 1.8476779999999999e-06 19.75p 1.8017700000000001e-06 19.762499999999999p 1.755188e-06 19.775000000000002p 1.707991e-06 19.787500000000001p 1.6602410000000001e-06 19.799999999999997p 1.6119960000000001e-06
+ 19.8125p 1.563318e-06 19.824999999999999p 1.514266e-06 19.837500000000002p 1.464902e-06 19.850000000000001p 1.415283e-06 19.862499999999997p 1.3654699999999999e-06 19.875p 1.3155219999999999e-06 19.887499999999999p 1.2654969999999999e-06 19.900000000000002p 1.215452e-06 19.912500000000001p 1.165444e-06 19.924999999999997p 1.1155299999999999e-06 19.9375p 1.0657640000000001e-06 19.949999999999999p 1.016202e-06 19.962499999999999p 9.6689580000000002e-07 19.975000000000001p 9.1789869999999998e-07 19.987500000000001p 8.6926149999999998e-07 20p 8.2103429999999997e-07 20.012499999999999p 4.9405379999999997e-07 20.024999999999999p 1.8344000000000001e-07
+ 20.037500000000001p -1.0922659999999999e-07 20.050000000000001p -3.833264e-07 20.0625p -6.3865920000000004e-07 20.074999999999999p -8.7526060000000002e-07 20.087499999999999p -1.0933369999999999e-06 20.100000000000001p -1.2932369999999999e-06 20.112500000000001p -1.475434e-06 20.125p -1.640514e-06 20.137499999999999p -1.7891660000000001e-06 20.149999999999999p -1.9221659999999999e-06 20.162500000000001p -2.0403650000000001e-06 20.175000000000001p -2.144684e-06 20.1875p -2.2360939999999999e-06 20.199999999999999p -2.3156080000000001e-06 20.212499999999999p -2.3842699999999998e-06 20.225000000000001p -2.4431450000000001e-06 20.237500000000001p -2.4933049999999998e-06 20.25p -2.5358209999999999e-06
+ 20.262499999999999p -2.5717540000000001e-06 20.274999999999999p -2.6021449999999998e-06 20.287500000000001p -2.6280079999999999e-06 20.300000000000001p -2.65032e-06 20.3125p -2.6700179999999999e-06 20.325000000000003p -2.6879889999999998e-06 20.337499999999999p -2.7050669999999999e-06 20.349999999999998p -2.7220270000000001e-06 20.362500000000001p -2.7395830000000002e-06 20.375p -2.7583840000000001e-06 20.387500000000003p -2.779009e-06 20.399999999999999p -2.8019709999999999e-06 20.412499999999998p -2.827712e-06 20.425000000000001p -2.8566030000000002e-06 20.4375p -2.888946e-06 20.450000000000003p -2.924972e-06 20.462499999999999p -2.9648489999999998e-06 20.474999999999998p -3.008675e-06
+ 20.487500000000001p -3.0564870000000002e-06 20.5p -3.1082639999999998e-06 20.512499999999999p -3.1639240000000001e-06 20.525000000000002p -3.223335e-06 20.537499999999998p -3.286317e-06 20.550000000000001p -3.3526420000000002e-06 20.5625p -3.4220430000000001e-06 20.574999999999999p -3.4942170000000002e-06 20.587500000000002p -3.5688290000000002e-06 20.599999999999998p -3.6455149999999999e-06 20.612500000000001p -3.7238919999999998e-06 20.625p -3.803558e-06 20.637499999999999p -3.8840950000000003e-06 20.650000000000002p -3.9650789999999996e-06 20.662499999999998p -4.0460800000000004e-06 20.675000000000001p -4.1266670000000004e-06 20.6875p -4.2064129999999998e-06 20.699999999999999p -4.2848970000000004e-06
+ 20.712500000000002p -4.3617089999999997e-06 20.725000000000001p -4.4364530000000004e-06 20.737499999999997p -4.5087480000000002e-06 20.75p -4.5782329999999999e-06 20.762499999999999p -4.6445689999999997e-06 20.775000000000002p -4.7074400000000003e-06 20.787500000000001p -4.7665549999999996e-06 20.799999999999997p -4.8216529999999997e-06 20.8125p -4.8724969999999996e-06 20.824999999999999p -4.9188820000000004e-06 20.837500000000002p -4.9606329999999998e-06 20.850000000000001p -4.9976040000000003e-06 20.862499999999997p -5.029681e-06 20.875p -5.0567799999999999e-06 20.887499999999999p -5.0788469999999998e-06 20.899999999999999p -5.0958579999999999e-06 20.912500000000001p -5.1078189999999999e-06 20.925000000000001p -5.1147640000000004e-06
+ 20.9375p -5.116751e-06 20.949999999999999p -5.1138689999999996e-06 20.962499999999999p -5.1062280000000003e-06 20.975000000000001p -5.0939639999999997e-06 20.987500000000001p -5.0772299999999998e-06 21p -5.0562050000000003e-06 21.012499999999999p -4.7518699999999998e-06 21.024999999999999p -4.4595089999999999e-06 21.037500000000001p -4.180882e-06 21.050000000000001p -3.9168030000000002e-06 21.0625p -3.6676779999999999e-06 21.074999999999999p -3.43369e-06 21.087499999999999p -3.2148609999999999e-06 21.100000000000001p -3.0110769999999999e-06 21.112500000000001p -2.8221059999999998e-06 21.125p -2.6476069999999998e-06 21.137499999999999p -2.487143e-06 21.149999999999999p -2.3401880000000001e-06
+ 21.162500000000001p -2.2061400000000002e-06 21.175000000000001p -2.0843320000000001e-06 21.1875p -1.9740410000000001e-06 21.199999999999999p -1.874498e-06 21.212499999999999p -1.7849019999999999e-06 21.225000000000001p -1.704424e-06 21.237500000000001p -1.632223e-06 21.25p -1.5674509999999999e-06 21.262500000000003p -1.5092619999999999e-06 21.274999999999999p -1.4568260000000001e-06 21.287499999999998p -1.4093269999999999e-06 21.300000000000001p -1.365978e-06 21.3125p -1.3260249999999999e-06 21.325000000000003p -1.288752e-06 21.337499999999999p -1.253486e-06 21.349999999999998p -1.2196050000000001e-06 21.362500000000001p -1.1865349999999999e-06 21.375p -1.153759e-06
+ 21.387500000000003p -1.120818e-06 21.399999999999999p -1.087309e-06 21.412499999999998p -1.0528919999999999e-06 21.425000000000001p -1.017285e-06 21.4375p -9.8026810000000007e-07 21.449999999999999p -9.4167879999999999e-07 21.462500000000002p -9.0141350000000001e-07 21.474999999999998p -8.5942489999999999e-07 21.487500000000001p -8.1571980000000002e-07 21.5p -7.7035630000000005e-07 21.512499999999999p -7.2344110000000004e-07 21.525000000000002p -6.7512610000000003e-07 21.537499999999998p -6.2560500000000002e-07 21.550000000000001p -5.7510940000000001e-07 21.5625p -5.2390480000000002e-07 21.574999999999999p -4.7228700000000003e-07 21.587500000000002p -4.2057740000000002e-07 21.599999999999998p -3.6911899999999998e-07
+ 21.612500000000001p -3.1827239999999997e-07 21.625p -2.6841120000000002e-07 21.637499999999999p -2.1991850000000001e-07 21.650000000000002p -1.7318209999999999e-07 21.662500000000001p -1.285915e-07 21.674999999999997p -8.6533349999999997e-08 21.6875p -4.738831e-08 21.699999999999999p -1.152766e-08 21.712500000000002p 2.068993e-08 21.725000000000001p 4.8921289999999998e-08 21.737499999999997p 7.2841410000000002e-08 21.75p 9.2145889999999995e-08 21.762499999999999p 1.0655309999999999e-07 21.775000000000002p 1.1580590000000001e-07 21.787500000000001p 1.196735e-07 21.799999999999997p 1.179528e-07 21.8125p 1.104691e-07 21.824999999999999p 9.7077409999999995e-08
+ 21.837499999999999p 7.7662720000000002e-08 21.850000000000001p 5.2140330000000002e-08 21.862500000000001p 2.0455969999999998e-08 21.875p -1.7414359999999999e-08 21.887499999999999p -6.1464770000000001e-08 21.899999999999999p -1.116601e-07 21.912500000000001p -1.6793660000000001e-07 21.925000000000001p -2.3020310000000001e-07 21.9375p -2.9834159999999999e-07 21.949999999999999p -3.7220909999999999e-07 21.962499999999999p -4.5163869999999998e-07 21.975000000000001p -5.3644109999999997e-07 21.987500000000001p -6.2640589999999996e-07 22p -7.2130399999999998e-07 22.012499999999999p -8.2088829999999996e-07 22.024999999999999p -9.2489639999999999e-07 22.037500000000001p -1.0330520000000001e-06 22.050000000000001p -1.1450649999999999e-06
+ 22.0625p -1.2606390000000001e-06 22.074999999999999p -1.3794639999999999e-06 22.087499999999999p -1.501227e-06 22.100000000000001p -1.625609e-06 22.112500000000001p -1.752286e-06 22.125p -1.880935e-06 22.137499999999999p -2.0112299999999999e-06 22.149999999999999p -2.1428500000000002e-06 22.162500000000001p -2.275473e-06 22.175000000000001p -2.4087840000000001e-06 22.1875p -2.5424710000000001e-06 22.200000000000003p -2.6762319999999999e-06 22.212499999999999p -2.8097680000000001e-06 22.224999999999998p -2.942793e-06 22.237500000000001p -3.0750280000000001e-06 22.25p -3.2062049999999998e-06 22.262500000000003p -3.336066e-06 22.274999999999999p -3.4643649999999999e-06
+ 22.287499999999998p -3.590869e-06 22.300000000000001p -3.7153549999999999e-06 22.3125p -3.8376149999999997e-06 22.325000000000003p -3.9574520000000002e-06 22.337499999999999p -4.0746830000000003e-06 22.349999999999998p -4.1891360000000004e-06 22.362500000000001p -4.3006519999999997e-06 22.375p -4.4090880000000004e-06 22.387499999999999p -4.5143089999999997e-06 22.400000000000002p -4.616193e-06 22.412499999999998p -4.714633e-06 22.425000000000001p -4.8095289999999996e-06 22.4375p -4.9007950000000002e-06 22.449999999999999p -4.9883530000000001e-06 22.462500000000002p -5.0721369999999996e-06 22.474999999999998p -5.1520890000000001e-06 22.487500000000001p -5.2281610000000002e-06 22.5p -5.300311e-06
+ 22.512499999999999p -5.3685079999999997e-06 22.525000000000002p -5.4327249999999997e-06 22.537499999999998p -5.4929429999999997e-06 22.550000000000001p -5.5491479999999996e-06 22.5625p -5.6013320000000001e-06 22.574999999999999p -5.64949e-06 22.587500000000002p -5.6936239999999998e-06 22.600000000000001p -5.733736e-06 22.612499999999997p -5.7698339999999999e-06 22.625p -5.801927e-06 22.637499999999999p -5.8300260000000004e-06 22.650000000000002p -5.8541439999999999e-06 22.662500000000001p -5.8742950000000003e-06 22.674999999999997p -5.890494e-06 22.6875p -5.9027579999999997e-06 22.699999999999999p -5.9111019999999997e-06 22.712500000000002p -5.915541e-06 22.725000000000001p -5.916093e-06
+ 22.737500000000001p -5.9127719999999996e-06 22.75p -5.9055950000000003e-06 22.762499999999999p -5.8945759999999996e-06 22.774999999999999p -5.879729e-06 22.787500000000001p -5.8610689999999999e-06 22.800000000000001p -5.8386089999999999e-06 22.8125p -5.8123630000000001e-06 22.824999999999999p -5.7823450000000003e-06 22.837499999999999p -5.748567e-06 22.850000000000001p -5.7110430000000002e-06 22.862500000000001p -5.669788e-06 22.875p -5.6248150000000001e-06 22.887499999999999p -5.5761410000000004e-06 22.899999999999999p -5.5237829999999997e-06 22.912500000000001p -5.4677579999999997e-06 22.925000000000001p -5.4080879999999996e-06 22.9375p -5.3447959999999999e-06 22.949999999999999p -5.2779050000000002e-06
+ 22.962499999999999p -5.2074439999999998e-06 22.975000000000001p -5.1334440000000002e-06 22.987500000000001p -5.0559409999999998e-06 23p -4.9749719999999999e-06 23.012499999999999p -4.8905809999999999e-06 23.024999999999999p -4.8028150000000002e-06 23.037500000000001p -4.7117259999999996e-06 23.050000000000001p -4.6173709999999999e-06 23.0625p -4.5198140000000003e-06 23.074999999999999p -4.4191230000000002e-06 23.087499999999999p -4.3153710000000001e-06 23.100000000000001p -4.2086389999999998e-06 23.112500000000001p -4.0990129999999998e-06 23.125p -3.9865860000000001e-06 23.137500000000003p -3.8714559999999998e-06 23.149999999999999p -3.7537289999999999e-06 23.162499999999998p -3.633516e-06 23.175000000000001p -3.5109359999999999e-06
+ 23.1875p -3.386114e-06 23.200000000000003p -3.2591799999999999e-06 23.212499999999999p -3.1302710000000002e-06 23.224999999999998p -2.9995299999999998e-06 23.237500000000001p -2.867107e-06 23.25p -2.733156e-06 23.262500000000003p -2.5978360000000001e-06 23.274999999999999p -2.4613130000000002e-06 23.287499999999998p -2.323757e-06 23.300000000000001p -2.1853410000000001e-06 23.3125p -2.0462450000000002e-06 23.324999999999999p -1.906649e-06 23.337500000000002p -1.766739e-06 23.349999999999998p -1.6267039999999999e-06 23.362500000000001p -1.4867319999999999e-06 23.375p -1.347017e-06 23.387499999999999p -1.2077530000000001e-06 23.400000000000002p -1.0691320000000001e-06
+ 23.412499999999998p -9.3135170000000001e-07 23.425000000000001p -7.9460579999999995e-07 23.4375p -6.5908869999999995e-07 23.449999999999999p -5.2499410000000004e-07 23.462500000000002p -3.925135e-07 23.474999999999998p -2.618369e-07 23.487500000000001p -1.3315150000000001e-07 23.5p -6.6418249999999997e-09 23.512499999999999p 1.175113e-07 23.525000000000002p 2.391306e-07 23.537500000000001p 3.5804320000000001e-07 23.549999999999997p 4.7408080000000001e-07 23.5625p 5.8708000000000004e-07 23.574999999999999p 6.9688310000000005e-07 23.587500000000002p 8.0333760000000002e-07 23.600000000000001p 9.0629729999999996e-07 23.612499999999997p 1.0056219999999999e-06 23.625p 1.101179e-06
+ 23.637499999999999p 1.1928409999999999e-06 23.650000000000002p 1.2804869999999999e-06 23.662500000000001p 1.364007e-06 23.675000000000001p 1.4432940000000001e-06 23.6875p 1.51825e-06 23.699999999999999p 1.5887849999999999e-06 23.712499999999999p 1.654816e-06 23.725000000000001p 1.716269e-06 23.737500000000001p 1.773076e-06 23.75p 1.8251769999999999e-06 23.762499999999999p 1.87252e-06 23.774999999999999p 1.9150619999999999e-06 23.787500000000001p 1.9527660000000001e-06 23.800000000000001p 1.9856040000000002e-06 23.8125p 2.0135540000000001e-06 23.824999999999999p 2.036603e-06 23.837499999999999p 2.0547450000000002e-06 23.850000000000001p 2.067981e-06
+ 23.862500000000001p 2.0763200000000001e-06 23.875p 2.0797779999999998e-06 23.887499999999999p 2.0783780000000001e-06 23.899999999999999p 2.0721480000000001e-06 23.912500000000001p 2.0611270000000002e-06 23.925000000000001p 2.045356e-06 23.9375p 2.0248870000000002e-06 23.949999999999999p 1.999774e-06 23.962499999999999p 1.9700799999999999e-06 23.975000000000001p 1.9358749999999999e-06 23.987500000000001p 1.8972320000000001e-06 24p 1.854231e-06 24.012499999999999p 1.80696e-06 24.024999999999999p 1.755508e-06 24.037500000000001p 1.6999729999999999e-06 24.050000000000001p 1.6404570000000001e-06 24.0625p 1.577067e-06 24.075000000000003p 1.5099149999999999e-06
+ 24.087499999999999p 1.439118e-06 24.099999999999998p 1.3647959999999999e-06 24.112500000000001p 1.2870750000000001e-06 24.125p 1.206085e-06 24.137500000000003p 1.1219589999999999e-06 24.149999999999999p 1.0348339999999999e-06 24.162499999999998p 9.4485210000000004e-07 24.175000000000001p 8.5215700000000005e-07 24.1875p 7.5689610000000005e-07 24.200000000000003p 6.5921989999999995e-07 24.212499999999999p 5.5928139999999996e-07 24.224999999999998p 4.5723610000000002e-07 24.237500000000001p 3.5324200000000001e-07 24.25p 2.4745870000000002e-07 24.262499999999999p 1.4004770000000001e-07 24.275000000000002p 3.1172140000000001e-08 24.287499999999998p -7.9003879999999999e-08 24.300000000000001p -1.903152e-07
+ 24.3125p -3.0259590000000003e-07 24.324999999999999p -4.1567989999999998e-07 24.337500000000002p -5.2940069999999996e-07 24.349999999999998p -6.435921e-07 24.362500000000001p -7.5808849999999999e-07 24.375p -8.7272460000000001e-07 24.387499999999999p -9.8733639999999996e-07 24.400000000000002p -1.101761e-06 24.412499999999998p -1.215837e-06 24.425000000000001p -1.3294060000000001e-06 24.4375p -1.442309e-06 24.449999999999999p -1.5543910000000001e-06 24.462500000000002p -1.665501e-06 24.475000000000001p -1.775487e-06 24.487499999999997p -1.884203e-06 24.5p -1.9915060000000001e-06 24.512499999999999p -2.097255e-06 24.525000000000002p -2.201314e-06
+ 24.537500000000001p -2.3035489999999999e-06 24.549999999999997p -2.4038319999999998e-06 24.5625p -2.5020380000000001e-06 24.574999999999999p -2.5980459999999999e-06 24.587500000000002p -2.691739e-06 24.600000000000001p -2.783006e-06 24.612500000000001p -2.8717380000000002e-06 24.625p -2.957834e-06 24.637499999999999p -3.0411929999999998e-06 24.649999999999999p -3.1217230000000001e-06 24.662500000000001p -3.1993340000000001e-06 24.675000000000001p -3.273942e-06 24.6875p -3.3454659999999999e-06 24.699999999999999p -3.4138319999999999e-06 24.712499999999999p -3.478968e-06 24.725000000000001p -3.5408079999999998e-06 24.737500000000001p -3.599291e-06 24.75p -3.6543579999999998e-06
+ 24.762499999999999p -3.7059579999999999e-06 24.774999999999999p -3.7540419999999999e-06 24.787500000000001p -3.7985640000000002e-06 24.800000000000001p -3.8394860000000003e-06 24.8125p -3.8767700000000003e-06 24.824999999999999p -3.9103840000000003e-06 24.837499999999999p -3.9403000000000002e-06 24.850000000000001p -3.9664930000000001e-06 24.862500000000001p -3.9889419999999999e-06 24.875p -4.0076310000000002e-06 24.887499999999999p -4.0225449999999998e-06 24.899999999999999p -4.0336739999999997e-06 24.912500000000001p -4.0410129999999997e-06 24.925000000000001p -4.0445559999999998e-06 24.9375p -4.0443060000000001e-06 24.949999999999999p -4.0402639999999999e-06 24.962499999999999p -4.0324380000000003e-06 24.975000000000001p -4.0208380000000003e-06
+ 24.987500000000001p -4.0054769999999996e-06 25p -3.9863710000000003e-06 25.012500000000003p -3.9635409999999999e-06 25.024999999999999p -3.9370099999999996e-06 25.037499999999998p -3.9068030000000003e-06 25.050000000000001p -3.8729520000000004e-06 25.0625p -3.8354879999999996e-06 25.075000000000003p -3.7944480000000001e-06 25.087499999999999p -3.7498730000000002e-06 25.099999999999998p -3.701806e-06 25.112500000000001p -3.6502939999999999e-06 25.125p -3.595388e-06 25.137500000000003p -3.5371430000000001e-06 25.149999999999999p -3.4756159999999998e-06 25.162499999999998p -3.4108699999999998e-06 25.175000000000001p -3.3429709999999998e-06 25.1875p -3.2719890000000001e-06 25.199999999999999p -3.1979969999999998e-06
+ 25.212500000000002p -3.1210740000000002e-06 25.224999999999998p -3.0413009999999998e-06 25.237500000000001p -2.958765e-06 25.25p -2.8735550000000001e-06 25.262499999999999p -2.785766e-06 25.275000000000002p -2.6954949999999999e-06 25.287499999999998p -2.6028470000000001e-06 25.300000000000001p -2.507926e-06 25.3125p -2.4108439999999998e-06 25.324999999999999p -2.311713e-06 25.337500000000002p -2.2106539999999999e-06 25.349999999999998p -2.1077869999999998e-06 25.362500000000001p -2.0032390000000002e-06 25.375p -1.897137e-06 25.387499999999999p -1.789615e-06 25.400000000000002p -1.6808080000000001e-06 25.412500000000001p -1.5708540000000001e-06 25.424999999999997p -1.4598950000000001e-06
+ 25.4375p -1.348076e-06 25.449999999999999p -1.2355409999999999e-06 25.462500000000002p -1.1224409999999999e-06 25.475000000000001p -1.008925e-06 25.487499999999997p -8.9514589999999997e-07 25.5p -7.8125660000000005e-07 25.512499999999999p -6.6741179999999998e-07 25.525000000000002p -5.5376700000000004e-07 25.537500000000001p -4.4047799999999998e-07 25.550000000000001p -3.2770089999999999e-07 25.5625p -2.1559170000000001e-07 25.574999999999999p -1.0430599999999999e-07 25.587499999999999p 6.0014709999999999e-09 25.600000000000001p 1.151768e-07 25.612500000000001p 2.230676e-07 25.625p 3.2952299999999998e-07 25.637499999999999p 4.343942e-07 25.649999999999999p 5.3753470000000003e-07
+ 25.662500000000001p 6.388004e-07 25.675000000000001p 7.3805010000000001e-07 25.6875p 8.3514590000000001e-07 25.699999999999999p 9.2995299999999996e-07 25.712499999999999p 1.02234e-06 25.725000000000001p 1.112181e-06 25.737500000000001p 1.1993520000000001e-06 25.75p 1.283735e-06 25.762499999999999p 1.3652150000000001e-06 25.774999999999999p 1.443683e-06 25.787500000000001p 1.5190350000000001e-06 25.800000000000001p 1.591172e-06 25.8125p 1.66e-06 25.824999999999999p 1.725429e-06 25.837499999999999p 1.7873780000000001e-06 25.850000000000001p 1.8457679999999999e-06 25.862500000000001p 1.900528e-06 25.875p 1.9515930000000001e-06
+ 25.887499999999999p 1.9989020000000001e-06 25.899999999999999p 2.0424009999999999e-06 25.912500000000001p 2.0820429999999998e-06 25.925000000000001p 2.1177850000000001e-06 25.9375p 2.1495910000000001e-06 25.950000000000003p 2.177433e-06 25.962499999999999p 2.2012849999999998e-06 25.974999999999998p 2.221131e-06 25.987500000000001p 2.2369589999999999e-06 26p 2.248763e-06 26.012500000000003p 2.2565439999999999e-06 26.024999999999999p 2.260308e-06 26.037499999999998p 2.2600669999999999e-06 26.050000000000001p 2.2558390000000001e-06 26.0625p 2.2476479999999999e-06 26.075000000000003p 2.235523e-06 26.087499999999999p 2.2195000000000001e-06 26.099999999999998p 2.1996180000000002e-06
+ 26.112500000000001p 2.175924e-06 26.125p 2.1484679999999998e-06 26.137499999999999p 2.1173079999999998e-06 26.150000000000002p 2.0825040000000001e-06 26.162499999999998p 2.0441239999999999e-06 26.175000000000001p 2.0022379999999999e-06 26.1875p 1.9569229999999998e-06 26.199999999999999p 1.9082589999999999e-06 26.212500000000002p 1.8563309999999999e-06 26.224999999999998p 1.8012279999999999e-06 26.237500000000001p 1.7430450000000001e-06 26.25p 1.681879e-06 26.262499999999999p 1.61783e-06 26.275000000000002p 1.551005e-06 26.287499999999998p 1.481512e-06 26.300000000000001p 1.409462e-06 26.3125p 1.334971e-06 26.324999999999999p 1.258157e-06
+ 26.337500000000002p 1.1791399999999999e-06 26.350000000000001p 1.0980450000000001e-06 26.362499999999997p 1.0149959999999999e-06 26.375p 9.301216e-07 26.387499999999999p 8.4355189999999996e-07 26.400000000000002p 7.554183e-07 26.412500000000001p 6.6585379999999996e-07 26.424999999999997p 5.7499300000000002e-07 26.4375p 4.829712e-07 26.449999999999999p 3.8992489999999997e-07 26.462500000000002p 2.9599079999999998e-07 26.475000000000001p 2.0130640000000001e-07 26.487500000000001p 1.060091e-07 26.5p 1.0236330000000001e-08 26.512499999999999p -8.5874810000000005e-08 26.524999999999999p -1.8218769999999999e-07 26.537500000000001p -2.785665e-07 26.550000000000001p -3.748764e-07
+ 26.5625p -4.7098349999999999e-07 26.574999999999999p -5.667556e-07 26.587499999999999p -6.6206180000000001e-07 26.600000000000001p -7.5677330000000003e-07 26.612500000000001p -8.5076300000000001e-07 26.625p -9.4390609999999997e-07 26.637499999999999p -1.03608e-06 26.649999999999999p -1.1271650000000001e-06 26.662500000000001p -1.2170420000000001e-06 26.675000000000001p -1.305599e-06 26.6875p -1.392723e-06 26.699999999999999p -1.478305e-06 26.712499999999999p -1.5622390000000001e-06 26.725000000000001p -1.6444249999999999e-06 26.737500000000001p -1.724762e-06 26.75p -1.803155e-06 26.762499999999999p -1.8795120000000001e-06 26.774999999999999p -1.9537449999999998e-06
+ 26.787500000000001p -2.0257689999999999e-06 26.800000000000001p -2.0955020000000002e-06 26.8125p -2.1628669999999998e-06 26.824999999999999p -2.227791e-06 26.837499999999999p -2.290203e-06 26.850000000000001p -2.3500369999999999e-06 26.862500000000001p -2.4072290000000002e-06 26.875p -2.461721e-06 26.887500000000003p -2.5134579999999998e-06 26.899999999999999p -2.5623870000000001e-06 26.912499999999998p -2.6084599999999998e-06 26.925000000000001p -2.6516339999999998e-06 26.9375p -2.6918650000000001e-06 26.950000000000003p -2.7291179999999999e-06 26.962499999999999p -2.7633580000000002e-06 26.974999999999998p -2.7945530000000001e-06 26.987500000000001p -2.8226779999999999e-06 27p -2.847706e-06
+ 27.012500000000003p -2.8696189999999999e-06 27.024999999999999p -2.8883980000000001e-06 27.037499999999998p -2.9040289999999998e-06 27.050000000000001p -2.9165010000000002e-06 27.0625p -2.9258049999999999e-06 27.074999999999999p -2.9319369999999998e-06 27.087500000000002p -2.9348959999999999e-06 27.099999999999998p -2.9346810000000002e-06 27.112500000000001p -2.9312980000000002e-06 27.125p -2.9247550000000002e-06 27.137499999999999p -2.91506e-06 27.150000000000002p -2.9022279999999999e-06 27.162499999999998p -2.886276e-06 27.175000000000001p -2.867222e-06 27.1875p -2.8450899999999998e-06 27.199999999999999p -2.8199049999999998e-06 27.212500000000002p -2.7916960000000002e-06 27.224999999999998p -2.7604950000000002e-06
+ 27.237500000000001p -2.726337e-06 27.25p -2.68926e-06 27.262499999999999p -2.6493050000000001e-06 27.275000000000002p -2.606518e-06 27.287500000000001p -2.5609459999999999e-06 27.299999999999997p -2.5126400000000001e-06 27.3125p -2.4616549999999999e-06 27.324999999999999p -2.4080480000000001e-06 27.337500000000002p -2.3518800000000002e-06 27.350000000000001p -2.2932159999999999e-06 27.362499999999997p -2.232124e-06 27.375p -2.168673e-06 27.387499999999999p -2.1029400000000001e-06 27.400000000000002p -2.035e-06 27.412500000000001p -1.9649360000000002e-06 27.425000000000001p -1.8928309999999999e-06 27.4375p -1.8187719999999999e-06 27.449999999999999p -1.74285e-06
+ 27.462499999999999p -1.6651580000000001e-06 27.475000000000001p -1.5857929999999999e-06 27.487500000000001p -1.504855e-06 27.5p -1.4224449999999999e-06 27.512499999999999p -1.338668e-06 27.524999999999999p -1.253632e-06 27.537500000000001p -1.1674470000000001e-06 27.550000000000001p -1.0802250000000001e-06 27.5625p -9.9208089999999996e-07 27.574999999999999p -9.0313099999999999e-07 27.587499999999999p -8.134936e-07 27.600000000000001p -7.2328889999999999e-07 27.612500000000001p -6.3263830000000001e-07 27.625p -5.4166459999999995e-07 27.637499999999999p -4.5049169999999998e-07 27.649999999999999p -3.5924430000000001e-07 27.662500000000001p -2.6804779999999998e-07 27.675000000000001p -1.7702810000000001e-07
+ 27.6875p -8.6311260000000001e-08 27.699999999999999p 3.9768330000000003e-09 27.712499999999999p 9.3710360000000006e-08 27.725000000000001p 1.827641e-07 27.737500000000001p 2.7101339999999999e-07 27.75p 3.583348e-07 27.762499999999999p 4.4460590000000001e-07 27.774999999999999p 5.2970570000000002e-07 27.787500000000001p 6.1351489999999998e-07 27.800000000000001p 6.9591619999999998e-07 27.8125p 7.7679410000000001e-07 27.825000000000003p 8.5603569999999995e-07 27.837499999999999p 9.3353039999999999e-07 27.849999999999998p 1.0091710000000001e-06 27.862500000000001p 1.082852e-06 27.875p 1.154471e-06 27.887500000000003p 1.2239310000000001e-06 27.899999999999999p 1.291137e-06
+ 27.912499999999998p 1.3559969999999999e-06 27.925000000000001p 1.4184240000000001e-06 27.9375p 1.478333e-06 27.949999999999999p 1.535646e-06 27.962499999999999p 1.5902869999999999e-06 27.974999999999998p 1.6421849999999999e-06 27.987500000000001p 1.6912729999999999e-06 28p 1.737489e-06 28.012499999999999p 1.7807740000000001e-06 28.025000000000002p 1.821077e-06 28.037499999999998p 1.8583489999999999e-06 28.050000000000001p 1.8925450000000001e-06 28.0625p 1.923628e-06 28.074999999999999p 1.9515630000000001e-06 28.087500000000002p 1.976321e-06 28.099999999999998p 1.9978780000000002e-06 28.112500000000001p 2.016213e-06 28.125p 2.0313130000000001e-06
+ 28.137499999999999p 2.0431680000000002e-06 28.150000000000002p 2.0517720000000001e-06 28.162499999999998p 2.0571269999999999e-06 28.175000000000001p 2.059235e-06 28.1875p 2.0581069999999998e-06 28.199999999999999p 2.053757e-06 28.212500000000002p 2.0462029999999999e-06 28.225000000000001p 2.035469e-06 28.237499999999997p 2.021583e-06 28.25p 2.004576e-06 28.262499999999999p 1.9844859999999998e-06 28.275000000000002p 1.9613519999999999e-06 28.287500000000001p 1.9352219999999999e-06 28.299999999999997p 1.906143e-06 28.3125p 1.874169e-06 28.324999999999999p 1.839357e-06 28.337500000000002p 1.801769e-06 28.350000000000001p 1.761468e-06
+ 28.362500000000001p 1.718524e-06 28.375p 1.6730079999999999e-06 28.387499999999999p 1.624996e-06 28.399999999999999p 1.574565e-06 28.412500000000001p 1.5217979999999999e-06 28.425000000000001p 1.4667789999999999e-06 28.4375p 1.4095940000000001e-06 28.449999999999999p 1.3503359999999999e-06 28.462499999999999p 1.2890949999999999e-06 28.475000000000001p 1.2259659999999999e-06 28.487500000000001p 1.161048e-06 28.5p 1.0944400000000001e-06 28.512499999999999p 1.0262419999999999e-06 28.524999999999999p 9.5655690000000001e-07 28.537500000000001p 8.8549049999999998e-07 28.550000000000001p 8.1314809999999999e-07 28.5625p 7.3963709999999999e-07 28.574999999999999p 6.6506569999999998e-07
+ 28.587499999999999p 5.8954320000000004e-07 28.600000000000001p 5.1317940000000004e-07 28.612500000000001p 4.36085e-07 28.625p 3.583707e-07 28.637499999999999p 2.8014760000000001e-07 28.649999999999999p 2.0152679999999999e-07 28.662500000000001p 1.2261920000000001e-07 28.675000000000001p 4.3535469999999997e-08 28.6875p -3.5614350000000003e-08 28.699999999999999p -1.147208e-07 28.712499999999999p -1.936753e-07 28.725000000000001p -2.7237009999999999e-07 28.737500000000001p -3.5069890000000002e-07 28.75p -4.2855639999999998e-07 28.762500000000003p -5.0583900000000001e-07 28.774999999999999p -5.8244440000000005e-07 28.787499999999998p -6.5827239999999995e-07 28.800000000000001p -7.3322440000000002e-07
+ 28.8125p -8.072038e-07 28.825000000000003p -8.8011619999999995e-07 28.837499999999999p -9.5186940000000001e-07 28.849999999999998p -1.0223740000000001e-06 28.862500000000001p -1.0915409999999999e-06 28.875p -1.1592869999999999e-06 28.887499999999999p -1.2255289999999999e-06 28.899999999999999p -1.290188e-06 28.912499999999998p -1.353185e-06 28.925000000000001p -1.414449e-06 28.9375p -1.4739059999999999e-06 28.949999999999999p -1.531488e-06 28.962500000000002p -1.587131e-06 28.974999999999998p -1.64077e-06 28.987500000000001p -1.6923479999999999e-06 29p -1.741808e-06 29.012499999999999p -1.789095e-06 29.025000000000002p -1.8341590000000001e-06
+ 29.037499999999998p -1.876954e-06 29.050000000000001p -1.9174340000000001e-06 29.0625p -1.9555580000000001e-06 29.074999999999999p -1.9912889999999998e-06 29.087500000000002p -2.0245900000000002e-06 29.099999999999998p -2.0554299999999998e-06 29.112500000000001p -2.0837780000000001e-06 29.125000000000004p -2.1096099999999999e-06 29.137499999999999p -2.1329010000000002e-06 29.149999999999999p -2.15363e-06 29.162500000000001p -2.171782e-06 29.174999999999997p -2.1873400000000001e-06 29.187500000000004p -2.2002929999999999e-06 29.199999999999999p -2.2106320000000001e-06 29.212499999999999p -2.2183509999999999e-06 29.225000000000001p -2.223447e-06 29.237499999999997p -2.225919e-06 29.250000000000004p -2.22577e-06
+ 29.262499999999999p -2.2230039999999998e-06 29.274999999999999p -2.2176300000000001e-06 29.287500000000001p -2.2096579999999999e-06 29.299999999999997p -2.1991010000000001e-06 29.312500000000004p -2.1859749999999999e-06 29.324999999999999p -2.170299e-06 29.337499999999999p -2.1520950000000002e-06 29.350000000000001p -2.1313869999999999e-06 29.362499999999997p -2.1082e-06 29.375000000000004p -2.0825660000000001e-06 29.387499999999999p -2.054516e-06 29.400000000000002p -2.0240859999999999e-06 29.412500000000001p -1.9913119999999998e-06 29.424999999999997p -1.9562349999999999e-06 29.4375p -1.9188979999999999e-06 29.449999999999999p -1.879347e-06 29.462500000000002p -1.837631e-06 29.475000000000001p -1.7937990000000001e-06
+ 29.487499999999997p -1.747907e-06 29.5p -1.7000090000000001e-06 29.512499999999999p -1.650165e-06 29.525000000000002p -1.598437e-06 29.537500000000001p -1.5448879999999999e-06 29.549999999999997p -1.4895849999999999e-06 29.5625p -1.4325959999999999e-06 29.574999999999999p -1.3739939999999999e-06 29.587500000000002p -1.313852e-06 29.600000000000001p -1.2522460000000001e-06 29.612499999999997p -1.189254e-06 29.625p -1.1249569999999999e-06 29.637499999999999p -1.0594369999999999e-06 29.650000000000002p -9.9277919999999998e-07 29.662500000000001p -9.2506999999999996e-07 29.674999999999997p -8.5639769999999999e-07 29.6875p -7.8685219999999997e-07 29.699999999999999p -7.1652539999999996e-07
+ 29.712500000000002p -6.4551029999999999e-07 29.724999999999998p -5.7390149999999996e-07 29.737499999999997p -5.0179470000000005e-07 29.75p -4.2928669999999999e-07 29.762499999999999p -3.5647530000000002e-07 29.775000000000002p -2.8345919999999998e-07 29.787499999999998p -2.103375e-07 29.800000000000004p -1.3721e-07 29.8125p -6.4176679999999997e-08 29.824999999999999p 8.662145e-09 29.837500000000002p 8.1206270000000006e-08 29.849999999999998p 1.5335559999999999e-07 29.862500000000004p 2.2501049999999999e-07 29.875p 2.9607160000000001e-07 29.887499999999999p 3.664405e-07 29.900000000000002p 4.360194e-07 29.912499999999998p 5.0471180000000004e-07 29.925000000000004p 5.7242199999999999e-07
+ 29.9375p 6.3905610000000005e-07 29.949999999999996p 7.0452140000000001e-07 29.962500000000002p 7.6872700000000005e-07 29.974999999999998p 8.3158399999999999e-07 29.987500000000001p 8.9300539999999996e-07 30p 9.5290610000000002e-07 30.012499999999996p 1.0112040000000001e-06 30.025000000000002p 1.067818e-06 30.037499999999998p 1.1226719999999999e-06 30.050000000000001p 1.17569e-06 30.0625p 1.2268010000000001e-06 30.074999999999996p 1.2759360000000001e-06 30.087500000000002p 1.323028e-06 30.099999999999998p 1.3680150000000001e-06 30.112500000000001p 1.4108380000000001e-06 30.125p 1.45144e-06 30.137500000000003p 1.4897689999999999e-06 30.150000000000002p 1.525775e-06
+ 30.162499999999998p 1.559414e-06 30.175000000000001p 1.590643e-06 30.1875p 1.6194239999999999e-06 30.200000000000003p 1.645723e-06 30.212500000000002p 1.6695090000000001e-06 30.224999999999998p 1.690755e-06 30.237500000000001p 1.7094389999999999e-06 30.25p 1.7255409999999999e-06 30.262500000000003p 1.739046e-06 30.274999999999999p 1.7499430000000001e-06 30.287499999999998p 1.758225e-06 30.300000000000001p 1.763887e-06 30.3125p 1.766931e-06 30.325000000000003p 1.76736e-06 30.337499999999999p 1.765183e-06 30.349999999999998p 1.76041e-06 30.362500000000001p 1.7530579999999999e-06 30.375p 1.7431460000000001e-06
+ 30.387500000000003p 1.7306959999999999e-06 30.399999999999999p 1.7157350000000001e-06 30.412499999999998p 1.6982929999999999e-06 30.425000000000001p 1.678403e-06 30.4375p 1.6561009999999999e-06 30.450000000000003p 1.6314289999999999e-06 30.462499999999999p 1.604429e-06 30.474999999999998p 1.575147e-06 30.487500000000001p 1.543634e-06 30.499999999999996p 1.509942e-06 30.512500000000003p 1.4741260000000001e-06 30.524999999999999p 1.4362440000000001e-06 30.537500000000001p 1.396358e-06 30.550000000000001p 1.3545309999999999e-06 30.562499999999996p 1.310829e-06 30.575000000000003p 1.2653199999999999e-06 30.587499999999999p 1.218075e-06 30.600000000000001p 1.1691660000000001e-06
+ 30.612500000000001p 1.118669e-06 30.624999999999996p 1.0666600000000001e-06 30.637500000000003p 1.013218e-06 30.649999999999999p 9.584225000000001e-07 30.662500000000001p 9.0235499999999996e-07 30.675000000000001p 8.4509870000000001e-07 30.687499999999996p 7.8673789999999997e-07 30.700000000000003p 7.2735789999999998e-07 30.712499999999999p 6.67045e-07 30.725000000000001p 6.0588650000000004e-07 30.737500000000001p 5.439702e-07 30.749999999999996p 4.8138479999999998e-07 30.762499999999999p 4.1821900000000002e-07 30.774999999999999p 3.5456220000000001e-07 30.787500000000001p 2.9050379999999998e-07 30.800000000000001p 2.2613319999999999e-07 30.812499999999996p 1.6153979999999999e-07 30.824999999999999p 9.6812799999999997e-08
+ 30.837499999999999p 3.2040920000000003e-08 30.850000000000001p -3.268752e-08 30.862500000000001p -9.728481e-08 30.874999999999996p -1.6166400000000001e-07 30.887499999999999p -2.2573900000000001e-07 30.899999999999999p -2.8942460000000002e-07 30.912500000000001p -3.526368e-07 30.925000000000001p -4.1529270000000001e-07 30.937500000000004p -4.7731079999999997e-07 30.949999999999999p -5.3861089999999996e-07 30.962499999999999p -5.9911419999999996e-07 30.975000000000001p -6.587438e-07 30.987500000000001p -7.1742429999999996e-07 31.000000000000004p -7.7508189999999999e-07 31.012499999999999p -8.3164499999999998e-07 31.024999999999999p -8.8704360000000002e-07 31.037500000000001p -9.412099e-07 31.049999999999997p -9.940780999999999e-07
+ 31.062500000000004p -1.045585e-06 31.074999999999999p -1.0956679999999999e-06 31.087499999999999p -1.144268e-06 31.100000000000001p -1.1913290000000001e-06 31.112499999999997p -1.236795e-06 31.125000000000004p -1.2806150000000001e-06 31.137499999999999p -1.322738e-06 31.149999999999999p -1.3631159999999999e-06 31.162500000000001p -1.401706e-06 31.174999999999997p -1.4384629999999999e-06 31.187500000000004p -1.473348e-06 31.199999999999999p -1.5063230000000001e-06 31.212499999999999p -1.5373540000000001e-06 31.225000000000001p -1.5664059999999999e-06 31.237499999999997p -1.593451e-06 31.250000000000004p -1.61846e-06 31.262499999999999p -1.6414089999999999e-06 31.275000000000002p -1.6622749999999999e-06
+ 31.287500000000001p -1.6810380000000001e-06 31.299999999999997p -1.697681e-06 31.3125p -1.712188e-06 31.324999999999999p -1.724547e-06 31.337500000000002p -1.734749e-06 31.350000000000001p -1.7427860000000001e-06 31.362499999999997p -1.748652e-06 31.375p -1.752347e-06 31.387499999999999p -1.753868e-06 31.400000000000002p -1.7532209999999999e-06 31.412500000000001p -1.750408e-06 31.424999999999997p -1.745438e-06 31.4375p -1.7383210000000001e-06 31.449999999999999p -1.7290690000000001e-06 31.462500000000002p -1.717696e-06 31.475000000000001p -1.7042210000000001e-06 31.487499999999997p -1.688661e-06 31.5p -1.671041e-06
+ 31.512499999999999p -1.6513829999999999e-06 31.525000000000002p -1.629715e-06 31.537500000000001p -1.6060650000000001e-06 31.549999999999997p -1.580465e-06 31.5625p -1.5529490000000001e-06 31.574999999999999p -1.5235530000000001e-06 31.587500000000002p -1.4923150000000001e-06 31.599999999999998p -1.4592750000000001e-06 31.612499999999997p -1.4244760000000001e-06 31.625p -1.3879629999999999e-06 31.637499999999999p -1.349784e-06 31.650000000000002p -1.309987e-06 31.662499999999998p -1.268624e-06 31.675000000000004p -1.225748e-06 31.6875p -1.181415e-06 31.699999999999999p -1.1356819999999999e-06 31.712500000000002p -1.0886080000000001e-06 31.724999999999998p -1.040254e-06
+ 31.737500000000004p -9.9068349999999997e-07 31.75p -9.3996110000000003e-07 31.762499999999999p -8.8815310000000004e-07 31.775000000000002p -8.353273e-07 31.787499999999998p -7.8155320000000002e-07 31.800000000000004p -7.2690189999999999e-07 31.8125p -6.7144539999999998e-07 31.824999999999996p -6.1525749999999995e-07 31.837500000000002p -5.5841279999999997e-07 31.849999999999998p -5.009872e-07 31.862500000000001p -4.4305739999999999e-07 31.875p -3.8470110000000002e-07 31.887499999999996p -3.2599680000000002e-07 31.900000000000002p -2.6702350000000001e-07 31.912499999999998p -2.078611e-07 31.925000000000001p -1.485894e-07 31.9375p -8.9289049999999996e-08 31.949999999999996p -3.0040499999999997e-08
+ 31.962500000000002p 2.9075540000000001e-08 31.974999999999998p 8.797845e-08 31.987500000000001p 1.465878e-07 32p 2.0482349999999999e-07 32.012500000000003p 2.626059e-07 32.024999999999999p 3.1985580000000002e-07 32.037500000000001p 3.7649489999999999e-07 32.050000000000004p 4.3244539999999997e-07 32.0625p 4.8763089999999996e-07 32.075000000000003p 5.4197559999999996e-07 32.087499999999999p 5.9540530000000001e-07 32.099999999999994p 6.4784680000000001e-07 32.112500000000004p 6.9922849999999995e-07 32.125p 7.4948040000000003e-07 32.137500000000003p 7.9853400000000005e-07 32.149999999999999p 8.4632279999999996e-07 32.162499999999994p 8.9278199999999998e-07 32.175000000000004p 9.3784880000000004e-07
+ 32.1875p 9.8146270000000006e-07 32.200000000000003p 1.0235649999999999e-06 32.212499999999999p 1.0640999999999999e-06 32.224999999999994p 1.103014e-06 32.237500000000004p 1.1402549999999999e-06 32.25p 1.175774e-06 32.262500000000003p 1.2095259999999999e-06 32.274999999999999p 1.241466e-06 32.287499999999994p 1.2715550000000001e-06 32.300000000000004p 1.299754e-06 32.3125p 1.326027e-06 32.325000000000003p 1.3503429999999999e-06 32.337499999999999p 1.3726720000000001e-06 32.349999999999994p 1.392989e-06 32.362499999999997p 1.4112689999999999e-06 32.375p 1.4274920000000001e-06 32.387500000000003p 1.441641e-06 32.399999999999999p 1.453703e-06
+ 32.412500000000001p 1.4636649999999999e-06 32.424999999999997p 1.4715189999999999e-06 32.4375p 1.477262e-06 32.450000000000003p 1.48089e-06 32.462499999999999p 1.4824059999999999e-06 32.475000000000001p 1.4818120000000001e-06 32.487499999999997p 1.479118e-06 32.5p 1.474332e-06 32.512500000000003p 1.4674680000000001e-06 32.524999999999999p 1.458543e-06 32.537500000000001p 1.4475750000000001e-06 32.549999999999997p 1.434586e-06 32.5625p 1.419601e-06 32.575000000000003p 1.402648e-06 32.587499999999999p 1.3837570000000001e-06 32.600000000000001p 1.3629610000000001e-06 32.612499999999997p 1.340295e-06 32.625p 1.3157970000000001e-06
+ 32.637500000000003p 1.2895079999999999e-06 32.649999999999999p 1.261471e-06 32.662500000000001p 1.231731e-06 32.674999999999997p 1.2003350000000001e-06 32.6875p 1.1673320000000001e-06 32.700000000000003p 1.1327749999999999e-06 32.712499999999999p 1.0967170000000001e-06 32.725000000000001p 1.0592139999999999e-06 32.737499999999997p 1.020322e-06 32.75p 9.801013e-07 32.762500000000003p 9.3861169999999998e-07 32.774999999999999p 8.9591540000000003e-07 32.787500000000001p 8.5207609999999998e-07 32.799999999999997p 8.0715849999999999e-07 32.8125p 7.6122849999999995e-07 32.825000000000003p 7.1435329999999999e-07 32.837499999999999p 6.6660089999999998e-07 32.850000000000001p 6.1804030000000002e-07
+ 32.862499999999997p 5.6874120000000001e-07 32.875p 5.1877400000000004e-07 32.887500000000003p 4.6820970000000001e-07 32.899999999999999p 4.1711969999999999e-07 32.912500000000001p 3.6557569999999999e-07 32.924999999999997p 3.1364969999999998e-07 32.9375p 2.6141400000000001e-07 32.950000000000003p 2.089405e-07 32.962499999999999p 1.5630140000000001e-07 32.975000000000001p 1.0356850000000001e-07 32.987499999999997p 5.081354e-08 33p -1.892332e-09 33.012500000000003p -5.4478369999999999e-08 33.024999999999999p -1.068744e-07 33.037500000000001p -1.590109e-07 33.049999999999997p -2.1081930000000001e-07 33.0625p -2.6223149999999997e-07 33.075000000000003p -3.131807e-07
+ 33.087499999999999p -3.6360089999999998e-07 33.100000000000001p -4.1342740000000001e-07 33.112499999999997p -4.6259639999999999e-07 33.125p -5.1104570000000003e-07 33.137500000000003p -5.5871409999999995e-07 33.150000000000006p -6.0554199999999996e-07 33.162500000000001p -6.5147110000000002e-07 33.174999999999997p -6.9644469999999996e-07 33.1875p -7.4040779999999996e-07 33.199999999999996p -7.8330679999999998e-07 33.212500000000006p -8.2508990000000005e-07 33.225000000000001p -8.6570700000000001e-07 33.237499999999997p -9.0510969999999995e-07 33.25p -9.4325160000000001e-07 33.262499999999996p -9.800879000000001e-07 33.275000000000006p -1.015576e-06 33.287500000000001p -1.049675e-06 33.299999999999997p -1.082345e-06
+ 33.3125p -1.1135509999999999e-06 33.324999999999996p -1.143256e-06 33.337500000000006p -1.1714280000000001e-06 33.350000000000001p -1.1980359999999999e-06 33.362499999999997p -1.2230519999999999e-06 33.375p -1.2464470000000001e-06 33.387499999999996p -1.2681979999999999e-06 33.400000000000006p -1.2882819999999999e-06 33.412500000000001p -1.3066779999999999e-06 33.424999999999997p -1.3233680000000001e-06 33.4375p -1.3383350000000001e-06 33.449999999999996p -1.351565e-06 33.462499999999999p -1.3630459999999999e-06 33.475000000000001p -1.3727669999999999e-06 33.487499999999997p -1.3807219999999999e-06 33.5p -1.3869030000000001e-06 33.512499999999996p -1.3913069999999999e-06 33.524999999999999p -1.393933e-06
+ 33.537500000000001p -1.3947810000000001e-06 33.550000000000004p -1.3938530000000001e-06 33.5625p -1.3911539999999999e-06 33.574999999999996p -1.386691e-06 33.587499999999999p -1.3804730000000001e-06 33.600000000000001p -1.3725100000000001e-06 33.612500000000004p -1.3628150000000001e-06 33.625p -1.351403e-06 33.637499999999996p -1.338292e-06 33.649999999999999p -1.3234999999999999e-06 33.662500000000001p -1.307048e-06 33.675000000000004p -1.288959e-06 33.6875p -1.269258e-06 33.699999999999996p -1.2479730000000001e-06 33.712499999999999p -1.2251309999999999e-06 33.725000000000001p -1.2007640000000001e-06 33.737500000000004p -1.1749040000000001e-06 33.75p -1.1475860000000001e-06
+ 33.762499999999996p -1.118846e-06 33.774999999999999p -1.088722e-06 33.787500000000001p -1.0572550000000001e-06 33.800000000000004p -1.0244859999999999e-06 33.8125p -9.9045790000000005e-07 33.824999999999996p -9.5521620000000009e-07 33.837499999999999p -9.1880760000000004e-07 33.850000000000001p -8.812802e-07 33.862500000000004p -8.4268369999999995e-07 33.875p -8.0306930000000001e-07 33.887500000000003p -7.6248970000000002e-07 33.899999999999999p -7.2099880000000005e-07 33.912500000000001p -6.7865189999999996e-07 33.925000000000004p -6.3550539999999999e-07 33.9375p -5.9161709999999996e-07 33.950000000000003p -5.4704560000000004e-07 33.962499999999999p -5.0185070000000001e-07 33.974999999999994p -4.5609310000000003e-07
+ 33.987500000000004p -4.0983439999999998e-07 34p -3.6313679999999999e-07 34.012500000000003p -3.1606349999999998e-07 34.024999999999999p -2.6867799999999999e-07 34.037499999999994p -2.2104449999999999e-07 34.050000000000004p -1.7322769999999999e-07 34.0625p -1.252924e-07 34.075000000000003p -7.7303739999999998e-08 34.087499999999999p -2.932714e-08 34.099999999999994p 1.8572090000000001e-08 34.112500000000004p 6.6328630000000006e-08 34.125p 1.138773e-07 34.137500000000003p 1.6115329999999999e-07 34.149999999999999p 2.0809189999999999e-07 34.162499999999994p 2.5462910000000002e-07 34.175000000000004p 3.007012e-07 34.1875p 3.462455e-07 34.200000000000003p 3.9119969999999998e-07
+ 34.212499999999999p 4.3550250000000002e-07 34.224999999999994p 4.7909339999999998e-07 34.237499999999997p 5.219133e-07 34.25p 5.6390380000000003e-07 34.262500000000003p 6.0500800000000004e-07 34.274999999999999p 6.4517019999999998e-07 34.287500000000001p 6.8433610000000004e-07 34.299999999999997p 7.2245300000000004e-07 34.3125p 7.594695e-07 34.325000000000003p 7.953363e-07 34.337499999999999p 8.3000529999999995e-07 34.350000000000001p 8.634306e-07 34.362499999999997p 8.9556789999999997e-07 34.375p 9.2637510000000003e-07 34.387500000000003p 9.5581180000000005e-07 34.399999999999999p 9.838398999999999e-07 34.412500000000001p 1.0104230000000001e-06 34.424999999999997p 1.035528e-06
+ 34.4375p 1.0591219999999999e-06 34.450000000000003p 1.0811769999999999e-06 34.462499999999999p 1.1016650000000001e-06 34.475000000000001p 1.1205600000000001e-06 34.487499999999997p 1.137842e-06 34.5p 1.153489e-06 34.512500000000003p 1.167484e-06 34.524999999999999p 1.179812e-06 34.537500000000001p 1.190459e-06 34.549999999999997p 1.1994169999999999e-06 34.5625p 1.206675e-06 34.575000000000003p 1.21223e-06 34.587499999999999p 1.2160779999999999e-06 34.600000000000001p 1.2182189999999999e-06 34.612499999999997p 1.2186549999999999e-06 34.625p 1.2173899999999999e-06 34.637500000000003p 1.2144299999999999e-06 34.649999999999999p 1.2097850000000001e-06
+ 34.662500000000001p 1.203468e-06 34.674999999999997p 1.19549e-06 34.6875p 1.18587e-06 34.700000000000003p 1.174624e-06 34.712499999999999p 1.161775e-06 34.725000000000001p 1.147345e-06 34.737499999999997p 1.131359e-06 34.75p 1.113844e-06 34.762500000000003p 1.0948300000000001e-06 34.774999999999999p 1.0743480000000001e-06 34.787500000000001p 1.0524319999999999e-06 34.799999999999997p 1.029115e-06 34.8125p 1.004437e-06 34.825000000000003p 9.7843459999999996e-07 34.837499999999999p 9.5114919999999995e-07 34.850000000000001p 9.2262270000000004e-07 34.862499999999997p 8.9289889999999999e-07 34.875p 8.6202299999999996e-07
+ 34.887500000000003p 8.3004160000000002e-07 34.899999999999999p 7.970027e-07 34.912500000000001p 7.6295560000000002e-07 34.924999999999997p 7.2795069999999995e-07 34.9375p 6.9203959999999997e-07 34.950000000000003p 6.552749e-07 34.962499999999999p 6.1771010000000004e-07 34.975000000000001p 5.7939969999999998e-07 34.987499999999997p 5.4039900000000002e-07 35p 5.0076369999999997e-07 35.012500000000003p 4.605504e-07 35.025000000000006p 4.1981619999999999e-07 35.037500000000001p 3.786185e-07 35.049999999999997p 3.3701519999999999e-07 35.0625p 2.9506450000000001e-07 35.074999999999996p 2.5282449999999998e-07 35.087500000000006p 2.1035379999999999e-07 35.100000000000001p 1.677108e-07
+ 35.112499999999997p 1.2495380000000001e-07 35.125p 8.2140980000000001e-08 35.137499999999996p 3.9330399999999997e-08 35.150000000000006p -3.4202949999999999e-09 35.162500000000001p -4.6053810000000002e-08 35.174999999999997p -8.8513320000000003e-08 35.1875p -1.3074250000000001e-07 35.199999999999996p -1.726858e-07 35.212500000000006p -2.1428810000000001e-07 35.225000000000001p -2.5549529999999998e-07 35.237499999999997p -2.9625379999999999e-07 35.25p -3.3651129999999999e-07 35.262499999999996p -3.7621600000000001e-07 35.275000000000006p -4.1531760000000002e-07 35.287500000000001p -4.5376639999999998e-07 35.299999999999997p -4.9151409999999998e-07 35.3125p -5.2851349999999995e-07 35.324999999999996p -5.6471870000000004e-07
+ 35.337499999999999p -6.0008510000000003e-07 35.350000000000001p -6.3456909999999996e-07 35.362499999999997p -6.6812899999999996e-07 35.375p -7.0072400000000005e-07 35.387499999999996p -7.323151e-07 35.399999999999999p -7.6286469999999999e-07 35.412500000000001p -7.9233649999999997e-07 35.425000000000004p -8.2069609999999997e-07 35.4375p -8.479104e-07 35.449999999999996p -8.739481e-07 35.462499999999999p -8.9877929999999995e-07 35.475000000000001p -9.2237589999999998e-07 35.487500000000004p -9.4471150000000004e-07 35.5p -9.6576129999999994e-07 35.512499999999996p -9.8550220000000007e-07 35.524999999999999p -1.003913e-06 35.537500000000001p -1.020974e-06 35.550000000000004p -1.0366669999999999e-06
+ 35.5625p -1.0509759999999999e-06 35.574999999999996p -1.0638869999999999e-06 35.587499999999999p -1.075387e-06 35.600000000000001p -1.0854649999999999e-06 35.612500000000004p -1.0941119999999999e-06 35.625p -1.1013200000000001e-06 35.637499999999996p -1.107085e-06 35.649999999999999p -1.1114019999999999e-06 35.662500000000001p -1.1142700000000001e-06 35.675000000000004p -1.115687e-06 35.6875p -1.115656e-06 35.699999999999996p -1.1141789999999999e-06 35.712499999999999p -1.1112620000000001e-06 35.725000000000001p -1.106911e-06 35.737500000000004p -1.101134e-06 35.75p -1.0939419999999999e-06 35.762500000000003p -1.085347e-06 35.774999999999999p -1.0753619999999999e-06
+ 35.787500000000001p -1.0640019999999999e-06 35.800000000000004p -1.051284e-06 35.8125p -1.0372269999999999e-06 35.825000000000003p -1.02185e-06 35.837499999999999p -1.0051759999999999e-06 35.849999999999994p -9.8722739999999992e-07 35.862500000000004p -9.6802949999999995e-07 35.875p -9.476086e-07 35.887500000000003p -9.259927e-07 35.899999999999999p -9.032113e-07 35.912499999999994p -8.7929510000000001e-07 35.925000000000004p -8.5427669999999999e-07 35.9375p -8.2818969999999998e-07 35.950000000000003p -8.0106920000000002e-07 35.962499999999999p -7.7295169999999997e-07 35.974999999999994p -7.4387489999999999e-07 35.987500000000004p -7.138778e-07 36p -6.8300069999999996e-07
+ 36.012500000000003p -6.5128480000000004e-07 36.024999999999999p -6.1877280000000002e-07 36.037499999999994p -5.855081e-07 36.050000000000004p -5.5153540000000002e-07 36.0625p -5.1690030000000001e-07 36.075000000000003p -4.8164920000000004e-07 36.087499999999999p -4.458295e-07 36.099999999999994p -4.0948939999999999e-07 36.112499999999997p -3.7267769999999999e-07 36.125p -3.3544409999999999e-07 36.137500000000003p -2.9783859999999998e-07 36.149999999999999p -2.599121e-07 36.162500000000001p -2.217157e-07 36.174999999999997p -1.8330119999999999e-07 36.1875p -1.4472040000000001e-07 36.200000000000003p -1.060255e-07 36.212499999999999p -6.7269150000000006e-08 36.225000000000001p -2.8503719999999998e-08
+ 36.237499999999997p 1.0218150000000001e-08 36.25p 4.8843879999999999e-08 36.262500000000003p 8.7321040000000004e-08 36.274999999999999p 1.2559730000000001e-07 36.287500000000001p 1.636208e-07 36.299999999999997p 2.013397e-07 36.3125p 2.3870290000000002e-07 36.325000000000003p 2.756596e-07 36.337499999999999p 3.121595e-07 36.350000000000001p 3.4815330000000001e-07 36.362499999999997p 3.8359200000000001e-07 36.375p 4.1842769999999999e-07 36.387500000000003p 4.5261329999999998e-07 36.399999999999999p 4.8610249999999996e-07 36.412500000000001p 5.1885030000000005e-07 36.424999999999997p 5.5081239999999996e-07 36.4375p 5.8194610000000003e-07 36.450000000000003p 6.1220949999999999e-07
+ 36.462499999999999p 6.4156220000000002e-07 36.475000000000001p 6.6996520000000001e-07 36.487499999999997p 6.9738080000000001e-07 36.5p 7.2377279999999997e-07 36.512500000000003p 7.4910630000000004e-07 36.524999999999999p 7.7334839999999999e-07 36.537500000000001p 7.9646749999999997e-07 36.549999999999997p 8.1843359999999999e-07 36.5625p 8.3921870000000002e-07 36.575000000000003p 8.5879620000000002e-07 36.587499999999999p 8.7714159999999996e-07 36.600000000000001p 8.9423199999999998e-07 36.612499999999997p 9.1004640000000004e-07 36.625p 9.2456569999999999e-07 36.637500000000003p 9.3777270000000001e-07 36.649999999999999p 9.4965200000000004e-07 36.662500000000001p 9.6019029999999989e-07 36.674999999999997p 9.6937620000000005e-07
+ 36.6875p 9.7720010000000009e-07 36.700000000000003p 9.8365460000000006e-07 36.712499999999999p 9.8873419999999992e-07 36.725000000000001p 9.924353999999999e-07 36.737499999999997p 9.9475649999999995e-07 36.75p 9.9569790000000006e-07 36.762500000000003p 9.9526200000000004e-07 36.774999999999999p 9.9345319999999995e-07 36.787500000000001p 9.9027759999999992e-07 36.799999999999997p 9.8574349999999998e-07 36.8125p 9.7986080000000003e-07 36.825000000000003p 9.7264170000000008e-07 36.837499999999999p 9.6409969999999998e-07 36.850000000000001p 9.5425070000000001e-07 36.862499999999997p 9.4311200000000003e-07 36.875p 9.3070280000000003e-07 36.887499999999996p 9.1704400000000002e-07 36.900000000000006p 9.0215829999999995e-07
+ 36.912500000000001p 8.8606980000000001e-07 36.924999999999997p 8.6880449999999996e-07 36.9375p 8.5038969999999995e-07 36.949999999999996p 8.3085440000000003e-07 36.962500000000006p 8.102289e-07 36.975000000000001p 7.8854520000000001e-07 36.987499999999997p 7.6583630000000001e-07 37p 7.4213680000000004e-07 37.012499999999996p 7.1748229999999997e-07 37.025000000000006p 6.9190979999999997e-07 37.037500000000001p 6.6545730000000003e-07 37.049999999999997p 6.3816400000000005e-07 37.0625p 6.1007000000000001e-07 37.074999999999996p 5.8121629999999998e-07 37.087500000000006p 5.5164509999999995e-07 37.100000000000001p 5.2139899999999997e-07 37.112499999999997p 4.9052160000000001e-07 37.125p 4.590571e-07
+ 37.137499999999996p 4.2705040000000002e-07 37.150000000000006p 3.9454689999999997e-07 37.162500000000001p 3.6159260000000001e-07 37.174999999999997p 3.282336e-07 37.1875p 2.9451680000000001e-07 37.199999999999996p 2.60489e-07 37.212499999999999p 2.2619739999999999e-07 37.225000000000001p 1.9168940000000001e-07 37.237499999999997p 1.5701230000000001e-07 37.25p 1.2221359999999999e-07 37.262499999999996p 8.7340659999999999e-08 37.274999999999999p 5.244067e-08 37.287500000000001p 1.7560740000000001e-08 37.300000000000004p -1.7252320000000001e-08 37.3125p -5.1951969999999998e-08 37.324999999999996p -8.6492080000000004e-08 37.337499999999999p -1.2082690000000001e-07 37.350000000000001p -1.5491119999999999e-07
+ 37.362500000000004p -1.8870040000000001e-07 37.375p -2.221502e-07 37.387499999999996p -2.5521740000000002e-07 37.399999999999999p -2.878591e-07 37.412500000000001p -3.2003339999999999e-07 37.425000000000004p -3.5169920000000002e-07 37.4375p -3.8281620000000002e-07 37.449999999999996p -4.1334509999999999e-07 37.462499999999999p -4.432473e-07 37.475000000000001p -4.724855e-07 37.487500000000004p -5.0102329999999998e-07 37.5p -5.288253e-07 37.512499999999996p -5.5585739999999999e-07 37.524999999999999p -5.8208649999999995e-07 37.537500000000001p -6.0748080000000003e-07 37.550000000000004p -6.3200960000000004e-07 37.5625p -6.5564340000000001e-07 37.574999999999996p -6.7835420000000002e-07
+ 37.587499999999999p -7.0011510000000001e-07 37.600000000000001p -7.2090049999999996e-07 37.612500000000004p -7.4068639999999996e-07 37.625p -7.5944990000000005e-07 37.637500000000003p -7.771696e-07 37.649999999999999p -7.9382540000000005e-07 37.662500000000001p -8.0939880000000002e-07 37.675000000000004p -8.2387270000000003e-07 37.6875p -8.372312e-07 37.700000000000003p -8.4946020000000002e-07 37.712499999999999p -8.605468e-07 37.724999999999994p -8.7047979999999996e-07 37.737500000000004p -8.7924920000000005e-07 37.75p -8.8684670000000002e-07 37.762500000000003p -8.9326540000000005e-07 37.774999999999999p -8.9849999999999995e-07 37.787499999999994p -9.0254659999999999e-07 37.800000000000004p -9.0540280000000004e-07
+ 37.8125p -9.0706759999999996e-07 37.825000000000003p -9.0754169999999996e-07 37.837499999999999p -9.0682709999999999e-07 37.849999999999994p -9.0492730000000004e-07 37.862500000000004p -9.0184730000000004e-07 37.875p -8.9759370000000001e-07 37.887500000000003p -8.9217420000000002e-07 37.899999999999999p -8.8559839999999996e-07 37.912499999999994p -8.7787689999999995e-07 37.925000000000004p -8.6902189999999999e-07 37.9375p -8.5904710000000002e-07 37.950000000000003p -8.4796739999999998e-07 37.962499999999999p -8.3579919999999996e-07 37.974999999999994p -8.2256029999999995e-07 37.987499999999997p -8.0826949999999996e-07 38p -7.9294730000000002e-07 38.012500000000003p -7.7661530000000003e-07 38.024999999999999p -7.5929640000000005e-07
+ 38.037500000000001p -7.4101470000000005e-07 38.049999999999997p -7.217955e-07 38.0625p -7.0166540000000005e-07 38.075000000000003p -6.8065209999999999e-07 38.087499999999999p -6.5878420000000002e-07 38.100000000000001p -6.3609180000000004e-07 38.112499999999997p -6.126057e-07 38.125p -5.8835790000000001e-07 38.137500000000003p -5.6338139999999995e-07 38.149999999999999p -5.3770989999999997e-07 38.162500000000001p -5.1137830000000004e-07 38.174999999999997p -4.8442229999999997e-07 38.1875p -4.5687819999999998e-07 38.200000000000003p -4.287834e-07 38.212499999999999p -4.0017569999999999e-07 38.225000000000001p -3.7109379999999999e-07 38.237499999999997p -3.4157699999999999e-07 38.25p -3.116651e-07
+ 38.262500000000003p -2.8139849999999998e-07 38.274999999999999p -2.5081810000000001e-07 38.287500000000001p -2.1996509999999999e-07 38.299999999999997p -1.888811e-07 38.3125p -1.576082e-07 38.325000000000003p -1.2618850000000001e-07 38.337499999999999p -9.4664440000000001e-08 38.350000000000001p -6.3078559999999997e-08 38.362499999999997p -3.1473489999999997e-08 38.375p 1.081188e-10 38.387500000000003p 3.1623660000000003e-08 38.399999999999999p 6.3030610000000005e-08 38.412500000000001p 9.4286629999999997e-08 38.424999999999997p 1.253496e-07 38.4375p 1.5617759999999999e-07 38.450000000000003p 1.8672919999999999e-07 38.462499999999999p 2.1696330000000001e-07 38.475000000000001p 2.4683920000000002e-07
+ 38.487499999999997p 2.7631670000000002e-07 38.5p 3.0535639999999999e-07 38.512500000000003p 3.3391930000000002e-07 38.524999999999999p 3.6196720000000001e-07 38.537500000000001p 3.894626e-07 38.549999999999997p 4.163688e-07 38.5625p 4.4265019999999999e-07 38.575000000000003p 4.6827159999999998e-07 38.587499999999999p 4.931993e-07 38.600000000000001p 5.1740030000000004e-07 38.612499999999997p 5.4084280000000001e-07 38.625p 5.6349590000000004e-07 38.637500000000003p 5.853302e-07 38.649999999999999p 6.0631710000000001e-07 38.662500000000001p 6.2642950000000002e-07 38.674999999999997p 6.4564160000000004e-07 38.6875p 6.6392870000000004e-07 38.700000000000003p 6.8126760000000004e-07
+ 38.712499999999999p 6.9763649999999995e-07 38.725000000000001p 7.130148e-07 38.737499999999997p 7.2738369999999997e-07 38.75p 7.4072539999999998e-07 38.762499999999996p 7.5302399999999995e-07 38.775000000000006p 7.6426489999999998e-07 38.787500000000001p 7.744351e-07 38.799999999999997p 7.8352299999999999e-07 38.8125p 7.9151870000000003e-07 38.824999999999996p 7.9841380000000003e-07 38.837500000000006p 8.0420160000000005e-07 38.850000000000001p 8.0887669999999997e-07 38.862499999999997p 8.1243549999999997e-07 38.875p 8.1487589999999995e-07 38.887499999999996p 8.1619749999999995e-07 38.900000000000006p 8.1640120000000004e-07 38.912500000000001p 8.1548989999999996e-07 38.924999999999997p 8.1346760000000002e-07
+ 38.9375p 8.1034009999999998e-07 38.949999999999996p 8.0611469999999996e-07 38.962500000000006p 8.0080020000000001e-07 38.975000000000001p 7.9440690000000001e-07 38.987499999999997p 7.8694659999999999e-07 39p 7.7843260000000002e-07 39.012499999999996p 7.6887939999999998e-07 39.025000000000006p 7.5830319999999997e-07 39.037500000000001p 7.4672150000000005e-07 39.049999999999997p 7.3415299999999997e-07 39.0625p 7.2061780000000002e-07 39.074999999999996p 7.0613740000000004e-07 39.087499999999999p 6.9073430000000003e-07 39.100000000000001p 6.7443230000000002e-07 39.112500000000004p 6.5725660000000005e-07 39.125p 6.392332e-07 39.137499999999996p 6.2038929999999996e-07 39.149999999999999p 6.0075310000000005e-07
+ 39.162500000000001p 5.8035390000000004e-07 39.175000000000004p 5.5922190000000001e-07 39.1875p 5.3738800000000002e-07 39.199999999999996p 5.1488430000000005e-07 39.212499999999999p 4.9174350000000003e-07 39.225000000000001p 4.6799899999999998e-07 39.237500000000004p 4.4368509999999998e-07 39.25p 4.1883639999999997e-07 39.262499999999996p 3.9348850000000002e-07 39.274999999999999p 3.6767730000000002e-07 39.287500000000001p 3.4143930000000002e-07 39.300000000000004p 3.1481120000000001e-07 39.3125p 2.8783040000000003e-07 39.324999999999996p 2.6053449999999998e-07 39.337499999999999p 2.329612e-07 39.350000000000001p 2.051488e-07 39.362500000000004p 1.771354e-07 39.375p 1.489594e-07
+ 39.387499999999996p 1.2065909999999999e-07 39.399999999999999p 9.2273109999999997e-08 39.412500000000001p 6.3839660000000005e-08 39.425000000000004p 3.5397049999999999e-08 39.4375p 6.9834040000000001e-09 39.449999999999996p -2.136337e-08 39.462499999999999p -4.9605590000000003e-08 39.475000000000001p -7.7705919999999995e-08 39.487500000000004p -1.056273e-07 39.5p -1.333332e-07 39.512500000000003p -1.607873e-07 39.524999999999999p -1.8795410000000001e-07 39.537500000000001p -2.1479829999999999e-07 39.550000000000004p -2.4128530000000001e-07 39.5625p -2.6738120000000001e-07 39.575000000000003p -2.9305269999999999e-07 39.587499999999999p -3.1826720000000001e-07 39.599999999999994p -3.4299280000000002e-07
+ 39.612500000000004p -3.6719829999999998e-07 39.625p -3.9085350000000003e-07 39.637500000000003p -4.1392889999999998e-07 39.649999999999999p -4.3639600000000001e-07 39.662499999999994p -4.5822690000000003e-07 39.675000000000004p -4.7939499999999999e-07 39.6875p -4.9987450000000001e-07 39.700000000000003p -5.1964050000000003e-07 39.712499999999999p -5.3866930000000005e-07 39.724999999999994p -5.5693800000000001e-07 39.737500000000004p -5.7442509999999995e-07 39.75p -5.9110980000000002e-07 39.762500000000003p -6.069726e-07 39.774999999999999p -6.2199519999999999e-07 39.787499999999994p -6.3616030000000003e-07 39.800000000000004p -6.4945159999999996e-07 39.8125p -6.6185440000000004e-07 39.825000000000003p -6.7335469999999998e-07
+ 39.837499999999999p -6.8393999999999997e-07 39.849999999999994p -6.9359899999999999e-07 39.862499999999997p -7.0232139999999995e-07 39.875p -7.1009820000000002e-07 39.887500000000003p -7.1692170000000002e-07 39.899999999999999p -7.2278539999999997e-07 39.912500000000001p -7.2768400000000002e-07 39.924999999999997p -7.3161349999999996e-07 39.9375p -7.3457090000000003e-07 39.950000000000003p -7.3655480000000001e-07 39.962499999999999p -7.375647e-07 39.975000000000001p -7.3760160000000002e-07 39.987499999999997p -7.3666750000000003e-07 40p -7.3476579999999997e-07 40.012500000000003p -7.3190099999999996e-07 40.024999999999999p -7.2807889999999997e-07 40.037500000000001p -7.2330649999999999e-07 40.049999999999997p -7.1759189999999997e-07
+ 40.0625p -7.1094439999999996e-07 40.075000000000003p -7.0337450000000005e-07 40.087499999999999p -6.9489399999999995e-07 40.100000000000001p -6.8551559999999999e-07 40.112499999999997p -6.7525330000000002e-07 40.125p -6.6412219999999998e-07 40.137500000000003p -6.5213829999999999e-07 40.149999999999999p -6.3931890000000002e-07 40.162500000000001p -6.2568229999999995e-07 40.174999999999997p -6.1124780000000004e-07 40.1875p -5.9603580000000005e-07 40.200000000000003p -5.8006750000000002e-07 40.212499999999999p -5.6336519999999995e-07 40.225000000000001p -5.4595210000000004e-07 40.237499999999997p -5.2785230000000004e-07 40.25p -5.0909090000000005e-07 40.262500000000003p -4.8969369999999996e-07 40.274999999999999p -4.6968730000000002e-07
+ 40.287500000000001p -4.4909909999999998e-07 40.299999999999997p -4.2795740000000002e-07 40.3125p -4.0629109999999999e-07 40.325000000000003p -3.8412970000000001e-07 40.337499999999999p -3.6150349999999999e-07 40.350000000000001p -3.3844330000000001e-07 40.362499999999997p -3.149804e-07 40.375p -2.9114689999999999e-07 40.387500000000003p -2.6697499999999999e-07 40.399999999999999p -2.4249759999999998e-07 40.412500000000001p -2.1774790000000001e-07 40.424999999999997p -1.9275959999999999e-07 40.4375p -1.675664e-07 40.450000000000003p -1.4220250000000001e-07 40.462499999999999p -1.1670220000000001e-07 40.475000000000001p -9.1100129999999997e-08 40.487499999999997p -6.5430849999999997e-08 40.5p -3.972907e-08
+ 40.512500000000003p -1.402952e-08 40.524999999999999p 1.1633099999999999e-08 40.537500000000001p 3.7224160000000001e-08 40.549999999999997p 6.2709159999999994e-08 40.5625p 8.8053770000000002e-08 40.575000000000003p 1.132239e-07 40.587499999999999p 1.381856e-07 40.600000000000001p 1.629055e-07 40.612499999999997p 1.8735039999999999e-07 40.625p 2.1148739999999999e-07 40.637499999999996p 2.352844e-07 40.650000000000006p 2.587096e-07 40.662500000000001p 2.817316e-07 40.674999999999997p 3.0432000000000001e-07 40.6875p 3.2644460000000001e-07 40.699999999999996p 3.4807620000000001e-07 40.712500000000006p 3.6918620000000002e-07 40.725000000000001p 3.8974679999999999e-07
+ 40.737499999999997p 4.0973099999999998e-07 40.75p 4.2911250000000003e-07 40.762499999999996p 4.4786619999999998e-07 40.775000000000006p 4.6596750000000002e-07 40.787500000000001p 4.8339330000000005e-07 40.799999999999997p 5.0012089999999999e-07 40.8125p 5.1612899999999998e-07 40.824999999999996p 5.3139720000000001e-07 40.837500000000006p 5.4590630000000002e-07 40.850000000000001p 5.59638e-07 40.862499999999997p 5.7257530000000001e-07 40.875p 5.8470220000000003e-07 40.887499999999996p 5.9600399999999999e-07 40.900000000000006p 6.0646719999999996e-07 40.912500000000001p 6.1607940000000004e-07 40.924999999999997p 6.2482939999999996e-07 40.9375p 6.3270730000000001e-07 40.949999999999996p 6.3970450000000001e-07
+ 40.962499999999999p 6.4581360000000002e-07 40.975000000000001p 6.5102839999999999e-07 40.987500000000004p 6.5534409999999999e-07 41p 6.5875700000000003e-07 41.012499999999996p 6.6126489999999997e-07 41.024999999999999p 6.6286660000000001e-07 41.037500000000001p 6.6356230000000003e-07 41.050000000000004p 6.6335349999999996e-07 41.0625p 6.6224309999999995e-07 41.074999999999996p 6.6023479999999997e-07 41.087499999999999p 6.5733400000000003e-07 41.100000000000001p 6.5354719999999998e-07 41.112500000000004p 6.4888190000000003e-07 41.125p 6.4334699999999997e-07 41.137499999999996p 6.3695270000000005e-07 41.149999999999999p 6.2971000000000004e-07 41.162500000000001p 6.2163150000000003e-07 41.175000000000004p 6.1273049999999997e-07
+ 41.1875p 6.0302159999999999e-07 41.199999999999996p 5.9252049999999998e-07 41.212499999999999p 5.8124390000000005e-07 41.225000000000001p 5.6920950000000004e-07 41.237500000000004p 5.5643600000000002e-07 41.25p 5.4294309999999999e-07 41.262499999999996p 5.2875140000000002e-07 41.274999999999999p 5.1388230000000002e-07 41.287500000000001p 4.9835819999999995e-07 41.300000000000004p 4.822023e-07 41.3125p 4.6543849999999998e-07 41.324999999999996p 4.4809160000000002e-07 41.337499999999999p 4.301868e-07 41.350000000000001p 4.1175049999999998e-07 41.362500000000004p 3.928091e-07 41.375p 3.7339020000000002e-07 41.387500000000003p 3.535214e-07 41.399999999999999p 3.3323129999999998e-07
+ 41.412500000000001p 3.1254859999999998e-07 41.425000000000004p 2.9150259999999999e-07 41.4375p 2.7012300000000002e-07 41.450000000000003p 2.484396e-07 41.462499999999999p 2.2648290000000001e-07 41.474999999999994p 2.0428330000000001e-07 41.487500000000004p 1.8187160000000001e-07 41.5p 1.592787e-07 41.512500000000003p 1.3653550000000001e-07 41.524999999999999p 1.136732e-07 41.537499999999994p 9.0722999999999998e-08 41.550000000000004p 6.7715919999999997e-08 41.5625p 4.4683060000000003e-08 41.575000000000003p 2.1655419999999999e-08 41.587499999999999p -1.33615e-09 41.599999999999994p -2.4260980000000002e-08 41.612500000000004p -4.7088599999999997e-08 41.625p -6.9788800000000006e-08
+ 41.637500000000003p -9.233168e-08 41.649999999999999p -1.1468760000000001e-07 41.662499999999994p -1.368275e-07 41.675000000000004p -1.5872240000000001e-07 41.6875p -1.8034399999999999e-07 41.700000000000003p -2.0166439999999999e-07 41.712499999999999p -2.2265619999999999e-07 41.724999999999994p -2.4329260000000001e-07 41.737499999999997p -2.6354739999999999e-07 41.75p -2.8339479999999999e-07 41.762500000000003p -3.0280980000000001e-07 41.774999999999999p -3.2176819999999998e-07 41.787500000000001p -3.4024609999999998e-07 41.799999999999997p -3.5822069999999999e-07 41.8125p -3.7566979999999999e-07 41.825000000000003p -3.9257189999999998e-07 41.837499999999999p -4.089063e-07 41.850000000000001p -4.2465339999999998e-07
+ 41.862499999999997p -4.3979390000000001e-07 41.875p -4.5430980000000001e-07 41.887500000000003p -4.6818390000000001e-07 41.899999999999999p -4.8139970000000003e-07 41.912500000000001p -4.9394170000000001e-07 41.924999999999997p -5.0579540000000003e-07 41.9375p -5.1694710000000005e-07 41.950000000000003p -5.2738410000000005e-07 41.962499999999999p -5.370948e-07 41.975000000000001p -5.4606839999999999e-07 41.987499999999997p -5.54295e-07 42p -5.6176590000000004e-07 42.012500000000003p -5.6847329999999996e-07 42.024999999999999p -5.7441030000000005e-07 42.037500000000001p -5.7957119999999995e-07 42.049999999999997p -5.8395120000000005e-07 42.0625p -5.8754639999999995e-07 42.075000000000003p -5.9035410000000004e-07
+ 42.087499999999999p -5.9237250000000002e-07 42.100000000000001p -5.9360079999999996e-07 42.112499999999997p -5.9403940000000004e-07 42.125p -5.9368949999999995e-07 42.137500000000003p -5.9255329999999995e-07 42.149999999999999p -5.9063410000000004e-07 42.162500000000001p -5.8793620000000004e-07 42.174999999999997p -5.8446479999999998e-07 42.1875p -5.8022609999999999e-07 42.200000000000003p -5.7522730000000005e-07 42.212499999999999p -5.6947660000000004e-07 42.225000000000001p -5.6298310000000005e-07 42.237499999999997p -5.5575680000000003e-07 42.25p -5.4780869999999998e-07 42.262500000000003p -5.3915060000000001e-07 42.274999999999999p -5.2979549999999997e-07 42.287500000000001p -5.1975679999999998e-07 42.299999999999997p -5.0904910000000004e-07
+ 42.3125p -4.9768789999999996e-07 42.325000000000003p -4.8568919999999996e-07 42.337499999999999p -4.7307009999999998e-07 42.350000000000001p -4.598484e-07 42.362499999999997p -4.4604269999999999e-07 42.375p -4.3167219999999999e-07 42.387500000000003p -4.16757e-07 42.399999999999999p -4.0131770000000002e-07 42.412500000000001p -3.8537579999999999e-07 42.424999999999997p -3.6895319999999999e-07 42.4375p -3.5207260000000001e-07 42.450000000000003p -3.3475730000000001e-07 42.462499999999999p -3.1703090000000001e-07 42.475000000000001p -2.9891779999999999e-07 42.487499999999997p -2.8044279999999998e-07 42.5p -2.6163120000000001e-07 42.512499999999996p -2.4250849999999998e-07 42.525000000000006p -2.2310100000000001e-07
+ 42.537500000000001p -2.034349e-07 42.549999999999997p -1.835372e-07 42.5625p -1.634348e-07 42.574999999999996p -1.431552e-07 42.587500000000006p -1.2272570000000001e-07 42.600000000000001p -1.021741e-07 42.612499999999997p -8.1528330000000006e-08 42.625p -6.0816299999999996e-08 42.637499999999996p -4.0066040000000002e-08 42.650000000000006p -1.9305619999999999e-08 42.662500000000001p 1.4369000000000001e-09 42.674999999999997p 2.2133520000000001e-08 42.6875p 4.2756330000000002e-08 42.699999999999996p 6.3277529999999995e-08 42.712500000000006p 8.3669489999999997e-08 42.725000000000001p 1.0390480000000001e-07 42.737499999999997p 1.2395620000000001e-07 42.75p 1.4379690000000001e-07
+ 42.762499999999996p 1.634003e-07 42.775000000000006p 1.827401e-07 42.787500000000001p 2.017905e-07 42.799999999999997p 2.2052609999999999e-07 42.8125p 2.3892189999999998e-07 42.824999999999996p 2.5695360000000002e-07 42.837499999999999p 2.7459719999999999e-07 42.850000000000001p 2.9182929999999999e-07 42.862500000000004p 3.0862729999999998e-07 42.875p 3.24969e-07 42.887499999999996p 3.4083309999999998e-07 42.899999999999999p 3.5619870000000002e-07 42.912500000000001p 3.7104589999999998e-07 42.925000000000004p 3.8535539999999999e-07 42.9375p 3.9910880000000002e-07 42.949999999999996p 4.1228830000000002e-07 42.962499999999999p 4.2487719999999998e-07 42.975000000000001p 4.368594e-07
+ 42.987500000000004p 4.4821979999999999e-07 43p 4.5894419999999999e-07 43.012499999999996p 4.690193e-07 43.024999999999999p 4.7843280000000002e-07 43.037500000000001p 4.8717319999999995e-07 43.050000000000004p 4.9523009999999996e-07 43.0625p 5.0259389999999996e-07 43.074999999999996p 5.0925619999999998e-07 43.087499999999999p 5.1520950000000001e-07 43.100000000000001p 5.2044729999999998e-07 43.112500000000004p 5.2496400000000001e-07 43.125p 5.2875529999999998e-07 43.137499999999996p 5.3181769999999998e-07 43.149999999999999p 5.3414879999999999e-07 43.162500000000001p 5.3574720000000002e-07 43.175000000000004p 5.366125e-07 43.1875p 5.3674540000000003e-07 43.199999999999996p 5.3614749999999998e-07
+ 43.212499999999999p 5.3482150000000001e-07 43.225000000000001p 5.3277120000000004e-07 43.237500000000004p 5.3000109999999997e-07 43.25p 5.26517e-07 43.262500000000003p 5.2232559999999997e-07 43.274999999999999p 5.1743439999999997e-07 43.287499999999994p 5.1185190000000003e-07 43.300000000000004p 5.0558779999999998e-07 43.3125p 4.9865229999999996e-07 43.325000000000003p 4.9105689999999998e-07 43.337499999999999p 4.8281359999999995e-07 43.349999999999994p 4.739355e-07 43.362500000000004p 4.644366e-07 43.375p 4.5433150000000001e-07 43.387500000000003p 4.4363569999999999e-07 43.399999999999999p 4.3236549999999998e-07 43.412499999999994p 4.2053779999999999e-07 43.425000000000004p 4.0817030000000001e-07
+ 43.4375p 3.9528150000000002e-07 43.450000000000003p 3.8189040000000001e-07 43.462499999999999p 3.6801669999999998e-07 43.474999999999994p 3.5368059999999998e-07 43.487500000000004p 3.3890299999999997e-07 43.5p 3.2370519999999998e-07 43.512500000000003p 3.0810909999999999e-07 43.524999999999999p 2.9213709999999998e-07 43.537499999999994p 2.7581189999999999e-07 43.550000000000004p 2.5915679999999999e-07 43.5625p 2.4219519999999999e-07 43.575000000000003p 2.2495110000000001e-07 43.587499999999999p 2.0744869999999999e-07 43.599999999999994p 1.897123e-07 43.612499999999997p 1.717667e-07 43.625p 1.5363670000000001e-07 43.637500000000003p 1.3534749999999999e-07 43.649999999999999p 1.16924e-07
+ 43.662500000000001p 9.8391720000000002e-08 43.674999999999997p 7.9775809999999998e-08 43.6875p 6.1101629999999995e-08 43.700000000000003p 4.239449e-08 43.712499999999999p 2.3679670000000002e-08 43.725000000000001p 4.9823420000000002e-09 43.737499999999997p -1.367243e-08 43.75p -3.2259720000000002e-08 43.762500000000003p -5.0754789999999999e-08 43.774999999999999p -6.9133129999999996e-08 43.787500000000001p -8.7370470000000005e-08 43.799999999999997p -1.054428e-07 43.8125p -1.233264e-07 43.825000000000003p -1.40998e-07 43.837499999999999p -1.5843449999999999e-07 43.850000000000001p -1.7561339999999999e-07 43.862499999999997p -1.925126e-07 43.875p -2.0911020000000001e-07
+ 43.887500000000003p -2.253851e-07 43.899999999999999p -2.4131640000000001e-07 43.912500000000001p -2.568842e-07 43.924999999999997p -2.7206849999999999e-07 43.9375p -2.8685040000000003e-07 43.950000000000003p -3.0121139999999998e-07 43.962499999999999p -3.1513360000000003e-07 43.975000000000001p -3.2859979999999998e-07 43.987499999999997p -3.4159339999999998e-07 44p -3.5409849999999999e-07 44.012500000000003p -3.6609989999999998e-07 44.024999999999999p -3.77583e-07 44.037500000000001p -3.885341e-07 44.049999999999997p -3.9894019999999998e-07 44.0625p -4.0878900000000002e-07 44.075000000000003p -4.1806890000000002e-07 44.087499999999999p -4.2676920000000001e-07 44.100000000000001p -4.3487999999999999e-07
+ 44.112499999999997p -4.4239199999999998e-07 44.125p -4.4929690000000001e-07 44.137500000000003p -4.5558709999999998e-07 44.149999999999999p -4.6125599999999998e-07 44.162500000000001p -4.6629760000000002e-07 44.174999999999997p -4.707068e-07 44.1875p -4.7447939999999999e-07 44.200000000000003p -4.77612e-07 44.212499999999999p -4.8010189999999997e-07 44.225000000000001p -4.8194750000000003e-07 44.237499999999997p -4.8314789999999999e-07 44.25p -4.83703e-07 44.262500000000003p -4.8361349999999996e-07 44.274999999999999p -4.8288110000000001e-07 44.287500000000001p -4.8150819999999996e-07 44.299999999999997p -4.7949810000000002e-07 44.3125p -4.7685479999999998e-07 44.325000000000003p -4.735832e-07
+ 44.337499999999999p -4.6968899999999999e-07 44.350000000000001p -4.6517869999999998e-07 44.362499999999997p -4.6005959999999998e-07 44.375p -4.5433960000000001e-07 44.387499999999996p -4.4802769999999999e-07 44.400000000000006p -4.4113329999999999e-07 44.412500000000001p -4.3366679999999998e-07 44.424999999999997p -4.2563910000000001e-07 44.4375p -4.170621e-07 44.449999999999996p -4.0794819999999998e-07 44.462500000000006p -3.9831049999999999e-07 44.475000000000001p -3.881627e-07 44.487499999999997p -3.7751930000000001e-07 44.5p -3.6639539999999999e-07 44.512499999999996p -3.5480659999999999e-07 44.525000000000006p -3.4276910000000001e-07 44.537500000000001p -3.302998e-07 44.549999999999997p -3.1741609999999998e-07
+ 44.5625p -3.0413569999999999e-07 44.574999999999996p -2.904772e-07 44.587500000000006p -2.7645929999999998e-07 44.600000000000001p -2.6210139999999999e-07 44.612499999999997p -2.474231e-07 44.625p -2.3244470000000001e-07 44.637499999999996p -2.1718669999999999e-07 44.650000000000006p -2.0166990000000001e-07 44.662500000000001p -1.8591549999999999e-07 44.674999999999997p -1.6994490000000001e-07 44.6875p -1.537799e-07 44.699999999999996p -1.3744250000000001e-07 44.712499999999999p -1.2095489999999999e-07 44.725000000000001p -1.043393e-07 44.737500000000004p -8.761834e-08 44.75p -7.0814589999999998e-08 44.762499999999996p -5.3950749999999998e-08 44.774999999999999p -3.7049580000000003e-08
+ 44.787500000000001p -2.0133849999999999e-08 44.800000000000004p -3.226351e-09 44.8125p 1.3650190000000001e-08 44.824999999999996p 3.047311e-08 44.837499999999999p 4.7219839999999997e-08 44.850000000000001p 6.3867929999999997e-08 44.862500000000004p 8.0395119999999998e-08 44.875p 9.6779330000000002e-08 44.887499999999996p 1.129987e-07 44.899999999999999p 1.2903159999999999e-07 44.912500000000001p 1.4485670000000001e-07 44.925000000000004p 1.6045299999999999e-07 44.9375p 1.7579990000000001e-07 44.949999999999996p 1.90877e-07 44.962499999999999p 2.056644e-07 44.975000000000001p 2.2014270000000001e-07 44.987500000000004p 2.3429280000000001e-07 45p 2.4809619999999998e-07
+ 45.012499999999996p 2.6153479999999998e-07 45.024999999999999p 2.7459119999999998e-07 45.037500000000001p 2.8724830000000001e-07 45.050000000000004p 2.9948980000000001e-07 45.0625p 3.112999e-07 45.074999999999996p 3.226635e-07 45.087499999999999p 3.3356599999999998e-07 45.100000000000001p 3.4399349999999999e-07 45.112500000000004p 3.5393300000000002e-07 45.125p 3.6337180000000002e-07 45.137500000000003p 3.7229829999999999e-07 45.149999999999999p 3.8070130000000002e-07 45.162499999999994p 3.8857069999999999e-07 45.175000000000004p 3.9589679999999998e-07 45.1875p 4.0267089999999997e-07 45.200000000000003p 4.0888500000000002e-07 45.212499999999999p 4.14532e-07 45.224999999999994p 4.1960529999999998e-07
+ 45.237500000000004p 4.2409939999999999e-07 45.25p 4.2800960000000001e-07 45.262500000000003p 4.313318e-07 45.274999999999999p 4.3406299999999999e-07 45.287499999999994p 4.362007e-07 45.300000000000004p 4.3774349999999999e-07 45.3125p 4.3869080000000001e-07 45.325000000000003p 4.390426e-07 45.337499999999999p 4.3879989999999999e-07 45.349999999999994p 4.379646e-07 45.362500000000004p 4.3653920000000003e-07 45.375p 4.3452709999999998e-07 45.387500000000003p 4.3193259999999999e-07 45.399999999999999p 4.287605e-07 45.412499999999994p 4.2501680000000002e-07 45.425000000000004p 4.2070790000000002e-07 45.4375p 4.1584110000000002e-07 45.450000000000003p 4.1042450000000001e-07
+ 45.462499999999999p 4.044669e-07 45.475000000000001p 3.9797779999999998e-07 45.487499999999997p 3.909674e-07 45.5p 3.8344650000000002e-07 45.512500000000003p 3.7542670000000001e-07 45.524999999999999p 3.6692029999999998e-07 45.537500000000001p 3.5793999999999999e-07 45.549999999999997p 3.4849929999999998e-07 45.5625p 3.3861230000000002e-07 45.575000000000003p 3.2829349999999997e-07 45.587499999999999p 3.1755809999999998e-07 45.600000000000001p 3.0642169999999999e-07 45.612499999999997p 2.9490049999999999e-07 45.625p 2.8301110000000001e-07 45.637500000000003p 2.7077069999999998e-07 45.649999999999999p 2.5819660000000002e-07 45.662500000000001p 2.4530699999999999e-07 45.674999999999997p 2.321199e-07
+ 45.6875p 2.1865399999999999e-07 45.700000000000003p 2.049283e-07 45.712499999999999p 1.9096200000000001e-07 45.725000000000001p 1.767746e-07 45.737499999999997p 1.6238570000000001e-07 45.75p 1.478154e-07 45.762500000000003p 1.330837e-07 45.774999999999999p 1.1821089999999999e-07 45.787500000000001p 1.032174e-07 45.799999999999997p 8.812366e-08 45.8125p 7.2950190000000002e-08 45.825000000000003p 5.7717610000000002e-08 45.837499999999999p 4.2446489999999999e-08 45.850000000000001p 2.7157400000000001e-08 45.862499999999997p 1.1870890000000001e-08 45.875p -3.3926109999999998e-09 45.887500000000003p -1.8612729999999999e-08 45.899999999999999p -3.3769250000000003e-08
+ 45.912500000000001p -4.8842080000000001e-08 45.924999999999997p -6.3811340000000004e-08 45.9375p -7.8657319999999997e-08 45.950000000000003p -9.336057e-08 45.962499999999999p -1.079019e-07 45.975000000000001p -1.2226229999999999e-07 45.987499999999997p -1.3642330000000001e-07 46p -1.5036640000000001e-07 46.012500000000003p -1.6407380000000001e-07 46.024999999999999p -1.7752779999999999e-07 46.037500000000001p -1.907113e-07 46.049999999999997p -2.0360749999999999e-07 46.0625p -2.1620010000000001e-07 46.075000000000003p -2.284731e-07 46.087499999999999p -2.4041119999999998e-07 46.100000000000001p -2.5199929999999998e-07 46.112499999999997p -2.6322310000000002e-07 46.125p -2.7406870000000001e-07
+ 46.137500000000003p -2.8452270000000001e-07 46.149999999999999p -2.945723e-07 46.162500000000001p -3.0420529999999999e-07 46.174999999999997p -3.1340990000000001e-07 46.1875p -3.221752e-07 46.200000000000003p -3.3049069999999999e-07 46.212499999999999p -3.3834650000000002e-07 46.225000000000001p -3.4573340000000001e-07 46.237499999999997p -3.526429e-07 46.25p -3.5906700000000002e-07 46.262499999999996p -3.6499840000000002e-07 46.275000000000006p -3.7043060000000002e-07 46.287500000000001p -3.7535760000000002e-07 46.299999999999997p -3.7977420000000001e-07 46.3125p -3.8367570000000002e-07 46.324999999999996p -3.8705820000000001e-07 46.337500000000006p -3.8991859999999999e-07 46.350000000000001p -3.9225430000000002e-07
+ 46.362499999999997p -3.9406350000000001e-07 46.375p -3.9534500000000002e-07 46.387499999999996p -3.9609829999999998e-07 46.400000000000006p -3.9632370000000002e-07 46.412500000000001p -3.9602220000000001e-07 46.424999999999997p -3.951952e-07 46.4375p -3.9384510000000001e-07 46.449999999999996p -3.9197490000000002e-07 46.462500000000006p -3.8958820000000002e-07 46.475000000000001p -3.8668919999999999e-07 46.487499999999997p -3.83283e-07 46.5p -3.793752e-07 46.512499999999996p -3.7497199999999998e-07 46.525000000000006p -3.7008019999999997e-07 46.537500000000001p -3.6470750000000003e-07 46.549999999999997p -3.5886199999999997e-07 46.5625p -3.5255239999999999e-07 46.574999999999996p -3.4578800000000003e-07
+ 46.587499999999999p -3.385787e-07 46.600000000000001p -3.3093509999999998e-07 46.612500000000004p -3.2286810000000002e-07 46.625p -3.1438939999999999e-07 46.637499999999996p -3.0551100000000002e-07 46.649999999999999p -2.962455e-07 46.662500000000001p -2.8660599999999999e-07 46.675000000000004p -2.7660609999999997e-07 46.6875p -2.6625990000000001e-07 46.699999999999996p -2.555816e-07 46.712499999999999p -2.4458630000000002e-07 46.725000000000001p -2.332892e-07 46.737500000000004p -2.2170589999999999e-07 46.75p -2.0985250000000001e-07 46.762499999999996p -1.977453e-07 46.774999999999999p -1.8540089999999999e-07 46.787500000000001p -1.728363e-07 46.800000000000004p -1.600687e-07
+ 46.8125p -1.4711560000000001e-07 46.824999999999996p -1.3399460000000001e-07 46.837499999999999p -1.2072359999999999e-07 46.850000000000001p -1.073208e-07 46.862500000000004p -9.3804170000000005e-08 46.875p -8.0192210000000002e-08 46.887499999999996p -6.6503309999999996e-08 46.899999999999999p -5.275598e-08 46.912500000000001p -3.8968779999999999e-08 46.925000000000004p -2.5160300000000001e-08 46.9375p -1.134913e-08 46.949999999999996p 2.4461600000000002e-09 46.962499999999999p 1.620706e-08 46.975000000000001p 2.9915130000000002e-08 46.987500000000004p 4.3552030000000001e-08 47p 5.7099540000000001e-08 47.012500000000003p 7.0539590000000003e-08 47.024999999999999p 8.3854310000000004e-08
+ 47.037499999999994p 9.7025990000000002e-08 47.050000000000004p 1.1003720000000001e-07 47.0625p 1.2287059999999999e-07 47.075000000000003p 1.3550939999999999e-07 47.087499999999999p 1.4793689999999999e-07 47.099999999999994p 1.601366e-07 47.112500000000004p 1.7209279999999999e-07 47.125p 1.8378960000000001e-07 47.137500000000003p 1.952119e-07 47.149999999999999p 2.0634470000000001e-07 47.162499999999994p 2.1717370000000001e-07 47.175000000000004p 2.276849e-07 47.1875p 2.3786469999999999e-07 47.200000000000003p 2.4770020000000001e-07 47.212499999999999p 2.5717870000000003e-07 47.224999999999994p 2.6628820000000002e-07 47.237500000000004p 2.7501719999999999e-07 47.25p 2.833548e-07
+ 47.262500000000003p 2.9129060000000002e-07 47.274999999999999p 2.9881470000000002e-07 47.287499999999994p 3.0591789999999998e-07 47.300000000000004p 3.1259150000000001e-07 47.3125p 3.1882759999999998e-07 47.325000000000003p 3.246187e-07 47.337499999999999p 3.2995800000000002e-07 47.350000000000001p 3.3483939999999999e-07 47.362499999999997p 3.3925739999999997e-07 47.375p 3.4320709999999998e-07 47.387500000000003p 3.4668430000000001e-07 47.399999999999999p 3.4968539999999999e-07 47.412500000000001p 3.5220759999999998e-07 47.424999999999997p 3.5424869999999998e-07 47.4375p 3.5580710000000002e-07 47.450000000000003p 3.5688190000000001e-07 47.462499999999999p 3.5747290000000002e-07 47.475000000000001p 3.5758060000000001e-07
+ 47.487499999999997p 3.57206e-07 47.5p 3.5635090000000002e-07 47.512500000000003p 3.5501780000000003e-07 47.524999999999999p 3.532096e-07 47.537500000000001p 3.5093020000000002e-07 47.549999999999997p 3.4818380000000001e-07 47.5625p 3.4497549999999999e-07 47.575000000000003p 3.4131080000000002e-07 47.587499999999999p 3.3719589999999998e-07 47.600000000000001p 3.3263760000000002e-07 47.612499999999997p 3.2764329999999999e-07 47.625p 3.2222090000000002e-07 47.637500000000003p 3.16379e-07 47.649999999999999p 3.1012669999999998e-07 47.662500000000001p 3.0347349999999999e-07 47.674999999999997p 2.964295e-07 47.6875p 2.8900540000000001e-07 47.700000000000003p 2.8121229999999999e-07
+ 47.712499999999999p 2.7306170000000001e-07 47.725000000000001p 2.6456570000000001e-07 47.737499999999997p 2.5573669999999998e-07 47.75p 2.4658760000000002e-07 47.762500000000003p 2.3713159999999999e-07 47.774999999999999p 2.2738240000000001e-07 47.787500000000001p 2.17354e-07 47.799999999999997p 2.0706060000000001e-07 47.8125p 1.9651700000000001e-07 47.825000000000003p 1.8573810000000001e-07 47.837499999999999p 1.7473899999999999e-07 47.850000000000001p 1.635352e-07 47.862499999999997p 1.5214240000000001e-07 47.875p 1.405764e-07 47.887500000000003p 1.2885339999999999e-07 47.899999999999999p 1.169894e-07 47.912500000000001p 1.050009e-07 47.924999999999997p 9.2904309999999996e-08
+ 47.9375p 8.071621e-08 47.950000000000003p 6.8453199999999995e-08 47.962499999999999p 5.6131960000000003e-08 47.975000000000001p 4.3769179999999998e-08 47.987499999999997p 3.1381529999999998e-08 48p 1.8985679999999999e-08 48.012500000000003p 6.598263e-09 48.024999999999999p -5.7641790000000003e-09 48.037500000000001p -1.8085180000000001e-08 48.049999999999997p -3.0348379999999997e-08 48.0625p -4.2537559999999999e-08 48.075000000000003p -5.4636659999999999e-08 48.087499999999999p -6.6629759999999998e-08 48.100000000000001p -7.850118e-08 48.112499999999997p -9.0235420000000002e-08 48.125p -1.018172e-07 48.137499999999996p -1.132316e-07 48.150000000000006p -1.2446380000000001e-07
+ 48.162500000000001p -1.3549929999999999e-07 48.174999999999997p -1.4632419999999999e-07 48.1875p -1.569244e-07 48.199999999999996p -1.6728660000000001e-07 48.212500000000006p -1.7739770000000001e-07 48.225000000000001p -1.872448e-07 48.237499999999997p -1.968157e-07 48.25p -2.0609839999999999e-07 48.262499999999996p -2.1508139999999999e-07 48.275000000000006p -2.2375349999999999e-07 48.287500000000001p -2.3210409999999999e-07 48.299999999999997p -2.4012299999999999e-07 48.3125p -2.478004e-07 48.324999999999996p -2.551271e-07 48.337500000000006p -2.6209430000000002e-07 48.350000000000001p -2.6869369999999998e-07 48.362499999999997p -2.7491750000000001e-07 48.375p -2.8075859999999998e-07
+ 48.387499999999996p -2.8621000000000002e-07 48.400000000000006p -2.9126570000000001e-07 48.412500000000001p -2.9592000000000002e-07 48.424999999999997p -3.001676e-07 48.4375p -3.0400410000000002e-07 48.449999999999996p -3.0742539999999998e-07 48.462499999999999p -3.1042800000000001e-07 48.475000000000001p -3.130089e-07 48.487500000000004p -3.1516589999999999e-07 48.5p -3.1689700000000001e-07 48.512499999999996p -3.182011e-07 48.524999999999999p -3.1907750000000001e-07 48.537500000000001p -3.1952590000000001e-07 48.550000000000004p -3.19547e-07 48.5625p -3.1914160000000002e-07 48.574999999999996p -3.183113e-07 48.587499999999999p -3.1705819999999999e-07 48.600000000000001p -3.153849e-07
+ 48.612500000000004p -3.1329470000000002e-07 48.625p -3.107913e-07 48.637499999999996p -3.07879e-07 48.649999999999999p -3.0456249999999999e-07 48.662500000000001p -3.0084710000000001e-07 48.675000000000004p -2.9673879999999998e-07 48.6875p -2.922438e-07 48.699999999999996p -2.8736889999999999e-07 48.712499999999999p -2.8212149999999998e-07 48.725000000000001p -2.7650940000000003e-07 48.737500000000004p -2.7054090000000002e-07 48.75p -2.6422449999999998e-07 48.762499999999996p -2.5756959999999997e-07 48.774999999999999p -2.5058569999999999e-07 48.787500000000001p -2.4328279999999998e-07 48.800000000000004p -2.356713e-07 48.8125p -2.27762e-07 48.824999999999996p -2.1956609999999999e-07
+ 48.837499999999999p -2.1109520000000001e-07 48.850000000000001p -2.0236109999999999e-07 48.862500000000004p -1.93376e-07 48.875p -1.8415250000000001e-07 48.887500000000003p -1.7470339999999999e-07 48.899999999999999p -1.650417e-07 48.912499999999994p -1.5518099999999999e-07 48.925000000000004p -1.4513470000000001e-07 48.9375p -1.3491680000000001e-07 48.950000000000003p -1.2454119999999999e-07 48.962499999999999p -1.140223e-07 48.974999999999994p -1.033743e-07 48.987500000000004p -9.2611980000000003e-08 49p -8.1749889999999999e-08 49.012500000000003p -7.0802850000000001e-08 49.024999999999999p -5.9785770000000003e-08 49.037499999999994p -4.87136e-08 49.050000000000004p -3.7601360000000003e-08
+ 49.0625p -2.646408e-08 49.075000000000003p -1.531682e-08 49.087499999999999p -4.1746140000000004e-09 49.099999999999994p 6.9475199999999996e-09 49.112500000000004p 1.803463e-08 49.125p 2.9071819999999999e-08 49.137500000000003p 4.0044300000000001e-08 49.149999999999999p 5.0937400000000003e-08 49.162499999999994p 6.1736550000000001e-08 49.175000000000004p 7.242736e-08 49.1875p 8.2995609999999999e-08 49.200000000000003p 9.3427259999999997e-08 49.212499999999999p 1.0370850000000001e-07 49.225000000000001p 1.138257e-07 49.237499999999997p 1.2376550000000001e-07 49.25p 1.335149e-07 49.262500000000003p 1.4306110000000001e-07 49.274999999999999p 1.5239149999999999e-07
+ 49.287500000000001p 1.61494e-07 49.299999999999997p 1.7035680000000001e-07 49.3125p 1.789682e-07 49.325000000000003p 1.8731730000000001e-07 49.337499999999999p 1.9539330000000001e-07 49.350000000000001p 2.0318579999999999e-07 49.362499999999997p 2.1068489999999999e-07 49.375p 2.1788099999999999e-07 49.387500000000003p 2.2476510000000001e-07 49.399999999999999p 2.313286e-07 49.412500000000001p 2.3756320000000001e-07 49.424999999999997p 2.434612e-07 49.4375p 2.4901550000000002e-07 49.450000000000003p 2.5421920000000002e-07 49.462499999999999p 2.5906619999999998e-07 49.475000000000001p 2.6355060000000001e-07 49.487499999999997p 2.6766730000000001e-07 49.5p 2.7141150000000001e-07
+ 49.512500000000003p 2.74779e-07 49.524999999999999p 2.7776620000000001e-07 49.537500000000001p 2.8036990000000002e-07 49.549999999999997p 2.8258749999999998e-07 49.5625p 2.8441689999999998e-07 49.575000000000003p 2.8585669999999999e-07 49.587499999999999p 2.8690579999999998e-07 49.600000000000001p 2.8756379999999998e-07 49.612499999999997p 2.8783079999999999e-07 49.625p 2.8770740000000002e-07 49.637500000000003p 2.8719470000000002e-07 49.649999999999999p 2.8629439999999998e-07 49.662500000000001p 2.8500880000000002e-07 49.674999999999997p 2.8334050000000001e-07 49.6875p 2.8129289999999998e-07 49.700000000000003p 2.7886980000000002e-07 49.712499999999999p 2.7607530000000002e-07 49.725000000000001p 2.7291420000000002e-07
+ 49.737499999999997p 2.6939180000000002e-07 49.75p 2.6551390000000001e-07 49.762500000000003p 2.6128659999999998e-07 49.774999999999999p 2.5671669999999998e-07 49.787500000000001p 2.518111e-07 49.799999999999997p 2.465776e-07 49.8125p 2.4102399999999998e-07 49.825000000000003p 2.3515869999999999e-07 49.837499999999999p 2.2899070000000001e-07 49.850000000000001p 2.225289e-07 49.862499999999997p 2.1578310000000001e-07 49.875p 2.08763e-07 49.887500000000003p 2.01479e-07 49.899999999999999p 1.939417e-07 49.912500000000001p 1.86162e-07 49.924999999999997p 1.7815099999999999e-07 49.9375p 1.6992020000000001e-07 49.950000000000003p 1.6148140000000001e-07
+ 49.962499999999999p 1.528466e-07 49.975000000000001p 1.44028e-07 49.987499999999997p 1.3503799999999999e-07 50p 1.2588920000000001e-07 50.012499999999996p 1.165944e-07 50.025000000000006p 1.0716670000000001e-07 50.037500000000001p 9.7618989999999999e-08 50.049999999999997p 8.7964620000000005e-08 50.0625p 7.8216880000000006e-08 50.074999999999996p 6.8389160000000003e-08 50.087500000000006p 5.8494940000000003e-08 50.100000000000001p 4.8547729999999999e-08 50.112499999999997p 3.8561089999999999e-08 50.125p 2.8548559999999998e-08 50.137499999999996p 1.8523700000000001e-08 50.150000000000006p 8.5000230000000007e-09 50.162500000000001p -1.5089870000000001e-09 50.174999999999997p -1.148992e-08
+ 50.1875p -2.1429430000000001e-08 50.199999999999996p -3.1314289999999998e-08 50.212500000000006p -4.1131369999999998e-08 50.225000000000001p -5.0867690000000003e-08 50.237499999999997p -6.0510390000000002e-08 50.25p -7.0046810000000004e-08 50.262499999999996p -7.9464449999999994e-08 50.275000000000006p -8.8750999999999998e-08 50.287500000000001p -9.7894399999999998e-08 50.299999999999997p -1.0688279999999999e-07 50.3125p -1.157045e-07 50.324999999999996p -1.243483e-07 50.337499999999999p -1.3280290000000001e-07 50.350000000000001p -1.4105769999999999e-07 50.362500000000004p -1.4910219999999999e-07 50.375p -1.5692600000000001e-07 50.387499999999996p -1.6451950000000001e-07 50.399999999999999p -1.7187299999999999e-07
+ 50.412500000000001p -1.789773e-07 50.425000000000004p -1.8582370000000001e-07 50.4375p -1.924037e-07 50.449999999999996p -1.987091e-07 50.462499999999999p -2.047324e-07 50.475000000000001p -2.1046609999999999e-07 50.487500000000004p -2.1590350000000001e-07 50.5p -2.210379e-07 50.512499999999996p -2.2586340000000001e-07 50.524999999999999p -2.303743e-07 50.537500000000001p -2.345654e-07 50.550000000000004p -2.3843190000000001e-07 50.5625p -2.4196949999999998e-07 50.574999999999996p -2.451743e-07 50.587499999999999p -2.4804279999999998e-07 50.600000000000001p -2.5057209999999999e-07 50.612500000000004p -2.5275960000000003e-07 50.625p -2.5460330000000002e-07
+ 50.637499999999996p -2.5610150000000001e-07 50.649999999999999p -2.5725310000000003e-07 50.662500000000001p -2.5805730000000002e-07 50.675000000000004p -2.5851400000000001e-07 50.6875p -2.5862329999999998e-07 50.699999999999996p -2.5838600000000002e-07 50.712499999999999p -2.5780310000000001e-07 50.725000000000001p -2.5687629999999998e-07 50.737500000000004p -2.5560749999999998e-07 50.75p -2.5399930000000003e-07 50.762500000000003p -2.520545e-07 50.774999999999999p -2.4977660000000001e-07 50.787499999999994p -2.4716920000000002e-07 50.800000000000004p -2.4423680000000001e-07 50.8125p -2.4098370000000001e-07 50.825000000000003p -2.374152e-07 50.837499999999999p -2.3353670000000001e-07 50.849999999999994p -2.29354e-07
+ 50.862500000000004p -2.2487330000000001e-07 50.875p -2.201013e-07 50.887500000000003p -2.15045e-07 50.899999999999999p -2.0971180000000001e-07 50.912499999999994p -2.0410929999999999e-07 50.925000000000004p -1.9824559999999999e-07 50.9375p -1.921291e-07 50.950000000000003p -1.8576849999999999e-07 50.962499999999999p -1.7917289999999999e-07 50.974999999999994p -1.723514e-07 50.987500000000004p -1.6531369999999999e-07 51p -1.5806970000000001e-07 51.012500000000003p -1.5062939999999999e-07 51.024999999999999p -1.430033e-07 51.037499999999994p -1.35202e-07 51.050000000000004p -1.2723610000000001e-07 51.0625p -1.191168e-07 51.075000000000003p -1.1085520000000001e-07
+ 51.087499999999999p -1.0246270000000001e-07 51.100000000000001p -9.3950730000000005e-08 51.112499999999997p -8.5331049999999994e-08 51.125p -7.6615410000000006e-08 51.137500000000003p -6.7815690000000004e-08 51.149999999999999p -5.894387e-08 51.162500000000001p -5.0012010000000001e-08 51.174999999999997p -4.1032219999999997e-08 51.1875p -3.2016670000000002e-08 51.200000000000003p -2.2977550000000001e-08 51.212499999999999p -1.3927050000000001e-08 51.225000000000001p -4.8773689999999998e-09 51.237499999999997p 4.159316e-09 51.25p 1.3170869999999999e-08 51.262500000000003p 2.2145230000000001e-08 51.274999999999999p 3.1070360000000002e-08 51.287500000000001p 3.9934360000000001e-08 51.299999999999997p 4.8725400000000003e-08
+ 51.3125p 5.743179e-08 51.325000000000003p 6.6041960000000004e-08 51.337499999999999p 7.454449e-08 51.350000000000001p 8.2928140000000005e-08 51.362499999999997p 9.1181840000000004e-08 51.375p 9.9294719999999994e-08 51.387500000000003p 1.072561e-07 51.399999999999999p 1.150556e-07 51.412500000000001p 1.2268299999999999e-07 51.424999999999997p 1.3012829999999999e-07 51.4375p 1.3738179999999999e-07 51.450000000000003p 1.4443430000000001e-07 51.462499999999999p 1.512765e-07 51.475000000000001p 1.5789960000000001e-07 51.487499999999997p 1.6429519999999999e-07 51.5p 1.7045509999999999e-07 51.512500000000003p 1.763715e-07 51.524999999999999p 1.8203679999999999e-07
+ 51.537500000000001p 1.8744399999999999e-07 51.549999999999997p 1.925864e-07 51.5625p 1.9745739999999999e-07 51.575000000000003p 2.020512e-07 51.587499999999999p 2.063621e-07 51.600000000000001p 2.103849e-07 51.612499999999997p 2.141148e-07 51.625p 2.175474e-07 51.637500000000003p 2.206788e-07 51.649999999999999p 2.235052e-07 51.662500000000001p 2.2602370000000001e-07 51.674999999999997p 2.2823160000000001e-07 51.6875p 2.301264e-07 51.700000000000003p 2.3170639999999999e-07 51.712499999999999p 2.3297009999999999e-07 51.725000000000001p 2.3391670000000001e-07 51.737499999999997p 2.3454540000000001e-07 51.75p 2.348563e-07
+ 51.762500000000003p 2.3484959999999999e-07 51.774999999999999p 2.3452610000000001e-07 51.787500000000001p 2.3388700000000001e-07 51.799999999999997p 2.329338e-07 51.8125p 2.3166870000000001e-07 51.825000000000003p 2.30094e-07 51.837500000000006p 2.282127e-07 51.850000000000001p 2.2602799999999999e-07 51.862499999999997p 2.2354360000000001e-07 51.875p 2.2076360000000001e-07 51.887499999999996p 2.176925e-07 51.900000000000006p 2.143352e-07 51.912500000000001p 2.1069680000000001e-07 51.924999999999997p 2.0678289999999999e-07 51.9375p 2.025997e-07 51.949999999999996p 1.9815329999999999e-07 51.962500000000006p 1.934504e-07 51.975000000000001p 1.88498e-07
+ 51.987499999999997p 1.8330340000000001e-07 52p 1.7787420000000001e-07 52.012499999999996p 1.7221840000000001e-07 52.025000000000006p 1.6634420000000001e-07 52.037500000000001p 1.6025989999999999e-07 52.049999999999997p 1.5397439999999999e-07 52.0625p 1.4749659999999999e-07 52.074999999999996p 1.4083579999999999e-07 52.087500000000006p 1.3400140000000001e-07 52.100000000000001p 1.2700299999999999e-07 52.112499999999997p 1.1985049999999999e-07 52.125p 1.125539e-07 52.137499999999996p 1.051234e-07 52.150000000000006p 9.7569289999999998e-08 52.162500000000001p 8.9902130000000002e-08 52.174999999999997p 8.2132469999999995e-08 52.1875p 7.427105e-08 52.199999999999996p 6.6328640000000002e-08
+ 52.212499999999999p 5.8316140000000002e-08 52.225000000000001p 5.024449e-08 52.237500000000004p 4.2124679999999999e-08 52.25p 3.396774e-08 52.262499999999996p 2.5784699999999999e-08 52.274999999999999p 1.7586619999999999e-08 52.287500000000001p 9.3845310000000004e-09 52.300000000000004p 1.1894370000000001e-09 52.3125p -6.9876919999999997e-09 52.324999999999996p -1.5135940000000001e-08 52.337499999999999p -2.324448e-08 52.350000000000001p -3.1302530000000002e-08 52.362500000000004p -3.9299449999999998e-08 52.375p -4.7224679999999998e-08 52.387499999999996p -5.5067809999999999e-08 52.399999999999999p -6.281854e-08 52.412500000000001p -7.0466759999999995e-08 52.425000000000004p -7.80025e-08
+ 52.4375p -8.5415960000000002e-08 52.449999999999996p -9.2697560000000006e-08 52.462499999999999p -9.9837900000000005e-08 52.475000000000001p -1.068278e-07 52.487500000000004p -1.136583e-07 52.5p -1.2032070000000001e-07 52.512499999999996p -1.2680649999999999e-07 52.524999999999999p -1.3310760000000001e-07 52.537500000000001p -1.392159e-07 52.550000000000004p -1.4512380000000001e-07 52.5625p -1.5082390000000001e-07 52.574999999999996p -1.5630909999999999e-07 52.587499999999999p -1.615728e-07 52.600000000000001p -1.6660830000000001e-07 52.612500000000004p -1.7140950000000001e-07 52.625p -1.759707e-07 52.637500000000003p -1.8028630000000001e-07 52.649999999999999p -1.8435119999999999e-07
+ 52.662499999999994p -1.881605e-07 52.675000000000004p -1.917099e-07 52.6875p -1.9499530000000001e-07 52.700000000000003p -1.980128e-07 52.712499999999999p -2.007591e-07 52.724999999999994p -2.0323120000000001e-07 52.737500000000004p -2.0542649999999999e-07 52.75p -2.073427e-07 52.762500000000003p -2.0897800000000001e-07 52.774999999999999p -2.103307e-07 52.787499999999994p -2.1139979999999999e-07 52.800000000000004p -2.1218440000000001e-07 52.8125p -2.126843e-07 52.825000000000003p -2.128994e-07 52.837499999999999p -2.128301e-07 52.849999999999994p -2.1247719999999999e-07 52.862500000000004p -2.118416e-07 52.875p -2.1092510000000001e-07
+ 52.887500000000003p -2.0972929999999999e-07 52.899999999999999p -2.082565e-07 52.912499999999994p -2.0650940000000001e-07 52.925000000000004p -2.0449079999999999e-07 52.9375p -2.02204e-07 52.950000000000003p -1.9965280000000001e-07 52.962499999999999p -1.9684100000000001e-07 52.975000000000001p -1.9377309999999999e-07 52.987499999999997p -1.904536e-07 53p -1.8688750000000001e-07 53.012500000000003p -1.8308020000000001e-07 53.024999999999999p -1.790372e-07 53.037500000000001p -1.7476440000000001e-07 53.049999999999997p -1.70268e-07 53.0625p -1.6555460000000001e-07 53.075000000000003p -1.6063079999999999e-07 53.087499999999999p -1.5550370000000001e-07 53.100000000000001p -1.5018059999999999e-07
+ 53.112499999999997p -1.4466900000000001e-07 53.125p -1.3897659999999999e-07 53.137500000000003p -1.331114e-07 53.149999999999999p -1.270817e-07 53.162500000000001p -1.2089579999999999e-07 53.174999999999997p -1.145624e-07 53.1875p -1.0809019999999999e-07 53.200000000000003p -1.0148809999999999e-07 53.212499999999999p -9.4765249999999996e-08 53.225000000000001p -8.7930909999999999e-08 53.237499999999997p -8.0994449999999995e-08 53.25p -7.3965359999999997e-08 53.262500000000003p -6.6853229999999997e-08 53.274999999999999p -5.9667760000000005e-08 53.287500000000001p -5.2418719999999998e-08 53.299999999999997p -4.5115939999999999e-08 53.3125p -3.7769329999999998e-08 53.325000000000003p -3.0388810000000001e-08
+ 53.337499999999999p -2.2984329999999999e-08 53.350000000000001p -1.556588e-08 53.362499999999997p -8.1434169999999994e-09 53.375p -7.2690459999999996e-10 53.387500000000003p 6.6737290000000004e-09 53.399999999999999p 1.40486e-08 53.412500000000001p 2.1387860000000001e-08 53.424999999999997p 2.8681750000000001e-08 53.4375p 3.592058e-08 53.450000000000003p 4.3094750000000003e-08 53.462499999999999p 5.019479e-08 53.475000000000001p 5.7211299999999998e-08 53.487499999999997p 6.4135070000000001e-08 53.5p 7.0956979999999998e-08 53.512500000000003p 7.7668110000000006e-08 53.524999999999999p 8.4259680000000005e-08 53.537500000000001p 9.0723100000000003e-08 53.549999999999997p 9.7049959999999999e-08
+ 53.5625p 1.032321e-07 53.575000000000003p 1.092614e-07 53.587499999999999p 1.151303e-07 53.600000000000001p 1.2083119999999999e-07 53.612499999999997p 1.2635669999999999e-07 53.625p 1.3169980000000001e-07 53.637500000000003p 1.368539e-07 53.649999999999999p 1.418123e-07 53.662500000000001p 1.465689e-07 53.674999999999997p 1.5111769999999999e-07 53.6875p 1.5545300000000001e-07 53.700000000000003p 1.595696e-07 53.712500000000006p 1.6346240000000001e-07 53.725000000000001p 1.6712670000000001e-07 53.737499999999997p 1.705582e-07 53.75p 1.7375260000000001e-07 53.762499999999996p 1.767063e-07 53.775000000000006p 1.79416e-07
+ 53.787500000000001p 1.818784e-07 53.799999999999997p 1.84091e-07 53.8125p 1.8605130000000001e-07 53.824999999999996p 1.8775730000000001e-07 53.837500000000006p 1.892074e-07 53.850000000000001p 1.904001e-07 53.862499999999997p 1.913345e-07 53.875p 1.920101e-07 53.887499999999996p 1.9242649999999999e-07 53.900000000000006p 1.9258379999999999e-07 53.912500000000001p 1.924825e-07 53.924999999999997p 1.9212330000000001e-07 53.9375p 1.9150739999999999e-07 53.949999999999996p 1.906362e-07 53.962500000000006p 1.8951159999999999e-07 53.975000000000001p 1.8813559999999999e-07 53.987499999999997p 1.865109e-07 54p 1.8464029999999999e-07
+ 54.012499999999996p 1.8252679999999999e-07 54.025000000000006p 1.8017389999999999e-07 54.037500000000001p 1.775855e-07 54.049999999999997p 1.747656e-07 54.0625p 1.7171860000000001e-07 54.074999999999996p 1.6844920000000001e-07 54.087499999999999p 1.6496239999999999e-07 54.100000000000001p 1.612634e-07 54.112500000000004p 1.573577e-07 54.125p 1.5325120000000001e-07 54.137499999999996p 1.489499e-07 54.149999999999999p 1.444601e-07 54.162500000000001p 1.397884e-07 54.175000000000004p 1.3494140000000001e-07 54.1875p 1.2992609999999999e-07 54.199999999999996p 1.2474979999999999e-07 54.212499999999999p 1.1941980000000001e-07 54.225000000000001p 1.139436e-07
+ 54.237500000000004p 1.083291e-07 54.25p 1.0258410000000001e-07 54.262499999999996p 9.6716679999999996e-08 54.274999999999999p 9.0735009999999995e-08 54.287500000000001p 8.4647430000000002e-08 54.300000000000004p 7.84624e-08 54.3125p 7.2188459999999999e-08 54.324999999999996p 6.5834249999999999e-08 54.337499999999999p 5.9408510000000002e-08 54.350000000000001p 5.292004e-08 54.362500000000004p 4.6377690000000001e-08 54.375p 3.9790360000000003e-08 54.387499999999996p 3.3167000000000002e-08 54.399999999999999p 2.651657e-08 54.412500000000001p 1.984804e-08 54.425000000000004p 1.317037e-08 54.4375p 6.4925240000000003e-09 54.449999999999996p -1.7657259999999999e-10
+ 54.462499999999999p -6.8280270000000003e-09 54.475000000000001p -1.3453e-08 54.487500000000004p -2.00427e-08 54.5p -2.6588440000000001e-08 54.512500000000003p -3.308157e-08 54.524999999999999p -3.9513570000000001e-08 54.537499999999994p -4.5876030000000003e-08 54.550000000000004p -5.2160619999999998e-08 54.5625p -5.8359170000000001e-08 54.575000000000003p -6.4463640000000005e-08 54.587499999999999p -7.0466139999999995e-08 54.599999999999994p -7.635893e-08 54.612500000000004p -8.2134439999999994e-08 54.625p -8.7785279999999998e-08 54.637500000000003p -9.3304250000000006e-08 54.649999999999999p -9.8684330000000005e-08 54.662499999999994p -1.039187e-07 54.675000000000004p -1.090008e-07
+ 54.6875p -1.139243e-07 54.700000000000003p -1.18683e-07 54.712499999999999p -1.232709e-07 54.724999999999994p -1.2768250000000001e-07 54.737500000000004p -1.319123e-07 54.75p -1.3595509999999999e-07 54.762500000000003p -1.3980609999999999e-07 54.774999999999999p -1.434605e-07 54.787499999999994p -1.469142e-07 54.800000000000004p -1.501629e-07 54.8125p -1.5320279999999999e-07 54.825000000000003p -1.5603049999999999e-07 54.837499999999999p -1.586427e-07 54.850000000000001p -1.610365e-07 54.862499999999997p -1.632092e-07 54.875p -1.6515860000000001e-07 54.887500000000003p -1.6688250000000001e-07 54.899999999999999p -1.683793e-07
+ 54.912500000000001p -1.696475e-07 54.924999999999997p -1.70686e-07 54.9375p -1.7149389999999999e-07 54.950000000000003p -1.7207089999999999e-07 54.962499999999999p -1.7241660000000001e-07 54.975000000000001p -1.7253120000000001e-07 54.987499999999997p -1.7241509999999999e-07 55p -1.72069e-07 55.012500000000003p -1.7149389999999999e-07 55.024999999999999p -1.7069119999999999e-07 55.037500000000001p -1.696624e-07 55.049999999999997p -1.684095e-07 55.0625p -1.669347e-07 55.075000000000003p -1.652405e-07 55.087499999999999p -1.6332969999999999e-07 55.100000000000001p -1.612053e-07 55.112499999999997p -1.5887069999999999e-07 55.125p -1.5632939999999999e-07
+ 55.137500000000003p -1.535855e-07 55.149999999999999p -1.5064289999999999e-07 55.162500000000001p -1.4750609999999999e-07 55.174999999999997p -1.441798e-07 55.1875p -1.4066879999999999e-07 55.200000000000003p -1.3697820000000001e-07 55.212499999999999p -1.331134e-07 55.225000000000001p -1.2907999999999999e-07 55.237499999999997p -1.2488369999999999e-07 55.25p -1.2053059999999999e-07 55.262500000000003p -1.160268e-07 55.274999999999999p -1.113787e-07 55.287500000000001p -1.065928e-07 55.299999999999997p -1.016759e-07 55.3125p -9.6634880000000006e-08 55.325000000000003p -9.1476719999999996e-08 55.337499999999999p -8.6208619999999999e-08 55.350000000000001p -8.0837899999999994e-08
+ 55.362499999999997p -7.5371989999999998e-08 55.375p -6.9818429999999995e-08 55.387500000000003p -6.4184869999999994e-08 55.399999999999999p -5.8479060000000003e-08 55.412500000000001p -5.2708809999999998e-08 55.424999999999997p -4.6882009999999999e-08 55.4375p -4.1006620000000002e-08 55.450000000000003p -3.5090630000000001e-08 55.462499999999999p -2.9142089999999999e-08 55.475000000000001p -2.316906e-08 55.487499999999997p -1.717962e-08 55.5p -1.1181860000000001e-08 55.512500000000003p -5.1838700000000002e-09 55.524999999999999p 8.062893e-10 55.537500000000001p 6.780578e-09 55.549999999999997p 1.273099e-08 55.5625p 1.864958e-08 55.575000000000003p 2.4528450000000001e-08
+ 55.587500000000006p 3.0359779999999998e-08 55.600000000000001p 3.6135820000000002e-08 55.612499999999997p 4.1848929999999997e-08 55.625p 4.7491539999999998e-08 55.637499999999996p 5.3056230000000003e-08 55.650000000000006p 5.8535670000000003e-08 55.662500000000001p 6.392268e-08 55.674999999999997p 6.9210210000000003e-08 55.6875p 7.4391360000000003e-08 55.699999999999996p 7.9459400000000005e-08 55.712500000000006p 8.440776e-08 55.725000000000001p 8.9230039999999998e-08 55.737499999999997p 9.3920039999999996e-08 55.75p 9.8471740000000006e-08 55.762499999999996p 1.0287929999999999e-07 55.775000000000006p 1.071372e-07 55.787500000000001p 1.1124e-07 55.799999999999997p 1.1518250000000001e-07
+ 55.8125p 1.189597e-07 55.824999999999996p 1.2256710000000001e-07 55.837500000000006p 1.2600010000000001e-07 55.850000000000001p 1.2925449999999999e-07 55.862499999999997p 1.3232640000000001e-07 55.875p 1.352121e-07 55.887499999999996p 1.3790799999999999e-07 55.899999999999999p 1.4041109999999999e-07 55.912500000000001p 1.4271850000000001e-07 55.924999999999997p 1.448274e-07 55.9375p 1.467356e-07 55.949999999999996p 1.48441e-07 55.962499999999999p 1.499418e-07 55.975000000000001p 1.5123639999999999e-07 55.987500000000004p 1.523237e-07 56p 1.532027e-07 56.012499999999996p 1.5387269999999999e-07 56.024999999999999p 1.543334e-07
+ 56.037500000000001p 1.5458460000000001e-07 56.050000000000004p 1.546267e-07 56.0625p 1.5445999999999999e-07 56.074999999999996p 1.540853e-07 56.087499999999999p 1.5350380000000001e-07 56.100000000000001p 1.5271660000000001e-07 56.112500000000004p 1.5172540000000001e-07 56.125p 1.5053210000000001e-07 56.137499999999996p 1.4913869999999999e-07 56.149999999999999p 1.475479e-07 56.162500000000001p 1.457621e-07 56.175000000000004p 1.4378429999999999e-07 56.1875p 1.4161769999999999e-07 56.199999999999996p 1.3926579999999999e-07 56.212499999999999p 1.367321e-07 56.225000000000001p 1.340207e-07 56.237500000000004p 1.311356e-07 56.25p 1.280812e-07
+ 56.262499999999996p 1.2486209999999999e-07 56.274999999999999p 1.214831e-07 56.287500000000001p 1.179491e-07 56.300000000000004p 1.1426540000000001e-07 56.3125p 1.104373e-07 56.324999999999996p 1.064705e-07 56.337499999999999p 1.023705e-07 56.350000000000001p 9.8143320000000003e-08 56.362500000000004p 9.3795009999999997e-08 56.375p 8.9331759999999998e-08 56.387500000000003p 8.4759889999999997e-08 56.399999999999999p 8.0085860000000002e-08 56.412499999999994p 7.5316269999999998e-08 56.425000000000004p 7.0457790000000001e-08 56.4375p 6.5517209999999998e-08 56.450000000000003p 6.0501430000000005e-08 56.462499999999999p 5.5417400000000001e-08 56.474999999999994p 5.027216e-08
+ 56.487500000000004p 4.5072810000000002e-08 56.5p 3.9826500000000003e-08 56.512500000000003p 3.4540410000000002e-08 56.524999999999999p 2.9221790000000001e-08 56.537499999999994p 2.3877869999999999e-08 56.550000000000004p 1.8515919999999999e-08 56.5625p 1.31432e-08 56.575000000000003p 7.7669639999999994e-09 56.587499999999999p 2.3944630000000002e-09 56.599999999999994p -2.9670920000000002e-09 56.612500000000004p -8.3105189999999996e-09 56.625p -1.362868e-08 56.637500000000003p -1.891451e-08 56.649999999999999p -2.4160970000000001e-08 56.662499999999994p -2.9361129999999999e-08 56.675000000000004p -3.4508119999999999e-08 56.6875p -3.9595180000000003e-08 56.700000000000003p -4.4615630000000002e-08
+ 56.712499999999999p -4.9562910000000003e-08 56.725000000000001p -5.4430579999999998e-08 56.737499999999997p -5.9212299999999997e-08 56.75p -6.3901889999999997e-08 56.762500000000003p -6.8493310000000003e-08 56.774999999999999p -7.2980649999999998e-08 56.787500000000001p -7.7358170000000005e-08 56.799999999999997p -8.1620290000000005e-08 56.8125p -8.5761590000000006e-08 56.825000000000003p -8.9776849999999996e-08 56.837499999999999p -9.3660989999999998e-08 56.850000000000001p -9.7409170000000004e-08 56.862499999999997p -1.0101669999999999e-07 56.875p -1.044791e-07 56.887500000000003p -1.077922e-07 56.899999999999999p -1.109518e-07 56.912500000000001p -1.139542e-07 56.924999999999997p -1.1679570000000001e-07
+ 56.9375p -1.1947290000000001e-07 56.950000000000003p -1.2198259999999999e-07 56.962499999999999p -1.2432199999999999e-07 56.975000000000001p -1.2648829999999999e-07 56.987499999999997p -1.28479e-07 57p -1.3029200000000001e-07 57.012500000000003p -1.319252e-07 57.024999999999999p -1.333769e-07 57.037500000000001p -1.346456e-07 57.049999999999997p -1.357301e-07 57.0625p -1.3662939999999999e-07 57.075000000000003p -1.3734270000000001e-07 57.087499999999999p -1.3786949999999999e-07 57.100000000000001p -1.382096e-07 57.112499999999997p -1.3836300000000001e-07 57.125p -1.383299e-07 57.137500000000003p -1.381108e-07 57.149999999999999p -1.3770649999999999e-07
+ 57.162500000000001p -1.37118e-07 57.174999999999997p -1.3634639999999999e-07 57.1875p -1.3539320000000001e-07 57.200000000000003p -1.342602e-07 57.212499999999999p -1.3294930000000001e-07 57.225000000000001p -1.3146269999999999e-07 57.237499999999997p -1.298028e-07 57.25p -1.2797209999999999e-07 57.262500000000003p -1.2597359999999999e-07 57.274999999999999p -1.2381039999999999e-07 57.287500000000001p -1.2148560000000001e-07 57.299999999999997p -1.190028e-07 57.3125p -1.163658e-07 57.325000000000003p -1.135783e-07 57.337499999999999p -1.106444e-07 57.350000000000001p -1.075685e-07 57.362499999999997p -1.04355e-07 57.375p -1.010085e-07
+ 57.387500000000003p -9.7533719999999995e-08 57.399999999999999p -9.3935720000000005e-08 57.412500000000001p -9.0219569999999998e-08 57.424999999999997p -8.6390529999999998e-08 57.4375p -8.2453979999999999e-08 57.450000000000003p -7.8415449999999996e-08 57.462500000000006p -7.4280599999999993e-08 57.475000000000001p -7.0055199999999999e-08 57.487499999999997p -6.5745109999999999e-08 57.5p -6.1356330000000003e-08 57.512499999999996p -5.6894920000000002e-08 57.525000000000006p -5.2367040000000001e-08 57.537500000000001p -4.7778940000000001e-08 57.549999999999997p -4.3136899999999999e-08 57.5625p -3.844729e-08 57.574999999999996p -3.3716529999999999e-08 57.587500000000006p -2.8951080000000001e-08 57.600000000000001p -2.4157410000000001e-08
+ 57.612499999999997p -1.9342060000000001e-08 57.625p -1.451154e-08 57.637499999999996p -9.6723950000000007e-09 57.650000000000006p -4.8311639999999997e-09 57.662500000000001p 5.6283740000000001e-12 57.674999999999997p 4.8314749999999996e-09 57.6875p 9.6398950000000002e-09 57.699999999999996p 1.442445e-08 57.712500000000006p 1.9178729999999999e-08 57.725000000000001p 2.3896409999999999e-08 57.737499999999997p 2.8571189999999999e-08 57.75p 3.3196870000000001e-08 57.762499999999996p 3.7767310000000003e-08 57.774999999999999p 4.2276469999999998e-08 57.787500000000001p 4.6718399999999997e-08 57.799999999999997p 5.108725e-08 57.8125p 5.5377279999999997e-08 57.824999999999996p 5.9582870000000003e-08
+ 57.837499999999999p 6.3698540000000006e-08 57.850000000000001p 6.771892e-08 57.862500000000004p 7.1638790000000003e-08 57.875p 7.5453080000000006e-08 57.887499999999996p 7.915688e-08 57.899999999999999p 8.2745409999999996e-08 57.912500000000001p 8.6214090000000002e-08 57.925000000000004p 8.9558500000000001e-08 57.9375p 9.2774390000000006e-08 57.949999999999996p 9.5857710000000004e-08 57.962499999999999p 9.8804580000000002e-08 57.975000000000001p 1.016113e-07 57.987500000000004p 1.042745e-07 58p 1.067907e-07 58.012499999999996p 1.09157e-07 58.024999999999999p 1.113705e-07 58.037500000000001p 1.134285e-07 58.050000000000004p 1.153286e-07
+ 58.0625p 1.1706860000000001e-07 58.074999999999996p 1.186465e-07 58.087499999999999p 1.2006049999999999e-07 58.100000000000001p 1.2130910000000001e-07 58.112500000000004p 1.2239109999999999e-07 58.125p 1.2330519999999999e-07 58.137499999999996p 1.240507e-07 58.149999999999999p 1.246269e-07 58.162500000000001p 1.250334e-07 58.175000000000004p 1.252701e-07 58.1875p 1.253371e-07 58.199999999999996p 1.2523469999999999e-07 58.212499999999991p 1.2496330000000001e-07 58.225000000000001p 1.245238e-07 58.237500000000004p 1.2391719999999999e-07 58.250000000000007p 1.2314459999999999e-07 58.262499999999996p 1.222074e-07 58.274999999999999p 1.211074e-07
+ 58.287500000000001p 1.198464e-07 58.299999999999997p 1.184265e-07 58.3125p 1.1685e-07 58.325000000000003p 1.151193e-07 58.337499999999991p 1.1323719999999999e-07 58.349999999999994p 1.1120669999999999e-07 58.362500000000004p 1.090306e-07 58.375000000000007p 1.067125e-07 58.387499999999996p 1.042557e-07 58.399999999999999p 1.0166380000000001e-07 58.412500000000001p 9.8940769999999999e-08 58.424999999999997p 9.6090520000000002e-08 58.4375p 9.3117199999999997e-08 58.450000000000003p 9.0025129999999996e-08 58.462500000000006p 8.6818770000000004e-08 58.474999999999994p 8.3502709999999997e-08 58.487500000000004p 8.0081690000000002e-08 58.500000000000007p 7.6560580000000005e-08
+ 58.512499999999996p 7.294437e-08 58.524999999999999p 6.9238150000000002e-08 58.537500000000001p 6.5447150000000005e-08 58.549999999999997p 6.157668e-08 58.5625p 5.7632149999999998e-08 58.575000000000003p 5.3619039999999998e-08 58.587500000000006p 4.9542940000000003e-08 58.599999999999994p 4.5409469999999997e-08 58.612499999999997p 4.1224360000000001e-08 58.625000000000007p 3.6993349999999998e-08 58.637499999999996p 3.272225e-08 58.649999999999999p 2.841691e-08 58.662500000000001p 2.4083209999999999e-08 58.674999999999997p 1.9727040000000001e-08 58.6875p 1.5354319999999999e-08 58.700000000000003p 1.097096e-08 58.712500000000006p 6.5828869999999997e-09 58.724999999999994p 2.1960110000000001e-09
+ 58.737499999999997p -2.183776e-09 58.750000000000007p -6.550605e-09 58.762499999999996p -1.089864e-08 58.774999999999999p -1.5222090000000001e-08 58.787500000000001p -1.951521e-08 58.800000000000004p -2.3772299999999999e-08 58.8125p -2.7987729999999999e-08 58.825000000000003p -3.2155960000000001e-08 58.837500000000006p -3.6271489999999998e-08 58.849999999999994p -4.0328939999999997e-08 58.862499999999997p -4.4322999999999999e-08 58.875p -4.8248470000000001e-08 58.887499999999996p -5.210024e-08 58.899999999999999p -5.5873329999999999e-08 58.912500000000001p -5.9562879999999997e-08 58.925000000000004p -6.3164119999999994e-08 58.9375p -6.6672449999999994e-08 58.950000000000003p -7.0083400000000001e-08
+ 58.962500000000006p -7.3392610000000002e-08 58.974999999999994p -7.6595909999999998e-08 58.987499999999997p -7.968925e-08 59p -8.2668750000000004e-08 59.012499999999996p -8.553069e-08 59.024999999999999p -8.8271520000000004e-08 59.037500000000001p -9.0887849999999998e-08 59.050000000000004p -9.3376479999999996e-08 59.062499999999993p -9.5734380000000004e-08 59.075000000000003p -9.7958689999999998e-08 59.087500000000006p -1.000468e-07 59.099999999999994p -1.019961e-07 59.112499999999997p -1.038044e-07 59.125p -1.054697e-07 59.13750000000001p -1.0698999999999999e-07 59.149999999999999p -1.083635e-07 59.162500000000001p -1.095889e-07 59.175000000000004p -1.1066479999999999e-07
+ 59.187499999999993p -1.1159020000000001e-07 59.200000000000003p -1.12364e-07 59.212500000000006p -1.1298580000000001e-07 59.224999999999994p -1.134549e-07 59.237499999999997p -1.137711e-07 59.25p -1.139342e-07 59.262500000000003p -1.139446e-07 59.274999999999999p -1.138024e-07 59.287500000000001p -1.135083e-07 59.300000000000004p -1.130628e-07 59.312499999999993p -1.124671e-07 59.325000000000003p -1.117222e-07 59.337500000000006p -1.1082950000000001e-07 59.349999999999994p -1.097904e-07 59.362499999999997p -1.086068e-07 59.375p -1.072804e-07 59.387500000000003p -1.058135e-07 59.399999999999999p -1.042082e-07
+ 59.412500000000001p -1.02467e-07 59.425000000000004p -1.005926e-07 59.437499999999993p -9.8587719999999999e-08 59.449999999999996p -9.6455370000000005e-08 59.462500000000006p -9.4198679999999999e-08 59.474999999999994p -9.1820929999999996e-08 59.487499999999997p -8.9325570000000004e-08 59.5p -8.6716200000000005e-08 59.512500000000003p -8.3996550000000003e-08 59.524999999999999p -8.1170510000000002e-08 59.537500000000001p -7.8242080000000006e-08 59.550000000000004p -7.5215399999999997e-08 59.562499999999993p -7.2094750000000004e-08 59.574999999999996p -6.8884490000000001e-08 59.587500000000006p -6.5589120000000004e-08 59.600000000000009p -6.2213230000000003e-08 59.612499999999997p -5.876152e-08 59.625p -5.5238759999999999e-08
+ 59.637500000000003p -5.1649830000000001e-08 59.649999999999999p -4.7999659999999997e-08 59.662500000000001p -4.4293289999999998e-08 59.675000000000004p -4.0535789999999999e-08 59.687499999999993p -3.6732299999999997e-08 59.699999999999996p -3.288801e-08 59.712499999999999p -2.9008159999999999e-08 59.725000000000009p -2.5098020000000001e-08 59.737499999999997p -2.11629e-08 59.75p -1.72081e-08 59.762500000000003p -1.3238980000000001e-08 59.774999999999999p -9.2608800000000008e-09 59.787500000000001p -5.2791459999999999e-09 59.800000000000004p -1.2991210000000001e-09 59.812499999999993p 2.6738669999999999e-09 59.824999999999996p 6.6345120000000003e-09 59.837499999999999p 1.057753e-08 59.850000000000009p 1.4497690000000001e-08
+ 59.862499999999997p 1.8389770000000001e-08 59.875p 2.2248630000000001e-08 59.887500000000003p 2.6069170000000001e-08 59.899999999999991p 2.9846339999999997e-08 59.912500000000001p 3.3575190000000002e-08 59.925000000000004p 3.7250820000000003e-08 59.937500000000007p 4.0868420000000001e-08 59.949999999999996p 4.442327e-08 59.962499999999999p 4.7910740000000001e-08 59.975000000000001p 5.1326300000000002e-08 59.987499999999997p 5.4665549999999997e-08 60p 5.7924160000000001e-08 60.012500000000003p 6.1097940000000003e-08 60.024999999999991p 6.4182840000000002e-08 60.037500000000001p 6.7174909999999995e-08 60.050000000000004p 7.0070350000000004e-08 60.062500000000007p 7.2865490000000002e-08 60.074999999999996p 7.5556820000000002e-08
+ 60.087499999999999p 7.8140940000000005e-08 60.100000000000001p 8.0614649999999999e-08 60.112499999999997p 8.2974859999999995e-08 60.125p 8.5218690000000004e-08 60.137500000000003p 8.7343369999999996e-08 60.149999999999991p 8.9346340000000001e-08 60.162499999999994p 9.1225180000000002e-08 60.175000000000004p 9.2977659999999998e-08 60.187500000000007p 9.4601709999999996e-08 60.199999999999996p 9.6095469999999999e-08 60.212499999999999p 9.7457220000000001e-08 60.225000000000001p 9.8685439999999995e-08 60.237499999999997p 9.9778799999999999e-08 60.25p 1.007361e-07 60.262500000000003p 1.015565e-07 60.275000000000006p 1.022391e-07 60.287499999999994p 1.027834e-07 60.300000000000004p 1.0318890000000001e-07
+ 60.312500000000007p 1.034554e-07 60.324999999999996p 1.035829e-07 60.337499999999999p 1.035716e-07 60.350000000000001p 1.0342169999999999e-07 60.362499999999997p 1.031339e-07 60.375p 1.027089e-07 60.387500000000003p 1.021475e-07 60.400000000000006p 1.014508e-07 60.412499999999994p 1.006201e-07 60.425000000000004p 9.9656850000000002e-08 60.437500000000007p 9.8562620000000005e-08 60.449999999999996p 9.7339200000000006e-08 60.462499999999999p 9.5988560000000005e-08 60.475000000000001p 9.4512799999999996e-08 60.487499999999997p 9.2914219999999998e-08 60.5p 9.1195259999999994e-08 60.512500000000003p 8.9358509999999996e-08 60.525000000000006p 8.740672e-08
+ 60.537499999999994p 8.5342790000000004e-08 60.549999999999997p 8.3169759999999999e-08 60.562500000000007p 8.0890810000000005e-08 60.574999999999996p 7.8509259999999995e-08 60.587499999999999p 7.6028539999999998e-08 60.600000000000001p 7.3452220000000005e-08 60.612499999999997p 7.0783999999999994e-08 60.625p 6.8027660000000003e-08 60.637500000000003p 6.5187129999999995e-08 60.650000000000006p 6.2266400000000005e-08 60.662499999999994p 5.9269599999999999e-08 60.674999999999997p 5.6200920000000002e-08 60.687500000000007p 5.3064639999999997e-08 60.699999999999996p 4.9865129999999999e-08 60.712499999999999p 4.6606839999999997e-08 60.725000000000001p 4.3294249999999997e-08 60.737500000000004p 3.993195e-08 60.75p 3.6524560000000003e-08
+ 60.762500000000003p 3.3076729999999999e-08 60.775000000000006p 2.959319e-08 60.787499999999994p 2.6078689999999999e-08 60.799999999999997p 2.253798e-08 60.8125p 1.8975889999999999e-08 60.824999999999996p 1.539721e-08 60.837499999999999p 1.1806770000000001e-08 60.850000000000001p 8.2094080000000003e-09 60.862500000000004p 4.6099350000000004e-09 60.875p 1.013169e-09 60.887500000000003p -2.5760930000000001e-09 60.900000000000006p -6.1530770000000003e-09 60.912499999999994p -9.7130369999999992e-09 60.924999999999997p -1.3251259999999999e-08 60.9375p -1.6763090000000002e-08 60.949999999999996p -2.0243880000000001e-08 60.962499999999999p -2.368909e-08 60.975000000000001p -2.7094189999999999e-08
+ 60.987500000000004p -3.0454749999999997e-08 60.999999999999993p -3.3766389999999998e-08 61.012500000000003p -3.7024819999999998e-08 61.025000000000006p -4.0225829999999998e-08 61.037499999999994p -4.3365280000000001e-08 61.049999999999997p -4.6439149999999998e-08 61.0625p -4.9443489999999999e-08 61.075000000000003p -5.237449e-08 61.087499999999999p -5.5228399999999998e-08 61.100000000000001p -5.8001619999999997e-08 61.112500000000004p -6.0690659999999995e-08 61.124999999999993p -6.3292130000000004e-08 61.137500000000003p -6.5802790000000003e-08 61.150000000000006p -6.8219520000000004e-08 61.162499999999994p -7.053933e-08 61.174999999999997p -7.2759370000000002e-08 61.1875p -7.487693e-08 61.200000000000003p -7.6889430000000006e-08
+ 61.212499999999999p -7.8794469999999995e-08 61.225000000000001p -8.0589759999999999e-08 61.237500000000004p -8.2273180000000003e-08 61.249999999999993p -8.3842780000000001e-08 61.262499999999996p -8.5296729999999999e-08 61.275000000000006p -8.6633390000000004e-08 61.287499999999994p -8.785126e-08 61.299999999999997p -8.8949009999999995e-08 61.3125p -8.9925489999999997e-08 61.325000000000003p -9.0779670000000004e-08 61.337499999999999p -9.1510730000000005e-08 61.350000000000001p -9.2118000000000005e-08 61.362500000000004p -9.2600969999999994e-08 61.374999999999993p -9.2959289999999999e-08 61.387499999999996p -9.3192799999999995e-08 61.400000000000006p -9.330149e-08 61.412500000000009p -9.3285529999999995e-08 61.424999999999997p -9.3145230000000005e-08
+ 61.4375p -9.2881090000000005e-08 61.450000000000003p -9.2493759999999997e-08 61.462499999999999p -9.1984060000000004e-08 61.475000000000001p -9.1352969999999995e-08 61.487500000000004p -9.0601620000000004e-08 61.499999999999993p -8.9731309999999998e-08 61.512499999999996p -8.8743479999999997e-08 61.524999999999999p -8.7639750000000002e-08 61.537500000000009p -8.642186e-08 61.549999999999997p -8.5091719999999995e-08 61.5625p -8.3651370000000005e-08 61.575000000000003p -8.2103000000000004e-08 61.587499999999999p -8.0448949999999999e-08 61.600000000000001p -7.8691669999999995e-08 61.612500000000004p -7.6833760000000001e-08 61.624999999999993p -7.4877939999999998e-08 61.637499999999996p -7.2827069999999997e-08 61.649999999999999p -7.0684110000000001e-08
+ 61.662500000000009p -6.8452149999999998e-08 61.674999999999997p -6.6134380000000004e-08 61.6875p -6.3734109999999996e-08 61.700000000000003p -6.1254749999999995e-08 61.712499999999991p -5.8699790000000002e-08 61.725000000000001p -5.607285e-08 61.737500000000004p -5.3377600000000001e-08 61.749999999999993p -5.0617810000000003e-08 61.762499999999996p -4.779733e-08 61.774999999999999p -4.4920089999999997e-08 61.787500000000009p -4.1990049999999997e-08 61.799999999999997p -3.9011289999999998e-08 61.8125p -3.5987890000000002e-08 61.825000000000003p -3.2924010000000001e-08 61.837499999999991p -2.9823859999999998e-08 61.850000000000001p -2.6691669999999999e-08 61.862500000000004p -2.3531709999999999e-08 61.875000000000007p -2.0348280000000001e-08
+ 61.887499999999996p -1.714571e-08 61.899999999999999p -1.392832e-08 61.912500000000001p -1.0700480000000001e-08 61.924999999999997p -7.4665230000000001e-09 61.9375p -4.2308049999999998e-09 61.950000000000003p -9.9766669999999991e-10 61.962499999999991p 2.2285630000000001e-09 61.975000000000001p 5.443575e-09 61.987500000000004p 8.6430859999999993e-09 62.000000000000007p 1.182284e-08 62.012499999999996p 1.4978619999999999e-08 62.024999999999999p 1.810626e-08 62.037500000000001p 2.1201620000000001e-08 62.049999999999997p 2.4260629999999999e-08 62.0625p 2.7279269999999999e-08 62.075000000000003p 3.0253599999999999e-08 62.087499999999991p 3.317972e-08 62.099999999999994p 3.6053829999999999e-08
+ 62.112500000000004p 3.8872200000000003e-08 62.125000000000007p 4.1631189999999998e-08 62.137499999999996p 4.4327220000000001e-08 62.149999999999999p 4.6956839999999997e-08 62.162500000000001p 4.951669e-08 62.174999999999997p 5.2003490000000003e-08 62.1875p 5.4414090000000002e-08 62.200000000000003p 5.6745450000000001e-08 62.212500000000006p 5.8994619999999998e-08 62.224999999999994p 6.1158779999999995e-08 62.237500000000004p 6.323526e-08 62.250000000000007p 6.5221469999999996e-08 62.262499999999996p 6.7114979999999996e-08 62.274999999999999p 6.8913470000000001e-08 62.287500000000001p 7.061477e-08 62.299999999999997p 7.2216840000000006e-08 62.3125p 7.3717769999999998e-08 62.325000000000003p 7.5115820000000005e-08
+ 62.337500000000006p 7.6409350000000005e-08 62.349999999999994p 7.7596899999999998e-08 62.362499999999997p 7.8677149999999999e-08 62.375000000000007p 7.9648920000000002e-08 62.387499999999996p 8.0511180000000003e-08 62.399999999999999p 8.1263059999999997e-08 62.412500000000001p 8.1903819999999999e-08 62.424999999999997p 8.2432909999999999e-08 62.4375p 8.2849890000000002e-08 62.450000000000003p 8.3154489999999995e-08 62.462500000000006p 8.334661e-08 62.474999999999994p 8.3426280000000005e-08 62.487499999999997p 8.3393680000000003e-08 62.500000000000007p 8.3249160000000005e-08 62.512499999999996p 8.2993200000000005e-08 62.524999999999999p 8.2626450000000006e-08 62.537500000000001p 8.2149679999999995e-08 62.550000000000004p 8.1563829999999994e-08
+ 62.5625p 8.0869980000000002e-08 62.575000000000003p 8.006935e-08 62.587500000000006p 7.9163299999999995e-08 62.599999999999994p 7.8153330000000004e-08 62.612499999999997p 7.7041079999999994e-08 62.625p 7.5828309999999995e-08 62.637499999999996p 7.4516920000000006e-08 62.649999999999999p 7.310895e-08 62.662500000000001p 7.160654e-08 62.675000000000004p 7.0011979999999999e-08 62.6875p 6.8327650000000002e-08 62.700000000000003p 6.6556059999999997e-08 62.712500000000006p 6.4699829999999996e-08 62.724999999999994p 6.2761679999999994e-08 62.737499999999997p 6.0744449999999996e-08 62.75p 5.8651050000000003e-08 62.762499999999996p 5.6484519999999998e-08 62.774999999999999p 5.4247950000000001e-08
+ 62.787500000000001p 5.1944559999999998e-08 62.800000000000004p 4.9577609999999997e-08 62.812499999999993p 4.7150460000000003e-08 62.825000000000003p 4.4666550000000001e-08 62.837500000000006p 4.2129349999999999e-08 62.849999999999994p 3.9542439999999999e-08 62.862499999999997p 3.6909410000000001e-08 62.875p 3.4233940000000001e-08 62.88750000000001p 3.1519739999999997e-08 62.899999999999999p 2.8770559999999999e-08 62.912500000000001p 2.5990190000000001e-08 62.925000000000004p 2.318245e-08 62.937499999999993p 2.0351189999999999e-08 62.950000000000003p 1.7500280000000001e-08 62.962500000000006p 1.46336e-08 62.974999999999994p 1.1755049999999999e-08 62.987499999999997p 8.8685309999999993e-09 63p 5.9779360000000001e-09
+ 63.012500000000003p 3.0871620000000001e-09 63.024999999999999p 2.000929e-10 63.037500000000001p -2.6794030000000002e-09 63.050000000000004p -5.5474780000000001e-09 63.062499999999993p -8.4003110000000006e-09 63.075000000000003p -1.123411e-08 63.087500000000006p -1.4045129999999999e-08 63.099999999999994p -1.682964e-08 63.112499999999997p -1.9583989999999999e-08 63.125p -2.2304549999999999e-08 63.137500000000003p -2.4987770000000001e-08 63.149999999999999p -2.7630129999999998e-08 63.162500000000001p -3.0228209999999999e-08 63.175000000000004p -3.277863e-08 63.187499999999993p -3.5278090000000002e-08 63.199999999999996p -3.7723389999999998e-08 63.212500000000006p -4.011137e-08 63.224999999999994p -4.2438989999999997e-08
+ 63.237499999999997p -4.4703280000000003e-08 63.25p -4.6901370000000003e-08 63.262500000000003p -4.903049e-08 63.274999999999999p -5.1087949999999998e-08 63.287500000000001p -5.3071199999999997e-08 63.300000000000004p -5.4977760000000001e-08 63.312499999999993p -5.6805269999999998e-08 63.324999999999996p -5.8551489999999997e-08 63.337500000000006p -6.0214290000000005e-08 63.350000000000009p -6.1791650000000003e-08 63.362499999999997p -6.3281689999999998e-08 63.375p -6.4682619999999996e-08 63.387500000000003p -6.5992800000000003e-08 63.399999999999999p -6.7210709999999999e-08 63.412500000000001p -6.833495e-08 63.425000000000004p -6.9364250000000005e-08 63.437499999999993p -7.0297480000000005e-08 63.449999999999996p -7.1133630000000001e-08
+ 63.462499999999999p -7.1871830000000002e-08 63.475000000000009p -7.2511329999999999e-08 63.487499999999997p -7.3051539999999997e-08 63.5p -7.3491970000000004e-08 63.512500000000003p -7.3832290000000002e-08 63.524999999999999p -7.4072300000000006e-08 63.537500000000001p -7.4211920000000004e-08 63.550000000000004p -7.4251229999999995e-08 63.562499999999993p -7.4190430000000003e-08 63.574999999999996p -7.4029839999999997e-08 63.587499999999999p -7.3769930000000002e-08 63.600000000000009p -7.3411309999999994e-08 63.612499999999997p -7.2954689999999994e-08 63.625p -7.2400929999999998e-08 63.637500000000003p -7.1751029999999995e-08 63.649999999999991p -7.1006090000000003e-08 63.662500000000001p -7.0167339999999998e-08 63.675000000000004p -6.923615e-08
+ 63.687500000000007p -6.8214000000000005e-08 63.699999999999996p -6.7102469999999999e-08 63.712499999999999p -6.5903289999999998e-08 63.725000000000001p -6.461828e-08 63.737499999999997p -6.3249380000000001e-08 63.75p -6.1798630000000004e-08 63.762500000000003p -6.0268179999999999e-08 63.774999999999991p -5.8660289999999997e-08 63.787500000000001p -5.6977299999999998e-08 63.800000000000004p -5.5221660000000001e-08 63.812500000000007p -5.3395899999999998e-08 63.824999999999996p -5.1502650000000002e-08 63.837499999999999p -4.9544629999999999e-08 63.850000000000001p -4.7524609999999998e-08 63.862499999999997p -4.5445480000000002e-08 63.875p -4.331016e-08 63.887500000000003p -4.1121670000000003e-08 63.899999999999991p -3.8883079999999997e-08
+ 63.912499999999994p -3.6597529999999997e-08 63.925000000000004p -3.4268199999999997e-08 63.937500000000007p -3.1898340000000001e-08 63.949999999999996p -2.949123e-08 63.962499999999999p -2.7050210000000001e-08 63.975000000000001p -2.4578639999999999e-08 63.987499999999997p -2.2079930000000001e-08 64p -1.9557520000000001e-08 64.012500000000003p -1.7014849999999999e-08 64.025000000000006p -1.44554e-08 64.037499999999994p -1.188266e-08 64.049999999999997p -9.3001429999999998e-09 64.0625p -6.7113420000000003e-09 64.075000000000003p -4.1197689999999998e-09 64.087500000000006p -1.528926e-09 64.100000000000009p 1.057693e-09 64.112499999999997p 3.6366080000000001e-09 64.125p 6.2043559999999998e-09
+ 64.137500000000003p 8.7574980000000002e-09 64.150000000000006p 1.129262e-08 64.162499999999994p 1.3806340000000001e-08 64.174999999999997p 1.6295330000000001e-08 64.1875p 1.875626e-08 64.199999999999989p 2.118589e-08 64.212500000000006p 2.3581010000000001e-08 64.225000000000009p 2.5938460000000001e-08 64.237499999999997p 2.8255139999999999e-08 64.25p 3.0528029999999997e-08 64.262500000000003p 3.2754149999999998e-08 64.275000000000006p 3.4930600000000002e-08 64.287499999999994p 3.7054569999999999e-08 64.299999999999997p 3.9123289999999999e-08 64.3125p 4.1134109999999998e-08 64.324999999999989p 4.3084439999999999e-08 64.337500000000006p 4.4971780000000003e-08 64.350000000000009p 4.6793739999999999e-08
+ 64.362499999999997p 4.8547999999999999e-08 64.375p 5.0232350000000002e-08 64.387500000000003p 5.1844680000000003e-08 64.400000000000006p 5.3382969999999999e-08 64.412499999999994p 5.4845309999999999e-08 64.424999999999997p 5.6229920000000002e-08 64.4375p 5.7535099999999997e-08 64.449999999999989p 5.875926e-08 64.462499999999991p 5.9900950000000005e-08 64.475000000000009p 6.0958809999999996e-08 64.487500000000011p 6.193162e-08 64.5p 6.2818249999999994e-08 64.512500000000003p 6.3617719999999998e-08 64.525000000000006p 6.4329130000000002e-08 64.537499999999994p 6.4951750000000005e-08 64.549999999999997p 6.5484940000000001e-08 64.5625p 6.5928189999999994e-08 64.574999999999989p 6.6281100000000002e-08
+ 64.587499999999991p 6.654343e-08 64.600000000000009p 6.6715020000000005e-08 64.612500000000011p 6.6795870000000003e-08 64.625p 6.6786079999999999e-08 64.637500000000003p 6.6685869999999997e-08 64.650000000000006p 6.6495599999999994e-08 64.662499999999994p 6.6215739999999999e-08 64.674999999999997p 6.5846890000000005e-08 64.6875p 6.5389740000000002e-08 64.699999999999989p 6.4845140000000001e-08 64.712499999999991p 6.4214029999999998e-08 64.724999999999994p 6.3497460000000004e-08 64.737500000000011p 6.2696609999999997e-08 64.75p 6.1812769999999999e-08 64.762500000000003p 6.0847329999999995e-08 64.775000000000006p 5.9801790000000001e-08 64.787499999999994p 5.8677749999999997e-08 64.799999999999997p 5.7476930000000003e-08
+ 64.8125p 5.6201130000000003e-08 64.825000000000003p 5.4852259999999997e-08 64.837499999999991p 5.3432309999999998e-08 64.849999999999994p 5.1943370000000003e-08 64.862500000000011p 5.0387630000000002e-08 64.875p 4.8767350000000002e-08 64.887500000000003p 4.7084860000000003e-08 64.900000000000006p 4.5342600000000003e-08 64.912499999999994p 4.3543060000000001e-08 64.924999999999997p 4.1688810000000003e-08 64.9375p 3.9782490000000002e-08 64.950000000000003p 3.7826789999999998e-08 64.962499999999991p 3.5824479999999998e-08 64.974999999999994p 3.3778369999999999e-08 64.987500000000011p 3.1691339999999998e-08 65p 2.9566290000000001e-08 65.012500000000003p 2.7406200000000002e-08 65.025000000000006p 2.5214049999999999e-08
+ 65.037499999999994p 2.2992880000000001e-08 65.049999999999997p 2.0745769999999999e-08 65.0625p 1.8475809999999998e-08 65.075000000000003p 1.6186109999999999e-08 65.087499999999991p 1.387981e-08 65.099999999999994p 1.156007e-08 65.112499999999997p 9.2300410000000004e-09 65.125p 6.8928940000000002e-09 65.137500000000003p 4.5517980000000001e-09 65.150000000000006p 2.2099189999999998e-09 65.162500000000009p -1.295829e-10 65.174999999999997p -2.4635600000000001e-09 65.1875p -4.7888790000000002e-09 65.200000000000003p -7.1024270000000001e-09 65.212499999999991p -9.4011130000000006e-09 65.224999999999994p -1.168188e-08 65.237499999999997p -1.3941680000000001e-08 65.25p -1.617754e-08
+ 65.262500000000003p -1.8386500000000001e-08 65.275000000000006p -2.0565640000000001e-08 65.287500000000009p -2.271211e-08 65.299999999999997p -2.4823079999999999e-08 65.3125p -2.6895800000000001e-08 65.325000000000003p -2.8927570000000001e-08 65.337499999999991p -3.0915749999999997e-08 65.349999999999994p -3.2857770000000002e-08 65.362499999999997p -3.4751120000000003e-08 65.375p -3.6593370000000001e-08 65.387500000000003p -3.8382159999999997e-08 65.400000000000006p -4.011521e-08 65.412500000000009p -4.1790309999999999e-08 65.424999999999997p -4.340536e-08 65.4375p -4.4958309999999998e-08 65.450000000000003p -4.6447229999999999e-08 65.462499999999991p -4.7870260000000001e-08 65.474999999999994p -4.9225639999999998e-08
+ 65.487499999999997p -5.05117e-08 65.5p -5.1726879999999999e-08 65.512500000000003p -5.28697e-08 65.525000000000006p -5.39388e-08 65.537500000000009p -5.4932909999999997e-08 65.549999999999997p -5.585087e-08 65.5625p -5.6691609999999997e-08 65.575000000000003p -5.7454190000000001e-08 65.587499999999991p -5.8137759999999997e-08 65.599999999999994p -5.8741580000000003e-08 65.612499999999997p -5.9265020000000001e-08 65.625p -5.970756e-08 65.637500000000003p -6.0068780000000003e-08 65.650000000000006p -6.0348400000000001e-08 65.662500000000009p -6.0546219999999996e-08 65.674999999999997p -6.0662150000000006e-08 65.6875p -6.0696219999999994e-08 65.700000000000003p -6.0648589999999998e-08
+ 65.712499999999991p -6.0519479999999995e-08 65.724999999999994p -6.0309260000000004e-08 65.737499999999997p -6.001839e-08 65.75p -5.9647439999999999e-08 65.762500000000003p -5.919709e-08 65.775000000000006p -5.8668119999999998e-08 65.787500000000009p -5.8061409999999998e-08 65.799999999999997p -5.7377950000000003e-08 65.8125p -5.6618829999999998e-08 65.825000000000003p -5.5785240000000003e-08 65.837499999999991p -5.4878450000000001e-08 65.849999999999994p -5.3899849999999998e-08 65.862499999999997p -5.2850900000000002e-08 65.875p -5.1733169999999999e-08 65.887500000000003p -5.054832e-08 65.900000000000006p -4.9298069999999998e-08 65.912500000000009p -4.7984239999999998e-08 65.924999999999997p -4.6608749999999997e-08
+ 65.9375p -4.517357e-08 65.950000000000003p -4.3680749999999999e-08 65.962500000000006p -4.2132430000000001e-08 65.974999999999994p -4.053079e-08 65.987499999999997p -3.8878119999999998e-08 66p -3.7176730000000003e-08 66.012499999999989p -3.5429019999999999e-08 66.025000000000006p -3.363742e-08 66.037500000000009p -3.1804439999999999e-08 66.049999999999997p -2.9932630000000002e-08 66.0625p -2.802458e-08 66.075000000000003p -2.608293e-08 66.087500000000006p -2.4110360000000001e-08 66.099999999999994p -2.2109579999999999e-08 66.112499999999997p -2.0083340000000001e-08 66.125p -1.80344e-08 66.137499999999989p -1.5965580000000001e-08 66.150000000000006p -1.387968e-08
+ 66.162500000000009p -1.1779539999999999e-08 66.174999999999997p -9.6680119999999998e-09 66.1875p -7.5479510000000001e-09 66.200000000000003p -5.4222209999999998e-09 66.212500000000006p -3.2936869999999999e-09 66.224999999999994p -1.165209e-09 66.237499999999997p 9.6035640000000007e-10 66.25p 3.080163e-09 66.262499999999989p 5.1913800000000003e-09 66.275000000000006p 7.2911919999999997e-09 66.287500000000009p 9.3768059999999996e-09 66.300000000000011p 1.144546e-08 66.3125p 1.34944e-08 66.325000000000003p 1.5520930000000001e-08 66.337500000000006p 1.7522379999999998e-08 66.349999999999994p 1.949612e-08 66.362499999999997p 2.1439560000000001e-08 66.375p 2.3350149999999999e-08
+ 66.387499999999989p 2.5225400000000001e-08 66.399999999999991p 2.706288e-08 66.412500000000009p 2.8860199999999999e-08 66.425000000000011p 3.0615030000000003e-08 66.4375p 3.2325119999999998e-08 66.450000000000003p 3.3988260000000003e-08 66.462500000000006p 3.560232e-08 66.474999999999994p 3.7165250000000003e-08 66.487499999999997p 3.8675070000000003e-08 66.5p 4.0129850000000001e-08 66.512499999999989p 4.1527769999999999e-08 66.524999999999991p 4.2867080000000002e-08 66.537500000000009p 4.4146109999999999e-08 66.550000000000011p 4.5363270000000001e-08 66.5625p 4.6517059999999998e-08 66.575000000000003p 4.7606089999999999e-08 66.587500000000006p 4.8629019999999998e-08 66.599999999999994p 4.9584640000000001e-08
+ 66.612499999999997p 5.0471799999999999e-08 66.625p 5.1289479999999998e-08 66.637500000000003p 5.2036720000000001e-08 66.649999999999991p 5.2712669999999998e-08 66.662499999999994p 5.3316599999999998e-08 66.675000000000011p 5.3847849999999999e-08 66.6875p 5.4305859999999998e-08 66.700000000000003p 5.4690190000000003e-08 66.712500000000006p 5.5000479999999997e-08 66.724999999999994p 5.5236490000000003e-08 66.737499999999997p 5.539805e-08 66.75p 5.5485129999999999e-08 66.762500000000003p 5.5497769999999998e-08 66.774999999999991p 5.5436119999999999e-08 66.787499999999994p 5.5300429999999997e-08 66.800000000000011p 5.5091050000000003e-08 66.8125p 5.4808419999999998e-08 66.825000000000003p 5.445309e-08
+ 66.837500000000006p 5.40257e-08 66.849999999999994p 5.352698e-08 66.862499999999997p 5.295776e-08 66.875p 5.2318960000000001e-08 66.887500000000003p 5.1611610000000001e-08 66.899999999999991p 5.083679e-08 66.912499999999994p 4.9995699999999997e-08 66.924999999999997p 4.9089620000000003e-08 66.9375p 4.8119919999999998e-08 66.950000000000003p 4.7088019999999998e-08 66.962500000000006p 4.599547e-08 66.974999999999994p 4.484385e-08 66.987499999999997p 4.3634849999999998e-08 67p 4.2370210000000002e-08 67.012500000000003p 4.1051759999999999e-08 67.024999999999991p 3.9681390000000002e-08 67.037499999999994p 3.826104e-08 67.049999999999997p 3.679274e-08
+ 67.0625p 3.5278550000000003e-08 67.075000000000003p 3.3720619999999999e-08 67.087500000000006p 3.2121119999999999e-08 67.100000000000009p 3.0482299999999998e-08 67.112499999999997p 2.8806430000000001e-08 67.125p 2.7095839999999999e-08 67.137500000000003p 2.53529e-08 67.149999999999991p 2.358002e-08 67.162499999999994p 2.1779630000000002e-08 67.174999999999997p 1.9954209999999999e-08 67.1875p 1.810625e-08 67.200000000000003p 1.6238289999999999e-08 67.212500000000006p 1.435285e-08 67.225000000000009p 1.245251e-08 67.237499999999997p 1.0539830000000001e-08 67.25p 8.6174029999999998e-09 67.262500000000003p 6.687818e-09 67.274999999999991p 4.7536690000000003e-09
+ 67.287499999999994p 2.817551e-09 67.299999999999997p 8.82054e-10 67.3125p -1.0502380000000001e-09 67.325000000000003p -2.9767519999999999e-09 67.337500000000006p -4.8949300000000002e-09 67.350000000000009p -6.8022289999999997e-09 67.362499999999997p -8.6961300000000007e-09 67.375p -1.0574129999999999e-08 67.387500000000003p -1.243377e-08 67.399999999999991p -1.427261e-08 67.412499999999994p -1.6088229999999999e-08 67.424999999999997p -1.787828e-08 67.4375p -1.9640420000000001e-08 67.450000000000003p -2.137237e-08 67.462500000000006p -2.3071880000000001e-08 67.475000000000009p -2.4736780000000001e-08 67.487499999999997p -2.6364909999999999e-08 67.5p -2.7954190000000001e-08
+ 67.512500000000003p -2.9502600000000001e-08 67.524999999999991p -3.1008169999999997e-08 67.537499999999994p -3.2468979999999998e-08 67.549999999999997p -3.3883199999999997e-08 67.5625p -3.5249050000000003e-08 67.575000000000003p -3.6564830000000002e-08 67.587500000000006p -3.7828889999999999e-08 67.600000000000009p -3.9039680000000001e-08 67.612499999999997p -4.0195700000000002e-08 67.625p -4.129554e-08 67.637500000000003p -4.233788e-08 67.649999999999991p -4.3321449999999999e-08 67.662499999999994p -4.4245089999999999e-08 67.674999999999997p -4.5107710000000003e-08 67.6875p -4.5908290000000003e-08 67.700000000000003p -4.6645920000000001e-08 67.712500000000006p -4.7319770000000002e-08 67.725000000000009p -4.7929090000000001e-08
+ 67.737499999999997p -4.8473210000000001e-08 67.75p -4.8951579999999999e-08 67.762500000000003p -4.9363700000000001e-08 67.775000000000006p -4.9709180000000003e-08 67.787499999999994p -4.9987720000000001e-08 67.799999999999997p -5.0199119999999997e-08 67.8125p -5.0343229999999997e-08 67.825000000000003p -5.042005e-08 67.837500000000006p -5.0429609999999997e-08 67.850000000000009p -5.0372060000000002e-08 67.862499999999997p -5.0247659999999999e-08 67.875p -5.00567e-08 67.887500000000003p -4.9799620000000001e-08 67.900000000000006p -4.9476909999999998e-08 67.912499999999994p -4.9089149999999999e-08 67.924999999999997p -4.863702e-08 67.9375p -4.8121269999999998e-08 67.949999999999989p -4.7542740000000001e-08
+ 67.962500000000006p -4.6902349999999998e-08 67.975000000000009p -4.620111e-08 67.987499999999997p -4.5440080000000001e-08 68p -4.462044e-08 68.012500000000003p -4.3743399999999998e-08 68.025000000000006p -4.2810280000000001e-08 68.037499999999994p -4.1822460000000003e-08 68.049999999999997p -4.0781369999999999e-08 68.0625p -3.9688550000000001e-08 68.074999999999989p -3.8545559999999999e-08 68.087500000000006p -3.7354059999999997e-08 68.100000000000009p -3.611574e-08 68.112499999999997p -3.4832370000000003e-08 68.125p -3.3505779999999998e-08 68.137500000000003p -3.2137820000000002e-08 68.150000000000006p -3.0730439999999999e-08 68.162499999999994p -2.928559e-08 68.174999999999997p -2.78053e-08
+ 68.1875p -2.6291629999999999e-08 68.199999999999989p -2.4746670000000001e-08 68.212499999999991p -2.317257e-08 68.225000000000009p -2.1571489999999999e-08 68.237500000000011p -1.994563e-08 68.25p -1.8297239999999999e-08 68.262500000000003p -1.6628549999999998e-08 68.275000000000006p -1.4941850000000001e-08 68.287499999999994p -1.323943e-08 68.299999999999997p -1.1523599999999999e-08 68.3125p -9.7966860000000008e-09 68.324999999999989p -8.0610210000000003e-09 68.337499999999991p -6.3189430000000002e-09 68.350000000000009p -4.572793e-09 68.362500000000011p -2.824913e-09 68.375p -1.077642e-09 68.387500000000003p 6.6668810000000002e-10 68.400000000000006p 2.4057549999999998e-09
+ 68.412499999999994p 4.1372490000000001e-09 68.424999999999997p 5.8588740000000001e-09 68.4375p 7.568357e-09 68.449999999999989p 9.2634420000000002e-09 68.462499999999991p 1.0941899999999999e-08 68.474999999999994p 1.260153e-08 68.487500000000011p 1.424016e-08 68.5p 1.5855650000000001e-08 68.512500000000003p 1.7445910000000001e-08 68.525000000000006p 1.900886e-08 68.537499999999994p 2.054249e-08 68.549999999999997p 2.2044819999999999e-08 68.5625p 2.3513919999999999e-08 68.575000000000003p 2.4947910000000001e-08 68.587499999999991p 2.6344959999999999e-08 68.599999999999994p 2.770329e-08 68.612500000000011p 2.902119e-08 68.625p 3.0297000000000003e-08
+ 68.637500000000003p 3.1529109999999999e-08 68.650000000000006p 3.2715989999999997e-08 68.662499999999994p 3.385616e-08 68.674999999999997p 3.4948229999999997e-08 68.6875p 3.5990840000000003e-08 68.700000000000003p 3.6982739999999998e-08 68.712499999999991p 3.7922719999999998e-08 68.724999999999994p 3.8809650000000002e-08 68.737500000000011p 3.9642499999999999e-08 68.75p 4.0420279999999997e-08 68.762500000000003p 4.1142090000000001e-08 68.775000000000006p 4.180711e-08 68.787499999999994p 4.2414599999999998e-08 68.799999999999997p 4.2963889999999998e-08 68.8125p 4.3454400000000002e-08 68.825000000000003p 4.3885619999999998e-08 68.837499999999991p 4.4257129999999999e-08 68.849999999999994p 4.4568590000000002e-08
+ 68.862499999999997p 4.481973e-08 68.875p 4.5010379999999999e-08 68.887500000000003p 4.5140449999999997e-08 68.900000000000006p 4.52099e-08 68.912500000000009p 4.5218819999999998e-08 68.924999999999997p 4.5167330000000003e-08 68.9375p 4.5055689999999997e-08 68.950000000000003p 4.4884179999999998e-08 68.962499999999991p 4.46532e-08 68.974999999999994p 4.4363209999999999e-08 68.987499999999997p 4.4014759999999997e-08 69p 4.360847e-08 69.012500000000003p 4.3145030000000003e-08 69.025000000000006p 4.262521e-08 69.037500000000009p 4.2049870000000001e-08 69.049999999999997p 4.1419919999999997e-08 69.0625p 4.0736339999999997e-08 69.075000000000003p 4.0000199999999998e-08
+ 69.087499999999991p 3.9212610000000003e-08 69.099999999999994p 3.8374780000000001e-08 69.112499999999997p 3.7487959999999998e-08 69.125p 3.6553459999999998e-08 69.137500000000003p 3.5572660000000001e-08 69.150000000000006p 3.4547010000000001e-08 69.162500000000009p 3.3477990000000001e-08 69.174999999999997p 3.2367150000000003e-08 69.1875p 3.1216090000000002e-08 69.200000000000003p 3.0026460000000001e-08 69.212499999999991p 2.879996e-08 69.224999999999994p 2.7538330000000001e-08 69.237499999999997p 2.6243350000000001e-08 69.25p 2.4916839999999999e-08 69.262500000000003p 2.3560669999999999e-08 69.275000000000006p 2.217674e-08 69.287500000000009p 2.076696e-08 69.299999999999997p 1.9333300000000001e-08
+ 69.3125p 1.787774e-08 69.325000000000003p 1.640229e-08 69.337499999999991p 1.4908980000000002e-08 69.349999999999994p 1.3399859999999999e-08 69.362499999999997p 1.187699e-08 69.375p 1.0342440000000001e-08 69.387500000000003p 8.7983070000000007e-09 69.400000000000006p 7.2466780000000002e-09 69.412500000000009p 5.6896539999999997e-09 69.424999999999997p 4.1293339999999999e-09 69.4375p 2.567815e-09 69.450000000000003p 1.0071919999999999e-09 69.462499999999991p -5.5044739999999999e-10 69.474999999999994p -2.1030259999999999e-09 69.487499999999997p -3.6484770000000001e-09 69.5p -5.1847520000000001e-09 69.512500000000003p -6.7098169999999998e-09 69.525000000000006p -8.2216610000000002e-09
+ 69.537500000000009p -9.7182949999999995e-09 69.549999999999997p -1.119776e-08 69.5625p -1.265811e-08 69.575000000000003p -1.409745e-08 69.587499999999991p -1.55139e-08 69.599999999999994p -1.690564e-08 69.612499999999997p -1.827086e-08 69.625p -1.9607799999999998e-08 69.637500000000003p -2.0914759999999999e-08 69.650000000000006p -2.2190060000000001e-08 69.662500000000009p -2.343207e-08 69.674999999999997p -2.463923e-08 69.6875p -2.5810020000000001e-08 69.700000000000003p -2.6942949999999999e-08 69.712500000000006p -2.803661e-08 69.724999999999994p -2.9089649999999999e-08 69.737499999999997p -3.0100760000000002e-08 69.75p -3.1068700000000002e-08
+ 69.762499999999989p -3.1992280000000003e-08 69.775000000000006p -3.2870399999999998e-08 69.787500000000009p -3.370198e-08 69.799999999999997p -3.4486049999999998e-08 69.8125p -3.522168e-08 69.825000000000003p -3.5908010000000003e-08 69.837500000000006p -3.654425e-08 69.849999999999994p -3.712968e-08 69.862499999999997p -3.766365e-08 69.875p -3.8145589999999998e-08 69.887499999999989p -3.857498e-08 69.900000000000006p -3.8951399999999998e-08 69.912500000000009p -3.9274459999999999e-08 69.924999999999997p -3.9543889999999998e-08 69.9375p -3.975946e-08 69.950000000000003p -3.992103e-08 69.962500000000006p -4.0028510000000003e-08 69.974999999999994p -4.0081920000000002e-08
+ 69.987499999999997p -4.008131e-08 70p -4.002684e-08 70.012499999999989p -3.9918710000000002e-08 70.025000000000006p -3.9757220000000001e-08 70.037500000000009p -3.9542709999999999e-08 70.050000000000011p -3.9275619999999998e-08 70.0625p -3.8956449999999999e-08 70.075000000000003p -3.8585749999999999e-08 70.087500000000006p -3.8164160000000002e-08 70.099999999999994p -3.769238e-08 70.112499999999997p -3.7171169999999997e-08 70.125p -3.6601369999999997e-08 70.137499999999989p -3.5983860000000002e-08 70.149999999999991p -3.5319590000000003e-08 70.162500000000009p -3.4609589999999999e-08 70.175000000000011p -3.3854920000000002e-08 70.1875p -3.305672e-08 70.200000000000003p -3.2216169999999997e-08
+ 70.212500000000006p -3.1334500000000002e-08 70.224999999999994p -3.0413020000000002e-08 70.237499999999997p -2.9453059999999998e-08 70.25p -2.845602e-08 70.262499999999989p -2.7423329999999999e-08 70.274999999999991p -2.6356469999999999e-08 70.287500000000009p -2.525696e-08 70.300000000000011p -2.4126379999999999e-08 70.3125p -2.2966310000000002e-08 70.325000000000003p -2.177841e-08 70.337500000000006p -2.0564330000000001e-08 70.349999999999994p -1.932578e-08 70.362499999999997p -1.8064499999999999e-08 70.375p -1.6782230000000002e-08 70.387500000000003p -1.5480760000000001e-08 70.399999999999991p -1.4161899999999999e-08 70.412499999999994p -1.2827450000000001e-08 70.425000000000011p -1.147927e-08
+ 70.4375p -1.01192e-08 70.450000000000003p -8.7491010000000002e-09 70.462500000000006p -7.3708540000000001e-09 70.474999999999994p -5.9863360000000002e-09 70.487499999999997p -4.5974279999999997e-09 70.5p -3.2060139999999998e-09 70.512500000000003p -1.8139790000000001e-09 70.524999999999991p -4.2320029999999999e-10 70.537499999999994p 9.6444809999999993e-10 70.550000000000011p 2.3471020000000001e-09 70.5625p 3.722909e-09 70.575000000000003p 5.0900289999999997e-09 70.587500000000006p 6.4466380000000002e-09 70.599999999999994p 7.7909340000000006e-09 70.612499999999997p 9.1211309999999998e-09 70.625p 1.043547e-08 70.637500000000003p 1.1732219999999999e-08 70.649999999999991p 1.300966e-08
+ 70.662499999999994p 1.426613e-08 70.674999999999997p 1.549998e-08 70.6875p 1.67096e-08 70.700000000000003p 1.7893419999999998e-08 70.712500000000006p 1.90499e-08 70.724999999999994p 2.0177559999999999e-08 70.737499999999997p 2.1274930000000001e-08 70.75p 2.2340609999999999e-08 70.762500000000003p 2.3373240000000001e-08 70.774999999999991p 2.4371520000000001e-08 70.787499999999994p 2.5334169999999998e-08 70.799999999999997p 2.6259989999999998e-08 70.8125p 2.7147820000000001e-08 70.825000000000003p 2.7996550000000001e-08 70.837500000000006p 2.8805130000000001e-08 70.850000000000009p 2.9572570000000001e-08 70.862499999999997p 3.0297950000000002e-08 70.875p 3.0980370000000002e-08
+ 70.887500000000003p 3.161904e-08 70.899999999999991p 3.221319e-08 70.912499999999994p 3.2762139999999997e-08 70.924999999999997p 3.3265250000000001e-08 70.9375p 3.3721960000000003e-08 70.950000000000003p 3.413178e-08 70.962500000000006p 3.4494260000000001e-08 70.975000000000009p 3.4809030000000001e-08 70.987499999999997p 3.5075790000000002e-08 71p 3.5294300000000001e-08 71.012500000000003p 3.5464389999999998e-08 71.024999999999991p 3.5585939999999999e-08 71.037499999999994p 3.5658920000000003e-08 71.049999999999997p 3.5683350000000002e-08 71.0625p 3.5659319999999998e-08 71.075000000000003p 3.5586990000000003e-08 71.087500000000006p 3.5466569999999998e-08 71.100000000000009p 3.5298339999999999e-08
+ 71.112499999999997p 3.5082669999999998e-08 71.125p 3.4819950000000001e-08 71.137500000000003p 3.4510669999999998e-08 71.149999999999991p 3.4155359999999999e-08 71.162499999999994p 3.3754619999999998e-08 71.174999999999997p 3.3309100000000003e-08 71.1875p 3.2819519999999998e-08 71.200000000000003p 3.2286649999999997e-08 71.212500000000006p 3.1711340000000001e-08 71.225000000000009p 3.1094449999999998e-08 71.237499999999997p 3.0436930000000001e-08 71.25p 2.973978e-08 71.262500000000003p 2.9004029999999999e-08 71.274999999999991p 2.8230779999999999e-08 71.287499999999994p 2.7421179999999999e-08 71.299999999999997p 2.6576400000000001e-08 71.3125p 2.569768e-08 71.325000000000003p 2.4786300000000001e-08
+ 71.337500000000006p 2.384357e-08 71.350000000000009p 2.2870849999999999e-08 71.362499999999997p 2.1869519999999999e-08 71.375p 2.0841020000000001e-08 71.387500000000003p 1.97868e-08 71.399999999999991p 1.870836e-08 71.412499999999994p 1.7607210000000001e-08 71.424999999999997p 1.6484909999999999e-08 71.4375p 1.534302e-08 71.450000000000003p 1.418314e-08 71.462500000000006p 1.300688e-08 71.475000000000009p 1.181587e-08 71.487499999999997p 1.061177e-08 71.5p 9.396238e-09 71.512500000000003p 8.1709410000000002e-09 71.525000000000006p 6.937562e-09 71.537499999999994p 5.6977919999999998e-09 71.549999999999997p 4.4533240000000001e-09
+ 71.5625p 3.205851e-09 71.575000000000003p 1.9570679999999999e-09 71.587500000000006p 7.0866910000000002e-10 71.600000000000009p -5.3765980000000002e-10 71.612499999999997p -1.780238e-09 71.625p -3.0173940000000001e-09 71.637500000000003p -4.2474689999999997e-09 71.650000000000006p -5.4688160000000001e-09 71.662499999999994p -6.6798060000000003e-09 71.674999999999997p -7.8788270000000001e-09 71.6875p -9.0642869999999998e-09 71.699999999999989p -1.023462e-08 71.712500000000006p -1.1388269999999999e-08 71.725000000000009p -1.252373e-08 71.737499999999997p -1.3639499999999999e-08 71.75p -1.473413e-08 71.762500000000003p -1.580619e-08 71.775000000000006p -1.685427e-08
+ 71.787499999999994p -1.7877040000000001e-08 71.799999999999997p -1.8873150000000001e-08 71.8125p -1.9841340000000001e-08 71.824999999999989p -2.0780350000000001e-08 71.837500000000006p -2.1689e-08 71.850000000000009p -2.256612e-08 71.862500000000011p -2.3410609999999998e-08 71.875p -2.4221400000000001e-08 71.887500000000003p -2.499748e-08 71.900000000000006p -2.573789e-08 71.912499999999994p -2.64417e-08 71.924999999999997p -2.710806e-08 71.9375p -2.7736149999999999e-08 71.949999999999989p -2.8325210000000001e-08 71.962499999999991p -2.8874540000000001e-08 71.975000000000009p -2.93835e-08 71.987500000000011p -2.9851480000000001e-08 72p -3.0277960000000002e-08
+ 72.012500000000003p -3.0662449999999998e-08 72.025000000000006p -3.1004539999999998e-08 72.037499999999994p -3.1303860000000002e-08 72.049999999999997p -3.1560099999999998e-08 72.0625p -3.1773020000000002e-08 72.074999999999989p -3.1942430000000001e-08 72.087499999999991p -3.206821e-08 72.100000000000009p -3.2150280000000003e-08 72.112500000000011p -3.2188629999999999e-08 72.125p -3.2183309999999997e-08 72.137500000000003p -3.2134440000000003e-08 72.150000000000006p -3.2042160000000001e-08 72.162499999999994p -3.1906719999999999e-08 72.174999999999997p -3.172838e-08 72.1875p -3.1507490000000003e-08 72.199999999999989p -3.124444e-08 72.212499999999991p -3.0939680000000002e-08 72.224999999999994p -3.0593719999999999e-08
+ 72.237500000000011p -3.0207110000000002e-08 72.25p -2.978047e-08 72.262500000000003p -2.9314460000000001e-08 72.275000000000006p -2.88098e-08 72.287499999999994p -2.8267260000000001e-08 72.299999999999997p -2.7687640000000001e-08 72.3125p -2.7071830000000001e-08 72.325000000000003p -2.6420719999999999e-08 72.337499999999991p -2.5735269999999999e-08 72.349999999999994p -2.5016490000000001e-08 72.362500000000011p -2.4265420000000001e-08 72.375p -2.3483130000000001e-08 72.387500000000003p -2.2670760000000001e-08 72.400000000000006p -2.1829460000000001e-08 72.412499999999994p -2.0960429999999999e-08 72.424999999999997p -2.0064909999999999e-08 72.4375p -1.9144160000000001e-08 72.450000000000003p -1.8199480000000001e-08
+ 72.462499999999991p -1.7232189999999999e-08 72.474999999999994p -1.6243640000000001e-08 72.487500000000011p -1.5235210000000001e-08 72.5p -1.420832e-08 72.512500000000003p -1.316437e-08 72.525000000000006p -1.2104810000000001e-08 72.537499999999994p -1.103111e-08 72.549999999999997p -9.9447500000000004e-09 72.5625p -8.8472100000000005e-09 72.575000000000003p -7.7399979999999995e-09 72.587499999999991p -6.6246280000000003e-09 72.599999999999994p -5.5026189999999999e-09 72.612499999999997p -4.3754980000000002e-09 72.625p -3.244794e-09 72.637500000000003p -2.1120390000000002e-09 72.650000000000006p -9.787640999999999e-10 72.662500000000009p 1.535033e-10 72.674999999999997p 1.2832390000000001e-09
+ 72.6875p 2.4089280000000001e-09 72.700000000000003p 3.5290599999999998e-09 72.712499999999991p 4.6421400000000003e-09 72.724999999999994p 5.7466819999999997e-09 72.737499999999997p 6.841216e-09 72.75p 7.9242900000000001e-09 72.762500000000003p 8.9944679999999996e-09 72.775000000000006p 1.005034e-08 72.787500000000009p 1.1090499999999999e-08 72.799999999999997p 1.21136e-08 72.8125p 1.311829e-08 72.825000000000003p 1.4103249999999999e-08 72.837499999999991p 1.5067209999999999e-08 72.849999999999994p 1.6008899999999999e-08 72.862499999999997p 1.6927099999999999e-08 72.875p 1.7820639999999999e-08 72.887500000000003p 1.8688350000000001e-08 72.900000000000006p 1.9529120000000001e-08
+ 72.912500000000009p 2.0341889999999999e-08 72.924999999999997p 2.1125610000000001e-08 72.9375p 2.187928e-08 72.950000000000003p 2.260197e-08 72.962499999999991p 2.3292759999999998e-08 72.974999999999994p 2.395079e-08 72.987499999999997p 2.457524e-08 73p 2.516534e-08 73.012500000000003p 2.572038e-08 73.025000000000006p 2.6239669999999999e-08 73.037500000000009p 2.6722599999999999e-08 73.049999999999997p 2.7168590000000002e-08 73.0625p 2.7577120000000001e-08 73.075000000000003p 2.794772e-08 73.087499999999991p 2.8279969999999999e-08 73.099999999999994p 2.8573510000000001e-08 73.112499999999997p 2.8828009999999998e-08 73.125p 2.9043230000000001e-08
+ 73.137500000000003p 2.9218959999999999e-08 73.150000000000006p 2.935504e-08 73.162500000000009p 2.9451369999999999e-08 73.174999999999997p 2.950791e-08 73.1875p 2.9524669999999999e-08 73.200000000000003p 2.9501709999999999e-08 73.212499999999991p 2.9439140000000001e-08 73.224999999999994p 2.9337130000000002e-08 73.237499999999997p 2.91959e-08 73.25p 2.901573e-08 73.262500000000003p 2.879694e-08 73.275000000000006p 2.8539900000000001e-08 73.287500000000009p 2.8245039999999999e-08 73.299999999999997p 2.7912849999999998e-08 73.3125p 2.754383e-08 73.325000000000003p 2.7138580000000001e-08 73.337499999999991p 2.6697699999999999e-08 73.349999999999994p 2.622188e-08
+ 73.362499999999997p 2.5711810000000001e-08 73.375p 2.5168260000000001e-08 73.387500000000003p 2.4592029999999999e-08 73.400000000000006p 2.3983959999999999e-08 73.412500000000009p 2.3344939999999999e-08 73.424999999999997p 2.2675889999999999e-08 73.4375p 2.1977769999999999e-08 73.450000000000003p 2.1251579999999999e-08 73.462500000000006p 2.0498360000000002e-08 73.474999999999994p 1.9719170000000001e-08 73.487499999999997p 1.891511e-08 73.5p 1.8087320000000001e-08 73.512499999999989p 1.7236960000000001e-08 73.525000000000006p 1.6365209999999999e-08 73.537500000000009p 1.5473289999999999e-08 73.549999999999997p 1.4562449999999999e-08 73.5625p 1.3633930000000001e-08 73.575000000000003p 1.268902e-08
+ 73.587500000000006p 1.172903e-08 73.599999999999994p 1.0755279999999999e-08 73.612499999999997p 9.7690879999999996e-09 73.625p 8.7718139999999993e-09 73.637499999999989p 7.7648159999999996e-09 73.650000000000006p 6.7494630000000001e-09 73.662500000000009p 5.727133e-09 73.674999999999997p 4.6992100000000004e-09 73.6875p 3.6670829999999998e-09 73.700000000000003p 2.6321409999999999e-09 73.712500000000006p 1.595778e-09 73.724999999999994p 5.59382e-10 73.737499999999997p -4.7565859999999996e-10 73.75p -1.5079620000000001e-09 73.762499999999989p -2.5361529999999999e-09 73.774999999999991p -3.5588639999999999e-09 73.787500000000009p -4.5747400000000003e-09 73.800000000000011p -5.5824370000000003e-09
+ 73.8125p -6.5806239999999996e-09 73.825000000000003p -7.5679869999999995e-09 73.837500000000006p -8.5432299999999997e-09 73.849999999999994p -9.5050750000000005e-09 73.862499999999997p -1.045226e-08 73.875p -1.138357e-08 73.887499999999989p -1.229777e-08 73.899999999999991p -1.3193679999999999e-08 73.912500000000009p -1.4070159999999999e-08 73.925000000000011p -1.492607e-08 73.9375p -1.576031e-08 73.950000000000003p -1.657181e-08 73.962500000000006p -1.735954e-08 73.974999999999994p -1.8122499999999999e-08 73.987499999999997p -1.8859730000000001e-08 74p -1.9570289999999999e-08 74.012499999999989p -2.0253299999999999e-08 74.024999999999991p -2.0907899999999999e-08
+ 74.037500000000009p -2.1533290000000001e-08 74.050000000000011p -2.212868e-08 74.0625p -2.2693359999999999e-08 74.075000000000003p -2.3226640000000001e-08 74.087500000000006p -2.3727870000000001e-08 74.099999999999994p -2.4196450000000002e-08 74.112499999999997p -2.463184e-08 74.125p -2.503352e-08 74.137500000000003p -2.540103e-08 74.149999999999991p -2.5733960000000001e-08 74.162499999999994p -2.6031939999999999e-08 74.175000000000011p -2.6294649999999999e-08 74.1875p -2.652181e-08 74.200000000000003p -2.67132e-08 74.212500000000006p -2.6868650000000002e-08 74.224999999999994p -2.6988029999999999e-08 74.237499999999997p -2.7071250000000002e-08 74.25p -2.7118290000000001e-08
+ 74.262500000000003p -2.7129159999999999e-08 74.274999999999991p -2.710393e-08 74.287499999999994p -2.7042719999999999e-08 74.300000000000011p -2.6945679999999999e-08 74.3125p -2.681302e-08 74.325000000000003p -2.6645000000000001e-08 74.337500000000006p -2.644193e-08 74.349999999999994p -2.6204139999999999e-08 74.362499999999997p -2.593204e-08 74.375p -2.562606e-08 74.387500000000003p -2.528669e-08 74.399999999999991p -2.4914459999999998e-08 74.412499999999994p -2.450992e-08 74.424999999999997p -2.4073710000000001e-08 74.4375p -2.3606450000000001e-08 74.450000000000003p -2.310886e-08 74.462500000000006p -2.2581650000000001e-08 74.474999999999994p -2.202561e-08
+ 74.487499999999997p -2.144152e-08 74.5p -2.0830249999999999e-08 74.512500000000003p -2.0192649999999999e-08 74.524999999999991p -1.9529640000000001e-08 74.537499999999994p -1.8842159999999999e-08 74.549999999999997p -1.813118e-08 74.5625p -1.7397699999999998e-08 74.575000000000003p -1.6642749999999999e-08 74.587500000000006p -1.5867380000000001e-08 74.600000000000009p -1.5072669999999999e-08 74.612499999999997p -1.425973e-08 74.625p -1.3429669999999999e-08 74.637500000000003p -1.258365e-08 74.649999999999991p -1.1722820000000001e-08 74.662499999999994p -1.084836e-08 74.674999999999997p -9.9614799999999998e-09 74.6875p -9.0633769999999992e-09 74.700000000000003p -8.1552759999999995e-09
+ 74.712500000000006p -7.2384089999999997e-09 74.725000000000009p -6.314017e-09 74.737499999999997p -5.3833489999999997e-09 74.75p -4.4476579999999997e-09 74.762500000000003p -3.5082020000000002e-09 74.774999999999991p -2.56624e-09 74.787499999999994p -1.6230330000000001e-09 74.799999999999997p -6.7983889999999996e-10 74.8125p 2.620862e-10 74.825000000000003p 1.2014910000000001e-09 74.837500000000006p 2.1371309999999999e-09 74.850000000000009p 3.0677679999999998e-09 74.862499999999997p 3.9921749999999998e-09 74.875p 4.9091370000000001e-09 74.887500000000003p 5.8174490000000001e-09 74.899999999999991p 6.7159220000000003e-09 74.912499999999994p 7.6033840000000003e-09 74.924999999999997p 8.4786789999999996e-09
+ 74.9375p 9.3406689999999994e-09 74.950000000000003p 1.018824e-08 74.962500000000006p 1.102029e-08 74.975000000000009p 1.183576e-08 74.987499999999997p 1.2633600000000001e-08 75p 1.341278e-08 75.012500000000003p 1.4172320000000001e-08 75.024999999999991p 1.4911250000000001e-08 75.037499999999994p 1.5628640000000002e-08 75.049999999999997p 1.632357e-08 75.0625p 1.6995189999999999e-08 75.075000000000003p 1.7642649999999999e-08 75.087500000000006p 1.826515e-08 75.100000000000009p 1.8861920000000001e-08 75.112499999999997p 1.9432219999999999e-08 75.125p 1.9975370000000001e-08 75.137500000000003p 2.0490700000000002e-08 75.149999999999991p 2.0977599999999999e-08
+ 75.162499999999994p 2.143549e-08 75.174999999999997p 2.1863819999999999e-08 75.1875p 2.226211e-08 75.200000000000003p 2.2629889999999999e-08 75.212500000000006p 2.296675e-08 75.225000000000009p 2.3272310000000001e-08 75.237499999999997p 2.3546250000000001e-08 75.25p 2.3788280000000001e-08 75.262500000000003p 2.3998159999999999e-08 75.275000000000006p 2.4175690000000001e-08 75.287499999999994p 2.43207e-08 75.299999999999997p 2.443309e-08 75.3125p 2.4512789999999998e-08 75.325000000000003p 2.4559779999999999e-08 75.337500000000006p 2.4574070000000001e-08 75.350000000000009p 2.4555730000000002e-08 75.362499999999997p 2.4504859999999998e-08 75.375p 2.442161e-08
+ 75.387500000000003p 2.4306180000000001e-08 75.400000000000006p 2.4158790000000001e-08 75.412499999999994p 2.397973e-08 75.424999999999997p 2.3769319999999999e-08 75.4375p 2.3527909999999998e-08 75.449999999999989p 2.3255910000000001e-08 75.462500000000006p 2.2953750000000001e-08 75.475000000000009p 2.262191e-08 75.487499999999997p 2.2260910000000001e-08 75.5p 2.1871310000000001e-08 75.512500000000003p 2.1453699999999998e-08 75.525000000000006p 2.10087e-08 75.537499999999994p 2.0536980000000001e-08 75.549999999999997p 2.0039229999999999e-08 75.5625p 1.9516189999999999e-08 75.574999999999989p 1.8968620000000001e-08 75.587500000000006p 1.8397299999999999e-08 75.600000000000009p 1.780307e-08
+ 75.612500000000011p 1.718677e-08 75.625p 1.6549280000000001e-08 75.637500000000003p 1.58915e-08 75.650000000000006p 1.5214359999999999e-08 75.662499999999994p 1.451882e-08 75.674999999999997p 1.380585e-08 75.6875p 1.307644e-08 75.699999999999989p 1.2331610000000001e-08 75.712499999999991p 1.157239e-08 75.725000000000009p 1.079983e-08 75.737500000000011p 1.0015000000000001e-08 75.75p 9.2189610000000005e-09 75.762500000000003p 8.4128170000000002e-09 75.775000000000006p 7.5976660000000007e-09 75.787499999999994p 6.7746160000000003e-09 75.799999999999997p 5.9447840000000003e-09 75.8125p 5.1092939999999999e-09 75.824999999999989p 4.269275e-09
+ 75.837499999999991p 3.425856e-09 75.850000000000009p 2.580172e-09 75.862500000000011p 1.733355e-09 75.875p 8.8653550000000003e-10 75.887500000000003p 4.0842940000000002e-11 75.900000000000006p -8.0259889999999996e-10 75.912499999999994p -1.6426720000000001e-09 75.924999999999997p -2.4782659999999999e-09 75.9375p -3.3082790000000002e-09 75.949999999999989p -4.1316190000000004e-09 75.962499999999991p -4.9472070000000002e-09 75.974999999999994p -5.7539760000000004e-09 75.987500000000011p -6.5508750000000001e-09 76p -7.3368670000000004e-09 76.012500000000003p -8.1109339999999994e-09 76.025000000000006p -8.8720759999999994e-09 76.037499999999994p -9.6193109999999999e-09 76.049999999999997p -1.035168e-08
+ 76.0625p -1.1068250000000001e-08 76.075000000000003p -1.176811e-08 76.087499999999991p -1.245036e-08 76.099999999999994p -1.3114140000000001e-08 76.112500000000011p -1.3758620000000001e-08 76.125p -1.4382990000000001e-08 76.137500000000003p -1.498648e-08 76.150000000000006p -1.556832e-08 76.162499999999994p -1.612781e-08 76.174999999999997p -1.666426e-08 76.1875p -1.7177009999999999e-08 76.200000000000003p -1.7665450000000001e-08 76.212499999999991p -1.812898e-08 76.224999999999994p -1.8567049999999999e-08 76.237500000000011p -1.8979159999999999e-08 76.25p -1.9364810000000001e-08 76.262500000000003p -1.972357e-08 76.275000000000006p -2.005503e-08
+ 76.287499999999994p -2.0358819999999999e-08 76.299999999999997p -2.0634610000000001e-08 76.3125p -2.08821e-08 76.325000000000003p -2.1101040000000001e-08 76.337499999999991p -2.1291229999999999e-08 76.349999999999994p -2.145247e-08 76.362499999999997p -2.1584629999999999e-08 76.375p -2.168762e-08 76.387500000000003p -2.1761380000000001e-08 76.400000000000006p -2.1805880000000002e-08 76.412500000000009p -2.1821149999999999e-08 76.424999999999997p -2.1807239999999998e-08 76.4375p -2.1764259999999999e-08 76.450000000000003p -2.1692339999999999e-08 76.462499999999991p -2.159164e-08 76.474999999999994p -2.1462399999999999e-08 76.487499999999997p -2.130485e-08 76.5p -2.1119279999999999e-08
+ 76.512500000000003p -2.0906019999999998e-08 76.525000000000006p -2.0665430000000002e-08 76.537500000000009p -2.03979e-08 76.549999999999997p -2.0103870000000001e-08 76.5625p -1.9783799999999999e-08 76.575000000000003p -1.943818e-08 76.587499999999991p -1.9067560000000001e-08 76.599999999999994p -1.8672500000000001e-08 76.612499999999997p -1.8253580000000001e-08 76.625p -1.7811440000000001e-08 76.637500000000003p -1.734673e-08 76.650000000000006p -1.6860139999999998e-08 76.662500000000009p -1.6352379999999998e-08 76.674999999999997p -1.5824180000000001e-08 76.6875p -1.527631e-08 76.700000000000003p -1.470955e-08 76.712499999999991p -1.4124730000000001e-08 76.724999999999994p -1.3522660000000001e-08
+ 76.737499999999997p -1.290421e-08 76.75p -1.227025e-08 76.762500000000003p -1.1621660000000001e-08 76.775000000000006p -1.095937e-08 76.787500000000009p -1.0284299999999999e-08 76.799999999999997p -9.5973800000000002e-09 76.8125p -8.8995750000000005e-09 76.825000000000003p -8.1918470000000007e-09 76.837499999999991p -7.475174e-09 76.849999999999994p -6.750542e-09 76.862499999999997p -6.0189469999999996e-09 76.875p -5.2813890000000002e-09 76.887500000000003p -4.538875e-09 76.900000000000006p -3.7924160000000004e-09 76.912500000000009p -3.0430269999999999e-09 76.924999999999997p -2.2917209999999999e-09 76.9375p -1.5395129999999999e-09 76.950000000000003p -7.8741800000000004e-10
+ 76.962499999999991p -3.6445390000000002e-11 76.974999999999994p 7.1239789999999999e-10 76.987499999999997p 1.4581109999999999e-09 77p 2.1996989999999999e-09 77.012500000000003p 2.936177e-09 77.025000000000006p 3.6665679999999999e-09 77.037500000000009p 4.3899050000000003e-09 77.049999999999997p 5.1052349999999997e-09 77.0625p 5.811618e-09 77.075000000000003p 6.5081259999999999e-09 77.087499999999991p 7.1938499999999999e-09 77.099999999999994p 7.8678959999999996e-09 77.112499999999997p 8.5293889999999997e-09 77.125p 9.1774709999999996e-09 77.137500000000003p 9.8113079999999999e-09 77.150000000000006p 1.043008e-08 77.162500000000009p 1.103301e-08 77.174999999999997p 1.1619309999999999e-08
+ 77.1875p 1.218825e-08 77.200000000000003p 1.27391e-08 77.212500000000006p 1.327117e-08 77.224999999999994p 1.37838e-08 77.237499999999997p 1.4276350000000001e-08 77.25p 1.474821e-08 77.262499999999989p 1.5198799999999998e-08 77.275000000000006p 1.5627570000000001e-08 77.287500000000009p 1.603401e-08 77.299999999999997p 1.641762e-08 77.3125p 1.677795e-08 77.325000000000003p 1.711459e-08 77.337500000000006p 1.742713e-08 77.349999999999994p 1.7715230000000001e-08 77.362499999999997p 1.797856e-08 77.375p 1.8216829999999999e-08 77.387499999999989p 1.8429799999999999e-08 77.400000000000006p 1.8617240000000001e-08
+ 77.412500000000009p 1.8778979999999999e-08 77.424999999999997p 1.8914859999999999e-08 77.4375p 1.9024769999999999e-08 77.450000000000003p 1.910863e-08 77.462500000000006p 1.9166409999999999e-08 77.474999999999994p 1.91981e-08 77.487499999999997p 1.9203720000000001e-08 77.5p 1.918333e-08 77.512499999999989p 1.9137050000000001e-08 77.524999999999991p 1.9064999999999999e-08 77.537500000000009p 1.8967349999999999e-08 77.550000000000011p 1.884429e-08 77.5625p 1.869608e-08 77.575000000000003p 1.852297e-08 77.587500000000006p 1.832527e-08 77.599999999999994p 1.8103319999999999e-08 77.612499999999997p 1.785747e-08 77.625p 1.758814e-08
+ 77.637499999999989p 1.7295740000000001e-08 77.649999999999991p 1.6980730000000002e-08 77.662500000000009p 1.6643600000000002e-08 77.675000000000011p 1.6284880000000001e-08 77.6875p 1.5905090000000001e-08 77.700000000000003p 1.5504820000000001e-08 77.712500000000006p 1.508466e-08 77.724999999999994p 1.464524e-08 77.737499999999997p 1.4187189999999999e-08 77.75p 1.3711190000000001e-08 77.762499999999989p 1.321794e-08 77.774999999999991p 1.270815e-08 77.787500000000009p 1.218254e-08 77.800000000000011p 1.1641880000000001e-08 77.8125p 1.1086949999999999e-08 77.825000000000003p 1.0518520000000001e-08 77.837500000000006p 9.9374e-09 77.849999999999994p 9.3444190000000004e-09
+ 77.862499999999997p 8.7404069999999999e-09 77.875p 8.1262110000000005e-09 77.887500000000003p 7.5026910000000002e-09 77.899999999999991p 6.8707160000000004e-09 77.912499999999994p 6.2311630000000004e-09 77.925000000000011p 5.5849189999999999e-09 77.9375p 4.9328769999999999e-09 77.950000000000003p 4.2759340000000002e-09 77.962500000000006p 3.6149950000000001e-09 77.974999999999994p 2.950963e-09 77.987499999999997p 2.2847469999999999e-09 78p 1.617254e-09 78.012500000000003p 9.493914e-10 78.024999999999991p 2.8206490000000002e-10 78.037499999999994p -3.838235e-10 78.050000000000011p -1.0473759999999999e-09 78.0625p -1.7077e-09 78.075000000000003p -2.3639090000000001e-09
+ 78.087500000000006p -3.015127e-09 78.099999999999994p -3.6604840000000002e-09 78.112499999999997p -4.2991209999999998e-09 78.125p -4.9301920000000001e-09 78.137500000000003p -5.5528600000000002e-09 78.149999999999991p -6.1663060000000004e-09 78.162499999999994p -6.7697220000000003e-09 78.174999999999997p -7.3623159999999998e-09 78.1875p -7.9433160000000002e-09 78.200000000000003p -8.5119619999999999e-09 78.212500000000006p -9.0675180000000007e-09 78.225000000000009p -9.6092650000000003e-09 78.237499999999997p -1.0136499999999999e-08 78.25p -1.064856e-08 78.262500000000003p -1.1144769999999999e-08 78.274999999999991p -1.1624520000000001e-08 78.287499999999994p -1.208719e-08 78.299999999999997p -1.253219e-08
+ 78.3125p -1.2958980000000001e-08 78.325000000000003p -1.336702e-08 78.337500000000006p -1.37558e-08 78.350000000000009p -1.4124849999999999e-08 78.362499999999997p -1.447371e-08 78.375p -1.4801969999999999e-08 78.387500000000003p -1.510923e-08 78.399999999999991p -1.5395130000000002e-08 78.412499999999994p -1.5659340000000001e-08 78.424999999999997p -1.5901550000000001e-08 78.4375p -1.612148e-08 78.450000000000003p -1.63189e-08 78.462500000000006p -1.64936e-08 78.475000000000009p -1.664539e-08 78.487499999999997p -1.677413e-08 78.5p -1.68797e-08 78.512500000000003p -1.696201e-08 78.524999999999991p -1.7021010000000001e-08
+ 78.537499999999994p -1.7056669999999999e-08 78.549999999999997p -1.7069009999999999e-08 78.5625p -1.7058059999999999e-08 78.575000000000003p -1.7023909999999999e-08 78.587500000000006p -1.696664e-08 78.600000000000009p -1.6886400000000002e-08 78.612499999999997p -1.6783340000000001e-08 78.625p -1.665767e-08 78.637500000000003p -1.6509609999999998e-08 78.649999999999991p -1.633941e-08 78.662499999999994p -1.6147360000000001e-08 78.674999999999997p -1.5933769999999998e-08 78.6875p -1.5698980000000001e-08 78.700000000000003p -1.544336e-08 78.712500000000006p -1.5167309999999999e-08 78.725000000000009p -1.487124e-08 78.737499999999997p -1.4555619999999999e-08 78.75p -1.42209e-08
+ 78.762500000000003p -1.38676e-08 78.774999999999991p -1.3496229999999999e-08 78.787499999999994p -1.310734e-08 78.799999999999997p -1.27015e-08 78.8125p -1.22793e-08 78.825000000000003p -1.1841340000000001e-08 78.837500000000006p -1.1388259999999999e-08 78.850000000000009p -1.0920709999999999e-08 78.862499999999997p -1.0439360000000001e-08 78.875p -9.9448840000000001e-09 78.887500000000003p -9.43799e-09 78.899999999999991p -8.9193919999999996e-09 78.912499999999994p -8.3898210000000002e-09 78.924999999999997p -7.8500179999999999e-09 78.9375p -7.3007400000000002e-09 78.950000000000003p -6.7427519999999999e-09 78.962500000000006p -6.1768319999999999e-09 78.975000000000009p -5.6037629999999998e-09
+ 78.987499999999997p -5.02434e-09 79p -4.4393619999999997e-09 79.012500000000003p -3.8496339999999997e-09 79.025000000000006p -3.2559670000000002e-09 79.037499999999994p -2.659175e-09 79.049999999999997p -2.0600720000000001e-09 79.0625p -1.459478e-09 79.075000000000003p -8.5820809999999999e-10 79.087500000000006p -2.5708009999999999e-10 79.100000000000009p 3.4309180000000001e-10 79.112499999999997p 9.4149619999999993e-10 79.125p 1.5373260000000001e-09 79.137500000000003p 2.1297790000000002e-09 79.150000000000006p 2.71806e-09 79.162499999999994p 3.3013809999999999e-09 79.174999999999997p 3.8789619999999998e-09 79.1875p 4.4500329999999999e-09 79.199999999999989p 5.0138340000000003e-09
+ 79.212500000000006p 5.5696169999999999e-09 79.225000000000009p 6.1166470000000003e-09 79.237499999999997p 6.6542009999999999e-09 79.25p 7.1815720000000003e-09 79.262500000000003p 7.698066e-09 79.275000000000006p 8.203008e-09 79.287499999999994p 8.6957390000000001e-09 79.299999999999997p 9.1756179999999996e-09 79.3125p 9.6420209999999997e-09 79.324999999999989p 1.009435e-08 79.337500000000006p 1.0532009999999999e-08 79.350000000000009p 1.0954459999999999e-08 79.362500000000011p 1.136114e-08 79.375p 1.1751540000000001e-08 79.387500000000003p 1.2125180000000001e-08 79.400000000000006p 1.2481570000000001e-08 79.412499999999994p 1.282027e-08 79.424999999999997p 1.314086e-08
+ 79.4375p 1.3442950000000001e-08 79.449999999999989p 1.372616e-08 79.462499999999991p 1.399016e-08 79.475000000000009p 1.4234619999999999e-08 79.487500000000011p 1.4459260000000001e-08 79.5p 1.466381e-08 79.512500000000003p 1.484804e-08 79.525000000000006p 1.5011739999999999e-08 79.537499999999994p 1.5154729999999999e-08 79.549999999999997p 1.527687e-08 79.5625p 1.537804e-08 79.574999999999989p 1.545813e-08 79.587499999999991p 1.5517090000000001e-08 79.600000000000009p 1.5554880000000001e-08 79.612500000000011p 1.5571490000000002e-08 79.625p 1.556695e-08 79.637500000000003p 1.55413e-08 79.650000000000006p 1.5494619999999999e-08
+ 79.662499999999994p 1.5427029999999999e-08 79.674999999999997p 1.533865e-08 79.6875p 1.5229649999999999e-08 79.699999999999989p 1.510022e-08 79.712499999999991p 1.4950580000000001e-08 79.724999999999994p 1.4780970000000001e-08 79.737500000000011p 1.459165e-08 79.75p 1.438294e-08 79.762500000000003p 1.415514e-08 79.775000000000006p 1.390861e-08 79.787499999999994p 1.364372e-08 79.799999999999997p 1.336086e-08 79.8125p 1.306045e-08 79.825000000000003p 1.2742939999999999e-08 79.837499999999991p 1.240878e-08 79.849999999999994p 1.205847e-08 79.862500000000011p 1.169252e-08 79.875p 1.1311429999999999e-08
+ 79.887500000000003p 1.0915769999999999e-08 79.900000000000006p 1.050609e-08 79.912499999999994p 1.008298e-08 79.924999999999997p 9.6470329999999992e-09 79.9375p 9.1988660000000005e-09 79.950000000000003p 8.7391070000000007e-09 79.962499999999991p 8.2684010000000004e-09 79.974999999999994p 7.7874040000000003e-09 79.987499999999997p 7.2967860000000004e-09 80p 6.797227e-09 80.012500000000003p 6.2894210000000003e-09 80.025000000000006p 5.7740659999999997e-09 80.037499999999994p 5.2518750000000003e-09 80.049999999999997p 4.7235630000000003e-09 80.0625p 4.1898560000000002e-09 80.075000000000003p 3.651483e-09 80.087499999999991p 3.1091789999999999e-09 80.099999999999994p 2.5636820000000002e-09
+ 80.112499999999997p 2.0157319999999998e-09 80.125p 1.4660739999999999e-09 80.137500000000003p 9.1544980000000002e-10 80.150000000000006p 3.6460269999999999e-10 80.162500000000009p -1.857254e-10 80.174999999999997p -7.3479490000000001e-10 80.1875p -1.28187e-09 80.200000000000003p -1.8262179999999999e-09 80.212499999999991p -2.3671129999999998e-09 80.224999999999994p -2.9038349999999998e-09 80.237499999999997p -3.4356690000000001e-09 80.25p -3.9619109999999999e-09 80.262500000000003p -4.481865e-09 80.275000000000006p -4.9948440000000001e-09 80.287500000000009p -5.5001739999999997e-09 80.299999999999997p -5.99719e-09 80.3125p -6.4852409999999997e-09 80.325000000000003p -6.96369e-09
+ 80.337499999999991p -7.4319139999999999e-09 80.349999999999994p -7.8893039999999997e-09 80.362499999999997p -8.3352689999999996e-09 80.375p -8.7692309999999998e-09 80.387500000000003p -9.1906329999999999e-09 80.400000000000006p -9.5989339999999993e-09 80.412500000000009p -9.9936139999999994e-09 80.424999999999997p -1.037417e-08 80.4375p -1.0740120000000001e-08 80.450000000000003p -1.1091e-08 80.462499999999991p -1.142637e-08 80.474999999999994p -1.174581e-08 80.487499999999997p -1.204893e-08 80.5p -1.233535e-08 80.512500000000003p -1.2604729999999999e-08 80.525000000000006p -1.2856730000000001e-08 80.537500000000009p -1.3091050000000001e-08 80.549999999999997p -1.330742e-08
+ 80.5625p -1.350558e-08 80.575000000000003p -1.3685299999999999e-08 80.587499999999991p -1.3846380000000001e-08 80.599999999999994p -1.398863e-08 80.612499999999997p -1.411191e-08 80.625p -1.42161e-08 80.637500000000003p -1.4301079999999999e-08 80.650000000000006p -1.436678e-08 80.662500000000009p -1.4413159999999999e-08 80.674999999999997p -1.444019e-08 80.6875p -1.444787e-08 80.700000000000003p -1.443623e-08 80.712499999999991p -1.440533e-08 80.724999999999994p -1.435525e-08 80.737499999999997p -1.428609e-08 80.75p -1.4197979999999999e-08 80.762500000000003p -1.4091090000000001e-08 80.775000000000006p -1.3965579999999999e-08
+ 80.787500000000009p -1.382166e-08 80.799999999999997p -1.365958e-08 80.8125p -1.3479559999999999e-08 80.825000000000003p -1.3281910000000001e-08 80.837499999999991p -1.30669e-08 80.849999999999994p -1.283488e-08 80.862499999999997p -1.2586170000000001e-08 80.875p -1.232115e-08 80.887500000000003p -1.204021e-08 80.900000000000006p -1.1743740000000001e-08 80.912500000000009p -1.143219e-08 80.924999999999997p -1.1105980000000001e-08 80.9375p -1.07656e-08 80.950000000000003p -1.041152e-08 80.962500000000006p -1.0044250000000001e-08 80.974999999999994p -9.6642889999999992e-09 80.987499999999997p -9.272186e-09 81p -8.8684830000000005e-09
+ 81.012499999999989p -8.4537429999999999e-09 81.025000000000006p -8.0285419999999999e-09 81.037500000000009p -7.5934679999999992e-09 81.049999999999997p -7.1491209999999997e-09 81.0625p -6.6961129999999997e-09 81.075000000000003p -6.2350659999999996e-09 81.087500000000006p -5.7666100000000002e-09 81.099999999999994p -5.2913859999999998e-09 81.112499999999997p -4.8100410000000004e-09 81.125p -4.323228e-09 81.137499999999989p -3.8316079999999999e-09 81.150000000000006p -3.3358449999999999e-09 81.162500000000009p -2.8366089999999999e-09 81.174999999999997p -2.3345729999999999e-09 81.1875p -1.8304100000000001e-09 81.200000000000003p -1.324796e-09 81.212500000000006p -8.1840820000000002e-10 81.224999999999994p -3.1192220000000002e-10
+ 81.237499999999997p 1.9398739999999999e-10 81.25p 6.9864820000000001e-10 81.262499999999989p 1.201391e-09 81.274999999999991p 1.70155e-09 81.287500000000009p 2.1984660000000001e-09 81.300000000000011p 2.6914839999999999e-09 81.3125p 3.1799559999999998e-09 81.325000000000003p 3.6632410000000002e-09 81.337500000000006p 4.1407069999999997e-09 81.349999999999994p 4.611732e-09 81.362499999999997p 5.0757020000000004e-09 81.375p 5.5320150000000002e-09 81.387499999999989p 5.9800800000000003e-09 81.399999999999991p 6.4193199999999997e-09 81.412500000000009p 6.8491679999999996e-09 81.425000000000011p 7.2690729999999997e-09 81.4375p 7.6784979999999993e-09 81.450000000000003p 8.0769199999999994e-09
+ 81.462500000000006p 8.4638349999999992e-09 81.474999999999994p 8.8387519999999993e-09 81.487499999999997p 9.2011989999999997e-09 81.5p 9.5507200000000007e-09 81.512499999999989p 9.8868799999999993e-09 81.524999999999991p 1.0209260000000001e-08 81.537500000000009p 1.051746e-08 81.550000000000011p 1.081111e-08 81.5625p 1.1089840000000001e-08 81.575000000000003p 1.135331e-08 81.587500000000006p 1.160122e-08 81.599999999999994p 1.1833259999999999e-08 81.612499999999997p 1.204917e-08 81.625p 1.224868e-08 81.637500000000003p 1.243158e-08 81.649999999999991p 1.2597650000000001e-08 81.662499999999994p 1.274671e-08 81.675000000000011p 1.2878600000000001e-08
+ 81.6875p 1.299319e-08 81.700000000000003p 1.3090370000000001e-08 81.712500000000006p 1.3170029999999999e-08 81.724999999999994p 1.3232109999999999e-08 81.737499999999997p 1.327658e-08 81.75p 1.330341e-08 81.762500000000003p 1.331261e-08 81.774999999999991p 1.33042e-08 81.787499999999994p 1.327823e-08 81.800000000000011p 1.323479e-08 81.8125p 1.317396e-08 81.825000000000003p 1.309587e-08 81.837500000000006p 1.3000649999999999e-08 81.849999999999994p 1.288848e-08 81.862499999999997p 1.275955e-08 81.875p 1.2614050000000001e-08 81.887500000000003p 1.245223e-08 81.899999999999991p 1.227434e-08
+ 81.912499999999994p 1.208064e-08 81.924999999999997p 1.1871440000000001e-08 81.9375p 1.164704e-08 81.950000000000003p 1.140778e-08 81.962500000000006p 1.115402e-08 81.975000000000009p 1.0886109999999999e-08 81.987499999999997p 1.060445e-08 82p 1.0309449999999999e-08 82.012500000000003p 1.000152e-08 82.024999999999991p 9.6811159999999997e-09 82.037499999999994p 9.3486790000000001e-09 82.049999999999997p 9.0046830000000001e-09 82.0625p 8.6496099999999995e-09 82.075000000000003p 8.2839569999999995e-09 82.087500000000006p 7.9082359999999995e-09 82.100000000000009p 7.522967e-09 82.112499999999997p 7.1286859999999997e-09 82.125p 6.7259350000000001e-09
+ 82.137500000000003p 6.3152690000000004e-09 82.149999999999991p 5.8972519999999999e-09 82.162499999999994p 5.4724550000000004e-09 82.174999999999997p 5.0414579999999999e-09 82.1875p 4.6048480000000001e-09 82.200000000000003p 4.1632170000000003e-09 82.212500000000006p 3.7171619999999998e-09 82.225000000000009p 3.2672860000000002e-09 82.237499999999997p 2.8141939999999998e-09 82.25p 2.3584939999999998e-09 82.262500000000003p 1.9007980000000001e-09 82.274999999999991p 1.441716e-09 82.287499999999994p 9.8186150000000002e-10 82.299999999999997p 5.218451e-10 82.3125p 6.227706e-11 82.325000000000003p -3.9623439999999999e-10 82.337500000000006p -8.5308409999999998e-10 82.350000000000009p -1.307671e-09
+ 82.362499999999997p -1.759397e-09 82.375p -2.207671e-09 82.387500000000003p -2.6519070000000001e-09 82.399999999999991p -3.0915280000000002e-09 82.412499999999994p -3.5259600000000001e-09 82.424999999999997p -3.9546419999999997e-09 82.4375p -4.3770190000000004e-09 82.450000000000003p -4.7925469999999998e-09 82.462500000000006p -5.2006939999999998e-09 82.475000000000009p -5.600935e-09 82.487499999999997p -5.9927610000000002e-09 82.5p -6.3756739999999998e-09 82.512500000000003p -6.7491869999999998e-09 82.524999999999991p -7.1128309999999996e-09 82.537499999999994p -7.4661469999999994e-09 82.549999999999997p -7.8086940000000007e-09 82.5625p -8.1400439999999996e-09 82.575000000000003p -8.4597879999999996e-09
+ 82.587500000000006p -8.7675310000000005e-09 82.600000000000009p -9.0628949999999994e-09 82.612499999999997p -9.3455209999999993e-09 82.625p -9.6150670000000003e-09 82.637500000000003p -9.8712079999999996e-09 82.649999999999991p -1.011364e-08 82.662499999999994p -1.034208e-08 82.674999999999997p -1.0556250000000001e-08 82.6875p -1.075592e-08 82.700000000000003p -1.094084e-08 82.712500000000006p -1.111083e-08 82.725000000000009p -1.126569e-08 82.737499999999997p -1.1405250000000001e-08 82.75p -1.1529360000000001e-08 82.762500000000003p -1.1637920000000001e-08 82.775000000000006p -1.17308e-08 82.787499999999994p -1.180794e-08 82.799999999999997p -1.186926e-08
+ 82.8125p -1.1914729999999999e-08 82.825000000000003p -1.194434e-08 82.837500000000006p -1.1958069999999999e-08 82.850000000000009p -1.195597e-08 82.862499999999997p -1.193806e-08 82.875p -1.190443e-08 82.887500000000003p -1.1855139999999999e-08 82.900000000000006p -1.1790319999999999e-08 82.912499999999994p -1.1710089999999999e-08 82.924999999999997p -1.16146e-08 82.9375p -1.150401e-08 82.949999999999989p -1.137851e-08 82.962500000000006p -1.1238320000000001e-08 82.975000000000009p -1.108364e-08 82.987499999999997p -1.091474e-08 83p -1.073187e-08 83.012500000000003p -1.0535309999999999e-08 83.025000000000006p -1.032537e-08
+ 83.037499999999994p -1.0102350000000001e-08 83.049999999999997p -9.8665949999999999e-09 83.0625p -9.6184450000000001e-09 83.074999999999989p -9.3582669999999992e-09 83.087500000000006p -9.0864390000000004e-09 83.100000000000009p -8.8033550000000002e-09 83.112500000000011p -8.5094220000000008e-09 83.125p -8.2050609999999993e-09 83.137500000000003p -7.8907059999999999e-09 83.150000000000006p -7.5668020000000006e-09 83.162499999999994p -7.2338079999999996e-09 83.174999999999997p -6.89219e-09 83.1875p -6.5424290000000002e-09 83.199999999999989p -6.1850109999999998e-09 83.212499999999991p -5.8204349999999999e-09 83.225000000000009p -5.4492049999999997e-09 83.237500000000011p -5.0718350000000002e-09 83.25p -4.6888439999999997e-09
+ 83.262500000000003p -4.3007579999999997e-09 83.275000000000006p -3.9081090000000002e-09 83.287499999999994p -3.511432e-09 83.299999999999997p -3.111267e-09 83.3125p -2.7081580000000001e-09 83.324999999999989p -2.3026500000000001e-09 83.337499999999991p -1.8952909999999999e-09 83.350000000000009p -1.486628e-09 83.362500000000011p -1.077211e-09 83.375p -6.6758779999999999e-10 83.387500000000003p -2.583051e-10 83.400000000000006p 1.500918e-10 83.412499999999994p 5.5706049999999999e-10 83.424999999999997p 9.6206190000000007e-10 83.4375p 1.364561e-09 83.449999999999989p 1.7640279999999999e-09 83.462499999999991p 2.1599380000000001e-09 83.474999999999994p 2.551772e-09
+ 83.487500000000011p 2.9390200000000001e-09 83.5p 3.3211759999999999e-09 83.512500000000003p 3.6977440000000001e-09 83.525000000000006p 4.0682389999999997e-09 83.537499999999994p 4.4321819999999997e-09 83.549999999999997p 4.7891050000000003e-09 83.5625p 5.138552e-09 83.575000000000003p 5.4800769999999998e-09 83.587499999999991p 5.8132460000000003e-09 83.599999999999994p 6.1376379999999997e-09 83.612500000000011p 6.4528439999999998e-09 83.625p 6.7584700000000001e-09 83.637500000000003p 7.0541340000000004e-09 83.650000000000006p 7.3394690000000002e-09 83.662499999999994p 7.6141239999999994e-09 83.674999999999997p 7.8777619999999997e-09 83.6875p 8.1300610000000003e-09 83.700000000000003p 8.3707180000000004e-09
+ 83.712499999999991p 8.5994440000000007e-09 83.724999999999994p 8.8159670000000004e-09 83.737499999999997p 9.0200319999999993e-09 83.75p 9.2114040000000003e-09 83.762500000000003p 9.3898610000000004e-09 83.775000000000006p 9.5552040000000007e-09 83.787499999999994p 9.7072480000000001e-09 83.799999999999997p 9.8458289999999994e-09 83.8125p 9.9707999999999995e-09 83.825000000000003p 1.008203e-08 83.837499999999991p 1.017942e-08 83.849999999999994p 1.0262870000000001e-08 83.862499999999997p 1.0332320000000001e-08 83.875p 1.03877e-08 83.887500000000003p 1.042899e-08 83.900000000000006p 1.0456180000000001e-08 83.912500000000009p 1.0469259999999999e-08 83.924999999999997p 1.046826e-08
+ 83.9375p 1.045323e-08 83.950000000000003p 1.042423e-08 83.962499999999991p 1.038133e-08 83.974999999999994p 1.0324639999999999e-08 83.987499999999997p 1.025427e-08 84p 1.017036e-08 84.012500000000003p 1.007305e-08 84.025000000000006p 9.9625260000000007e-09 84.037500000000009p 9.8389660000000004e-09 84.049999999999997p 9.7025780000000004e-09 84.0625p 9.5535819999999998e-09 84.075000000000003p 9.392216e-09 84.087499999999991p 9.2187330000000006e-09 84.099999999999994p 9.0334019999999997e-09 84.112499999999997p 8.8365080000000003e-09 84.125p 8.6283479999999997e-09 84.137500000000003p 8.4092380000000008e-09 84.150000000000006p 8.1795029999999999e-09
+ 84.162500000000009p 7.9394839999999996e-09 84.174999999999997p 7.6895340000000001e-09 84.1875p 7.4300199999999999e-09 84.200000000000003p 7.161318e-09 84.212499999999991p 6.8838179999999997e-09 84.224999999999994p 6.5979180000000001e-09 84.237499999999997p 6.3040300000000002e-09 84.25p 6.0025709999999998e-09 84.262500000000003p 5.6939719999999997e-09 84.275000000000006p 5.3786670000000003e-09 84.287500000000009p 5.0571019999999996e-09 84.299999999999997p 4.7297289999999996e-09 84.3125p 4.3970059999999999e-09 84.325000000000003p 4.0593970000000001e-09 84.337499999999991p 3.7173709999999999e-09 84.349999999999994p 3.3714029999999999e-09 84.362499999999997p 3.0219700000000001e-09 84.375p 2.6695550000000001e-09
+ 84.387500000000003p 2.3146410000000001e-09 84.400000000000006p 1.9577139999999999e-09 84.412500000000009p 1.5992619999999999e-09 84.424999999999997p 1.239772e-09 84.4375p 8.7973379999999999e-10 84.450000000000003p 5.1963379999999996e-10 84.462499999999991p 1.599585e-10 84.474999999999994p -1.988077e-10 84.487499999999997p -5.5618320000000002e-10 84.5p -9.116894e-10 84.512500000000003p -1.264852e-09 84.525000000000006p -1.6152e-09 84.537500000000009p -1.9622690000000002e-09 84.549999999999997p -2.3055990000000001e-09 84.5625p -2.644737e-09 84.575000000000003p -2.9792379999999999e-09 84.587500000000006p -3.3086630000000002e-09 84.599999999999994p -3.6325799999999999e-09
+ 84.612499999999997p -3.9505679999999997e-09 84.625p -4.2622139999999999e-09 84.637500000000003p -4.5671160000000002e-09 84.650000000000006p -4.8648790000000004e-09 84.662500000000009p -5.1551219999999997e-09 84.674999999999997p -5.4374739999999999e-09 84.6875p -5.7115750000000003e-09 84.700000000000003p -5.9770789999999999e-09 84.712500000000006p -6.2336499999999999e-09 84.724999999999994p -6.4809660000000002e-09 84.737499999999997p -6.718721e-09 84.75p -6.9466179999999999e-09 84.762499999999989p -7.1643769999999999e-09 84.775000000000006p -7.3717320000000004e-09 84.787500000000009p -7.5684320000000007e-09 84.799999999999997p -7.7542410000000002e-09 84.8125p -7.9289379999999995e-09 84.825000000000003p -8.0923170000000007e-09
+ 84.837500000000006p -8.2441889999999999e-09 84.849999999999994p -8.3843809999999999e-09 84.862499999999997p -8.5127349999999998e-09 84.875p -8.6291099999999994e-09 84.887499999999989p -8.7333829999999992e-09 84.900000000000006p -8.8254459999999995e-09 84.912500000000009p -8.9052079999999995e-09 84.924999999999997p -8.9725960000000006e-09 84.9375p -9.0275510000000006e-09 84.950000000000003p -9.0700350000000007e-09 84.962500000000006p -9.1000239999999998e-09 84.974999999999994p -9.1175129999999996e-09 84.987499999999997p -9.1225109999999997e-09 85p -9.1150460000000007e-09 85.012499999999989p -9.0951640000000007e-09 85.024999999999991p -9.0629240000000004e-09 85.037500000000009p -9.0184050000000001e-09 85.050000000000011p -8.9617010000000001e-09
+ 85.0625p -8.8929210000000003e-09 85.075000000000003p -8.8121930000000001e-09 85.087500000000006p -8.7196579999999998e-09 85.099999999999994p -8.6154750000000006e-09 85.112499999999997p -8.4998150000000006e-09 85.125p -8.3728679999999992e-09 85.137499999999989p -8.2348359999999996e-09 85.149999999999991p -8.0859370000000002e-09 85.162500000000009p -7.9264020000000001e-09 85.175000000000011p -7.7564759999999996e-09 85.1875p -7.5764190000000007e-09 85.200000000000003p -7.3865020000000003e-09 85.212500000000006p -7.1870089999999997e-09 85.224999999999994p -6.9782380000000003e-09 85.237499999999997p -6.7604970000000003e-09 85.25p -6.5341050000000004e-09 85.262499999999989p -6.2993939999999997e-09 85.274999999999991p -6.0567050000000003e-09
+ 85.287500000000009p -5.8063879999999996e-09 85.300000000000011p -5.5488049999999996e-09 85.3125p -5.2843249999999997e-09 85.325000000000003p -5.0133259999999997e-09 85.337500000000006p -4.7361929999999997e-09 85.349999999999994p -4.4533199999999997e-09 85.362499999999997p -4.1651069999999998e-09 85.375p -3.8719600000000003e-09 85.387500000000003p -3.5742900000000001e-09 85.399999999999991p -3.2725160000000002e-09 85.412499999999994p -2.9670570000000002e-09 85.425000000000011p -2.6583400000000001e-09 85.4375p -2.346794e-09 85.450000000000003p -2.0328490000000002e-09 85.462500000000006p -1.7169400000000001e-09 85.474999999999994p -1.3995029999999999e-09 85.487499999999997p -1.0809720000000001e-09 85.5p -7.6178610000000001e-10
+ 85.512500000000003p -4.4238049999999998e-10 85.524999999999991p -1.231914e-10 85.537499999999994p 1.9534670000000001e-10 85.550000000000011p 5.1280139999999996e-10 85.5625p 8.2874270000000001e-10 85.575000000000003p 1.142744e-09 85.587500000000006p 1.454381e-09 85.599999999999994p 1.7632370000000001e-09 85.612499999999997p 2.0688949999999998e-09 85.625p 2.3709480000000002e-09 85.637500000000003p 2.668993e-09 85.649999999999991p 2.9626329999999999e-09 85.662499999999994p 3.2514779999999998e-09 85.674999999999997p 3.5351460000000001e-09 85.6875p 3.8132639999999997e-09 85.700000000000003p 4.0854639999999997e-09 85.712500000000006p 4.3513910000000001e-09 85.725000000000009p 4.6106970000000001e-09
+ 85.737499999999997p 4.8630440000000002e-09 85.75p 5.1081040000000002e-09 85.762500000000003p 5.3455610000000002e-09 85.774999999999991p 5.5751099999999998e-09 85.787499999999994p 5.7964549999999997e-09 85.799999999999997p 6.0093140000000002e-09 85.8125p 6.213418e-09 85.825000000000003p 6.408508e-09 85.837500000000006p 6.5943400000000002e-09 85.850000000000009p 6.7706820000000003e-09 85.862499999999997p 6.9373149999999998e-09 85.875p 7.0940350000000001e-09 85.887500000000003p 7.2406509999999997e-09 85.899999999999991p 7.376988e-09 85.912499999999994p 7.5028819999999999e-09 85.924999999999997p 7.6181860000000005e-09 85.9375p 7.7227679999999996e-09 85.950000000000003p 7.8165090000000004e-09
+ 85.962500000000006p 7.8993060000000001e-09 85.975000000000009p 7.9710720000000005e-09 85.987499999999997p 8.031734e-09 86p 8.0812339999999998e-09 86.012500000000003p 8.1195310000000003e-09 86.024999999999991p 8.1465970000000007e-09 86.037499999999994p 8.1624210000000008e-09 86.049999999999997p 8.1670059999999999e-09 86.0625p 8.1603719999999994e-09 86.075000000000003p 8.1425530000000003e-09 86.087500000000006p 8.1135990000000003e-09 86.100000000000009p 8.0735719999999993e-09 86.112499999999997p 8.0225540000000002e-09 86.125p 7.9606369999999994e-09 86.137500000000003p 7.8879310000000004e-09 86.149999999999991p 7.8045570000000005e-09 86.162499999999994p 7.7106539999999993e-09 86.174999999999997p 7.6063719999999999e-09
+ 86.1875p 7.4918770000000007e-09 86.200000000000003p 7.3673460000000002e-09 86.212500000000006p 7.2329720000000003e-09 86.225000000000009p 7.0889579999999997e-09 86.237499999999997p 6.9355219999999999e-09 86.25p 6.7728939999999998e-09 86.262500000000003p 6.6013139999999999e-09 86.274999999999991p 6.4210349999999996e-09 86.287499999999994p 6.2323230000000004e-09 86.299999999999997p 6.0354520000000001e-09 86.3125p 5.8307070000000003e-09 86.325000000000003p 5.6183840000000002e-09 86.337500000000006p 5.3987889999999998e-09 86.350000000000009p 5.1722359999999999e-09 86.362499999999997p 4.9390469999999997e-09 86.375p 4.699554e-09 86.387500000000003p 4.4540980000000003e-09 86.399999999999991p 4.2030230000000004e-09
+ 86.412499999999994p 3.9466830000000004e-09 86.424999999999997p 3.6854390000000001e-09 86.4375p 3.4196560000000001e-09 86.450000000000003p 3.1497049999999999e-09 86.462500000000006p 2.8759619999999999e-09 86.475000000000009p 2.598806e-09 86.487499999999997p 2.3186230000000001e-09 86.5p 2.0357980000000001e-09 86.512500000000003p 1.7507230000000001e-09 86.525000000000006p 1.4637890000000001e-09 86.537499999999994p 1.1753889999999999e-09 86.549999999999997p 8.8591969999999998e-10 86.5625p 5.9577569999999996e-10 86.574999999999989p 3.0535270000000002e-10 86.587500000000006p 1.504587e-11 86.600000000000009p -2.7475070000000002e-10 86.612499999999997p -5.6364450000000002e-10 86.625p -8.5124489999999996e-10
+ 86.637500000000003p -1.1371640000000001e-09 86.650000000000006p -1.421017e-09 86.662499999999994p -1.7024229999999999e-09 86.674999999999997p -1.981005e-09 86.6875p -2.2563899999999999e-09 86.699999999999989p -2.5282109999999998e-09 86.712500000000006p -2.7961060000000001e-09 86.725000000000009p -3.0597189999999999e-09 86.737499999999997p -3.3187019999999999e-09 86.75p -3.5727129999999999e-09 86.762500000000003p -3.8214160000000002e-09 86.775000000000006p -4.0644860000000003e-09 86.787499999999994p -4.3016019999999999e-09 86.799999999999997p -4.5324569999999997e-09 86.8125p -4.7567479999999999e-09 86.824999999999989p -4.9741860000000001e-09 86.837500000000006p -5.1844880000000003e-09 86.850000000000009p -5.3873839999999997e-09
+ 86.862500000000011p -5.5826130000000001e-09 86.875p -5.7699249999999998e-09 86.887500000000003p -5.949083e-09 86.900000000000006p -6.1198590000000001e-09 86.912499999999994p -6.2820389999999996e-09 86.924999999999997p -6.4354180000000003e-09 86.9375p -6.5798069999999997e-09 86.949999999999989p -6.7150270000000004e-09 86.962499999999991p -6.8409130000000002e-09 86.975000000000009p -6.9573120000000001e-09 86.987500000000011p -7.0640850000000002e-09 87p -7.1611060000000003e-09 87.012500000000003p -7.2482610000000003e-09 87.025000000000006p -7.3254520000000004e-09 87.037499999999994p -7.392594e-09 87.049999999999997p -7.4496129999999996e-09 87.0625p -7.4964519999999999e-09 87.074999999999989p -7.5330680000000005e-09
+ 87.087499999999991p -7.5594279999999992e-09 87.100000000000009p -7.5755179999999997e-09 87.112500000000011p -7.5813340000000008e-09 87.125p -7.5768879999999997e-09 87.137500000000003p -7.5622040000000007e-09 87.150000000000006p -7.537322e-09 87.162499999999994p -7.5022930000000007e-09 87.174999999999997p -7.4571839999999993e-09 87.1875p -7.4020740000000003e-09 87.199999999999989p -7.3370560000000003e-09 87.212499999999991p -7.2622350000000004e-09 87.224999999999994p -7.1777299999999998e-09 87.237500000000011p -7.0836740000000002e-09 87.25p -6.9802100000000002e-09 87.262500000000003p -6.8674939999999999e-09 87.275000000000006p -6.7456960000000004e-09 87.287499999999994p -6.6149950000000001e-09 87.299999999999997p -6.4755849999999996e-09
+ 87.3125p -6.3276679999999997e-09 87.325000000000003p -6.1714590000000002e-09 87.337499999999991p -6.0071830000000001e-09 87.349999999999994p -5.835076e-09 87.362500000000011p -5.6553829999999997e-09 87.375p -5.4683600000000003e-09 87.387500000000003p -5.2742719999999996e-09 87.400000000000006p -5.0733920000000002e-09 87.412499999999994p -4.8660020000000002e-09 87.424999999999997p -4.6523929999999996e-09 87.4375p -4.4328630000000001e-09 87.450000000000003p -4.2077170000000003e-09 87.462499999999991p -3.977268e-09 87.474999999999994p -3.7418360000000004e-09 87.487499999999997p -3.501744e-09 87.5p -3.2573229999999998e-09 87.512500000000003p -3.0089100000000001e-09 87.525000000000006p -2.7568450000000001e-09
+ 87.537499999999994p -2.5014719999999999e-09 87.549999999999997p -2.2431410000000001e-09 87.5625p -1.9822009999999999e-09 87.575000000000003p -1.7190089999999999e-09 87.587499999999991p -1.453921e-09 87.599999999999994p -1.187296e-09 87.612499999999997p -9.1949349999999997e-10 87.625p -6.508744e-10 87.637500000000003p -3.818001e-10 87.650000000000006p -1.126319e-10 87.662500000000009p 1.5626989999999999e-10 87.674999999999997p 4.2454550000000001e-10 87.6875p 6.918372e-10 87.700000000000003p 9.5778899999999995e-10 87.712499999999991p 1.222047e-09 87.724999999999994p 1.484262e-09 87.737499999999997p 1.7440860000000001e-09 87.75p 2.0011759999999999e-09
+ 87.762500000000003p 2.2551930000000001e-09 87.775000000000006p 2.5058039999999998e-09 87.787500000000009p 2.7526790000000001e-09 87.799999999999997p 2.9954959999999998e-09 87.8125p 3.233937e-09 87.825000000000003p 3.4676919999999999e-09 87.837499999999991p 3.6964559999999998e-09 87.849999999999994p 3.9199349999999997e-09 87.862499999999997p 4.137838e-09 87.875p 4.3498860000000001e-09 87.887500000000003p 4.5558059999999998e-09 87.900000000000006p 4.755334e-09 87.912500000000009p 4.9482160000000001e-09 87.924999999999997p 5.1342069999999997e-09 87.9375p 5.3130709999999996e-09 87.950000000000003p 5.4845830000000002e-09 87.962499999999991p 5.6485279999999999e-09 87.974999999999994p 5.8047e-09
+ 87.987499999999997p 5.9529080000000001e-09 88p 6.0929660000000003e-09 88.012500000000003p 6.2247049999999998e-09 88.025000000000006p 6.3479640000000001e-09 88.037500000000009p 6.4625940000000002e-09 88.049999999999997p 6.5684590000000004e-09 88.0625p 6.6654339999999998e-09 88.075000000000003p 6.7534080000000003e-09 88.087499999999991p 6.8322779999999997e-09 88.099999999999994p 6.9019589999999997e-09 88.112499999999997p 6.9623730000000004e-09 88.125p 7.0134580000000001e-09 88.137500000000003p 7.0551649999999998e-09 88.150000000000006p 7.087454e-09 88.162500000000009p 7.1103009999999996e-09 88.174999999999997p 7.1236930000000004e-09 88.1875p 7.127631e-09 88.200000000000003p 7.1221280000000003e-09
+ 88.212499999999991p 7.1072070000000002e-09 88.224999999999994p 7.0829090000000004e-09 88.237499999999997p 7.0492810000000002e-09 88.25p 7.0063879999999996e-09 88.262500000000003p 6.9543039999999999e-09 88.275000000000006p 6.8931159999999998e-09 88.287500000000009p 6.8229220000000001e-09 88.299999999999997p 6.7438339999999999e-09 88.3125p 6.6559729999999998e-09 88.325000000000003p 6.5594729999999996e-09 88.337500000000006p 6.4544800000000002e-09 88.349999999999994p 6.3411480000000004e-09 88.362499999999997p 6.2196449999999998e-09 88.375p 6.0901480000000003e-09 88.387500000000003p 5.9528440000000003e-09 88.400000000000006p 5.8079310000000001e-09 88.412500000000009p 5.6556160000000003e-09 88.424999999999997p 5.4961159999999998e-09
+ 88.4375p 5.3296549999999996e-09 88.450000000000003p 5.1564700000000001e-09 88.462500000000006p 4.9768020000000002e-09 88.474999999999994p 4.7909030000000002e-09 88.487499999999997p 4.5990319999999998e-09 88.5p 4.4014550000000003e-09 88.512499999999989p 4.1984439999999999e-09 88.525000000000006p 3.9902800000000004e-09 88.537500000000009p 3.7772489999999996e-09 88.549999999999997p 3.5596430000000001e-09 88.5625p 3.3377599999999999e-09 88.575000000000003p 3.1119009999999999e-09 88.587500000000006p 2.8823739999999999e-09 88.599999999999994p 2.6494900000000001e-09 88.612499999999997p 2.4135640000000001e-09 88.625p 2.1749160000000001e-09 88.637499999999989p 1.9338650000000001e-09 88.650000000000006p 1.6907360000000001e-09
+ 88.662500000000009p 1.4458550000000001e-09 88.674999999999997p 1.1995500000000001e-09 88.6875p 9.521485e-10 88.700000000000003p 7.0398080000000003e-10 88.712500000000006p 4.553765e-10 88.724999999999994p 2.0666510000000001e-10 88.737499999999997p -4.182437e-11 88.75p -2.8976389999999999e-10 88.762499999999989p -5.3682699999999997e-10 88.774999999999991p -7.82689e-10 88.787500000000009p -1.0270279999999999e-09 88.800000000000011p -1.2695229999999999e-09 88.8125p -1.5098590000000001e-09 88.825000000000003p -1.747723e-09 88.837500000000006p -1.9828060000000001e-09 88.849999999999994p -2.214803e-09 88.862499999999997p -2.443414e-09 88.875p -2.6683460000000002e-09
+ 88.887499999999989p -2.8893089999999999e-09 88.899999999999991p -3.10602e-09 88.912500000000009p -3.3182020000000002e-09 88.925000000000011p -3.5255850000000001e-09 88.9375p -3.7279060000000002e-09 88.950000000000003p -3.9249099999999998e-09 88.962500000000006p -4.116347e-09 88.974999999999994p -4.3019779999999998e-09 88.987499999999997p -4.4815700000000003e-09 89p -4.6548999999999997e-09 89.012499999999989p -4.8217540000000003e-09 89.024999999999991p -4.9819259999999999e-09 89.037500000000009p -5.1352189999999997e-09 89.050000000000011p -5.281448e-09 89.0625p -5.4204340000000001e-09 89.075000000000003p -5.5520120000000004e-09 89.087500000000006p -5.676024e-09 89.099999999999994p -5.7923250000000001e-09
+ 89.112499999999997p -5.9007790000000001e-09 89.125p -6.0012599999999996e-09 89.137500000000003p -6.0936549999999999e-09 89.149999999999991p -6.1778610000000003e-09 89.162499999999994p -6.2537850000000002e-09 89.175000000000011p -6.3213469999999998e-09 89.1875p -6.3804780000000001e-09 89.200000000000003p -6.4311180000000002e-09 89.212500000000006p -6.4732219999999999e-09 89.224999999999994p -6.5067540000000001e-09 89.237499999999997p -6.5316899999999998e-09 89.25p -6.5480169999999998e-09 89.262500000000003p -6.555735e-09 89.274999999999991p -6.5548540000000004e-09 89.287499999999994p -6.5453959999999997e-09 89.300000000000011p -6.5273929999999999e-09 89.3125p -6.5008909999999998e-09 89.325000000000003p -6.4659440000000001e-09
+ 89.337500000000006p -6.422619e-09 89.349999999999994p -6.3709940000000002e-09 89.362499999999997p -6.3111569999999998e-09 89.375p -6.2432069999999999e-09 89.387500000000003p -6.1672539999999998e-09 89.399999999999991p -6.083416e-09 89.412499999999994p -5.9918249999999996e-09 89.424999999999997p -5.8926199999999999e-09 89.4375p -5.7859509999999998e-09 89.450000000000003p -5.6719770000000004e-09 89.462500000000006p -5.5508670000000002e-09 89.475000000000009p -5.4227980000000001e-09 89.487499999999997p -5.287956e-09 89.5p -5.1465370000000002e-09 89.512500000000003p -4.9987429999999998e-09 89.524999999999991p -4.8447860000000001e-09 89.537499999999994p -4.6848839999999997e-09 89.549999999999997p -4.5192630000000001e-09
+ 89.5625p -4.3481569999999999e-09 89.575000000000003p -4.1718039999999996e-09 89.587500000000006p -3.9904519999999998e-09 89.600000000000009p -3.8043509999999999e-09 89.612499999999997p -3.613761e-09 89.625p -3.4189429999999999e-09 89.637500000000003p -3.2201669999999999e-09 89.649999999999991p -3.0177040000000001e-09 89.662499999999994p -2.8118310000000001e-09 89.674999999999997p -2.6028289999999999e-09 89.6875p -2.3909809999999999e-09 89.700000000000003p -2.1765759999999999e-09 89.712500000000006p -1.959902e-09 89.725000000000009p -1.7412510000000001e-09 89.737499999999997p -1.520917e-09 89.75p -1.2991970000000001e-09 89.762500000000003p -1.0763849999999999e-09 89.774999999999991p -8.5277879999999995e-10
+ 89.787499999999994p -6.2867619999999997e-10 89.799999999999997p -4.0437420000000002e-10 89.8125p -1.801694e-10 89.825000000000003p 4.3642380000000001e-11 89.837500000000006p 2.667666e-10 89.850000000000009p 4.8891040000000004e-10 89.862499999999997p 7.0978319999999999e-10 89.875p 9.2909650000000005e-10 89.887500000000003p 1.146565e-09 89.899999999999991p 1.3619060000000001e-09 89.912499999999994p 1.5748419999999999e-09 89.924999999999997p 1.785097e-09 89.9375p 1.9924010000000002e-09 89.950000000000003p 2.1964889999999998e-09 89.962500000000006p 2.397099e-09 89.975000000000009p 2.5939749999999998e-09 89.987499999999997p 2.786869e-09 90p 2.9755359999999998e-09
+ 90.012500000000003p 3.1597379999999999e-09 90.024999999999991p 3.3392450000000001e-09 90.037499999999994p 3.5138319999999999e-09 90.049999999999997p 3.6832829999999998e-09 90.0625p 3.8473869999999998e-09 90.075000000000003p 4.0059420000000001e-09 90.087500000000006p 4.1587560000000002e-09 90.100000000000009p 4.3056410000000004e-09 90.112499999999997p 4.4464199999999996e-09 90.125p 4.5809249999999999e-09 90.137500000000003p 4.7089950000000002e-09 90.149999999999991p 4.8304789999999997e-09 90.162499999999994p 4.9452359999999997e-09 90.174999999999997p 5.053133e-09 90.1875p 5.154046e-09 90.200000000000003p 5.2478630000000002e-09 90.212500000000006p 5.3344789999999996e-09 90.225000000000009p 5.413801e-09
+ 90.237499999999997p 5.4857460000000004e-09 90.25p 5.5502379999999998e-09 90.262500000000003p 5.6072150000000001e-09 90.275000000000006p 5.6566230000000004e-09 90.287499999999994p 5.6984190000000004e-09 90.299999999999997p 5.7325689999999999e-09 90.3125p 5.7590519999999997e-09 90.324999999999989p 5.7778540000000003e-09 90.337500000000006p 5.7889730000000003e-09 90.350000000000009p 5.7924179999999999e-09 90.362499999999997p 5.7882059999999998e-09 90.375p 5.7763659999999999e-09 90.387500000000003p 5.7569369999999996e-09 90.400000000000006p 5.7299670000000001e-09 90.412499999999994p 5.6955139999999999e-09 90.424999999999997p 5.6536460000000002e-09 90.4375p 5.604441e-09 90.449999999999989p 5.5479879999999998e-09
+ 90.462500000000006p 5.4843810000000004e-09 90.475000000000009p 5.4137290000000002e-09 90.487499999999997p 5.3361449999999997e-09 90.5p 5.2517539999999998e-09 90.512500000000003p 5.160689e-09 90.525000000000006p 5.0630909999999996e-09 90.537499999999994p 4.9591089999999999e-09 90.549999999999997p 4.8489020000000003e-09 90.5625p 4.7326350000000004e-09 90.574999999999989p 4.6104809999999999e-09 90.587500000000006p 4.48262e-09 90.600000000000009p 4.349242e-09 90.612500000000011p 4.2105379999999996e-09 90.625p 4.0667120000000001e-09 90.637500000000003p 3.9179700000000003e-09 90.650000000000006p 3.7645250000000001e-09 90.662499999999994p 3.6065959999999999e-09 90.674999999999997p 3.444407e-09
+ 90.6875p 3.2781889999999999e-09 90.699999999999989p 3.1081730000000002e-09 90.712499999999991p 2.9346000000000002e-09 90.725000000000009p 2.7577120000000002e-09 90.737500000000011p 2.5777540000000002e-09 90.75p 2.3949769999999998e-09 90.762500000000003p 2.2096320000000002e-09 90.775000000000006p 2.021976e-09 90.787499999999994p 1.832265e-09 90.799999999999997p 1.64076e-09 90.8125p 1.4477209999999999e-09 90.824999999999989p 1.2534119999999999e-09 90.837499999999991p 1.058095e-09 90.850000000000009p 8.6203549999999996e-10 90.862500000000011p 6.65497e-10 90.875p 4.6874380000000005e-10 90.887500000000003p 2.7203950000000002e-10 90.900000000000006p 7.5647139999999995e-11
+ 90.912499999999994p -1.2017179999999999e-10 90.924999999999997p -3.1515709999999998e-10 90.9375p -5.090506e-10 90.950000000000003p -7.0159619999999996e-10 90.962499999999991p -8.9254040000000003e-10 90.974999999999994p -1.081633e-09 90.987500000000011p -1.268626e-09 91p -1.4532759999999999e-09 91.012500000000003p -1.635343e-09 91.025000000000006p -1.8145909999999999e-09 91.037499999999994p -1.9907880000000001e-09 91.049999999999997p -2.1637089999999999e-09 91.0625p -2.333132e-09 91.075000000000003p -2.49884e-09 91.087499999999991p -2.6606239999999999e-09 91.099999999999994p -2.8182770000000002e-09 91.112500000000011p -2.9716020000000002e-09 91.125p -3.1204069999999999e-09
+ 91.137500000000003p -3.2645069999999998e-09 91.150000000000006p -3.4037209999999998e-09 91.162499999999994p -3.5378800000000002e-09 91.174999999999997p -3.6668180000000001e-09 91.1875p -3.7903790000000004e-09 91.200000000000003p -3.9084139999999998e-09 91.212499999999991p -4.0207809999999997e-09 91.224999999999994p -4.1273479999999996e-09 91.237499999999997p -4.2279889999999997e-09 91.25p -4.3225869999999999e-09 91.262500000000003p -4.4110350000000002e-09 91.275000000000006p -4.4932319999999996e-09 91.287499999999994p -4.5690880000000002e-09 91.299999999999997p -4.6385209999999997e-09 91.3125p -4.7014570000000003e-09 91.325000000000003p -4.7578319999999997e-09 91.337499999999991p -4.8075910000000003e-09 91.349999999999994p -4.8506870000000002e-09
+ 91.362499999999997p -4.8870830000000002e-09 91.375p -4.9167510000000003e-09 91.387500000000003p -4.9396729999999999e-09 91.400000000000006p -4.9558380000000003e-09 91.412500000000009p -4.965246e-09 91.424999999999997p -4.967906e-09 91.4375p -4.9638339999999998e-09 91.450000000000003p -4.9530590000000004e-09 91.462499999999991p -4.9356139999999997e-09 91.474999999999994p -4.9115450000000001e-09 91.487499999999997p -4.8809050000000003e-09 91.5p -4.8437549999999999e-09 91.512500000000003p -4.8001670000000003e-09 91.525000000000006p -4.7502189999999998e-09 91.537500000000009p -4.6939990000000002e-09 91.549999999999997p -4.6316009999999999e-09 91.5625p -4.5631309999999996e-09 91.575000000000003p -4.4886989999999997e-09
+ 91.587499999999991p -4.4084250000000003e-09 91.599999999999994p -4.3224350000000003e-09 91.612499999999997p -4.2308639999999996e-09 91.625p -4.1338530000000003e-09 91.637500000000003p -4.0315510000000001e-09 91.650000000000006p -3.9241109999999999e-09 91.662500000000009p -3.8116969999999998e-09 91.674999999999997p -3.694474e-09 91.6875p -3.5726190000000001e-09 91.700000000000003p -3.446309e-09 91.712499999999991p -3.3157300000000001e-09 91.724999999999994p -3.1810719999999999e-09 91.737499999999997p -3.0425310000000002e-09 91.75p -2.9003059999999998e-09 91.762500000000003p -2.7546020000000002e-09 91.775000000000006p -2.605628e-09 91.787500000000009p -2.4535949999999999e-09 91.799999999999997p -2.298721e-09
+ 91.8125p -2.1412229999999999e-09 91.825000000000003p -1.981324e-09 91.837499999999991p -1.819249e-09 91.849999999999994p -1.6552249999999999e-09 91.862499999999997p -1.489481e-09 91.875p -1.3222469999999999e-09 91.887500000000003p -1.153755e-09 91.900000000000006p -9.8423990000000008e-10 91.912500000000009p -8.1393409999999996e-10 91.924999999999997p -6.4307230000000004e-10 91.9375p -4.7188889999999997e-10 91.950000000000003p -3.0061810000000001e-10 91.962499999999991p -1.2949349999999999e-10 91.974999999999994p 4.1252009999999997e-11 91.987499999999997p 2.1138679999999999e-10 92p 3.8068069999999999e-10 92.012500000000003p 5.489054e-10 92.025000000000006p 7.1583439999999995e-10
+ 92.037500000000009p 8.8124389999999995e-10 92.049999999999997p 1.044913e-09 92.0625p 1.2066219999999999e-09 92.075000000000003p 1.3661579999999999e-09 92.087500000000006p 1.523308e-09 92.099999999999994p 1.677865e-09 92.112499999999997p 1.8296250000000001e-09 92.125p 1.9783889999999999e-09 92.137500000000003p 2.123962e-09 92.150000000000006p 2.2661559999999999e-09 92.162500000000009p 2.4047840000000001e-09 92.174999999999997p 2.5396689999999999e-09 92.1875p 2.6706360000000002e-09 92.200000000000003p 2.7975169999999999e-09 92.212500000000006p 2.9201500000000001e-09 92.224999999999994p 3.0383809999999999e-09 92.237499999999997p 3.1520590000000001e-09 92.25p 3.261042e-09
+ 92.262499999999989p 3.3651940000000001e-09 92.275000000000006p 3.4643870000000001e-09 92.287500000000009p 3.5584979999999998e-09 92.299999999999997p 3.647413e-09 92.3125p 3.7310250000000002e-09 92.325000000000003p 3.8092330000000002e-09 92.337500000000006p 3.8819470000000001e-09 92.349999999999994p 3.9490809999999997e-09 92.362499999999997p 4.0105590000000004e-09 92.375p 4.0663130000000003e-09 92.387499999999989p 4.116282e-09 92.400000000000006p 4.1604129999999998e-09 92.412500000000009p 4.1986619999999999e-09 92.424999999999997p 4.2309919999999999e-09 92.4375p 4.2573759999999996e-09 92.450000000000003p 4.2777929999999997e-09 92.462500000000006p 4.292232e-09 92.474999999999994p 4.3006879999999997e-09
+ 92.487499999999997p 4.303167e-09 92.5p 4.2996809999999997e-09 92.512499999999989p 4.2902509999999996e-09 92.524999999999991p 4.274906e-09 92.537500000000009p 4.253682e-09 92.550000000000011p 4.2266239999999997e-09 92.5625p 4.1937850000000003e-09 92.575000000000003p 4.1552250000000004e-09 92.587500000000006p 4.1110120000000001e-09 92.599999999999994p 4.0612220000000004e-09 92.612499999999997p 4.0059379999999997e-09 92.625p 3.9452489999999999e-09 92.637499999999989p 3.8792529999999999e-09 92.649999999999991p 3.8080550000000002e-09 92.662500000000009p 3.7317650000000003e-09 92.675000000000011p 3.650502e-09 92.6875p 3.5643899999999999e-09 92.700000000000003p 3.4735589999999998e-09
+ 92.712500000000006p 3.3781459999999999e-09 92.724999999999994p 3.2782939999999999e-09 92.737499999999997p 3.1741510000000002e-09 92.75p 3.0658720000000001e-09 92.762499999999989p 2.9536140000000001e-09 92.774999999999991p 2.8375429999999998e-09 92.787499999999994p 2.7178270000000002e-09 92.800000000000011p 2.59464e-09 92.8125p 2.468159e-09 92.825000000000003p 2.338567e-09 92.837500000000006p 2.2060489999999999e-09 92.849999999999994p 2.0707940000000001e-09 92.862499999999997p 1.932994e-09 92.875p 1.792846e-09 92.887500000000003p 1.650548e-09 92.899999999999991p 1.5062989999999999e-09 92.912499999999994p 1.360304e-09 92.925000000000011p 1.2127659999999999e-09
+ 92.9375p 1.0638919999999999e-09 92.950000000000003p 9.1389009999999996e-10 92.962500000000006p 7.6296829999999998e-10 92.974999999999994p 6.113365e-10 92.987499999999997p 4.5920450000000001e-10 93p 3.0678250000000002e-10 93.012500000000003p 1.5428049999999999e-10 93.024999999999991p 1.9081500000000001e-12 93.037499999999994p -1.5012549999999999e-10 93.050000000000011p -3.0161260000000001e-10 93.0625p -4.5234620000000002e-10 93.075000000000003p -6.0212099999999999e-10 93.087500000000006p -7.5073350000000003e-10 93.099999999999994p -8.9798239999999997e-10 93.112499999999997p -1.043668e-09 93.125p -1.187595e-09 93.137500000000003p -1.3295690000000001e-09 93.149999999999991p -1.469399e-09
+ 93.162499999999994p -1.6068980000000001e-09 93.174999999999997p -1.7418829999999999e-09 93.1875p -1.874174e-09 93.200000000000003p -2.003595e-09 93.212500000000006p -2.1299739999999999e-09 93.225000000000009p -2.2531460000000002e-09 93.237499999999997p -2.372947e-09 93.25p -2.4892210000000001e-09 93.262500000000003p -2.6018150000000001e-09 93.274999999999991p -2.710584e-09 93.287499999999994p -2.8153850000000002e-09 93.299999999999997p -2.9160840000000002e-09 93.3125p -3.0125509999999998e-09 93.325000000000003p -3.104663e-09 93.337500000000006p -3.192302e-09 93.350000000000009p -3.275357e-09 93.362499999999997p -3.3537239999999999e-09 93.375p -3.4273060000000002e-09
+ 93.387500000000003p -3.4960110000000001e-09 93.399999999999991p -3.5597539999999999e-09 93.412499999999994p -3.618459e-09 93.424999999999997p -3.6720559999999998e-09 93.4375p -3.72048e-09 93.450000000000003p -3.7636770000000003e-09 93.462500000000006p -3.8015969999999996e-09 93.475000000000009p -3.8341990000000004e-09 93.487499999999997p -3.8614480000000003e-09 93.5p -3.8833180000000004e-09 93.512500000000003p -3.8997900000000002e-09 93.524999999999991p -3.9108509999999999e-09 93.537499999999994p -3.9164960000000002e-09 93.549999999999997p -3.9167290000000001e-09 93.5625p -3.9115589999999998e-09 93.575000000000003p -3.9010040000000001e-09 93.587500000000006p -3.8850879999999996e-09 93.600000000000009p -3.8638439999999998e-09
+ 93.612499999999997p -3.8373089999999999e-09 93.625p -3.805532e-09 93.637500000000003p -3.7685630000000002e-09 93.649999999999991p -3.7264649999999999e-09 93.662499999999994p -3.679303e-09 93.674999999999997p -3.627152e-09 93.6875p -3.5700919999999998e-09 93.700000000000003p -3.5082089999999999e-09 93.712500000000006p -3.441598e-09 93.725000000000009p -3.3703559999999999e-09 93.737499999999997p -3.2945909999999998e-09 93.75p -3.214413e-09 93.762500000000003p -3.1299390000000001e-09 93.774999999999991p -3.0412930000000001e-09 93.787499999999994p -2.9486030000000001e-09 93.799999999999997p -2.852001e-09 93.8125p -2.7516280000000001e-09 93.825000000000003p -2.6476249999999999e-09
+ 93.837500000000006p -2.5401420000000001e-09 93.850000000000009p -2.4293299999999999e-09 93.862499999999997p -2.3153459999999998e-09 93.875p -2.1983509999999999e-09 93.887500000000003p -2.0785100000000001e-09 93.899999999999991p -1.9559890000000001e-09 93.912499999999994p -1.830961e-09 93.924999999999997p -1.7036e-09 93.9375p -1.574082e-09 93.950000000000003p -1.442589e-09 93.962500000000006p -1.3093009999999999e-09 93.975000000000009p -1.174402e-09 93.987499999999997p -1.03808e-09 94p -9.0052130000000001e-10 94.012500000000003p -7.6191469999999996e-10 94.025000000000006p -6.2245039999999998e-10 94.037499999999994p -4.8231909999999997e-10 94.049999999999997p -3.4171200000000002e-10
+ 94.0625p -2.0082080000000001e-10 94.074999999999989p -5.9837019999999996e-11 94.087500000000006p 8.1047980000000004e-11 94.100000000000009p 2.2164329999999999e-10 94.112499999999997p 3.6175879999999998e-10 94.125p 5.0120539999999995e-10 94.137500000000003p 6.3979520000000002e-10 94.150000000000006p 7.7734179999999998e-10 94.162499999999994p 9.1366060000000001e-10 94.174999999999997p 1.0485689999999999e-09 94.1875p 1.181887e-09 94.199999999999989p 1.3134359999999999e-09 94.212500000000006p 1.4430409999999999e-09 94.225000000000009p 1.57053e-09 94.237499999999997p 1.6957339999999999e-09 94.25p 1.8184870000000001e-09 94.262500000000003p 1.9386269999999998e-09 94.275000000000006p 2.0559959999999999e-09
+ 94.287499999999994p 2.1704389999999999e-09 94.299999999999997p 2.2818069999999999e-09 94.3125p 2.389954e-09 94.324999999999989p 2.4947390000000001e-09 94.337500000000006p 2.5960260000000002e-09 94.350000000000009p 2.6936840000000002e-09 94.362500000000011p 2.7875859999999998e-09 94.375p 2.8776109999999999e-09 94.387500000000003p 2.9636449999999999e-09 94.400000000000006p 3.045577e-09 94.412499999999994p 3.1233040000000002e-09 94.424999999999997p 3.1967269999999999e-09 94.4375p 3.2657539999999998e-09 94.449999999999989p 3.3302980000000002e-09 94.462499999999991p 3.39028e-09 94.475000000000009p 3.4456260000000002e-09 94.487500000000011p 3.4962680000000002e-09 94.5p 3.5421460000000002e-09
+ 94.512500000000003p 3.583206e-09 94.525000000000006p 3.6193979999999999e-09 94.537499999999994p 3.6506830000000002e-09 94.549999999999997p 3.677026e-09 94.5625p 3.6983980000000002e-09 94.574999999999989p 3.7147799999999999e-09 94.587499999999991p 3.7261550000000004e-09 94.600000000000009p 3.7325170000000001e-09 94.612500000000011p 3.7338649999999997e-09 94.625p 3.7302050000000001e-09 94.637500000000003p 3.7215489999999999e-09 94.650000000000006p 3.7079160000000001e-09 94.662499999999994p 3.6893329999999998e-09 94.674999999999997p 3.6658309999999998e-09 94.6875p 3.6374500000000001e-09 94.700000000000003p 3.6042359999999999e-09 94.712499999999991p 3.5662399999999999e-09 94.724999999999994p 3.5235199999999998e-09
+ 94.737500000000011p 3.47614e-09 94.75p 3.424172e-09 94.762500000000003p 3.3676920000000002e-09 94.775000000000006p 3.3067819999999998e-09 94.787499999999994p 3.241531e-09 94.799999999999997p 3.1720320000000001e-09 94.8125p 3.0983850000000002e-09 94.825000000000003p 3.0206950000000002e-09 94.837499999999991p 2.9390710000000002e-09 94.849999999999994p 2.8536289999999999e-09 94.862500000000011p 2.764488e-09 94.875p 2.6717739999999998e-09 94.887500000000003p 2.5756159999999998e-09 94.900000000000006p 2.4761469999999998e-09 94.912499999999994p 2.3735050000000001e-09 94.924999999999997p 2.2678309999999999e-09 94.9375p 2.1592719999999999e-09 94.950000000000003p 2.0479770000000001e-09
+ 94.962499999999991p 1.934097e-09 94.974999999999994p 1.81779e-09 94.987499999999997p 1.6992130000000001e-09 95p 1.5785279999999999e-09 95.012500000000003p 5.7123050000000003e-07 95.025000000000006p 1.1086179999999999e-06 95.037499999999994p 1.610704e-06 95.049999999999997p 2.07641e-06 95.0625p 2.5055099999999998e-06 95.075000000000003p 2.898251e-06 95.087499999999991p 3.2552160000000002e-06 95.099999999999994p 3.5772700000000001e-06 95.112499999999997p 3.8655240000000003e-06 95.125p 4.1213060000000004e-06 95.137500000000003p 4.3461410000000003e-06 95.150000000000006p 4.5417260000000004e-06 95.162500000000009p 4.7099030000000003e-06 95.174999999999997p 4.8526379999999997e-06
+ 95.1875p 4.9719970000000001e-06 95.200000000000003p 5.0701220000000001e-06 95.212499999999991p 5.1492069999999997e-06 95.224999999999994p 5.211479e-06 95.237499999999997p 5.2591750000000003e-06 95.25p 5.2945199999999996e-06 95.262500000000003p 5.3197150000000003e-06 95.275000000000006p 5.3369090000000001e-06 95.287500000000009p 5.3481910000000003e-06 95.299999999999997p 5.3555739999999997e-06 95.3125p 5.3609779999999998e-06 95.325000000000003p 5.3662200000000001e-06 95.337499999999991p 5.3730040000000002e-06 95.349999999999994p 5.3829139999999997e-06 95.362499999999997p 5.3974040000000003e-06 95.375p 5.4177910000000004e-06 95.387500000000003p 5.4452559999999998e-06 95.400000000000006p 5.4808379999999999e-06
+ 95.412500000000009p 5.5254310000000003e-06 95.424999999999997p 5.5797890000000003e-06 95.4375p 5.6445220000000001e-06 95.450000000000003p 5.7201020000000001e-06 95.462499999999991p 5.8068640000000001e-06 95.474999999999994p 5.9050129999999999e-06 95.487499999999997p 6.0146300000000004e-06 95.5p 6.1356740000000001e-06 95.512500000000003p 6.267993e-06 95.525000000000006p 6.411332e-06 95.537500000000009p 6.5653359999999998e-06 95.549999999999997p 6.7295679999999999e-06 95.5625p 6.9035059999999998e-06 95.575000000000003p 7.0865639999999999e-06 95.587499999999991p 7.2780919999999996e-06 95.599999999999994p 7.4773920000000004e-06 95.612499999999997p 7.6837230000000002e-06 95.625p 7.8963120000000004e-06
+ 95.637500000000003p 8.1143639999999996e-06 95.650000000000006p 8.3370669999999999e-06 95.662500000000009p 8.5636069999999996e-06 95.674999999999997p 8.7931689999999993e-06 95.6875p 9.0249489999999996e-06 95.700000000000003p 9.2581619999999999e-06 95.712499999999991p 9.4920429999999992e-06 95.724999999999994p 9.7258620000000006e-06 95.737499999999997p 9.9589200000000002e-06 95.75p 1.0190559999999999e-05 95.762500000000003p 1.0420179999999999e-05 95.775000000000006p 1.06472e-05 95.787500000000009p 1.087113e-05 95.799999999999997p 1.10915e-05 95.8125p 1.130792e-05 95.825000000000003p 1.152005e-05 95.837500000000006p 1.172761e-05 95.849999999999994p 1.193038e-05
+ 95.862499999999997p 1.21282e-05 95.875p 1.2320970000000001e-05 95.887500000000003p 1.250864e-05 95.900000000000006p 1.2691240000000001e-05 95.912500000000009p 1.2868819999999999e-05 95.924999999999997p 1.30415e-05 95.9375p 1.3209470000000001e-05 95.950000000000003p 1.3372930000000001e-05 95.962500000000006p 1.3532150000000001e-05 95.974999999999994p 1.3687429999999999e-05 95.987499999999997p 1.3839120000000001e-05 96p 1.3987590000000001e-05 96.012499999999989p 1.356346e-05 96.025000000000006p 1.3169220000000001e-05 96.037500000000009p 1.280834e-05 96.049999999999997p 1.248239e-05 96.0625p 1.219208e-05 96.075000000000003p 1.193766e-05
+ 96.087500000000006p 1.1719049999999999e-05 96.099999999999994p 1.153591e-05 96.112499999999997p 1.138764e-05 96.125p 1.12734e-05 96.137499999999989p 1.119219e-05 96.150000000000006p 1.114279e-05 96.162500000000009p 1.1123830000000001e-05 96.174999999999997p 1.113382e-05 96.1875p 1.117112e-05 96.200000000000003p 1.1234019999999999e-05 96.212500000000006p 1.132072e-05 96.224999999999994p 1.1429370000000001e-05 96.237499999999997p 1.1558059999999999e-05 96.25p 1.17049e-05 96.262499999999989p 1.1867959999999999e-05 96.274999999999991p 1.204535e-05 96.287500000000009p 1.223521e-05 96.300000000000011p 1.2435709999999999e-05
+ 96.3125p 1.264509e-05 96.325000000000003p 1.286166e-05 96.337500000000006p 1.30838e-05 96.349999999999994p 1.331e-05 96.362499999999997p 1.353882e-05 96.375p 1.3768940000000001e-05 96.387499999999989p 1.399916e-05 96.399999999999991p 1.422836e-05 96.412500000000009p 1.445558e-05 96.425000000000011p 1.4679939999999999e-05 96.4375p 1.490068e-05 96.450000000000003p 1.5117189999999999e-05 96.462500000000006p 1.5328940000000001e-05 96.474999999999994p 1.5535519999999999e-05 96.487499999999997p 1.5736650000000001e-05 96.5p 1.593211e-05 96.512499999999989p 1.6121830000000001e-05 96.524999999999991p 1.630581e-05
+ 96.537499999999994p 1.6484129999999999e-05 96.550000000000011p 1.6656960000000001e-05 96.5625p 1.6824559999999999e-05 96.575000000000003p 1.6987230000000001e-05 96.587500000000006p 1.7145360000000001e-05 96.599999999999994p 1.729936e-05 96.612499999999997p 1.7449710000000001e-05 96.625p 1.7596919999999999e-05 96.637500000000003p 1.7741539999999999e-05 96.649999999999991p 1.788414e-05 96.662499999999994p 1.8025299999999998e-05 96.675000000000011p 1.8165619999999999e-05 96.6875p 1.8305689999999999e-05 96.700000000000003p 1.8446120000000001e-05 96.712500000000006p 1.8587500000000001e-05 96.724999999999994p 1.873041e-05 96.737499999999997p 1.887541e-05 96.75p 1.9023050000000001e-05
+ 96.762500000000003p 1.9173839999999999e-05 96.774999999999991p 1.9328270000000001e-05 96.787499999999994p 1.9486809999999999e-05 96.800000000000011p 1.964986e-05 96.8125p 1.9817830000000001e-05 96.825000000000003p 1.999107e-05 96.837500000000006p 2.0169869999999999e-05 96.849999999999994p 2.0354529999999998e-05 96.862499999999997p 2.054528e-05 96.875p 2.074231e-05 96.887500000000003p 2.094577e-05 96.899999999999991p 2.1155790000000001e-05 96.912499999999994p 2.137246e-05 96.924999999999997p 2.1595810000000002e-05 96.9375p 2.1825860000000001e-05 96.950000000000003p 2.2062600000000001e-05 96.962500000000006p 2.2305970000000001e-05 96.975000000000009p 2.2555899999999999e-05
+ 96.987499999999997p 2.281228e-05 97p 2.3074999999999998e-05 97.012500000000003p 2.3343909999999999e-05 97.024999999999991p 2.3618849999999998e-05 97.037499999999994p 2.3899629999999999e-05 97.049999999999997p 2.418607e-05 97.0625p 2.4477959999999999e-05 97.075000000000003p 2.4775089999999999e-05 97.087500000000006p 2.507724e-05 97.100000000000009p 2.53842e-05 97.112499999999997p 2.5695740000000001e-05 97.125p 2.6011629999999999e-05 97.137500000000003p 2.6331660000000001e-05 97.149999999999991p 2.665561e-05 97.162499999999994p 2.698326e-05 97.174999999999997p 2.7314410000000001e-05 97.1875p 2.7648849999999999e-05 97.200000000000003p 2.798639e-05
+ 97.212500000000006p 2.8326850000000001e-05 97.225000000000009p 2.8670049999999998e-05 97.237499999999997p 2.9015819999999999e-05 97.25p 2.9364009999999999e-05 97.262500000000003p 2.9714450000000001e-05 97.274999999999991p 3.0067009999999999e-05 97.287499999999994p 3.0421560000000001e-05 97.299999999999997p 3.077796e-05 97.3125p 3.1136090000000001e-05 97.325000000000003p 3.149583e-05 97.337500000000006p 3.1857060000000001e-05 97.350000000000009p 3.2219669999999997e-05 97.362499999999997p 3.2583550000000001e-05 97.375p 3.2948570000000003e-05 97.387500000000003p 3.3314610000000002e-05 97.399999999999991p 3.3681559999999997e-05 97.412499999999994p 3.4049259999999997e-05 97.424999999999997p 3.441759e-05
+ 97.4375p 3.4786370000000001e-05 97.450000000000003p 3.5155440000000002e-05 97.462500000000006p 3.5524610000000003e-05 97.475000000000009p 3.5893670000000003e-05 97.487499999999997p 3.626239e-05 97.5p 3.6630520000000002e-05 97.512500000000003p 3.6997769999999998e-05 97.524999999999991p 3.7363839999999999e-05 97.537499999999994p 3.7728400000000003e-05 97.549999999999997p 3.8091070000000003e-05 97.5625p 3.8451449999999999e-05 97.575000000000003p 3.8809100000000001e-05 97.587500000000006p 3.9163560000000003e-05 97.600000000000009p 3.9514300000000002e-05 97.612499999999997p 3.9860790000000002e-05 97.625p 4.0202430000000002e-05 97.637500000000003p 4.0538599999999998e-05 97.649999999999991p 4.0868629999999999e-05
+ 97.662499999999994p 4.1191820000000002e-05 97.674999999999997p 4.1507429999999997e-05 97.6875p 4.1814689999999997e-05 97.700000000000003p 4.211278e-05 97.712500000000006p 4.240087e-05 97.725000000000009p 4.2678079999999999e-05 97.737499999999997p 4.2943520000000001e-05 97.75p 4.3196279999999997e-05 97.762500000000003p 4.3435430000000003e-05 97.775000000000006p 4.366002e-05 97.787499999999994p 4.3869090000000003e-05 97.799999999999997p 4.4061699999999999e-05 97.8125p 4.4236909999999997e-05 97.824999999999989p 4.439378e-05 97.837500000000006p 4.4531389999999998e-05 97.850000000000009p 4.4648879999999997e-05 97.862499999999997p 4.4745379999999999e-05 97.875p 4.4820100000000001e-05
+ 97.887500000000003p 4.4872279999999999e-05 97.900000000000006p 4.4901229999999998e-05 97.912499999999994p 4.4906339999999997e-05 97.924999999999997p 4.4887060000000003e-05 97.9375p 4.4842929999999999e-05 97.949999999999989p 4.4773600000000001e-05 97.962500000000006p 4.4678790000000003e-05 97.975000000000009p 4.4558360000000001e-05 97.987499999999997p 4.4412259999999999e-05 98p 4.4240570000000003e-05 98.012500000000003p 4.4043489999999999e-05 98.025000000000006p 4.3821349999999997e-05 98.037499999999994p 4.3574600000000001e-05 98.049999999999997p 4.330384e-05 98.0625p 4.3009770000000001e-05 98.074999999999989p 4.2693259999999997e-05 98.087500000000006p 4.2355260000000001e-05 98.100000000000009p 4.1996889999999997e-05
+ 98.112500000000011p 4.1619360000000001e-05 98.125p 4.1223990000000003e-05 98.137500000000003p 4.0812219999999997e-05 98.150000000000006p 4.0385590000000001e-05 98.162499999999994p 3.9945720000000001e-05 98.174999999999997p 3.9494299999999999e-05 98.1875p 3.9033089999999997e-05 98.199999999999989p 3.8563930000000001e-05 98.212499999999991p 3.8088659999999997e-05 98.225000000000009p 3.7609189999999998e-05 98.237500000000011p 3.7127420000000001e-05 98.25p 3.6645259999999997e-05 98.262500000000003p 3.6164619999999997e-05 98.275000000000006p 3.5687369999999998e-05 98.287499999999994p 3.5215359999999999e-05 98.299999999999997p 3.4750389999999998e-05 98.3125p 3.429418e-05 98.324999999999989p 3.384841e-05
+ 98.337499999999991p 3.3414660000000001e-05 98.350000000000009p 3.2994409999999998e-05 98.362500000000011p 3.2589070000000001e-05 98.375p 3.2199900000000003e-05 98.387500000000003p 3.182809e-05 98.400000000000006p 3.1474679999999997e-05 98.412499999999994p 3.1140589999999997e-05 98.424999999999997p 3.0826639999999997e-05 98.4375p 3.053347e-05 98.450000000000003p 3.0261649999999999e-05 98.462499999999991p 3.001157e-05 98.474999999999994p 2.9783519999999998e-05 98.487500000000011p 2.9577670000000001e-05 98.5p 2.9394029999999999e-05 98.512500000000003p 2.9232540000000001e-05 98.525000000000006p 2.9093010000000002e-05 98.537499999999994p 2.8975120000000001e-05 98.549999999999997p 2.8878490000000001e-05
+ 98.5625p 2.8802619999999999e-05 98.575000000000003p 2.8746950000000001e-05 98.587499999999991p 2.871081e-05 98.599999999999994p 2.869351e-05 98.612500000000011p 2.8694250000000001e-05 98.625p 2.8712230000000001e-05 98.637500000000003p 2.8746570000000001e-05 98.650000000000006p 2.8796400000000001e-05 98.662499999999994p 2.8860789999999999e-05 98.674999999999997p 2.893882e-05 98.6875p 2.9029569999999999e-05 98.700000000000003p 2.9132109999999999e-05 98.712499999999991p 2.9245520000000001e-05 98.724999999999994p 2.9368920000000001e-05 98.737499999999997p 2.9501440000000001e-05 98.75p 2.9642249999999999e-05 98.762500000000003p 2.9790549999999999e-05 98.775000000000006p 2.9945610000000001e-05
+ 98.787499999999994p 3.0106700000000001e-05 98.799999999999997p 3.0273189999999999e-05 98.8125p 3.0444480000000002e-05 98.825000000000003p 3.0620029999999997e-05 98.837499999999991p 3.079937e-05 98.849999999999994p 3.0982070000000001e-05 98.862499999999997p 3.1167770000000001e-05 98.875p 3.1356180000000002e-05 98.887500000000003p 3.1547049999999998e-05 98.900000000000006p 3.1740199999999998e-05 98.912500000000009p 3.1935489999999999e-05 98.924999999999997p 3.2132850000000002e-05 98.9375p 3.2332239999999998e-05 98.950000000000003p 3.2533680000000002e-05 98.962499999999991p 3.2737200000000002e-05 98.974999999999994p 3.294291e-05 98.987499999999997p 3.3150920000000003e-05 99p 3.3361359999999999e-05
+ 99.012500000000003p 3.3574410000000002e-05 99.025000000000006p 3.3790240000000003e-05 99.037500000000009p 3.4009030000000001e-05 99.049999999999997p 3.4230979999999997e-05 99.0625p 3.4456270000000002e-05 99.075000000000003p 3.4685099999999998e-05 99.087499999999991p 3.4917630000000001e-05 99.099999999999994p 3.5154039999999999e-05 99.112499999999997p 3.5394459999999999e-05 99.125p 3.5639010000000003e-05 99.137500000000003p 3.5887779999999997e-05 99.150000000000006p 3.6140860000000002e-05 99.162500000000009p 3.6398259999999997e-05 99.174999999999997p 3.6660009999999999e-05 99.1875p 3.6926070000000003e-05 99.200000000000003p 3.719637e-05 99.212499999999991p 3.7470830000000003e-05 99.224999999999994p 3.7749300000000001e-05
+ 99.237499999999997p 3.8031629999999999e-05 99.25p 3.8317610000000001e-05 99.262500000000003p 3.8606989999999997e-05 99.275000000000006p 3.8899529999999998e-05 99.287500000000009p 3.919491e-05 99.299999999999997p 3.9492810000000003e-05 99.3125p 3.9792870000000001e-05 99.325000000000003p 4.0094710000000002e-05 99.337499999999991p 4.0397910000000002e-05 99.349999999999994p 4.070204e-05 99.362499999999997p 4.1006649999999998e-05 99.375p 4.1311270000000003e-05 99.387500000000003p 4.1615390000000001e-05 99.400000000000006p 4.1918500000000002e-05 99.412500000000009p 4.2220089999999998e-05 99.424999999999997p 4.2519609999999999e-05 99.4375p 4.2816499999999999e-05 99.450000000000003p 4.3110199999999999e-05
+ 99.462499999999991p 4.340013e-05 99.474999999999994p 4.3685720000000002e-05 99.487499999999997p 4.3966379999999998e-05 99.5p 4.4241510000000001e-05 99.512500000000003p 4.4510520000000002e-05 99.525000000000006p 4.477281e-05 99.537500000000009p 4.5027790000000002e-05 99.549999999999997p 4.527487e-05 99.5625p 4.5513470000000002e-05 99.575000000000003p 4.574301e-05 99.587500000000006p 4.5962920000000001e-05 99.599999999999994p 4.6172650000000003e-05 99.612499999999997p 4.6371680000000001e-05 99.625p 4.6559469999999998e-05 99.637500000000003p 4.6735549999999997e-05 99.650000000000006p 4.6899440000000003e-05 99.662500000000009p 4.7050710000000001e-05 99.674999999999997p 4.7188940000000001e-05
+ 99.6875p 4.7313759999999998e-05 99.700000000000003p 4.7424840000000003e-05 99.712500000000006p 4.7521890000000003e-05 99.724999999999994p 4.7604649999999998e-05 99.737499999999997p 4.7672910000000003e-05 99.75p 4.772653e-05 99.762499999999989p 4.7765400000000002e-05 99.775000000000006p 4.7789469999999998e-05 99.787500000000009p 4.7798749999999997e-05 99.799999999999997p 4.7793310000000003e-05 99.8125p 4.7773279999999997e-05 99.825000000000003p 4.773884e-05 99.837500000000006p 4.7690250000000003e-05 99.849999999999994p 4.762782e-05 99.862499999999997p 4.7551949999999998e-05 99.875p 4.746306e-05 99.887499999999989p 4.7361689999999997e-05 99.900000000000006p 4.72484e-05
+ 99.912500000000009p 4.712383e-05 99.924999999999997p 4.69887e-05 99.9375p 4.6843749999999997e-05 99.950000000000003p 4.6689820000000003e-05 99.962500000000006p 4.6527770000000003e-05 99.974999999999994p 4.6358549999999997e-05 99.987499999999997p 4.6183129999999997e-05 100p 4.6002550000000002e-05 100.01249999999999p 4.5817869999999998e-05 100.02499999999999p 4.5630190000000002e-05 100.03750000000001p 4.5440669999999998e-05 100.05000000000001p 4.5250470000000001e-05 100.0625p 4.5060779999999999e-05 100.075p 4.4872810000000002e-05 100.08750000000001p 4.4687780000000001e-05 100.09999999999999p 4.450692e-05 100.1125p 4.4331449999999997e-05 100.125p 4.4162590000000002e-05
+ 100.13749999999999p 4.4001549999999999e-05 100.14999999999999p 4.3849510000000002e-05 100.16250000000001p 4.3707629999999997e-05 100.17500000000001p 4.3577050000000003e-05 100.1875p 4.3458850000000002e-05 100.2p 4.3354069999999997e-05 100.21250000000001p 4.3263719999999999e-05 100.22499999999999p 4.3188729999999997e-05 100.2375p 4.3129980000000001e-05 100.25p 4.3088299999999999e-05 100.26249999999999p 4.3064410000000001e-05 100.27499999999999p 4.3058980000000001e-05 100.28749999999999p 4.3072609999999999e-05 100.30000000000001p 4.3105800000000003e-05 100.3125p 4.3158960000000002e-05 100.325p 4.3232429999999998e-05 100.33750000000001p 4.332642e-05 100.34999999999999p 4.3441089999999999e-05
+ 100.3625p 4.3576470000000003e-05 100.375p 4.3732510000000003e-05 100.3875p 4.3909039999999999e-05 100.39999999999999p 4.4105810000000001e-05 100.41249999999999p 4.4322459999999998e-05 100.42500000000001p 4.4558519999999998e-05 100.4375p 4.4813420000000002e-05 100.45p 4.5086509999999997e-05 100.46250000000001p 4.5377009999999997e-05 100.47499999999999p 4.5684050000000002e-05 100.4875p 4.6006669999999999e-05 100.5p 4.6343800000000002e-05 100.5125p 4.6694280000000003e-05 100.52499999999999p 4.7056859999999997e-05 100.53749999999999p 4.7430189999999998e-05 100.55000000000001p 4.7812850000000001e-05 100.5625p 4.820331e-05 100.575p 4.859997e-05
+ 100.58750000000001p 4.9001159999999998e-05 100.59999999999999p 4.940512e-05 100.6125p 4.9810040000000002e-05 100.625p 5.021404e-05 100.6375p 5.061516e-05 100.64999999999999p 5.101143e-05 100.66249999999999p 5.1400799999999998e-05 100.675p 5.1781199999999998e-05 100.6875p 5.2150529999999997e-05 100.7p 5.2506660000000001e-05 100.71250000000001p 5.2847479999999997e-05 100.72500000000001p 5.3170839999999999e-05 100.7375p 5.347463e-05 100.75p 5.3756750000000003e-05 100.7625p 5.4015160000000001e-05 100.77499999999999p 5.4247850000000003e-05 100.78749999999999p 5.445287e-05 100.8p 5.4628359999999997e-05
+ 100.8125p 5.4772550000000001e-05 100.825p 5.4883780000000003e-05 100.83750000000001p 5.4960509999999997e-05 100.85000000000001p 5.5001350000000002e-05 100.8625p 5.5005030000000001e-05 100.875p 5.4970479999999997e-05 100.8875p 5.4896799999999999e-05 100.89999999999999p 5.478328e-05 100.91249999999999p 5.4629410000000003e-05 100.925p 5.4434900000000003e-05 100.9375p 5.4199690000000001e-05 100.95p 5.3923920000000002e-05 100.96250000000001p 5.360801e-05 100.97500000000001p 5.3252569999999997e-05 100.9875p 5.2858500000000002e-05 101p 5.2426880000000003e-05 101.0125p 5.1959080000000001e-05 101.02499999999999p 5.1456660000000002e-05
+ 101.03749999999999p 5.0921419999999998e-05 101.05p 5.0355349999999999e-05 101.0625p 4.9760650000000003e-05 101.075p 4.9139710000000001e-05 101.08750000000001p 4.8495080000000001e-05 101.10000000000001p 4.7829440000000003e-05 101.1125p 4.7145619999999999e-05 101.125p 4.644655e-05 101.1375p 4.5735239999999998e-05 101.14999999999999p 4.501478e-05 101.16249999999999p 4.4288259999999998e-05 101.175p 4.3558830000000003e-05 101.1875p 4.2829610000000001e-05 101.2p 4.210368e-05 101.21250000000001p 4.1384080000000001e-05 101.22500000000001p 4.0673770000000001e-05 101.2375p 3.9975619999999999e-05 101.25p 3.9292370000000001e-05
+ 101.2625p 3.8626630000000003e-05 101.27499999999999p 3.7980879999999999e-05 101.28749999999999p 3.7357410000000003e-05 101.3p 3.6758329999999999e-05 101.3125p 3.6185600000000001e-05 101.325p 3.5640940000000002e-05 101.33750000000001p 3.5125890000000001e-05 101.35000000000001p 3.4641780000000003e-05 101.3625p 3.4189719999999997e-05 101.375p 3.377062e-05 101.3875p 3.3385179999999999e-05 101.39999999999999p 3.3033890000000002e-05 101.41249999999999p 3.2717030000000001e-05 101.425p 3.2434709999999997e-05 101.4375p 3.2186839999999998e-05 101.45p 3.1973149999999997e-05 101.46250000000001p 3.1793199999999999e-05 101.47500000000001p 3.1646419999999997e-05
+ 101.4875p 3.153207e-05 101.5p 3.1449309999999998e-05 101.5125p 3.1397160000000002e-05 101.52500000000001p 3.1374549999999999e-05 101.53749999999999p 3.1380339999999998e-05 101.55p 3.14133e-05 101.5625p 3.1472150000000003e-05 101.57499999999999p 3.1555579999999998e-05 101.58750000000001p 3.1662229999999999e-05 101.60000000000001p 3.1790730000000003e-05 101.6125p 3.1939739999999998e-05 101.625p 3.2107880000000003e-05 101.6375p 3.2293830000000001e-05 101.65000000000001p 3.2496280000000001e-05 101.66249999999999p 3.2713969999999997e-05 101.675p 3.2945679999999997e-05 101.6875p 3.3190259999999997e-05 101.69999999999999p 3.3446599999999999e-05
+ 101.71250000000001p 3.3713680000000001e-05 101.72500000000001p 3.3990520000000001e-05 101.7375p 3.4276249999999999e-05 101.75p 3.4570029999999998e-05 101.7625p 3.4871140000000002e-05 101.77500000000001p 3.5178900000000003e-05 101.78749999999999p 3.5492710000000001e-05 101.8p 3.5812059999999999e-05 101.8125p 3.6136480000000001e-05 101.82499999999999p 3.6465570000000003e-05 101.83750000000001p 3.6799009999999999e-05 101.85000000000001p 3.713651e-05 101.86250000000001p 3.7477839999999998e-05 101.875p 3.78228e-05 101.8875p 3.8171260000000002e-05 101.90000000000001p 3.8523099999999997e-05 101.91249999999999p 3.8878209999999997e-05 101.925p 3.9236519999999997e-05
+ 101.9375p 3.9597980000000001e-05 101.94999999999999p 3.9962529999999998e-05 101.96249999999999p 4.0330129999999997e-05 101.97500000000001p 4.0700710000000002e-05 101.98750000000001p 4.1074230000000003e-05 102p 4.1450599999999999e-05 102.0125p 4.182974e-05 102.02500000000001p 4.2211539999999997e-05 102.03749999999999p 4.259586e-05 102.05p 4.2982560000000001e-05 102.0625p 4.3371439999999999e-05 102.07499999999999p 4.3762299999999999e-05 102.08749999999999p 4.41549e-05 102.10000000000001p 4.454895e-05 102.11250000000001p 4.494416e-05 102.125p 4.5340199999999997e-05 102.1375p 4.5736699999999999e-05 102.15000000000001p 4.613329e-05
+ 102.16249999999999p 4.6529539999999998e-05 102.175p 4.6925019999999997e-05 102.1875p 4.7319269999999997e-05 102.2p 4.7711820000000001e-05 102.21249999999999p 4.810218e-05 102.22499999999999p 4.8489819999999999e-05 102.23750000000001p 4.8874249999999997e-05 102.25p 4.9254939999999998e-05 102.2625p 4.9631349999999997e-05 102.27500000000001p 5.0002949999999999e-05 102.28749999999999p 5.0369230000000001e-05 102.3p 5.072965e-05 102.3125p 5.1083689999999999e-05 102.325p 5.1430839999999998e-05 102.33749999999999p 5.1770619999999997e-05 102.34999999999999p 5.210253e-05 102.36250000000001p 5.2426109999999997e-05 102.375p 5.2740910000000003e-05
+ 102.3875p 5.304649e-05 102.40000000000001p 5.3342440000000002e-05 102.41249999999999p 5.362836e-05 102.425p 5.3903889999999997e-05 102.4375p 5.4168649999999998e-05 102.45p 5.4422310000000003e-05 102.46249999999999p 5.4664550000000002e-05 102.47499999999999p 5.489506e-05 102.4875p 5.5113559999999998e-05 102.5p 5.5319750000000002e-05 102.5125p 5.5513370000000001e-05 102.52500000000001p 5.5694169999999997e-05 102.53749999999999p 5.5861869999999999e-05 102.55p 5.6016230000000003e-05 102.5625p 5.6156999999999998e-05 102.575p 5.6283909999999999e-05 102.58749999999999p 5.6396729999999997e-05 102.59999999999999p 5.6495179999999999e-05
+ 102.6125p 5.6579010000000002e-05 102.625p 5.6647929999999999e-05 102.6375p 5.6701679999999998e-05 102.65000000000001p 5.6739959999999999e-05 102.66250000000001p 5.6762509999999998e-05 102.675p 5.6769040000000001e-05 102.6875p 5.675925e-05 102.7p 5.673289e-05 102.71249999999999p 5.6689679999999999e-05 102.72499999999999p 5.6629380000000002e-05 102.7375p 5.6551770000000001e-05 102.75p 5.6456660000000002e-05 102.7625p 5.6343900000000001e-05 102.77500000000001p 5.6213389999999999e-05 102.78750000000001p 5.6065089999999999e-05 102.8p 5.5899010000000002e-05 102.8125p 5.5715279999999997e-05 102.825p 5.5514060000000002e-05
+ 102.83749999999999p 5.5295640000000002e-05 102.84999999999999p 5.506042e-05 102.8625p 5.4808900000000003e-05 102.875p 5.4541689999999999e-05 102.8875p 5.4259560000000002e-05 102.90000000000001p 5.3963389999999998e-05 102.91250000000001p 5.365422e-05 102.925p 5.33332e-05 102.9375p 5.3001670000000002e-05 102.95p 5.2661070000000001e-05 102.96249999999999p 5.2313009999999999e-05 102.97499999999999p 5.1959239999999998e-05 102.9875p 5.1601629999999999e-05 103p 5.124217e-05 103.0125p 5.0883000000000001e-05 103.02500000000001p 5.052633e-05 103.03750000000001p 5.0174489999999998e-05 103.05p 4.9829880000000001e-05
+ 103.0625p 4.9494950000000003e-05 103.075p 4.9172219999999998e-05 103.08749999999999p 4.8864230000000001e-05 103.09999999999999p 4.857353e-05 103.1125p 4.8302659999999998e-05 103.125p 4.8054119999999999e-05 103.1375p 4.7830380000000001e-05 103.15000000000001p 4.763383e-05 103.16250000000001p 4.7466760000000002e-05 103.175p 4.7331360000000003e-05 103.1875p 4.7229689999999999e-05 103.2p 4.7163660000000001e-05 103.21249999999999p 4.7134990000000001e-05 103.22499999999999p 4.7145250000000001e-05 103.2375p 4.71958e-05 103.25p 4.7287760000000002e-05 103.2625p 4.7422069999999999e-05 103.27500000000001p 4.7599390000000003e-05
+ 103.28750000000001p 4.7820140000000003e-05 103.3p 4.8084509999999997e-05 103.3125p 4.839238e-05 103.325p 4.8743399999999998e-05 103.33750000000001p 4.9136930000000003e-05 103.34999999999999p 4.9572050000000003e-05 103.3625p 5.0047579999999997e-05 103.375p 5.0562039999999997e-05 103.3875p 5.1113689999999997e-05 103.40000000000001p 5.1700529999999999e-05 103.41250000000001p 5.232028e-05 103.425p 5.2970399999999997e-05 103.4375p 5.364812e-05 103.45p 5.4350420000000002e-05 103.46250000000001p 5.5074039999999998e-05 103.47499999999999p 5.5815500000000001e-05 103.4875p 5.6571150000000001e-05 103.5p 5.7337119999999998e-05
+ 103.51249999999999p 5.8109370000000001e-05 103.52500000000001p 5.8883720000000001e-05 103.53750000000001p 5.9655850000000002e-05 103.55p 6.0421329999999999e-05 103.5625p 6.1175650000000001e-05 103.575p 6.1914220000000006e-05 103.58750000000001p 6.2632419999999995e-05 103.59999999999999p 6.3325639999999998e-05 103.6125p 6.3989260000000005e-05 103.625p 6.4618739999999995e-05 103.63749999999999p 6.5209629999999995e-05 103.65000000000001p 6.5757559999999999e-05 103.66250000000001p 6.625837e-05 103.67500000000001p 6.6708060000000003e-05 103.6875p 6.7102850000000001e-05 103.7p 6.7439250000000007e-05 103.71250000000001p 6.7714049999999999e-05 103.72499999999999p 6.7924369999999994e-05
+ 103.7375p 6.8067710000000006e-05 103.75p 6.8141949999999996e-05 103.76249999999999p 6.8145400000000007e-05 103.77499999999999p 6.8076810000000006e-05 103.78750000000001p 6.7935399999999993e-05 103.80000000000001p 6.7720890000000003e-05 103.8125p 6.7433469999999995e-05 103.825p 6.7073850000000005e-05 103.83750000000001p 6.6643239999999995e-05 103.84999999999999p 6.6143370000000006e-05 103.8625p 6.5576419999999999e-05 103.875p 6.4945090000000002e-05 103.88749999999999p 6.4252520000000003e-05 103.89999999999999p 6.3502289999999996e-05 103.91250000000001p 6.269836e-05 103.92500000000001p 6.1845089999999994e-05 103.9375p 6.0947150000000001e-05 103.95p 6.0009490000000001e-05
+ 103.96250000000001p 5.9037319999999999e-05 103.97499999999999p 5.8036019999999999e-05 103.9875p 5.7011140000000003e-05 104p 5.5968289999999997e-05 104.01249999999999p 5.4913149999999998e-05 104.02499999999999p 5.3851380000000003e-05 104.03749999999999p 5.2788579999999997e-05 104.05000000000001p 5.1730249999999998e-05 104.0625p 5.0681730000000002e-05 104.075p 4.9648160000000001e-05 104.08750000000001p 4.8634460000000001e-05 104.09999999999999p 4.7645270000000001e-05 104.1125p 4.6684919999999999e-05 104.125p 4.5757419999999998e-05 104.1375p 4.4866410000000002e-05 104.14999999999999p 4.4015140000000001e-05 104.16249999999999p 4.320649e-05 104.17500000000001p 4.2442920000000001e-05
+ 104.1875p 4.172648e-05 104.2p 4.1058800000000001e-05 104.21250000000001p 4.0441110000000002e-05 104.22499999999999p 3.9874209999999999e-05 104.2375p 3.935851e-05 104.25p 3.889404e-05 104.2625p 3.8480450000000002e-05 104.27499999999999p 3.8117039999999997e-05 104.28749999999999p 3.7802790000000003e-05 104.30000000000001p 3.7536359999999999e-05 104.3125p 3.7316130000000002e-05 104.325p 3.7140230000000003e-05 104.33750000000001p 3.7006560000000003e-05 104.34999999999999p 3.6912829999999999e-05 104.3625p 3.6856590000000001e-05 104.375p 3.6835239999999999e-05 104.3875p 3.6846069999999997e-05 104.39999999999999p 3.6886340000000002e-05
+ 104.41249999999999p 3.6953199999999997e-05 104.425p 3.7043840000000002e-05 104.4375p 3.7155440000000003e-05 104.45p 3.7285210000000001e-05 104.46250000000001p 3.7430449999999997e-05 104.47500000000001p 3.7588530000000003e-05 104.4875p 3.775693e-05 104.5p 3.7933279999999997e-05 104.5125p 3.811533e-05 104.52499999999999p 3.830103e-05 104.53749999999999p 3.848847e-05 104.55p 3.8675979999999999e-05 104.5625p 3.8862049999999998e-05 104.575p 3.9045390000000003e-05 104.58750000000001p 3.9224919999999999e-05 104.60000000000001p 3.9399790000000001e-05 104.6125p 3.9569349999999997e-05 104.625p 3.9733159999999998e-05
+ 104.6375p 3.9891010000000002e-05 104.64999999999999p 4.004287e-05 104.66249999999999p 4.0188919999999999e-05 104.675p 4.0329510000000001e-05 104.6875p 4.0465179999999999e-05 104.7p 4.0596609999999998e-05 104.71250000000001p 4.0724640000000002e-05 104.72500000000001p 4.0850219999999999e-05 104.7375p 4.0974430000000001e-05 104.75p 4.1098430000000001e-05 104.7625p 4.1223449999999999e-05 104.77499999999999p 4.1350770000000002e-05 104.78749999999999p 4.1481720000000001e-05 104.8p 4.1617630000000002e-05 104.8125p 4.175981e-05 104.825p 4.190956e-05 104.83750000000001p 4.2068140000000001e-05 104.85000000000001p 4.2236710000000002e-05
+ 104.8625p 4.2416390000000002e-05 104.875p 4.2608180000000002e-05 104.8875p 4.2812960000000002e-05 104.89999999999999p 4.3031509999999997e-05 104.91249999999999p 4.3264450000000002e-05 104.925p 4.3512249999999997e-05 104.9375p 4.3775239999999997e-05 104.95p 4.405359e-05 104.96250000000001p 4.4347300000000001e-05 104.97500000000001p 4.465619e-05 104.9875p 4.4979950000000003e-05 105p 4.531806e-05 105.0125p 4.566988e-05 105.02499999999999p 4.6034610000000002e-05 105.03749999999999p 4.641129e-05 105.05p 4.6798839999999999e-05 105.0625p 4.7196040000000003e-05 105.075p 4.760158e-05
+ 105.08750000000001p 4.8014050000000002e-05 105.10000000000001p 4.8431930000000002e-05 105.1125p 4.885366e-05 105.125p 4.9277619999999999e-05 105.1375p 4.9702150000000003e-05 105.14999999999999p 5.0125569999999998e-05 105.16249999999999p 5.0546200000000001e-05 105.175p 5.0962370000000003e-05 105.1875p 5.1372419999999998e-05 105.2p 5.1774750000000001e-05 105.21250000000001p 5.216782e-05 105.22500000000001p 5.2550129999999999e-05 105.2375p 5.2920280000000001e-05 105.25p 5.3276940000000001e-05 105.2625p 5.3618900000000003e-05 105.27500000000001p 5.3945040000000002e-05 105.28749999999999p 5.4254340000000003e-05 105.3p 5.4545910000000003e-05
+ 105.3125p 5.4818970000000003e-05 105.32499999999999p 5.5072850000000002e-05 105.33750000000001p 5.5306999999999997e-05 105.35000000000001p 5.5520999999999999e-05 105.3625p 5.5714519999999998e-05 105.375p 5.5887349999999999e-05 105.3875p 5.6039350000000001e-05 105.40000000000001p 5.61705e-05 105.41249999999999p 5.6280860000000002e-05 105.425p 5.6370540000000001e-05 105.4375p 5.6439739999999997e-05 105.44999999999999p 5.64887e-05 105.46250000000001p 5.6517680000000001e-05 105.47500000000001p 5.6526990000000002e-05 105.4875p 5.6516939999999997e-05 105.5p 5.6487870000000003e-05 105.5125p 5.6440080000000001e-05 105.52500000000001p 5.6373860000000003e-05
+ 105.53749999999999p 5.6289480000000002e-05 105.55p 5.618715e-05 105.5625p 5.6067060000000001e-05 105.57499999999999p 5.5929330000000002e-05 105.58749999999999p 5.5774009999999999e-05 105.60000000000001p 5.5601099999999999e-05 105.61250000000001p 5.5410520000000002e-05 105.625p 5.5202140000000001e-05 105.6375p 5.497575e-05 105.65000000000001p 5.473107e-05 105.66249999999999p 5.446779e-05 105.675p 5.418552e-05 105.6875p 5.3883839999999997e-05 105.69999999999999p 5.35623e-05 105.71249999999999p 5.322045e-05 105.72500000000001p 5.2857800000000001e-05 105.73750000000001p 5.2473930000000001e-05 105.75p 5.2068399999999998e-05
+ 105.7625p 5.164087e-05 105.77500000000001p 5.1191040000000001e-05 105.78749999999999p 5.0718720000000001e-05 105.8p 5.0223830000000001e-05 105.8125p 4.9706419999999997e-05 105.82499999999999p 4.9166719999999999e-05 105.83749999999999p 4.8605089999999999e-05 105.85000000000001p 4.8022119999999997e-05 105.86250000000001p 4.741859e-05 105.875p 4.6795490000000002e-05 105.8875p 4.6154040000000002e-05 105.90000000000001p 4.549572e-05 105.91249999999999p 4.4822220000000001e-05 105.925p 4.4135489999999997e-05 105.9375p 4.343771e-05 105.95p 4.2731300000000002e-05 105.96249999999999p 4.2018889999999998e-05 105.97499999999999p 4.1303329999999997e-05
+ 105.98750000000001p 4.0587660000000002e-05 106p 3.9875079999999999e-05 106.0125p 3.916894e-05 106.02500000000001p 3.8472729999999997e-05 106.03749999999999p 3.7790010000000003e-05 106.05p 3.7124410000000001e-05 106.0625p 3.6479580000000001e-05 106.075p 3.5859170000000002e-05 106.08749999999999p 3.5266789999999998e-05 106.09999999999999p 3.4705970000000001e-05 106.11250000000001p 3.4180139999999998e-05 106.125p 3.369255e-05 106.1375p 3.32463e-05 106.15000000000001p 3.2844269999999998e-05 106.16249999999999p 3.2489079999999999e-05 106.175p 3.218309e-05 106.1875p 3.1928350000000001e-05 106.2p 3.1726580000000001e-05
+ 106.21249999999999p 3.1579150000000001e-05 106.22499999999999p 3.1487079999999997e-05 106.2375p 3.1450969999999999e-05 106.25p 3.147104e-05 106.2625p 3.1547090000000001e-05 106.27500000000001p 3.167852e-05 106.28749999999999p 3.1864269999999997e-05 106.3p 3.2102910000000001e-05 106.3125p 3.2392530000000001e-05 106.325p 3.2730839999999998e-05 106.33749999999999p 3.3115119999999999e-05 106.34999999999999p 3.3542260000000003e-05 106.3625p 3.4008770000000003e-05 106.375p 3.451077e-05 106.3875p 3.5044050000000002e-05 106.40000000000001p 3.5604049999999997e-05 106.41250000000001p 3.6185929999999997e-05 106.425p 3.6784540000000003e-05
+ 106.4375p 3.7394519999999997e-05 106.45p 3.8010250000000001e-05 106.46249999999999p 3.8625960000000003e-05 106.47499999999999p 3.9235730000000003e-05 106.4875p 3.9833509999999998e-05 106.5p 4.0413210000000002e-05 106.5125p 4.0968689999999999e-05 106.52500000000001p 4.1493840000000002e-05 106.53750000000001p 4.1982630000000002e-05 106.55p 4.2429119999999998e-05 106.5625p 4.2827529999999998e-05 106.575p 4.3172310000000001e-05 106.58749999999999p 4.3458129999999999e-05 106.59999999999999p 4.3679980000000001e-05 106.6125p 4.383322e-05 106.625p 4.3913569999999997e-05 106.6375p 4.39172e-05 106.65000000000001p 4.384077e-05
+ 106.66250000000001p 4.3681440000000001e-05 106.675p 4.3436919999999999e-05 106.6875p 4.3105519999999997e-05 106.7p 4.2686119999999999e-05 106.71249999999999p 4.2178239999999998e-05 106.72499999999999p 4.1582029999999998e-05 106.7375p 4.089829e-05 106.75p 4.0128459999999998e-05 106.7625p 3.9274609999999999e-05 106.77500000000001p 3.8339449999999998e-05 106.78750000000001p 3.7326280000000001e-05 106.8p 3.6239009999999997e-05 106.8125p 3.508209e-05 106.825p 3.3860489999999998e-05 106.83749999999999p 3.2579680000000001e-05 106.84999999999999p 3.1245560000000002e-05 106.8625p 2.9864400000000002e-05 106.875p 2.844283e-05
+ 106.8875p 2.6987770000000001e-05 106.90000000000001p 2.550635e-05 106.91250000000001p 2.4005879999999999e-05 106.925p 2.2493800000000001e-05 106.9375p 2.097759e-05 106.95p 1.946475e-05 106.96249999999999p 1.7962720000000001e-05 106.97499999999999p 1.647882e-05 106.9875p 1.502022e-05 107p 1.35939e-05 107.0125p 1.2206570000000001e-05 107.02500000000001p 1.0864649999999999e-05 107.03750000000001p 9.5742019999999994e-06 107.05p 8.3409479999999997e-06 107.0625p 7.1701850000000002e-06 107.075p 6.0667779999999999e-06 107.08750000000001p 5.0351310000000001e-06 107.09999999999999p 4.0791649999999999e-06
+ 107.1125p 3.202299e-06 107.125p 2.4074379999999998e-06 107.1375p 1.696954e-06 107.15000000000001p 1.0726900000000001e-06 107.16250000000001p 5.3594259999999998e-07 107.175p 8.7471660000000001e-08 107.1875p -2.725039e-07 107.2p -5.442983e-07 107.21250000000001p -7.2875109999999998e-07 107.22499999999999p -8.2721510000000003e-07 107.2375p -8.4154210000000005e-07 107.25p -7.7406489999999997e-07 107.26249999999999p -6.2757759999999999e-07 107.27500000000001p -4.053116e-07 107.28750000000001p -1.109101e-07 107.3p 2.516001e-07 107.3125p 6.7784009999999998e-07 107.325p 1.163111e-06
+ 107.33750000000001p 1.702431e-06 107.34999999999999p 2.2905680000000001e-06 107.3625p 2.9220850000000002e-06 107.375p 3.5913729999999999e-06 107.38749999999999p 4.2926960000000003e-06 107.40000000000001p 5.0202330000000001e-06 107.41250000000001p 5.7681169999999997e-06 107.42500000000001p 6.5304799999999999e-06 107.4375p 7.3014930000000003e-06 107.45p 8.0754069999999998e-06 107.46250000000001p 8.8465939999999995e-06 107.47499999999999p 9.6095849999999992e-06 107.4875p 1.0359109999999999e-05 107.5p 1.109012e-05 107.51249999999999p 1.1797829999999999e-05 107.52499999999999p 1.2477770000000001e-05 107.53750000000001p 1.312574e-05 107.55000000000001p 1.373793e-05
+ 107.5625p 1.431087e-05 107.575p 1.484145e-05 107.58750000000001p 1.5326969999999999e-05 107.59999999999999p 1.5765130000000001e-05 107.6125p 1.6154009999999999e-05 107.625p 1.6492110000000002e-05 107.63749999999999p 1.677832e-05 107.64999999999999p 1.7011940000000002e-05 107.66250000000001p 1.7192640000000001e-05 107.67500000000001p 1.7320450000000001e-05 107.6875p 1.7395779999999999e-05 107.7p 1.7419369999999999e-05 107.71250000000001p 1.7392270000000001e-05 107.72499999999999p 1.7315819999999999e-05 107.7375p 1.7191639999999999e-05 107.75p 1.7021589999999999e-05 107.76249999999999p 1.6807740000000001e-05 107.77499999999999p 1.6552369999999999e-05
+ 107.78749999999999p 1.6257880000000001e-05 107.80000000000001p 1.5926859999999999e-05 107.8125p 1.556194e-05 107.825p 1.516593e-05 107.83750000000001p 1.4741449999999999e-05 107.84999999999999p 1.429116e-05 107.8625p 1.3817859999999999e-05 107.875p 1.332446e-05 107.8875p 1.2813870000000001e-05 107.89999999999999p 1.228888e-05 107.91249999999999p 1.175216e-05 107.92500000000001p 1.1206240000000001e-05 107.9375p 1.065357e-05 107.95p 1.009642e-05 107.96250000000001p 9.5369610000000003e-06 107.97499999999999p 8.9772010000000004e-06 107.9875p 8.4189929999999994e-06 108p 7.8640260000000007e-06
+ 108.0125p 7.3138229999999998e-06 108.02499999999999p 6.769733e-06 108.03749999999999p 6.2329269999999998e-06 108.05000000000001p 5.7044050000000003e-06 108.0625p 5.184988e-06 108.075p 4.675325e-06 108.08750000000001p 4.1758940000000004e-06 108.09999999999999p 3.6870110000000001e-06 108.1125p 3.2088329999999999e-06 108.125p 2.7413689999999999e-06 108.1375p 2.284488e-06 108.14999999999999p 1.837931e-06 108.16249999999999p 1.401323e-06 108.175p 9.7418599999999996e-07 108.1875p 5.5595569999999998e-07 108.2p 1.45995e-07 108.21250000000001p -2.5638859999999999e-07 108.22500000000001p -6.5192580000000005e-07
+ 108.2375p -1.0413680000000001e-06 108.25p -1.42547e-06 108.2625p -1.8049690000000001e-06 108.27499999999999p -2.1805710000000002e-06 108.28749999999999p -2.552926e-06 108.3p -2.9226179999999998e-06 108.3125p -3.2901419999999999e-06 108.325p -3.6558900000000002e-06 108.33750000000001p -4.0201319999999999e-06 108.35000000000001p -4.3830079999999996e-06 108.3625p -4.744507e-06 108.375p -5.104461e-06 108.3875p -5.4625309999999996e-06 108.39999999999999p -5.8182020000000001e-06 108.41249999999999p -6.1707710000000001e-06 108.425p -6.5193460000000004e-06 108.4375p -6.8628450000000004e-06 108.45p -7.1999889999999996e-06
+ 108.46250000000001p -7.5293110000000002e-06 108.47500000000001p -7.8491549999999996e-06 108.4875p -8.1576859999999999e-06 108.5p -8.4528960000000007e-06 108.5125p -8.7326160000000005e-06 108.52499999999999p -8.9945289999999993e-06 108.53749999999999p -9.2361850000000004e-06 108.55p -9.4550199999999998e-06 108.5625p -9.6483739999999995e-06 108.575p -9.8135100000000008e-06 108.58750000000001p -9.9476409999999999e-06 108.60000000000001p -1.0047949999999999e-05 108.6125p -1.0111610000000001e-05 108.625p -1.0135830000000001e-05 108.6375p -1.011785e-05 108.64999999999999p -1.0054999999999999e-05 108.66249999999999p -9.9446999999999998e-06 108.675p -9.7845010000000003e-06
+ 108.6875p -9.5721150000000004e-06 108.7p -9.3054319999999999e-06 108.71250000000001p -8.9825530000000008e-06 108.72500000000001p -8.6018130000000001e-06 108.7375p -8.1618069999999995e-06 108.75p -7.6614170000000007e-06 108.7625p -7.0998320000000002e-06 108.77499999999999p -6.4765779999999998e-06 108.78749999999999p -5.7915369999999999e-06 108.8p -5.0449709999999998e-06 108.8125p -4.2375469999999999e-06 108.825p -3.3703600000000001e-06 108.83750000000001p -2.4449530000000001e-06 108.85000000000001p -1.4633400000000001e-06 108.8625p -4.2802879999999999e-07 108.875p 6.5795880000000004e-07 108.8875p 1.791067e-06 108.89999999999999p 2.9665930000000001e-06
+ 108.91249999999999p 4.163047e-06 108.925p 5.3514260000000004e-06 108.9375p 6.4912989999999998e-06 108.95p 7.5588899999999999e-06 108.96250000000001p 8.542879e-06 108.97500000000001p 9.4383849999999999e-06 108.9875p 1.0243379999999999e-05 109p 1.0956939999999999e-05 109.0125p 1.100874e-05 109.02500000000001p 1.1000280000000001e-05 109.03749999999999p 1.093402e-05 109.05p 1.081039e-05 109.0625p 1.062889e-05 109.07499999999999p 1.038854e-05 109.08750000000001p 1.008809e-05 109.10000000000001p 9.7260910000000003e-06 109.1125p 9.3010859999999998e-06 109.125p 8.8116539999999998e-06
+ 109.1375p 8.2565490000000004e-06 109.15000000000001p 7.6347940000000004e-06 109.16249999999999p 6.9457920000000003e-06 109.175p 6.189416e-06 109.1875p 5.3660939999999996e-06 109.19999999999999p 4.4895e-06 109.21250000000001p 3.5766420000000001e-06 109.22500000000001p 2.6444489999999999e-06 109.2375p 1.7087099999999999e-06 109.25p 7.8381060000000003e-07 109.2625p -1.1725169999999999e-07 109.27500000000001p -9.8381110000000004e-07 109.28749999999999p -1.81157e-06 109.3p -2.6000250000000001e-06 109.3125p -3.3502679999999999e-06 109.32499999999999p -4.0637900000000001e-06 109.33749999999999p -4.7419299999999998e-06 109.35000000000001p -5.3856359999999999e-06
+ 109.36250000000001p -5.9953890000000001e-06 109.375p -6.5711919999999996e-06 109.3875p -7.112588e-06 109.40000000000001p -7.618709e-06 109.41249999999999p -8.0883280000000001e-06 109.425p -8.5199180000000004e-06 109.4375p -8.9117229999999993e-06 109.44999999999999p -9.2618270000000005e-06 109.46249999999999p -9.568224e-06 109.47500000000001p -9.8288860000000001e-06 109.48750000000001p -1.004183e-05 109.5p -1.0205210000000001e-05 109.5125p -1.0317309999999999e-05 109.52500000000001p -1.037667e-05 109.53749999999999p -1.038213e-05 109.55p -1.03328e-05 109.5625p -1.022818e-05 109.57499999999999p -1.006816e-05
+ 109.58749999999999p -9.8530369999999999e-06 109.60000000000001p -9.5835189999999993e-06 109.61250000000001p -9.260763e-06 109.625p -8.8863589999999997e-06 109.6375p -8.4623280000000002e-06 109.65000000000001p -7.9911170000000003e-06 109.66249999999999p -7.4755769999999996e-06 109.675p -6.9189470000000002e-06 109.6875p -6.3248260000000003e-06 109.7p -5.6971449999999998e-06 109.71249999999999p -5.0401329999999997e-06 109.72499999999999p -4.3582790000000003e-06 109.73750000000001p -3.6562970000000002e-06 109.75p -2.9390799999999998e-06 109.7625p -2.211656e-06 109.77500000000001p -1.479149e-06 109.78749999999999p -7.4672769999999999e-07 109.8p -1.9561019999999999e-08
+ 109.8125p 6.9722690000000003e-07 109.825p 1.3986029999999999e-06 109.83749999999999p 2.0796719999999998e-06 109.84999999999999p 2.7357159999999999e-06 109.86250000000001p 3.3622409999999998e-06 109.875p 3.955013e-06 109.8875p 4.5101000000000002e-06 109.90000000000001p 5.0239030000000002e-06 109.91249999999999p 5.493192e-06 109.925p 5.9151299999999999e-06 109.9375p 6.2873029999999998e-06 109.95p 6.6077430000000004e-06 109.96249999999999p 6.8749379999999998e-06 109.97499999999999p 7.0878530000000001e-06 109.9875p 7.2459369999999999e-06 110p 7.3491270000000002e-06 110.0125p 7.9676229999999993e-06 110.02500000000001p 8.5002989999999995e-06
+ 110.03749999999999p 8.9455029999999992e-06 110.05p 9.3040060000000008e-06 110.0625p 9.5778720000000003e-06 110.075p 9.7700619999999992e-06 110.08749999999999p 9.8842710000000002e-06 110.09999999999999p 9.9248360000000004e-06 110.1125p 9.8966740000000002e-06 110.125p 9.8052149999999999e-06 110.1375p 9.656338e-06 110.15000000000001p 9.456302e-06 110.16250000000001p 9.2116809999999999e-06 110.175p 8.9292889999999993e-06 110.1875p 8.6161110000000005e-06 110.2p 8.2792270000000008e-06 110.21249999999999p 7.9257419999999992e-06 110.22499999999999p 7.5627140000000004e-06 110.2375p 7.1970839999999996e-06 110.25p 6.8356089999999999e-06
+ 110.2625p 6.4844010000000004e-06 110.27500000000001p 6.1487820000000002e-06 110.28750000000001p 5.8335519999999999e-06 110.3p 5.5431630000000002e-06 110.3125p 5.2817660000000003e-06 110.325p 5.0531890000000001e-06 110.33749999999999p 4.8609009999999997e-06 110.34999999999999p 4.7079670000000002e-06 110.3625p 4.5961449999999997e-06 110.375p 4.528058e-06 110.3875p 4.5049709999999999e-06 110.40000000000001p 4.5286210000000001e-06 110.41250000000001p 4.5992379999999997e-06 110.425p 4.7174930000000002e-06 110.4375p 4.8824299999999996e-06 110.45p 5.0937510000000004e-06 110.46249999999999p 5.3504599999999996e-06 110.47499999999999p 5.6508339999999998e-06
+ 110.4875p 5.9925849999999998e-06 110.5p 6.3729870000000001e-06 110.5125p 6.7889630000000002e-06 110.52500000000001p 7.2371459999999997e-06 110.53750000000001p 7.7139239999999998e-06 110.55p 8.2154870000000006e-06 110.5625p 8.7378680000000006e-06 110.575p 9.2769840000000007e-06 110.58749999999999p 9.8286779999999994e-06 110.59999999999999p 1.038876e-05 110.6125p 1.095302e-05 110.625p 1.151692e-05 110.6375p 1.207579e-05 110.65000000000001p 1.2625009999999999e-05 110.66250000000001p 1.316006e-05 110.675p 1.367669e-05 110.6875p 1.417085e-05 110.7p 1.463881e-05
+ 110.71249999999999p 1.5077139999999999e-05 110.72499999999999p 1.548275e-05 110.7375p 1.5852859999999999e-05 110.75p 1.6185080000000001e-05 110.7625p 1.6477339999999998e-05 110.77500000000001p 1.6727930000000002e-05 110.78750000000001p 1.6935519999999999e-05 110.8p 1.7099070000000002e-05 110.8125p 1.7217929999999999e-05 110.825p 1.7291730000000001e-05 110.83750000000001p 1.732044e-05 110.84999999999999p 1.73043e-05 110.8625p 1.7243839999999999e-05 110.875p 1.713983e-05 110.8875p 1.6993290000000001e-05 110.90000000000001p 1.6805439999999999e-05 110.91250000000001p 1.657771e-05 110.925p 1.631167e-05
+ 110.9375p 1.600907e-05 110.95p 1.5671759999999999e-05 110.96250000000001p 1.53017e-05 110.97499999999999p 1.490095e-05 110.9875p 1.44716e-05 111p 1.4015800000000001e-05 111.01249999999999p 1.353573e-05 111.02500000000001p 1.3033560000000001e-05 111.03750000000001p 1.2511459999999999e-05 111.05p 1.197157e-05 111.0625p 1.141599e-05 111.075p 1.0846770000000001e-05 111.08750000000001p 1.0265899999999999e-05 111.09999999999999p 9.6752959999999994e-06 111.1125p 9.0767900000000002e-06 111.125p 8.472133e-06 111.13749999999999p 7.8629829999999993e-06 111.15000000000001p 7.2509009999999997e-06
+ 111.16250000000001p 6.6373529999999999e-06 111.17500000000001p 6.023705e-06 111.1875p 5.4112260000000003e-06 111.2p 4.8010890000000004e-06 111.21250000000001p 4.1943739999999997e-06 111.22499999999999p 3.5920699999999999e-06 111.2375p 2.9950830000000001e-06 111.25p 2.4042389999999998e-06 111.26249999999999p 1.820292e-06 111.27499999999999p 1.2439329999999999e-06 111.28750000000001p 6.7579469999999999e-07 111.30000000000001p 1.164615e-07 111.3125p -4.3352049999999999e-07 111.325p -9.7363530000000003e-07 111.33750000000001p -1.5033869999999999e-06 111.34999999999999p -2.0222910000000001e-06 111.3625p -2.529864e-06 111.375p -3.0256119999999998e-06
+ 111.38749999999999p -3.5090260000000001e-06 111.39999999999999p -3.9795700000000004e-06 111.41250000000001p -4.4366710000000001e-06 111.42500000000001p -4.879714e-06 111.4375p -5.3080349999999997e-06 111.45p -5.7209109999999998e-06 111.46250000000001p -6.1175570000000004e-06 111.47499999999999p -6.497121e-06 111.4875p -6.858682e-06 111.5p -7.2012419999999997e-06 111.51249999999999p -7.5237319999999997e-06 111.52499999999999p -7.8250060000000002e-06 111.53749999999999p -8.1038459999999994e-06 111.55000000000001p -8.3589620000000001e-06 111.5625p -8.5890020000000007e-06 111.575p -8.792549e-06 111.58750000000001p -8.9681350000000005e-06 111.59999999999999p -9.11425e-06
+ 111.6125p -9.2293460000000007e-06 111.625p -9.3118570000000005e-06 111.6375p -9.3602069999999997e-06 111.64999999999999p -9.3728260000000006e-06 111.66249999999999p -9.3481669999999994e-06 111.67500000000001p -9.2847230000000007e-06 111.6875p -9.1810439999999994e-06 111.7p -9.0357590000000003e-06 111.71250000000001p -8.847594e-06 111.72499999999999p -8.6153959999999996e-06 111.7375p -8.3381500000000008e-06 111.75p -8.0150069999999995e-06 111.7625p -7.6453019999999999e-06 111.77499999999999p -7.2285740000000003e-06 111.78749999999999p -6.7645960000000003e-06 111.8p -6.2533879999999998e-06 111.8125p -5.6952409999999998e-06 111.825p -5.0907390000000003e-06
+ 111.83750000000001p -4.4407739999999996e-06 111.84999999999999p -3.7465640000000001e-06 111.8625p -3.0096700000000002e-06 111.875p -2.2320099999999998e-06 111.8875p -1.415866e-06 111.89999999999999p -5.6389820000000005e-07 111.91249999999999p 3.2085010000000001e-07 111.925p 1.234951e-06 111.9375p 2.17459e-06 111.95p 3.1355720000000002e-06 111.96250000000001p 4.1133239999999999e-06 111.97500000000001p 5.1029139999999998e-06 111.9875p 6.0990609999999997e-06 112p 7.0961590000000003e-06 112.0125p 8.088303e-06 112.02499999999999p 9.0693210000000005e-06 112.03749999999999p 1.0032810000000001e-05 112.05p 1.097218e-05
+ 112.0625p 1.188071e-05 112.075p 1.275158e-05 112.08750000000001p 1.3577949999999999e-05 112.10000000000001p 1.4353040000000001e-05 112.1125p 1.507015e-05 112.125p 1.572278e-05 112.1375p 1.6304689999999999e-05 112.14999999999999p 1.6809989999999999e-05 112.16249999999999p 1.7233180000000002e-05 112.175p 1.7569269999999999e-05 112.1875p 1.7813849999999999e-05 112.2p 1.7963150000000001e-05 112.21250000000001p 1.8014119999999999e-05 112.22500000000001p 1.796449e-05 112.2375p 1.7812789999999999e-05 112.25p 1.7558469999999999e-05 112.2625p 1.7201859999999999e-05 112.27499999999999p 1.6744200000000001e-05
+ 112.28749999999999p 1.6187710000000002e-05 112.3p 1.5535510000000001e-05 112.3125p 1.479163e-05 112.325p 1.3961000000000001e-05 112.33750000000001p 1.3049379999999999e-05 112.35000000000001p 1.2063309999999999e-05 112.3625p 1.1010040000000001e-05 112.375p 9.8974730000000008e-06 112.3875p 8.7340440000000001e-06 112.39999999999999p 7.5286539999999996e-06 112.41249999999999p 6.2905610000000004e-06 112.425p 5.0292820000000002e-06 112.4375p 3.754483e-06 112.45p 2.4758789999999999e-06 112.46250000000001p 1.2031280000000001e-06 112.47500000000001p -5.4267800000000002e-08 112.4875p -1.2870619999999999e-06 112.5p -2.4863510000000002e-06
+ 112.5125p -3.643665e-06 112.52499999999999p -4.7510400000000002e-06 112.53749999999999p -5.8010890000000002e-06 112.55p -6.7870630000000002e-06 112.5625p -7.7029060000000001e-06 112.575p -8.5432899999999993e-06 112.58750000000001p -9.303656e-06 112.60000000000001p -9.9802320000000006e-06 112.6125p -1.0570050000000001e-05 112.625p -1.1070949999999999e-05 112.6375p -1.1481580000000001e-05 112.64999999999999p -1.1801380000000001e-05 112.66249999999999p -1.203056e-05 112.675p -1.2170100000000001e-05 112.6875p -1.2221680000000001e-05 112.7p -1.218765e-05 112.71250000000001p -1.2071030000000001e-05 112.72500000000001p -1.18754e-05
+ 112.7375p -1.16049e-05 112.75p -1.126413e-05 112.7625p -1.085815e-05 112.77500000000001p -1.0392379999999999e-05 112.78749999999999p -9.8725359999999992e-06 112.8p -9.3046129999999995e-06 112.8125p -8.6947899999999995e-06 112.82499999999999p -8.0493850000000002e-06 112.83750000000001p -7.3747979999999996e-06 112.85000000000001p -6.6774520000000004e-06 112.8625p -5.9637439999999997e-06 112.875p -5.2399919999999996e-06 112.8875p -4.5123869999999996e-06 112.90000000000001p -3.7869460000000001e-06 112.91249999999999p -3.0694740000000001e-06 112.925p -2.3655239999999999e-06 112.9375p -1.680359e-06 112.94999999999999p -1.0189230000000001e-06
+ 112.96250000000001p -3.8581370000000001e-07 112.97500000000001p 2.147414e-07 112.9875p 7.7890740000000002e-07 113p 1.3032559999999999e-06 113.0125p 1.784782e-06 113.02500000000001p 2.2209050000000001e-06 113.03749999999999p 2.609487e-06 113.05p 2.9488219999999998e-06 113.0625p 3.2376440000000001e-06 113.07499999999999p 3.4751220000000002e-06 113.08749999999999p 3.660849e-06 113.10000000000001p 3.7948359999999998e-06 113.11250000000001p 3.877501e-06 113.125p 3.9096489999999997e-06 113.1375p 3.8924619999999998e-06 113.15000000000001p 3.827478e-06 113.16249999999999p 3.7165680000000001e-06 113.175p 3.5619179999999998e-06
+ 113.1875p 3.3660029999999999e-06 113.19999999999999p 3.131562e-06 113.21249999999999p 2.861574e-06 113.22500000000001p 2.559232e-06 113.23750000000001p 2.227911e-06 113.25p 1.8711439999999999e-06 113.2625p 1.492594e-06 113.27500000000001p 1.0960209999999999e-06 113.28749999999999p 6.8525759999999996e-07 113.3p 2.6417600000000002e-07 113.3125p -1.6333730000000001e-07 113.32499999999999p -5.9341209999999996e-07 113.33749999999999p -1.0222219999999999e-06 113.35000000000001p -1.4460110000000001e-06 113.36250000000001p -1.861122e-06 113.375p -2.2640210000000002e-06 113.3875p -2.6513220000000001e-06 113.40000000000001p -3.019811e-06
+ 113.41249999999999p -3.3664699999999999e-06 113.425p -3.6884920000000001e-06 113.4375p -3.9833069999999996e-06 113.45p -4.2485920000000001e-06 113.46249999999999p -4.4822930000000003e-06 113.47499999999999p -4.6826319999999999e-06 113.48750000000001p -4.8481220000000004e-06 113.5p -4.9775740000000001e-06 113.5125p -5.0701019999999996e-06 113.52500000000001p -5.1251259999999997e-06 113.53749999999999p -5.1423769999999997e-06 113.55p -5.1218900000000002e-06 113.5625p -5.064003e-06 113.575p -4.9693479999999996e-06 113.58749999999999p -4.8388460000000002e-06 113.59999999999999p -4.6736880000000003e-06 113.61250000000001p -4.4753280000000001e-06 113.625p -4.2454640000000001e-06
+ 113.6375p -3.9860170000000003e-06 113.65000000000001p -3.6991170000000001e-06 113.66249999999999p -3.3870770000000001e-06 113.675p -3.052369e-06 113.6875p -2.697606e-06 113.7p -2.3255119999999999e-06 113.71249999999999p -1.9388980000000001e-06 113.72499999999999p -1.5406370000000001e-06 113.7375p -1.1336390000000001e-06 113.75p -7.2082399999999997e-07 113.7625p -3.0509770000000002e-07 113.77500000000001p 1.1067139999999999e-07 113.78750000000001p 5.2367609999999998e-07 113.8p 9.3119179999999998e-07 113.8125p 1.3305969999999999e-06 113.825p 1.719392e-06 113.83749999999999p 2.0952159999999999e-06 113.84999999999999p 2.4558619999999999e-06
+ 113.8625p 2.799291e-06 113.875p 3.1236399999999999e-06 113.8875p 3.4272369999999999e-06 113.90000000000001p 3.7086029999999998e-06 113.91250000000001p 3.9664580000000002e-06 113.925p 4.1997270000000003e-06 113.9375p 4.4075359999999999e-06 113.95p 4.5892169999999999e-06 113.96249999999999p 4.7443009999999999e-06 113.97499999999999p 4.8725170000000002e-06 113.9875p 4.9737829999999999e-06 114p 5.0482030000000001e-06 114.0125p 5.0960540000000002e-06 114.02500000000001p 5.1177810000000001e-06 114.03750000000001p 5.1139850000000003e-06 114.05p 5.0854090000000001e-06 114.0625p 5.0329319999999997e-06 114.075p 4.9575499999999997e-06
+ 114.08749999999999p 4.8603690000000003e-06 114.09999999999999p 4.742589e-06 114.1125p 4.6054890000000001e-06 114.125p 4.4504190000000001e-06 114.1375p 4.2787810000000001e-06 114.15000000000001p 4.0920209999999999e-06 114.16250000000001p 3.8916119999999996e-06 114.175p 3.679043e-06 114.1875p 3.4558079999999998e-06 114.2p 3.2233909999999999e-06 114.21249999999999p 2.983258e-06 114.22499999999999p 2.7368440000000002e-06 114.2375p 2.4855420000000001e-06 114.25p 2.2306969999999998e-06 114.2625p 1.9735930000000001e-06 114.27500000000001p 1.7154440000000001e-06 114.28750000000001p 1.457392e-06 114.3p 1.200493e-06
+ 114.3125p 9.457176e-07 114.325p 6.9393999999999998e-07 114.33749999999999p 4.4593729999999998e-07 114.34999999999999p 2.02385e-07 114.3625p -3.6146019999999998e-08 114.375p -2.691905e-07 114.3875p -4.9638990000000002e-07 114.40000000000001p -7.1749210000000005e-07 114.41250000000001p -9.3235049999999997e-07 114.425p -1.1409219999999999e-06 114.4375p -1.343264e-06 114.45p -1.539531e-06 114.46249999999999p -1.72997e-06 114.47499999999999p -1.9149180000000002e-06 114.4875p -2.0947909999999998e-06 114.5p -2.2700829999999998e-06 114.5125p -2.4413560000000001e-06 114.52500000000001p -2.6092360000000001e-06
+ 114.53750000000001p -2.7744000000000001e-06 114.55p -2.9375740000000002e-06 114.5625p -3.0995219999999999e-06 114.575p -3.261038e-06 114.58750000000001p -3.4229389999999999e-06 114.59999999999999p -3.5860550000000001e-06 114.6125p -3.7512210000000001e-06 114.625p -3.9192709999999997e-06 114.6375p -4.0910299999999999e-06 114.65000000000001p -4.2673029999999997e-06 114.66250000000001p -4.4488709999999997e-06 114.675p -4.6364859999999996e-06 114.6875p -4.8308590000000001e-06 114.7p -5.0326610000000001e-06 114.71250000000001p -5.2425119999999997e-06 114.72499999999999p -5.4609800000000002e-06 114.7375p -5.6885739999999998e-06 114.75p -5.925743e-06
+ 114.76249999999999p -6.1728709999999996e-06 114.77500000000001p -6.430275e-06 114.78750000000001p -6.698205e-06 114.8p -6.9768400000000001e-06 114.8125p -7.2662879999999999e-06 114.825p -7.566587e-06 114.83750000000001p -7.8777060000000006e-06 114.84999999999999p -8.1995429999999993e-06 114.8625p -8.5319280000000003e-06 114.875p -8.8746279999999996e-06 114.88749999999999p -9.2273439999999992e-06 114.90000000000001p -9.5897159999999994e-06 114.91250000000001p -9.9613280000000006e-06 114.92500000000001p -1.034171e-05 114.9375p -1.0730340000000001e-05 114.95p -1.1126640000000001e-05 114.96250000000001p -1.1530019999999999e-05 114.97499999999999p -1.1939809999999999e-05
+ 114.9875p -1.235535e-05 115p -1.277591e-05 115.01249999999999p -1.320076e-05 115.02499999999999p -1.3629140000000001e-05 115.03750000000001p -1.4060289999999999e-05 115.05000000000001p -1.449343e-05 115.0625p -1.492775e-05 115.075p -1.5362479999999999e-05 115.08750000000001p -1.5796819999999999e-05 115.09999999999999p -1.6229990000000001e-05 115.1125p -1.666122e-05 115.125p -1.7089739999999999e-05 115.13749999999999p -1.7514810000000001e-05 115.14999999999999p -1.7935690000000001e-05 115.16250000000001p -1.8351689999999998e-05 115.17500000000001p -1.8762119999999999e-05 115.1875p -1.9166320000000001e-05 115.2p -1.9563660000000001e-05
+ 115.21250000000001p -1.9953550000000001e-05 115.22499999999999p -2.0335399999999998e-05 115.2375p -2.070869e-05 115.25p -2.1072889999999999e-05 115.26249999999999p -2.1427540000000001e-05 115.27499999999999p -2.177218e-05 115.28749999999999p -2.2106399999999999e-05 115.30000000000001p -2.2429820000000001e-05 115.3125p -2.2742070000000002e-05 115.325p -2.3042839999999998e-05 115.33750000000001p -2.3331830000000001e-05 115.34999999999999p -2.3608760000000001e-05 115.3625p -2.387339e-05 115.375p -2.4125500000000001e-05 115.3875p -2.436489e-05 115.39999999999999p -2.4591389999999999e-05 115.41249999999999p -2.4804829999999999e-05 115.42500000000001p -2.5005090000000002e-05
+ 115.4375p -2.5192030000000001e-05 115.45p -2.536556e-05 115.46250000000001p -2.552558e-05 115.47499999999999p -2.5672019999999999e-05 115.4875p -2.5804810000000001e-05 115.5p -2.5923900000000001e-05 115.5125p -2.6029240000000001e-05 115.52499999999999p -2.6120790000000002e-05 115.53749999999999p -2.619855e-05 115.55p -2.6262490000000001e-05 115.5625p -2.6312599999999999e-05 115.575p -2.6348900000000001e-05 115.58750000000001p -2.63714e-05 115.59999999999999p -2.638012e-05 115.6125p -2.6375110000000002e-05 115.625p -2.6356419999999999e-05 115.6375p -2.6324100000000001e-05 115.64999999999999p -2.6278240000000001e-05
+ 115.66249999999999p -2.6218929999999999e-05 115.675p -2.614629e-05 115.6875p -2.6060440000000002e-05 115.7p -2.5961549999999999e-05 115.71250000000001p -2.584978e-05 115.72500000000001p -2.5725339999999999e-05 115.7375p -2.558844e-05 115.75p -2.5439349999999999e-05 115.7625p -2.527832e-05 115.77499999999999p -2.5105680000000001e-05 115.78749999999999p -2.4921749999999999e-05 115.8p -2.4726909999999999e-05 115.8125p -2.4521539999999998e-05 115.825p -2.430609e-05 115.83750000000001p -2.4080999999999999e-05 115.85000000000001p -2.3846760000000001e-05 115.8625p -2.3603899999999999e-05 115.875p -2.3352969999999999e-05
+ 115.8875p -2.3094519999999999e-05 115.89999999999999p -2.282918e-05 115.91249999999999p -2.2557549999999999e-05 115.925p -2.228029e-05 115.9375p -2.1998059999999999e-05 115.95p -2.1711529999999999e-05 115.96250000000001p -2.1421409999999999e-05 115.97500000000001p -2.1128389999999998e-05 115.9875p -2.0833180000000001e-05 116p -2.0536480000000001e-05 116.0125p -2.0239010000000001e-05 116.02499999999999p -1.9941459999999999e-05 116.03749999999999p -1.964453e-05 116.05p -1.934889e-05 116.0625p -1.9055210000000001e-05 116.075p -1.8764109999999999e-05 116.08750000000001p -1.8476200000000001e-05 116.10000000000001p -1.819208e-05
+ 116.1125p -1.7912290000000001e-05 116.125p -1.763733e-05 116.1375p -1.7367689999999999e-05 116.14999999999999p -1.710379e-05 116.16249999999999p -1.684603e-05 116.175p -1.6594730000000001e-05 116.1875p -1.6350200000000001e-05 116.2p -1.6112680000000001e-05 116.21250000000001p -1.588237e-05 116.22500000000001p -1.5659400000000001e-05 116.2375p -1.5443870000000001e-05 116.25p -1.523582e-05 116.2625p -1.503525e-05 116.27499999999999p -1.484211e-05 116.28749999999999p -1.4656279999999999e-05 116.3p -1.447764e-05 116.3125p -1.430598e-05 116.325p -1.4141079999999999e-05
+ 116.33750000000001p -1.398267e-05 116.35000000000001p -1.383046e-05 116.3625p -1.3684110000000001e-05 116.375p -1.354326e-05 116.3875p -1.3407539999999999e-05 116.39999999999999p -1.327654e-05 116.41249999999999p -1.314984e-05 116.42499999999998p -1.302701e-05 116.43749999999999p -1.290762e-05 116.45p -1.279122e-05 116.46250000000001p -1.267737e-05 116.47500000000001p -1.256562e-05 116.48750000000001p -1.245555e-05 116.50000000000001p -1.234673e-05 116.51249999999999p -1.2238759999999999e-05 116.52499999999999p -1.2131239999999999e-05 116.53749999999999p -1.2023810000000001e-05 116.55p -1.1916120000000001e-05
+ 116.5625p -1.180784e-05 116.575p -1.169869e-05 116.58750000000001p -1.158841e-05 116.59999999999999p -1.147675e-05 116.6125p -1.136354e-05 116.625p -1.124859e-05 116.6375p -1.1131800000000001e-05 116.65000000000001p -1.101306e-05 116.66250000000001p -1.089232e-05 116.67499999999998p -1.0769570000000001e-05 116.68749999999999p -1.0644830000000001e-05 116.69999999999999p -1.051815e-05 116.71250000000001p -1.0389619999999999e-05 116.72500000000001p -1.025937e-05 116.73750000000001p -1.012756e-05 116.75000000000001p -9.9943679999999995e-06 116.76249999999999p -9.8600269999999993e-06 116.77499999999999p -9.724784e-06
+ 116.78749999999999p -9.5889140000000006e-06 116.8p -9.4527199999999999e-06 116.8125p -9.3165249999999997e-06 116.825p -9.180675e-06 116.83750000000001p -9.0455339999999997e-06 116.84999999999999p -8.9114799999999996e-06 116.8625p -8.7789089999999995e-06 116.875p -8.6482260000000008e-06 116.8875p -8.5198439999999997e-06 116.90000000000001p -8.3941860000000001e-06 116.91250000000001p -8.2716780000000006e-06 116.92500000000001p -8.1527469999999993e-06 116.93749999999999p -8.0378219999999997e-06 116.94999999999999p -7.9273290000000005e-06 116.96249999999999p -7.8216910000000004e-06 116.97500000000001p -7.7213220000000003e-06 116.98750000000001p -7.6266290000000001e-06 117.00000000000001p -7.5380100000000004e-06
+ 117.01249999999999p -7.4558480000000003e-06 117.02499999999999p -7.3805160000000003e-06 117.03749999999999p -7.3123670000000002e-06 117.05p -7.2517399999999998e-06 117.0625p -7.198954e-06 117.075p -7.1543089999999999e-06 117.08750000000001p -7.1180819999999996e-06 117.09999999999999p -7.0905290000000003e-06 117.1125p -7.0718809999999997e-06 117.125p -7.0623460000000001e-06 117.1375p -7.062105e-06 117.15000000000001p -7.0713130000000001e-06 117.16250000000001p -7.0900970000000002e-06 117.17500000000001p -7.118558e-06 117.18749999999999p -7.1567660000000001e-06 117.19999999999999p -7.2047639999999999e-06 117.21249999999999p -7.2625660000000001e-06 117.22499999999999p -7.330155e-06
+ 117.23750000000001p -7.4074870000000001e-06 117.25000000000001p -7.4944870000000003e-06 117.26250000000002p -7.5910499999999999e-06 117.27499999999999p -7.6970430000000003e-06 117.28749999999999p -7.8123050000000001e-06 117.3p -7.9366449999999993e-06 117.3125p -8.069845e-06 117.325p -8.2116620000000007e-06 117.33750000000001p -8.3618250000000002e-06 117.34999999999999p -8.5200389999999998e-06 117.3625p -8.6859840000000008e-06 117.375p -8.8593190000000003e-06 117.3875p -9.0396810000000006e-06 117.40000000000001p -9.2266879999999998e-06 117.41250000000001p -9.4199400000000005e-06 117.42500000000001p -9.6190209999999997e-06 117.43749999999999p -9.8234979999999996e-06 117.44999999999999p -1.0032930000000001e-05
+ 117.46249999999999p -1.0246860000000001e-05 117.47499999999999p -1.0464830000000001e-05 117.4875p -1.0686369999999999e-05 117.50000000000001p -1.0910999999999999e-05 117.51250000000002p -1.113826e-05 117.52499999999999p -1.1367669999999999e-05 117.53749999999999p -1.159875e-05 117.55p -1.183104e-05 117.5625p -1.2064080000000001e-05 117.575p -1.2297430000000001e-05 117.58750000000001p -1.2530639999999999e-05 117.60000000000001p -1.276329e-05 117.6125p -1.2994960000000001e-05 117.625p -1.3225280000000001e-05 117.6375p -1.3453860000000001e-05 117.65000000000001p -1.3680359999999999e-05 117.66250000000001p -1.390444e-05 117.67500000000001p -1.412581e-05
+ 117.68749999999999p -1.434417e-05 117.69999999999999p -1.4559290000000001e-05 117.71249999999999p -1.4770919999999999e-05 117.72499999999999p -1.497888e-05 117.7375p -1.518298e-05 117.75p -1.5383099999999998e-05 117.76250000000002p -1.5579109999999999e-05 117.77499999999999p -1.577093e-05 117.78749999999999p -1.59585e-05 117.8p -1.6141809999999999e-05 117.8125p -1.632083e-05 117.825p -1.6495609999999999e-05 117.83750000000001p -1.6666189999999999e-05 117.85000000000001p -1.6832649999999999e-05 117.86249999999998p -1.6995089999999999e-05 117.875p -1.7153619999999999e-05 117.8875p -1.7308399999999998e-05 117.90000000000001p -1.7459590000000001e-05
+ 117.91250000000001p -1.760735e-05 117.92500000000001p -1.7751890000000001e-05 117.93750000000001p -1.78934e-05 117.94999999999999p -1.8032120000000001e-05 117.96249999999999p -1.8168260000000001e-05 117.97499999999999p -1.8302059999999999e-05 117.9875p -1.843376e-05 118p -1.85636e-05 118.0125p -1.8691830000000002e-05 118.02499999999999p -1.8818679999999999e-05 118.03749999999999p -1.894439e-05 118.05p -1.9069210000000001e-05 118.0625p -1.9193350000000001e-05 118.075p -1.931703e-05 118.08750000000001p -1.9440459999999999e-05 118.10000000000001p -1.956384e-05 118.11249999999998p -1.968734e-05 118.12499999999999p -1.9811129999999999e-05
+ 118.1375p -1.9935349999999999e-05 118.15000000000001p -2.0060150000000001e-05 118.16250000000001p -2.018562e-05 118.17500000000001p -2.0311869999999999e-05 118.18750000000001p -2.0438959999999999e-05 118.19999999999999p -2.0566950000000001e-05 118.21249999999999p -2.0695870000000001e-05 118.22499999999999p -2.0825720000000001e-05 118.2375p -2.0956490000000001e-05 118.25p -2.108816e-05 118.2625p -2.1220659999999999e-05 118.27500000000002p -2.1353930000000001e-05 118.28749999999999p -2.1487869999999999e-05 118.3p -2.1622369999999999e-05 118.3125p -2.1757299999999999e-05 118.325p -2.1892519999999999e-05 118.33750000000001p -2.202786e-05 118.35000000000001p -2.2163159999999999e-05
+ 118.36249999999998p -2.2298230000000001e-05 118.37499999999999p -2.2432860000000001e-05 118.38749999999999p -2.256687e-05 118.40000000000001p -2.2700030000000002e-05 118.41250000000001p -2.2832119999999999e-05 118.42500000000001p -2.2962939999999999e-05 118.43750000000001p -2.3092249999999999e-05 118.44999999999999p -2.321983e-05 118.46249999999999p -2.3345459999999999e-05 118.47499999999999p -2.3468940000000001e-05 118.4875p -2.3590039999999999e-05 118.5p -2.3708559999999999e-05 118.5125p -2.3824300000000002e-05 118.52500000000001p -2.3937090000000001e-05 118.53749999999999p -2.4046750000000001e-05 118.55p -2.4153110000000002e-05 118.5625p -2.4256030000000002e-05 118.575p -2.4355379999999999e-05
+ 118.58750000000001p -2.4451029999999999e-05 118.60000000000001p -2.4542890000000001e-05 118.61249999999998p -2.463087e-05 118.62499999999999p -2.4714899999999999e-05 118.63749999999999p -2.4794940000000002e-05 118.65000000000001p -2.4870949999999999e-05 118.66250000000001p -2.4942909999999999e-05 118.67500000000001p -2.501083e-05 118.68750000000001p -2.5074730000000001e-05 118.69999999999999p -2.5134650000000002e-05 118.71249999999999p -2.5190639999999998e-05 118.72499999999999p -2.5242759999999999e-05 118.7375p -2.529111e-05 118.75p -2.5335790000000002e-05 118.7625p -2.5376900000000001e-05 118.77500000000001p -2.541457e-05 118.78749999999999p -2.544895e-05 118.8p -2.5480179999999999e-05
+ 118.8125p -2.5508409999999999e-05 118.825p -2.5533820000000001e-05 118.83750000000001p -2.555657e-05 118.85000000000001p -2.5576849999999999e-05 118.86250000000001p -2.559484e-05 118.87499999999999p -2.5610730000000001e-05 118.88749999999999p -2.5624690000000001e-05 118.89999999999999p -2.5636930000000001e-05 118.91250000000001p -2.564762e-05 118.92500000000001p -2.5656959999999999e-05 118.93750000000001p -2.566511e-05 118.94999999999999p -2.5672250000000001e-05 118.96249999999999p -2.5678559999999999e-05 118.97499999999999p -2.5684179999999999e-05 118.9875p -2.5689269999999999e-05 119p -2.5693959999999999e-05 119.0125p -2.569839e-05 119.02500000000001p -2.570265e-05
+ 119.03749999999999p -2.5706849999999999e-05 119.05p -2.571107e-05 119.0625p -2.5715369999999999e-05 119.075p -2.5719810000000001e-05 119.08750000000001p -2.5724419999999999e-05 119.10000000000001p -2.5729200000000001e-05 119.11250000000001p -2.5734159999999999e-05 119.12499999999999p -2.573926e-05 119.13749999999999p -2.5744460000000001e-05 119.14999999999999p -2.5749699999999998e-05 119.16249999999999p -2.5754889999999999e-05 119.17500000000001p -2.5759929999999999e-05 119.18750000000001p -2.576469e-05 119.20000000000002p -2.576905e-05 119.21249999999999p -2.577283e-05 119.22499999999999p -2.577587e-05 119.2375p -2.577796e-05 119.25p -2.5778919999999999e-05
+ 119.2625p -2.5778500000000001e-05 119.27500000000001p -2.5776480000000002e-05 119.28749999999999p -2.5772619999999999e-05 119.3p -2.5766649999999998e-05 119.3125p -2.5758310000000001e-05 119.325p -2.5747329999999999e-05 119.33750000000001p -2.5733420000000001e-05 119.35000000000001p -2.571631e-05 119.36250000000001p -2.5695699999999999e-05 119.37499999999999p -2.5671320000000001e-05 119.38749999999999p -2.5642869999999999e-05 119.39999999999999p -2.5610069999999999e-05 119.41249999999999p -2.557265e-05 119.425p -2.553032e-05 119.43750000000001p -2.5482839999999999e-05 119.45000000000002p -2.5429940000000001e-05 119.46249999999999p -2.5371389999999998e-05 119.47499999999999p -2.5306939999999999e-05
+ 119.4875p -2.523639e-05 119.5p -2.5159530000000001e-05 119.5125p -2.5076190000000002e-05 119.52500000000001p -2.4986209999999999e-05 119.53750000000001p -2.4889430000000001e-05 119.55p -2.4785730000000001e-05 119.5625p -2.4675020000000001e-05 119.575p -2.4557220000000001e-05 119.58750000000001p -2.4432279999999998e-05 119.60000000000001p -2.4300150000000001e-05 119.61250000000001p -2.4160850000000001e-05 119.62499999999999p -2.401438e-05 119.63749999999999p -2.38608e-05 119.64999999999999p -2.3700169999999998e-05 119.66249999999999p -2.3532590000000002e-05 119.675p -2.3358180000000001e-05 119.6875p -2.3177090000000001e-05 119.70000000000002p -2.2989479999999999e-05
+ 119.71249999999999p -2.2795540000000002e-05 119.72499999999999p -2.2595510000000001e-05 119.7375p -2.23896e-05 119.75p -2.21781e-05 119.7625p -2.196126e-05 119.77500000000001p -2.1739400000000001e-05 119.78750000000001p -2.1512840000000001e-05 119.79999999999998p -2.12819e-05 119.8125p -2.1046929999999999e-05 119.825p -2.0808309999999999e-05 119.83750000000001p -2.0566410000000001e-05 119.85000000000001p -2.0321599999999999e-05 119.86250000000001p -2.0074290000000001e-05 119.87500000000001p -1.9824879999999999e-05 119.88749999999999p -1.9573780000000001e-05 119.89999999999999p -1.9321400000000001e-05 119.91249999999999p -1.9068140000000001e-05 119.925p -1.8814429999999999e-05
+ 119.9375p -1.8560670000000001e-05 119.95p -1.8307260000000001e-05 119.96249999999999p -1.805462e-05 119.97499999999999p -1.780312e-05 119.9875p -1.7553160000000001e-05 120p -1.7305090000000001e-05 120.0125p -1.705929e-05 120.02500000000001p -1.6816079999999998e-05 120.03750000000001p -1.6575800000000001e-05 120.04999999999998p -1.633875e-05 120.06249999999999p -1.610521e-05 120.075p -1.5875450000000001e-05 120.08750000000001p -1.5649710000000001e-05 120.10000000000001p -1.5428199999999999e-05 120.11250000000001p -1.521111e-05 120.12500000000001p -1.4998600000000001e-05 120.13749999999999p -1.479081e-05 120.14999999999999p -1.458785e-05
+ 120.16249999999999p -1.4389779999999999e-05 120.175p -1.419666e-05 120.1875p -1.4008490000000001e-05 120.2p -1.382526e-05 120.21250000000001p -1.364693e-05 120.22499999999999p -1.3473409999999999e-05 120.2375p -1.3304590000000001e-05 120.25p -1.314034e-05 120.2625p -1.2980480000000001e-05 120.27500000000001p -1.2824819999999999e-05 120.28750000000001p -1.267314e-05 120.29999999999998p -1.252517e-05 120.31249999999999p -1.238065e-05 120.32499999999999p -1.223926e-05 120.33750000000001p -1.2100699999999999e-05 120.35000000000001p -1.196461e-05 120.36250000000001p -1.183063e-05 120.37500000000001p -1.16984e-05
+ 120.38749999999999p -1.156751e-05 120.39999999999999p -1.1437580000000001e-05 120.41249999999999p -1.130818e-05 120.425p -1.117891e-05 120.4375p -1.104934e-05 120.45p -1.0919060000000001e-05 120.46250000000001p -1.0787660000000001e-05 120.47499999999999p -1.0654710000000001e-05 120.4875p -1.0519829999999999e-05 120.5p -1.038261e-05 120.5125p -1.024268e-05 120.52500000000001p -1.0099679999999999e-05 120.53750000000001p -9.9532559999999997e-06 120.55000000000001p -9.8030920000000008e-06 120.56249999999999p -9.6488860000000001e-06 120.57499999999999p -9.4903639999999997e-06 120.58749999999999p -9.3272779999999994e-06 120.60000000000001p -9.1594109999999992e-06
+ 120.61250000000001p -8.9865749999999996e-06 120.62500000000001p -8.8086159999999994e-06 120.63749999999999p -8.6254110000000006e-06 120.64999999999999p -8.436873e-06 120.66249999999999p -8.2429500000000004e-06 120.675p -8.0436259999999998e-06 120.6875p -7.8389190000000008e-06 120.7p -7.6288849999999997e-06 120.71250000000001p -7.4136130000000002e-06 120.72499999999999p -7.1932309999999998e-06 120.7375p -6.9678969999999999e-06 120.75p -6.7378070000000001e-06 120.7625p -6.5031870000000001e-06 120.77500000000001p -6.2642939999999997e-06 120.78750000000001p -6.0214160000000001e-06 120.80000000000001p -5.7748689999999997e-06 120.81249999999999p -5.5249939999999999e-06 120.82499999999999p -5.2721589999999996e-06
+ 120.83749999999999p -5.0167499999999999e-06 120.85000000000001p -4.7591779999999999e-06 120.86250000000001p -4.4998669999999996e-06 120.87500000000001p -4.23926e-06 120.88749999999999p -3.9778110000000004e-06 120.89999999999999p -3.7159869999999999e-06 120.91249999999999p -3.4542599999999999e-06 120.925p -3.193109e-06 120.9375p -2.9330180000000002e-06 120.95p -2.6744709999999998e-06 120.96250000000001p -2.4179499999999999e-06 120.97499999999999p -2.163933e-06 120.9875p -1.9128959999999998e-06 121p -1.665303e-06 121.0125p -1.421611e-06 121.02500000000001p -1.182265e-06 121.03750000000001p -9.4769889999999998e-07 121.05000000000001p -7.1832939999999999e-07
+ 121.06249999999999p -4.9455900000000003e-07 121.07499999999999p -2.7677330000000002e-07 121.08749999999999p -6.5339739999999998e-08 121.09999999999999p 1.3939289999999999e-07 121.11250000000001p 3.370955e-07 121.12500000000001p 5.2745890000000002e-07 121.13750000000002p 7.1019420000000002e-07 121.14999999999999p 8.8503360000000001e-07 121.16249999999999p 1.05173e-06 121.175p 1.2100559999999999e-06 121.1875p 1.3598070000000001e-06 121.2p 1.500797e-06 121.21250000000001p 1.63286e-06 121.22499999999999p 1.7558490000000001e-06 121.2375p 1.869637e-06 121.25p 1.9741150000000001e-06 121.2625p 2.0691889999999999e-06 121.27500000000001p 2.1547840000000001e-06
+ 121.28750000000001p 2.2308389999999999e-06 121.30000000000001p 2.2973079999999998e-06 121.31249999999999p 2.35416e-06 121.32499999999999p 2.4013729999999999e-06 121.33749999999999p 2.4389399999999999e-06 121.34999999999999p 2.4668639999999999e-06 121.3625p 2.4851569999999998e-06 121.37500000000001p 2.49384e-06 121.38750000000002p 2.4929420000000002e-06 121.39999999999999p 2.4824999999999999e-06 121.41249999999999p 2.4625539999999999e-06 121.425p 2.433153e-06 121.4375p 2.3943500000000002e-06 121.45p 2.3462000000000001e-06 121.46250000000001p 2.2887650000000001e-06 121.47500000000001p 2.222106e-06 121.4875p 2.1462910000000001e-06 121.5p 2.0613870000000001e-06
+ 121.5125p 1.9674660000000001e-06 121.52500000000001p 1.8645999999999999e-06 121.53750000000001p 1.7528650000000001e-06 121.55000000000001p 1.632337e-06 121.56249999999999p 1.503097e-06 121.57499999999999p 1.3652249999999999e-06 121.58749999999999p 1.2188080000000001e-06 121.59999999999999p 1.063934e-06 121.6125p 9.0069429999999998e-07 121.625p 7.2918590000000004e-07 121.63750000000002p 5.4951029999999998e-07 121.64999999999999p 3.6177450000000001e-07 121.66249999999999p 1.660924e-07 121.675p -3.7415279999999998e-08 121.6875p -2.4861930000000001e-07 121.7p -4.6738159999999997e-07 121.71250000000001p -6.9355389999999997e-07 121.72500000000001p -9.2697699999999998e-07
+ 121.73749999999998p -1.1674799999999999e-06 121.75p -1.414877e-06 121.7625p -1.6689720000000001e-06 121.77500000000001p -1.92955e-06 121.78750000000001p -2.196381e-06 121.80000000000001p -2.4692180000000001e-06 121.81250000000001p -2.7477960000000001e-06 121.82499999999999p -3.0318310000000001e-06 121.83749999999999p -3.3210180000000001e-06 121.84999999999999p -3.6150300000000001e-06 121.8625p -3.9135220000000001e-06 121.875p -4.2161220000000004e-06 121.8875p -4.5224379999999999e-06 121.89999999999999p -4.8320520000000002e-06 121.91249999999999p -5.144523e-06 121.925p -5.4593859999999998e-06 121.9375p -5.7761490000000004e-06 121.95p -6.0942970000000004e-06
+ 121.96250000000001p -6.4132919999999999e-06 121.97500000000001p -6.7325670000000003e-06 121.98749999999998p -7.0515350000000001e-06 121.99999999999999p -7.3695850000000004e-06 122.0125p -7.6860829999999993e-06 122.02500000000001p -8.0003750000000005e-06 122.03750000000001p -8.311787e-06 122.05000000000001p -8.6196260000000007e-06 122.06250000000001p -8.9231850000000002e-06 122.07499999999999p -9.2217399999999996e-06 122.08749999999999p -9.5145599999999992e-06 122.09999999999999p -9.8009010000000007e-06 122.1125p -1.008002e-05 122.125p -1.0351160000000001e-05 122.1375p -1.0613570000000001e-05 122.15000000000001p -1.086652e-05 122.16249999999999p -1.1109259999999999e-05 122.175p -1.1341079999999999e-05
+ 122.1875p -1.156127e-05 122.2p -1.1769150000000001e-05 122.21250000000001p -1.196408e-05 122.22500000000001p -1.214542e-05 122.23749999999998p -1.23126e-05 122.24999999999999p -1.246507e-05 122.26249999999999p -1.2602340000000001e-05 122.27500000000001p -1.272397e-05 122.28750000000001p -1.282957e-05 122.30000000000001p -1.2918829999999999e-05 122.31250000000001p -1.299147e-05 122.32499999999999p -1.304731e-05 122.33749999999999p -1.308624e-05 122.34999999999999p -1.310821e-05 122.3625p -1.3113259999999999e-05 122.375p -1.31015e-05 122.3875p -1.307314e-05 122.40000000000001p -1.3028450000000001e-05
+ 122.41249999999999p -1.29678e-05 122.425p -1.2891630000000001e-05 122.4375p -1.2800459999999999e-05 122.45p -1.269489e-05 122.46250000000001p -1.257559e-05 122.47500000000001p -1.244332e-05 122.48750000000001p -1.229888e-05 122.49999999999999p -1.2143150000000001e-05 122.51249999999999p -1.1977050000000001e-05 122.52499999999999p -1.180157e-05 122.53750000000001p -1.161772e-05 122.55000000000001p -1.142657e-05 122.56250000000001p -1.1229179999999999e-05 122.57499999999999p -1.102667e-05 122.58749999999999p -1.0820160000000001e-05 122.59999999999999p -1.061075e-05 122.6125p -1.0399549999999999e-05 122.625p -1.0187679999999999e-05
+ 122.6375p -9.9761900000000004e-06 122.65000000000001p -9.7661370000000008e-06 122.66249999999999p -9.5585250000000001e-06 122.675p -9.3543139999999995e-06 122.6875p -9.1544119999999995e-06 122.7p -8.9596669999999997e-06 122.71250000000001p -8.7708629999999998e-06 122.72500000000001p -8.5887130000000002e-06 122.73750000000001p -8.4138560000000005e-06 122.74999999999999p -8.2468509999999999e-06 122.76249999999999p -8.0881770000000003e-06 122.77499999999999p -7.9382260000000008e-06 122.78749999999999p -7.7973069999999998e-06 122.80000000000001p -7.6656410000000004e-06 122.81250000000001p -7.5433630000000001e-06 122.82500000000002p -7.43052e-06 122.83749999999999p -7.3270780000000004e-06 122.84999999999999p -7.2329179999999999e-06
+ 122.8625p -7.1478439999999999e-06 122.875p -7.0715820000000001e-06 122.8875p -7.0037880000000003e-06 122.90000000000001p -6.94405e-06 122.91249999999999p -6.8918949999999997e-06 122.925p -6.846792e-06 122.9375p -6.8081619999999997e-06 122.95p -6.7753799999999998e-06 122.96250000000001p -6.7477840000000004e-06 122.97500000000001p -6.7246830000000003e-06 122.98750000000001p -6.7053580000000003e-06 122.99999999999999p -6.6890760000000002e-06 123.01249999999999p -6.6750929999999999e-06 123.02499999999999p -6.6626609999999997e-06 123.03749999999999p -6.6510350000000003e-06 123.05p -6.6394819999999996e-06 123.06250000000001p -6.627282e-06 123.07500000000002p -6.6137400000000001e-06
+ 123.08749999999999p -6.5981870000000001e-06 123.09999999999999p -6.5799910000000001e-06 123.1125p -6.5585549999999996e-06 123.125p -6.5333289999999999e-06 123.1375p -6.5038070000000003e-06 123.15000000000001p -6.4695380000000003e-06 123.16250000000001p -6.4301259999999999e-06 123.175p -6.3852310000000001e-06 123.1875p -6.3345759999999996e-06 123.2p -6.2779450000000002e-06 123.21250000000001p -6.2151879999999999e-06 123.22500000000001p -6.1462179999999998e-06 123.23750000000001p -6.0710150000000002e-06 123.24999999999999p -5.9896250000000003e-06 123.26249999999999p -5.9021580000000001e-06 123.27499999999999p -5.8087890000000001e-06 123.28749999999999p -5.7097580000000001e-06 123.3p -5.605362e-06
+ 123.31250000000001p -5.4959610000000004e-06 123.32500000000002p -5.3819689999999997e-06 123.33749999999999p -5.2638549999999999e-06 123.34999999999999p -5.1421359999999996e-06 123.3625p -5.017377e-06 123.375p -4.8901830000000004e-06 123.3875p -4.761199e-06 123.40000000000001p -4.6311020000000001e-06 123.41250000000001p -4.5005950000000002e-06 123.42499999999998p -4.3704069999999997e-06 123.4375p -4.2412829999999997e-06 123.45p -4.1139779999999997e-06 123.46250000000001p -3.9892569999999999e-06 123.47500000000001p -3.8678800000000001e-06 123.48750000000001p -3.7506070000000001e-06 123.49999999999999p -3.6381809999999999e-06 123.51249999999999p -3.531332e-06 123.52499999999999p -3.4307620000000001e-06
+ 123.53749999999999p -3.337147e-06 123.55p -3.2511250000000001e-06 123.5625p -3.1732960000000001e-06 123.57500000000002p -3.1042100000000001e-06 123.58749999999999p -3.0443689999999998e-06 123.59999999999999p -2.9942169999999999e-06 123.6125p -2.954136e-06 123.625p -2.9244450000000001e-06 123.6375p -2.9053919999999999e-06 123.65000000000001p -2.897156e-06 123.66250000000001p -2.8998379999999999e-06 123.67499999999998p -2.9134630000000002e-06 123.6875p -2.9379779999999999e-06 123.7p -2.9732510000000001e-06 123.71250000000001p -3.0190670000000002e-06 123.72500000000001p -3.0751340000000001e-06 123.73750000000001p -3.1410800000000002e-06 123.75000000000001p -3.2164560000000001e-06
+ 123.76249999999999p -3.300737e-06 123.77499999999999p -3.3933269999999999e-06 123.78749999999999p -3.4935620000000001e-06 123.8p -3.6007110000000002e-06 123.8125p -3.713986e-06 123.825p -3.8325439999999997e-06 123.83749999999999p -3.9554929999999997e-06 123.84999999999999p -4.0818980000000002e-06 123.8625p -4.2107920000000002e-06 123.875p -4.3411760000000002e-06 123.8875p -4.4720310000000003e-06 123.90000000000001p -4.6023239999999998e-06 123.91250000000001p -4.7310190000000004e-06 123.92499999999998p -4.8570759999999998e-06 123.93749999999999p -4.9794710000000002e-06 123.95p -5.0971919999999999e-06 123.96250000000001p -5.2092540000000003e-06 123.97500000000001p -5.3147040000000002e-06
+ 123.98750000000001p -5.4126280000000004e-06 124.00000000000001p -5.5021549999999998e-06 124.01249999999999p -5.5824680000000003e-06 124.02499999999999p -5.6528070000000003e-06 124.03749999999999p -5.7124730000000003e-06 124.05p -5.7608370000000004e-06 124.0625p -5.7973369999999999e-06 124.075p -5.821489e-06 124.08750000000001p -5.8328859999999997e-06 124.09999999999999p -5.8311979999999997e-06 124.1125p -5.8161780000000001e-06 124.125p -5.7876600000000003e-06 124.1375p -5.7455609999999997e-06 124.15000000000001p -5.6898769999999999e-06 124.16250000000001p -5.6206860000000003e-06 124.17499999999998p -5.5381429999999997e-06 124.18749999999999p -5.4424800000000003e-06 124.19999999999999p -5.3340019999999997e-06
+ 124.21250000000001p -5.2130830000000003e-06 124.22500000000001p -5.0801639999999999e-06 124.23750000000001p -4.9357479999999997e-06 124.25000000000001p -4.780393e-06 124.26249999999999p -4.614714e-06 124.27499999999999p -4.4393669999999999e-06 124.28749999999999p -4.2550559999999998e-06 124.3p -4.0625160000000001e-06 124.3125p -3.8625179999999999e-06 124.325p -3.655854e-06 124.33750000000001p -3.4433370000000001e-06 124.34999999999999p -3.225796e-06 124.3625p -3.004064e-06 124.375p -2.7789810000000001e-06 124.3875p -2.551383e-06 124.40000000000001p -2.3221000000000002e-06 124.41250000000001p -2.0919490000000001e-06 124.42500000000001p -1.8617309999999999e-06
+ 124.43749999999999p -1.6322269999999999e-06 124.44999999999999p -1.4041930000000001e-06 124.46249999999999p -1.1783570000000001e-06 124.47500000000001p -9.5541520000000007e-07 124.48750000000001p -7.3603170000000003e-07 124.50000000000001p -5.2083269999999999e-07 124.51249999999999p -3.1040589999999999e-07 124.52499999999999p -1.052991e-07 124.53749999999999p 9.398208e-08 124.55p 2.8697430000000002e-07 124.5625p 4.7325799999999999e-07 124.575p 6.5245710000000002e-07 124.58750000000001p 8.2423950000000001e-07 124.59999999999999p 9.8831639999999991e-07 124.6125p 1.1444420000000001e-06 124.625p 1.292413e-06 124.6375p 1.4320659999999999e-06 124.65000000000001p 1.563279e-06
+ 124.66250000000001p 1.685967e-06 124.67500000000001p 1.800081e-06 124.68749999999999p 1.9056090000000001e-06 124.69999999999999p 2.0025689999999999e-06 124.71249999999999p 2.0910119999999999e-06 124.72499999999999p 2.1710169999999999e-06 124.73750000000001p 2.2426879999999998e-06 124.75000000000001p 2.3061549999999999e-06 124.76250000000002p 2.3615690000000002e-06 124.77499999999999p 2.4091010000000002e-06 124.78749999999999p 2.4489380000000002e-06 124.8p 2.4812850000000001e-06 124.8125p 2.5063590000000002e-06 124.825p 2.524386e-06 124.83750000000001p 2.5356030000000002e-06 124.84999999999999p 2.5402560000000001e-06 124.8625p 2.5385919999999999e-06 124.875p 2.5308669999999999e-06
+ 124.8875p 2.5173340000000001e-06 124.90000000000001p 2.498251e-06 124.91250000000001p 2.473873e-06 124.92500000000001p 2.4444549999999999e-06 124.93749999999999p 2.4102490000000001e-06 124.94999999999999p 2.371503e-06 124.96249999999999p 2.3284609999999998e-06 124.97499999999999p 2.2813609999999999e-06 124.9875p 2.2304369999999998e-06 125.00000000000001p 2.175917e-06 125.01250000000002p 2.1180220000000001e-06 125.02499999999999p 2.0569670000000001e-06 125.03749999999999p 1.9929609999999998e-06 125.05p 1.9262049999999998e-06 125.0625p 1.856894e-06 125.075p 1.7852169999999999e-06 125.08750000000001p 1.7113579999999999e-06 125.10000000000001p 1.635492e-06
+ 125.1125p 1.5577890000000001e-06 125.125p 1.4784159999999999e-06 125.1375p 1.397532e-06 125.15000000000001p 1.3152910000000001e-06 125.16250000000001p 1.231845e-06 125.17500000000001p 1.147337e-06 125.18749999999999p 1.061911e-06 125.19999999999999p 9.7570270000000009e-07 125.21249999999999p 8.8884699999999999e-07 125.22499999999999p 8.0147410000000004e-07 125.2375p 7.1371100000000003e-07 125.25p 6.2568130000000003e-07 125.26250000000002p 5.3750549999999998e-07 125.27499999999999p 4.4930090000000002e-07 125.28749999999999p 3.611815e-07 125.3p 2.7325790000000001e-07 125.3125p 1.8563719999999999e-07 125.325p 9.8422839999999996e-08
+ 125.33750000000001p 1.171437e-08 125.35000000000001p -7.4392900000000004e-08 125.36249999999998p -1.5980820000000001e-07 125.375p -2.4444539999999998e-07 125.3875p -3.2822400000000001e-07 125.40000000000001p -4.1106859999999999e-07 125.41250000000001p -4.9291020000000002e-07 125.42500000000001p -5.7368600000000005e-07 125.43750000000001p -6.5334010000000004e-07 125.44999999999999p -7.3182399999999995e-07 125.46249999999999p -8.0909659999999996e-07 125.47499999999999p -8.8512490000000001e-07 125.4875p -9.5988450000000001e-07 125.5p -1.0333590000000001e-06 125.5125p -1.1055419999999999e-06 125.52499999999999p -1.176436e-06 125.53749999999999p -1.2460509999999999e-06 125.55p -1.3144099999999999e-06
+ 125.5625p -1.3815419999999999e-06 125.575p -1.447487e-06 125.58750000000001p -1.512295e-06 125.60000000000001p -1.576023e-06 125.61249999999998p -1.6387399999999999e-06 125.62499999999999p -1.700522e-06 125.6375p -1.7614509999999999e-06 125.65000000000001p -1.821621e-06 125.66250000000001p -1.881129e-06 125.67500000000001p -1.9400820000000002e-06 125.68750000000001p -1.9985890000000001e-06 125.69999999999999p -2.0567679999999999e-06 125.71249999999999p -2.114738e-06 125.72499999999999p -2.1726219999999999e-06 125.7375p -2.2305460000000001e-06 125.75p -2.288637e-06 125.7625p -2.3470210000000001e-06 125.77500000000002p -2.4058260000000002e-06
+ 125.78749999999999p -2.4651750000000001e-06 125.8p -2.5251909999999999e-06 125.8125p -2.58599e-06 125.825p -2.6476860000000001e-06 125.83750000000001p -2.710386e-06 125.85000000000001p -2.7741880000000001e-06 125.86249999999998p -2.8391850000000001e-06 125.87499999999999p -2.9054600000000001e-06 125.88749999999999p -2.9730850000000002e-06 125.90000000000001p -3.0421250000000001e-06 125.91250000000001p -3.11263e-06 125.92500000000001p -3.1846399999999998e-06 125.93750000000001p -3.2581830000000002e-06 125.94999999999999p -3.3332749999999999e-06 125.96249999999999p -3.4099160000000002e-06 125.97499999999999p -3.488096e-06 125.9875p -3.5677889999999999e-06 126p -3.648957e-06
+ 126.0125p -3.731547e-06 126.02500000000001p -3.815496e-06 126.03749999999999p -3.9007230000000002e-06 126.05p -3.9871380000000001e-06 126.0625p -4.0746370000000003e-06 126.075p -4.1631059999999997e-06 126.08750000000001p -4.2524159999999997e-06 126.10000000000001p -4.3424320000000002e-06 126.11249999999998p -4.4330060000000003e-06 126.12499999999999p -4.5239820000000001e-06 126.13749999999999p -4.6151969999999996e-06 126.15000000000001p -4.7064789999999998e-06 126.16250000000001p -4.797651e-06 126.17500000000001p -4.8885309999999997e-06 126.18750000000001p -4.9789309999999997e-06 126.19999999999999p -5.0686619999999997e-06 126.21249999999999p -5.1575320000000002e-06 126.22499999999999p -5.245348e-06
+ 126.2375p -5.3319170000000004e-06 126.25p -5.4170479999999996e-06 126.2625p -5.5005500000000002e-06 126.27500000000001p -5.5822359999999998e-06 126.28749999999999p -5.661925e-06 126.3p -5.739437e-06 126.3125p -5.8146019999999998e-06 126.325p -5.8872540000000004e-06 126.33750000000001p -5.957234e-06 126.35000000000001p -6.0243930000000003e-06 126.36250000000001p -6.0885899999999998e-06 126.37499999999999p -6.1496910000000001e-06 126.38749999999999p -6.2075749999999996e-06 126.39999999999999p -6.2621289999999999e-06 126.41250000000001p -6.3132510000000003e-06 126.42500000000001p -6.3608500000000003e-06 126.43750000000001p -6.4048470000000003e-06 126.44999999999999p -6.4451710000000004e-06
+ 126.46249999999999p -6.4817649999999996e-06 126.47499999999999p -6.5145820000000002e-06 126.4875p -6.5435860000000004e-06 126.5p -6.5687520000000001e-06 126.5125p -6.5900660000000001e-06 126.52500000000001p -6.6075239999999997e-06 126.53749999999999p -6.6211309999999998e-06 126.55p -6.6309049999999998e-06 126.5625p -6.6368690000000001e-06 126.575p -6.639059e-06 126.58750000000001p -6.6375149999999998e-06 126.60000000000001p -6.6322879999999997e-06 126.61250000000001p -6.6234360000000001e-06 126.62499999999999p -6.6110209999999998e-06 126.63749999999999p -6.5951139999999997e-06 126.64999999999999p -6.5757889999999997e-06 126.66249999999999p -6.5531260000000003e-06 126.67500000000001p -6.5272080000000002e-06
+ 126.68750000000001p -6.4981219999999999e-06 126.70000000000002p -6.4659589999999999e-06 126.71249999999999p -6.4308089999999999e-06 126.72499999999999p -6.3927660000000003e-06 126.7375p -6.3519239999999999e-06 126.75p -6.3083759999999998e-06 126.7625p -6.2622160000000004e-06 126.77500000000001p -6.213536e-06 126.78749999999999p -6.1624289999999998e-06 126.8p -6.1089820000000002e-06 126.8125p -6.0532820000000001e-06 126.825p -5.9954140000000002e-06 126.83750000000001p -5.9354580000000003e-06 126.85000000000001p -5.8734889999999997e-06 126.86250000000001p -5.8095820000000002e-06 126.87499999999999p -5.7438050000000003e-06 126.88749999999999p -5.6762220000000001e-06 126.89999999999999p -5.6068920000000003e-06
+ 126.91249999999999p -5.5358709999999996e-06 126.925p -5.4632079999999999e-06 126.93750000000001p -5.3889490000000001e-06 126.95000000000002p -5.3131339999999997e-06 126.96249999999999p -5.235797e-06 126.97499999999999p -5.1569700000000004e-06 126.9875p -5.0766790000000001e-06 127p -4.9949439999999998e-06 127.0125p -4.9117830000000003e-06 127.02500000000001p -4.82721e-06 127.03750000000001p -4.7412319999999996e-06 127.05p -4.6538570000000003e-06 127.0625p -4.565087e-06 127.075p -4.4749199999999998e-06 127.08750000000001p -4.3833549999999996e-06 127.10000000000001p -4.2903869999999999e-06 127.11250000000001p -4.1960089999999998e-06 127.12499999999999p -4.1002129999999999e-06
+ 127.13749999999999p -4.002991e-06 127.14999999999999p -3.9043330000000003e-06 127.16249999999999p -3.8042299999999999e-06 127.175p -3.702673e-06 127.1875p -3.5996549999999998e-06 127.20000000000002p -3.495168e-06 127.21249999999999p -3.3892070000000001e-06 127.22499999999999p -3.2817700000000001e-06 127.2375p -3.172855e-06 127.25p -3.0624640000000002e-06 127.2625p -2.9506019999999998e-06 127.27500000000001p -2.8372769999999999e-06 127.28750000000001p -2.722501e-06 127.29999999999998p -2.6062900000000001e-06 127.3125p -2.4886619999999998e-06 127.325p -2.3696429999999999e-06 127.33750000000001p -2.24926e-06 127.35000000000001p -2.1275450000000001e-06
+ 127.36250000000001p -2.004537e-06 127.37500000000001p -1.880277e-06 127.38749999999999p -1.754812e-06 127.39999999999999p -1.6281929999999999e-06 127.41249999999999p -1.500476e-06 127.425p -1.3717229999999999e-06 127.4375p -1.2419989999999999e-06 127.45p -1.111373e-06 127.46249999999999p -9.7991979999999997e-07 127.47499999999999p -8.4771859999999997e-07 127.4875p -7.1485179999999999e-07 127.5p -5.8140659999999996e-07 127.5125p -4.4747350000000001e-07 127.52500000000001p -3.1314709999999998e-07 127.53750000000001p -1.7852539999999999e-07 127.54999999999998p -4.3709700000000003e-08 127.56249999999999p 9.1195430000000002e-08 127.575p 2.2608250000000001e-07
+ 127.58750000000001p 3.608413e-07 127.60000000000001p 4.9535890000000004e-07 127.61250000000001p 6.2952010000000003e-07 127.62500000000001p 7.6320740000000001e-07 127.63749999999999p 8.963014e-07 127.64999999999999p 1.0286810000000001e-06 127.66249999999999p 1.1602220000000001e-06 127.675p 1.290802e-06 127.6875p 1.420294e-06 127.7p 1.5485709999999999e-06 127.71250000000001p 1.675506e-06 127.72499999999999p 1.800971e-06 127.7375p 1.9248359999999999e-06 127.75p 2.0469729999999999e-06 127.7625p 2.1672519999999999e-06 127.77500000000001p 2.2855430000000001e-06 127.78750000000001p 2.4017170000000001e-06 127.79999999999998p 2.5156469999999999e-06
+ 127.81249999999999p 2.6272020000000001e-06 127.82499999999999p 2.736256e-06 127.83750000000001p 2.8426819999999998e-06 127.85000000000001p 2.9463550000000001e-06 127.86250000000001p 3.0471509999999999e-06 127.87500000000001p 3.144947e-06 127.88749999999999p 3.2396229999999999e-06 127.89999999999999p 3.3310579999999999e-06 127.91249999999999p 3.4191379999999998e-06 127.925p 3.503746e-06 127.9375p 3.5847709999999998e-06 127.95p 3.6621029999999999e-06 127.96250000000001p 3.7356369999999998e-06 127.97499999999999p 3.805267e-06 127.9875p 3.8708939999999999e-06 128p 3.9324200000000004e-06 128.01249999999999p 3.9897530000000001e-06 128.02500000000001p 4.0428009999999999e-06
+ 128.03750000000002p 4.0914789999999998e-06 128.05000000000001p 4.1357059999999998e-06 128.0625p 4.1754010000000001e-06 128.07499999999999p 4.2104929999999998e-06 128.08750000000001p 4.2409119999999998e-06 128.09999999999999p 4.2665919999999997e-06 128.11250000000001p 4.2874730000000003e-06 128.125p 4.3034990000000001e-06 128.13749999999999p 4.3146210000000001e-06 128.15000000000001p 4.3207909999999997e-06 128.16249999999999p 4.3219699999999999e-06 128.17500000000001p 4.3181199999999999e-06 128.1875p 4.3092119999999997e-06 128.20000000000002p 4.2952199999999997e-06 128.21250000000001p 4.276123e-06 128.22499999999999p 4.2519080000000001e-06 128.23749999999998p 4.2225650000000001e-06 128.25p 4.1880899999999999e-06
+ 128.26249999999999p 4.148485e-06 128.27500000000001p 4.1037579999999997e-06 128.28749999999999p 4.0539229999999998e-06 128.30000000000001p 3.9989970000000003e-06 128.3125p 3.9390080000000001e-06 128.32499999999999p 3.8739850000000003e-06 128.33750000000001p 3.8039659999999998e-06 128.34999999999999p 3.728994e-06 128.36250000000001p 3.6491189999999998e-06 128.375p 3.5643969999999998e-06 128.38750000000002p 3.4748900000000001e-06 128.39999999999998p 3.3806669999999998e-06 128.41249999999999p 3.2818020000000001e-06 128.42500000000001p 3.1783780000000002e-06 128.4375p 3.0704829999999998e-06 128.45000000000002p 2.958213e-06 128.46250000000001p 2.8416699999999998e-06 128.47499999999999p 2.7209620000000001e-06
+ 128.48749999999998p 2.5962069999999998e-06 128.5p 2.4675270000000002e-06 128.51249999999999p 2.335051e-06 128.52500000000001p 2.1989179999999999e-06 128.53749999999999p 2.059272e-06 128.55000000000001p 1.916264e-06 128.5625p 1.7700519999999999e-06 128.57499999999999p 1.6208030000000001e-06 128.58750000000001p 1.4686879999999999e-06 128.59999999999999p 1.3138879999999999e-06 128.61250000000001p 1.156589e-06 128.625p 9.9698340000000008e-07 128.63750000000002p 8.3527229999999997e-07 128.64999999999998p 6.7166170000000005e-07 128.66249999999999p 5.0636430000000002e-07 128.67500000000001p 3.3959889999999998e-07 128.6875p 1.715902e-07 128.70000000000002p 2.5685680000000001e-09
+ 128.71250000000001p -1.6723050000000001e-07 128.72499999999999p -3.3756639999999999e-07 128.73749999999998p -5.0819389999999996e-07 128.75p -6.7886350000000002e-07 128.76249999999999p -8.4932200000000004e-07 128.77500000000001p -1.0193130000000001e-06 128.78749999999999p -1.1885759999999999e-06 128.80000000000001p -1.356851e-06 128.8125p -1.523872e-06 128.82499999999999p -1.6893760000000001e-06 128.83750000000001p -1.853097e-06 128.84999999999999p -2.014769e-06 128.86250000000001p -2.174128e-06 128.875p -2.330909e-06 128.88750000000002p -2.4848520000000001e-06 128.89999999999998p -2.635698e-06 128.91249999999999p -2.7831920000000001e-06 128.92499999999998p -2.9270830000000001e-06
+ 128.9375p -3.0671269999999999e-06 128.95000000000002p -3.2030839999999999e-06 128.96250000000001p -3.3347220000000002e-06 128.97500000000002p -3.4618149999999998e-06 128.98749999999998p -3.5841469999999999e-06 129p -3.701512e-06 129.01249999999999p -3.8137119999999999e-06 129.02500000000001p -3.9205619999999996e-06 129.03749999999999p -4.0218880000000001e-06 129.05000000000001p -4.1175269999999997e-06 129.0625p -4.2073329999999998e-06 129.07499999999999p -4.2911700000000001e-06 129.08750000000001p -4.3689200000000003e-06 129.09999999999999p -4.4404779999999999e-06 129.11250000000001p -4.5057550000000004e-06 129.125p -4.56468e-06 129.13750000000002p -4.6171990000000002e-06 129.14999999999998p -4.6632730000000002e-06
+ 129.16249999999999p -4.7028820000000002e-06 129.17499999999998p -4.7360239999999999e-06 129.1875p -4.7627150000000004e-06 129.20000000000002p -4.7829899999999999e-06 129.21250000000001p -4.7968980000000001e-06 129.22500000000002p -4.8045109999999996e-06 129.23749999999998p -4.8059169999999998e-06 129.25p -4.8012179999999999e-06 129.26249999999999p -4.7905379999999999e-06 129.27500000000001p -4.7740149999999997e-06 129.28749999999999p -4.7518010000000002e-06 129.30000000000001p -4.7240669999999999e-06 129.3125p -4.6909950000000001e-06 129.32499999999999p -4.6527810000000003e-06 129.33750000000001p -4.6096340000000004e-06 129.34999999999999p -4.5617730000000004e-06 129.36250000000001p -4.5094289999999997e-06 129.375p -4.4528400000000002e-06
+ 129.38750000000002p -4.3922519999999998e-06 129.39999999999998p -4.3279170000000004e-06 129.41249999999999p -4.2600909999999996e-06 129.42499999999998p -4.1890349999999999e-06 129.4375p -4.1150109999999997e-06 129.44999999999999p -4.0382809999999996e-06 129.46250000000001p -3.9591069999999999e-06 129.47500000000002p -3.8777470000000004e-06 129.48749999999998p -3.7944559999999999e-06 129.5p -3.7094840000000002e-06 129.51249999999999p -3.6230739999999998e-06 129.52500000000001p -3.5354609999999998e-06 129.53749999999999p -3.4468709999999998e-06 129.55000000000001p -3.3575200000000002e-06 129.5625p -3.2676120000000002e-06 129.57499999999999p -3.1773399999999999e-06 129.58750000000001p -3.0868830000000002e-06 129.59999999999999p -2.9964070000000002e-06
+ 129.61250000000001p -2.9060619999999998e-06 129.625p -2.8159859999999998e-06 129.63750000000002p -2.7262989999999998e-06 129.65000000000001p -2.6371059999999999e-06 129.66249999999999p -2.5484980000000002e-06 129.67499999999998p -2.4605500000000001e-06 129.6875p -2.3733199999999999e-06 129.69999999999999p -2.2868540000000001e-06 129.71250000000001p -2.2011789999999998e-06 129.72500000000002p -2.1163130000000001e-06 129.73749999999998p -2.0322569999999999e-06 129.75p -1.9489990000000001e-06 129.76249999999999p -1.8665189999999999e-06 129.77500000000001p -1.784782e-06 129.78749999999999p -1.7037460000000001e-06 129.80000000000001p -1.6233589999999999e-06 129.8125p -1.5435609999999999e-06 129.82499999999999p -1.464287e-06
+ 129.83750000000001p -1.3854670000000001e-06 129.84999999999999p -1.307027e-06 129.86250000000001p -1.2288899999999999e-06 129.875p -1.150981e-06 129.88750000000002p -1.0732219999999999e-06 129.90000000000001p -9.9553940000000003e-07 129.91249999999999p -9.1786130000000005e-07 129.92499999999998p -8.401211e-07 129.9375p -7.6225789999999995e-07 129.94999999999999p -6.8421780000000003e-07 129.96250000000001p -6.0595489999999998e-07 129.97500000000002p -5.2743269999999995e-07 129.98750000000001p -4.4862489999999999e-07 130p -3.6951620000000002e-07 130.01249999999999p -2.901032e-07 130.02500000000001p -2.1039509999999999e-07 130.03749999999999p -1.304143e-07 130.05000000000001p -5.0196890000000001e-08
+ 130.0625p 3.0207190000000001e-08 130.07499999999999p 1.1073380000000001e-07 130.08750000000001p 1.913044e-07 130.09999999999999p 2.7182629999999999e-07 130.11250000000001p 3.5219290000000002e-07 130.125p 4.3228369999999998e-07 130.13750000000002p 5.1196469999999999e-07 130.15000000000001p 5.9108949999999997e-07 130.16249999999999p 6.6949930000000001e-07 130.17499999999998p 7.4702429999999996e-07 130.1875p 8.2348409999999996e-07 130.19999999999999p 8.9868919999999997e-07 130.21250000000001p 9.7244189999999995e-07 130.22499999999999p 1.0445370000000001e-06 130.23750000000001p 1.114765e-06 130.25p 1.1829120000000001e-06 130.26249999999999p 1.2487589999999999e-06 130.27500000000001p 1.312088e-06
+ 130.28749999999999p 1.372683e-06 130.30000000000001p 1.430326e-06 130.3125p 1.4848050000000001e-06 130.32500000000002p 1.535915e-06 130.33749999999998p 1.583456e-06 130.34999999999999p 1.627236e-06 130.36250000000001p 1.6670760000000001e-06 130.375p 1.702807e-06 130.38750000000002p 1.734274e-06 130.40000000000001p 1.761339e-06 130.41249999999999p 1.783878e-06 130.42499999999998p 1.8017860000000001e-06 130.4375p 1.814977e-06 130.44999999999999p 1.823386e-06 130.46250000000001p 1.826968e-06 130.47499999999999p 1.825701e-06 130.48750000000001p 1.8195859999999999e-06 130.5p 1.808647e-06
+ 130.51249999999999p 1.7929320000000001e-06 130.52500000000001p 1.7725129999999999e-06 130.53749999999999p 1.747486e-06 130.55000000000001p 1.717972e-06 130.5625p 1.6841140000000001e-06 130.57500000000002p 1.6460800000000001e-06 130.58749999999998p 1.604061e-06 130.59999999999999p 1.5582679999999999e-06 130.61250000000001p 1.508934e-06 130.625p 1.456311e-06 130.63750000000002p 1.4006720000000001e-06 130.65000000000001p 1.3423039999999999e-06 130.66250000000002p 1.28151e-06 130.67499999999998p 1.2186080000000001e-06 130.6875p 1.153926e-06 130.69999999999999p 1.0878040000000001e-06 130.71250000000001p 1.0205889999999999e-06 130.72499999999999p 9.5263209999999997e-07
+ 130.73750000000001p 8.842905e-07 130.75p 8.1592140000000001e-07 130.76249999999999p 7.4788140000000005e-07 130.77500000000001p 6.8052439999999998e-07 130.78749999999999p 6.1419859999999998e-07 130.80000000000001p 5.4924509999999998e-07 130.8125p 4.8599540000000003e-07 130.82500000000002p 4.2476909999999998e-07 130.83749999999998p 3.658725e-07 130.84999999999999p 3.095962e-07 130.86249999999998p 2.5621380000000001e-07 130.875p 2.059796e-07 130.88750000000002p 1.591276e-07 130.90000000000001p 1.158702e-07 130.91250000000002p 7.6396270000000005e-08 130.92499999999998p 4.0871040000000002e-08 130.9375p 9.4345169999999997e-09 130.94999999999999p -1.779892e-08
+ 130.96250000000001p -4.0741090000000003e-08 130.97499999999999p -5.9330399999999998e-08 130.98750000000001p -7.353196e-08 131p -8.3337559999999994e-08 131.01249999999999p -8.8765549999999998e-08 131.02500000000001p -8.9860349999999998e-08 131.03749999999999p -8.6692040000000006e-08 131.05000000000001p -7.9355549999999995e-08 131.0625p -6.7969860000000001e-08 131.07500000000002p -5.2676989999999999e-08 131.08749999999998p -3.3640859999999998e-08 131.09999999999999p -1.1046e-08 131.11249999999998p 1.4903790000000002e-08 131.125p 4.3986949999999999e-08 131.13750000000002p 7.5965689999999994e-08 131.15000000000001p 1.1058769999999999e-07 131.16250000000002p 1.475878e-07 131.17499999999998p 1.866898e-07
+ 131.1875p 2.276081e-07 131.19999999999999p 2.7004979999999998e-07 131.21250000000001p 3.1371620000000001e-07 131.22499999999999p 3.58305e-07 131.23750000000001p 4.0351170000000002e-07 131.25p 4.490319e-07 131.26249999999999p 4.945627e-07 131.27500000000001p 5.3980430000000004e-07 131.28749999999999p 5.8446210000000003e-07 131.30000000000001p 6.2824800000000003e-07 131.3125p 6.7088179999999995e-07 131.32500000000002p 7.1209309999999999e-07 131.33749999999998p 7.5162210000000005e-07 131.34999999999999p 7.8922120000000003e-07 131.36249999999998p 8.2465619999999995e-07 131.375p 8.577069e-07 131.38749999999999p 8.8816869999999999e-07 131.40000000000001p 9.1585299999999996e-07
+ 131.41250000000002p 9.4058800000000003e-07 131.42499999999998p 9.6221939999999994e-07 131.4375p 9.8061089999999992e-07 131.44999999999999p 9.9564479999999993e-07 131.46250000000001p 1.007222e-06 131.47499999999999p 1.0152620000000001e-06 131.48750000000001p 1.019703e-06 131.5p 1.0205039999999999e-06 131.51249999999999p 1.0176410000000001e-06 131.52500000000001p 1.01111e-06 131.53749999999999p 1.000923e-06 131.55000000000001p 9.8711330000000001e-07 131.5625p 9.6972999999999999e-07 131.57500000000002p 9.488396e-07 131.58750000000001p 9.2452529999999998e-07 131.59999999999999p 8.9688599999999998e-07 131.61249999999998p 8.6603590000000005e-07 131.625p 8.3210370000000002e-07
+ 131.63749999999999p 7.9523159999999999e-07 131.65000000000001p 7.5557479999999998e-07 131.66250000000002p 7.133002e-07 131.67499999999998p 6.6858599999999998e-07 131.6875p 6.2162029999999995e-07 131.69999999999999p 5.7260050000000005e-07 131.71250000000001p 5.2173199999999995e-07 131.72499999999999p 4.6922750000000001e-07 131.73750000000001p 4.1530589999999998e-07 131.75p 3.6019120000000001e-07 131.76249999999999p 3.0411160000000002e-07 131.77500000000001p 2.4729840000000002e-07 131.78749999999999p 1.8998510000000001e-07 131.80000000000001p 1.324063e-07 131.8125p 7.4796759999999994e-08 131.82500000000002p 1.7390259999999999e-08 131.83750000000001p -3.9581109999999998e-08 131.84999999999999p -9.588813e-08
+ 131.86249999999998p -1.5130529999999999e-07 131.875p -2.0561179999999999e-07 131.88749999999999p -2.585925e-07 131.90000000000001p -3.100385e-07 131.91249999999999p -3.5974839999999999e-07 131.92500000000001p -4.0752910000000001e-07 131.9375p -4.531961e-07 131.94999999999999p -4.9657490000000005e-07 131.96250000000001p -5.3750149999999998e-07 131.97499999999999p -5.7582299999999995e-07 131.98750000000001p -6.1139820000000002e-07 132p -6.4409870000000005e-07 132.01249999999999p -6.738089e-07 132.02499999999998p -7.0042680000000002e-07 132.03749999999999p -7.2386450000000004e-07 132.05000000000001p -7.440486e-07 132.0625p -7.6092050000000003e-07 132.07500000000002p -7.7443669999999999e-07
+ 132.08750000000001p -7.8456940000000004e-07 132.09999999999999p -7.9130600000000001e-07 132.11249999999998p -7.946498e-07 132.125p -7.9462e-07 132.13749999999999p -7.912513e-07 132.15000000000001p -7.8459409999999996e-07 132.16249999999999p -7.7471440000000001e-07 132.17500000000001p -7.6169329999999999e-07 132.1875p -7.4562680000000003e-07 132.19999999999999p -7.2662539999999998e-07 132.21250000000001p -7.0481360000000001e-07 132.22499999999999p -6.8032929999999995e-07 132.23750000000001p -6.5332329999999998e-07 132.25p -6.2395839999999995e-07 132.26250000000002p -5.9240870000000004e-07 132.27499999999998p -5.588588e-07 132.28749999999999p -5.2350300000000003e-07 132.30000000000001p -4.8654390000000003e-07
+ 132.3125p -4.4819170000000002e-07 132.32500000000002p -4.0866309999999998e-07 132.33750000000001p -3.6818029999999998e-07 132.34999999999999p -3.2696930000000002e-07 132.36249999999998p -2.852594e-07 132.375p -2.432813e-07 132.38749999999999p -2.0126650000000001e-07 132.40000000000001p -1.5944559999999999e-07 132.41249999999999p -1.180473e-07 132.42500000000001p -7.7296999999999994e-08 132.4375p -3.741564e-08 132.44999999999999p 1.381415e-09 132.46250000000001p 3.888562e-08 132.47499999999999p 7.4896359999999993e-08 132.48750000000001p 1.09222e-07 132.5p 1.4168089999999999e-07 132.51250000000002p 1.7210229999999999e-07 132.52499999999998p 2.0032740000000001e-07
+ 132.53749999999999p 2.2621000000000001e-07 132.55000000000001p 2.4961690000000001e-07 132.5625p 2.7042940000000001e-07 132.57500000000002p 2.8854270000000002e-07 132.58750000000001p 3.0386740000000003e-07 132.60000000000002p 3.16329e-07 132.61249999999998p 3.2586869999999999e-07 132.625p 3.324431e-07 132.63749999999999p 3.3602460000000002e-07 132.65000000000001p 3.366011e-07 132.66249999999999p 3.3417599999999999e-07 132.67500000000001p 3.2876759999999997e-07 132.6875p 3.2040910000000001e-07 132.69999999999999p 3.0914789999999999e-07 132.71250000000001p 2.9504519999999999e-07 132.72499999999999p 2.7817530000000002e-07 132.73750000000001p 2.5862480000000002e-07 132.75p 2.36492e-07
+ 132.76250000000002p 2.1188580000000001e-07 132.77499999999998p 1.8492509999999999e-07 132.78749999999999p 1.557378e-07 132.79999999999998p 1.244595e-07 132.8125p 9.1232649999999995e-08 132.82500000000002p 5.6205719999999997e-08 132.83750000000001p 1.9531789999999998e-08 132.85000000000002p -1.863237e-08 132.86249999999998p -5.8127420000000003e-08 132.875p -9.8792509999999999e-08 132.88749999999999p -1.404664e-07 132.90000000000001p -1.8298839999999999e-07 132.91249999999999p -2.2619939999999999e-07 132.92500000000001p -2.6994310000000002e-07 132.9375p -3.1406650000000002e-07 132.94999999999999p -3.5842110000000002e-07 132.96250000000001p -4.0286359999999998e-07 132.97499999999999p -4.4725679999999998e-07
+ 132.98750000000001p -4.9147019999999998e-07 133p -5.3538049999999998e-07 133.01250000000002p -5.7887240000000002e-07 133.02499999999998p -6.2183909999999998e-07 133.03749999999999p -6.6418249999999997e-07 133.04999999999998p -7.0581359999999997e-07 133.0625p -7.4665279999999997e-07 133.07500000000002p -7.8663019999999998e-07 133.08750000000001p -8.2568530000000003e-07 133.10000000000002p -8.6376759999999999e-07 133.11249999999998p -9.0083579999999997e-07 133.125p -9.3685830000000001e-07 133.13749999999999p -9.7181270000000007e-07 133.15000000000001p -1.005686e-06 133.16249999999999p -1.038472e-06 133.17500000000001p -1.0701759999999999e-06 133.1875p -1.1008070000000001e-06 133.19999999999999p -1.130385e-06
+ 133.21250000000001p -1.1589330000000001e-06 133.22499999999999p -1.186484e-06 133.23750000000001p -1.2130719999999999e-06 133.25p -1.2387399999999999e-06 133.26250000000002p -1.2635310000000001e-06 133.27500000000001p -1.287493e-06 133.28749999999999p -1.310677e-06 133.29999999999998p -1.3331349999999999e-06 133.3125p -1.3549200000000001e-06 133.32499999999999p -1.3760850000000001e-06 133.33750000000001p -1.396682e-06 133.35000000000002p -1.4167619999999999e-06 133.36249999999998p -1.4363750000000001e-06 133.375p -1.455566e-06 133.38749999999999p -1.4743790000000001e-06 133.40000000000001p -1.4928529999999999e-06 133.41249999999999p -1.511022e-06 133.42500000000001p -1.5289150000000001e-06
+ 133.4375p -1.546555e-06 133.44999999999999p -1.563961e-06 133.46250000000001p -1.5811420000000001e-06 133.47499999999999p -1.5981049999999999e-06 133.48750000000001p -1.614845e-06 133.5p -1.6313529999999999e-06 133.51250000000002p -1.647612e-06 133.52500000000001p -1.6635959999999999e-06 133.53749999999999p -1.6792749999999999e-06 133.54999999999998p -1.6946080000000001e-06 133.5625p -1.709549e-06 133.57499999999999p -1.7240430000000001e-06 133.58750000000001p -1.7380299999999999e-06 133.60000000000002p -1.751444e-06 133.61249999999998p -1.76421e-06 133.625p -1.7762499999999999e-06 133.63749999999999p -1.7874780000000001e-06 133.65000000000001p -1.7978059999999999e-06
+ 133.66249999999999p -1.807139e-06 133.67500000000001p -1.8153819999999999e-06 133.6875p -1.8224319999999999e-06 133.69999999999999p -1.828187e-06 133.71250000000001p -1.8325429999999999e-06 133.72499999999999p -1.8353930000000001e-06 133.73750000000001p -1.836632e-06 133.75p -1.8361530000000001e-06 133.76250000000002p -1.8338510000000001e-06 133.77500000000001p -1.829623e-06 133.78749999999999p -1.8233679999999999e-06 133.79999999999998p -1.8149880000000001e-06 133.8125p -1.80439e-06 133.82499999999999p -1.7914830000000001e-06 133.83750000000001p -1.776182e-06 133.84999999999999p -1.75841e-06 133.86250000000001p -1.7380919999999999e-06 133.875p -1.715164e-06
+ 133.88749999999999p -1.689566e-06 133.90000000000001p -1.6612470000000001e-06 133.91249999999999p -1.6301629999999999e-06 133.92500000000001p -1.596282e-06 133.9375p -1.559576e-06 133.94999999999999p -1.520029e-06 133.96249999999998p -1.4776339999999999e-06 133.97499999999999p -1.432392e-06 133.98750000000001p -1.384316e-06 134p -1.3334250000000001e-06 134.01250000000002p -1.279752e-06 134.02500000000001p -1.2233359999999999e-06 134.03749999999999p -1.1642279999999999e-06 134.04999999999998p -1.1024860000000001e-06 134.0625p -1.0381799999999999e-06 134.07499999999999p -9.7138769999999999e-07 134.08750000000001p -9.0219469999999996e-07 134.09999999999999p -8.3069649999999995e-07
+ 134.11250000000001p -7.5699630000000004e-07 134.125p -6.8120490000000003e-07 134.13749999999999p -6.034408e-07 134.15000000000001p -5.2382950000000004e-07 134.16249999999999p -4.4250299999999998e-07 134.17500000000001p -3.5959940000000001e-07 134.1875p -2.752626e-07 134.20000000000002p -1.896413e-07 134.21249999999998p -1.0288909999999999e-07 134.22499999999999p -1.5163580000000001e-08 134.23750000000001p 7.3374050000000002e-08 134.25p 1.625596e-07 134.26250000000002p 2.5222649999999999e-07 134.27500000000001p 3.4220599999999999e-07 134.28749999999999p 4.323281e-07 134.29999999999998p 5.224219e-07 134.3125p 6.1231610000000001e-07 134.32499999999999p 7.0183970000000001e-07
+ 134.33750000000001p 7.9082210000000003e-07 134.34999999999999p 8.7909409999999996e-07 134.36250000000001p 9.6648800000000007e-07 134.375p 1.0528380000000001e-06 134.38749999999999p 1.1379820000000001e-06 134.40000000000001p 1.221759e-06 134.41249999999999p 1.3040130000000001e-06 134.42500000000001p 1.384591e-06 134.4375p 1.463343e-06 134.45000000000002p 1.540127e-06 134.46249999999998p 1.614801e-06 134.47499999999999p 1.687233e-06 134.48749999999998p 1.7572920000000001e-06 134.5p 1.8248559999999999e-06 134.51250000000002p 1.8898070000000001e-06 134.52500000000001p 1.952033e-06 134.53750000000002p 2.0114290000000001e-06 134.54999999999998p 2.067896e-06
+ 134.5625p 2.121343e-06 134.57499999999999p 2.1716830000000001e-06 134.58750000000001p 2.2188369999999998e-06 134.59999999999999p 2.262734e-06 134.61250000000001p 2.3033079999999998e-06 134.625p 2.3405010000000001e-06 134.63749999999999p 2.3742629999999999e-06 134.65000000000001p 2.4045480000000001e-06 134.66249999999999p 2.4313189999999998e-06 134.67500000000001p 2.454546e-06 134.6875p 2.4742049999999999e-06 134.70000000000002p 2.49028e-06 134.71249999999998p 2.5027600000000002e-06 134.72499999999999p 2.5116409999999999e-06 134.73749999999998p 2.5169279999999999e-06 134.75p 2.5186290000000001e-06 134.76250000000002p 2.5167599999999999e-06 134.77500000000001p 2.5113430000000001e-06
+ 134.78750000000002p 2.5024060000000001e-06 134.79999999999998p 2.489983e-06 134.8125p 2.4741129999999999e-06 134.82499999999999p 2.4548409999999998e-06 134.83750000000001p 2.4322179999999998e-06 134.84999999999999p 2.4062989999999999e-06 134.86250000000001p 2.3771449999999998e-06 134.875p 2.3448209999999999e-06 134.88749999999999p 2.309397e-06 134.90000000000001p 2.270947e-06 134.91249999999999p 2.2295509999999999e-06 134.92500000000001p 2.185291e-06 134.9375p 2.1382530000000001e-06 134.95000000000002p 2.0885270000000001e-06 134.96249999999998p 2.0362070000000001e-06 134.97499999999999p 1.9813899999999999e-06 134.98749999999998p 1.9241750000000001e-06 135p 1.864664e-06
+ 135.01250000000002p 1.802963e-06 135.02500000000001p 1.739178e-06 135.03750000000002p 1.673418e-06 135.04999999999998p 1.605795e-06 135.0625p 1.536421e-06 135.07499999999999p 1.46541e-06 135.08750000000001p 1.392877e-06 135.09999999999999p 1.318939e-06 135.11250000000001p 1.243712e-06 135.125p 1.167313e-06 135.13749999999999p 1.0898609999999999e-06 135.15000000000001p 1.011472e-06 135.16249999999999p 9.3226450000000003e-07 135.17500000000001p 8.5235500000000001e-07 135.1875p 7.7186020000000002e-07 135.20000000000002p 6.9089539999999996e-07 135.21250000000001p 6.0957530000000003e-07 135.22499999999999p 5.2801319999999999e-07
+ 135.23749999999998p 4.4632090000000002e-07 135.25p 3.6460859999999998e-07 135.26249999999999p 2.8298470000000001e-07 135.27500000000001p 2.0155560000000001e-07 135.28750000000002p 1.2042539999999999e-07 135.29999999999998p 3.9696070000000003e-08 135.3125p -4.0533189999999997e-08 135.32499999999999p -1.2016569999999999e-07 135.33750000000001p -1.9910759999999999e-07 135.34999999999999p -2.7726809999999998e-07 135.36250000000001p -3.5455919999999998e-07 135.375p -4.308963e-07 135.38749999999999p -5.0619810000000001e-07 135.40000000000001p -5.8038659999999997e-07 135.41249999999999p -6.5338709999999997e-07 135.42500000000001p -7.2512880000000002e-07 135.4375p -7.9554399999999999e-07 135.45000000000002p -8.6456900000000004e-07
+ 135.46250000000001p -9.3214349999999997e-07 135.47499999999999p -9.9821099999999991e-07 135.48749999999998p -1.0627189999999999e-06 135.5p -1.1256169999999999e-06 135.51249999999999p -1.186861e-06 135.52500000000001p -1.2464090000000001e-06 135.53750000000002p -1.3042210000000001e-06 135.55000000000001p -1.360263e-06 135.5625p -1.4145040000000001e-06 135.57499999999999p -1.4669159999999999e-06 135.58750000000001p -1.517474e-06 135.59999999999999p -1.566156e-06 135.61250000000001p -1.612943e-06 135.625p -1.657821e-06 135.63749999999999p -1.7007760000000001e-06 135.65000000000001p -1.741799e-06 135.66249999999999p -1.7808820000000001e-06 135.67500000000001p -1.8180199999999999e-06
+ 135.6875p -1.85321e-06 135.70000000000002p -1.886452e-06 135.71250000000001p -1.9177470000000001e-06 135.72499999999999p -1.9470979999999999e-06 135.73749999999998p -1.974511e-06 135.75p -1.9999900000000001e-06 135.76249999999999p -2.023545e-06 135.77500000000001p -2.0451839999999999e-06 135.78749999999999p -2.0649170000000002e-06 135.80000000000001p -2.0827540000000002e-06 135.8125p -2.0987069999999999e-06 135.82499999999999p -2.112788e-06 135.83750000000001p -2.1250099999999998e-06 135.84999999999999p -2.135386e-06 135.86250000000001p -2.1439279999999998e-06 135.875p -2.1506499999999999e-06 135.88750000000002p -2.1555649999999998e-06 135.89999999999998p -2.1586859999999998e-06
+ 135.91249999999999p -2.1600259999999999e-06 135.92500000000001p -2.159598e-06 135.9375p -2.1574150000000001e-06 135.95000000000002p -2.1534890000000001e-06 135.96250000000001p -2.1478309999999998e-06 135.97499999999999p -2.1404540000000001e-06 135.98749999999998p -2.1313689999999998e-06 136p -2.1205869999999999e-06 136.01249999999999p -2.1081190000000001e-06 136.02500000000001p -2.093976e-06 136.03749999999999p -2.0781679999999998e-06 136.05000000000001p -2.0607060000000002e-06 136.0625p -2.0416000000000001e-06 136.07499999999999p -2.020861e-06 136.08750000000001p -1.9985009999999998e-06 136.09999999999999p -1.9745290000000001e-06 136.11250000000001p -1.9489600000000001e-06 136.125p -1.9218040000000001e-06
+ 136.13750000000002p -1.8930759999999999e-06 136.14999999999998p -1.8627899999999999e-06 136.16249999999999p -1.8309600000000001e-06 136.17500000000001p -1.7976050000000001e-06 136.1875p -1.762743e-06 136.20000000000002p -1.7263920000000001e-06 136.21250000000001p -1.688576e-06 136.22499999999999p -1.6493170000000001e-06 136.23749999999998p -1.608641e-06 136.25p -1.5665759999999999e-06 136.26249999999999p -1.5231540000000001e-06 136.27500000000001p -1.4784060000000001e-06 136.28749999999999p -1.432368e-06 136.30000000000001p -1.38508e-06 136.3125p -1.3365809999999999e-06 136.32499999999999p -1.286918e-06 136.33750000000001p -1.2361370000000001e-06 136.34999999999999p -1.1842889999999999e-06
+ 136.36250000000001p -1.131427e-06 136.375p -1.0776099999999999e-06 136.38750000000002p -1.0228960000000001e-06 136.39999999999998p -9.6734999999999994e-07 136.41249999999999p -9.1103820000000002e-07 136.42499999999998p -8.5403030000000001e-07 136.4375p -7.9639899999999998e-07 136.45000000000002p -7.3822019999999999e-07 136.46250000000001p -6.7957219999999998e-07 136.47500000000002p -6.205363e-07 136.48749999999998p -5.611962e-07 136.5p -5.0163790000000004e-07 136.51249999999999p -4.4194959999999999e-07 136.52500000000001p -3.822212e-07 136.53749999999999p -3.225444e-07 136.55000000000001p -2.6301220000000001e-07 136.5625p -2.037187e-07 136.57499999999999p -1.4475889999999999e-07
+ 136.58750000000001p -8.6228060000000002e-08 136.59999999999999p -2.8221799999999999e-08 136.61250000000001p 2.9164589999999998e-08 136.625p 8.5836329999999994e-08 136.63750000000002p 1.4169949999999999e-07 136.64999999999998p 1.966616e-07 136.66249999999999p 2.506316e-07 136.67499999999998p 3.0352050000000002e-07 136.6875p 3.5524190000000001e-07 136.70000000000002p 4.05712e-07 136.71250000000001p 4.5485020000000001e-07 136.72500000000002p 5.0257950000000003e-07 136.73749999999998p 5.4882650000000003e-07 136.75p 5.9352230000000002e-07 136.76249999999999p 6.3660259999999998e-07 136.77500000000001p 6.7800760000000005e-07 136.78749999999999p 7.1768310000000003e-07 136.80000000000001p 7.5558010000000004e-07
+ 136.8125p 7.9165539999999997e-07 136.82499999999999p 8.2587190000000003e-07 136.83750000000001p 8.5819840000000001e-07 136.84999999999999p 8.886102e-07 136.86250000000001p 9.1708919999999997e-07 136.875p 9.4362369999999995e-07 136.88750000000002p 9.6820889999999999e-07 136.89999999999998p 9.9084689999999999e-07 136.91249999999999p 1.011546e-06 136.92499999999998p 1.0303220000000001e-06 136.9375p 1.0471980000000001e-06 136.94999999999999p 1.062201e-06 136.96250000000001p 1.075367e-06 136.97500000000002p 1.0867389999999999e-06 136.98749999999998p 1.096363e-06 137p 1.104295e-06 137.01249999999999p 1.110591e-06 137.02500000000001p 1.115319e-06
+ 137.03749999999999p 1.118547e-06 137.05000000000001p 1.120349e-06 137.0625p 1.120804e-06 137.07499999999999p 1.1199930000000001e-06 137.08750000000001p 1.118003e-06 137.09999999999999p 1.1149210000000001e-06 137.11250000000001p 1.110838e-06 137.125p 1.1058460000000001e-06 137.13750000000002p 1.100038e-06 137.15000000000001p 1.093508e-06 137.16249999999999p 1.086352e-06 137.17499999999998p 1.0786609999999999e-06 137.1875p 1.0705289999999999e-06 137.19999999999999p 1.062048e-06 137.21250000000001p 1.0533060000000001e-06 137.22500000000002p 1.044389e-06 137.23749999999998p 1.035381e-06 137.25p 1.026362e-06
+ 137.26249999999999p 1.0174059999999999e-06 137.27500000000001p 1.008585e-06 137.28749999999999p 9.9996449999999993e-07 137.30000000000001p 9.9160400000000007e-07 137.3125p 9.8355829999999992e-07 137.32499999999999p 9.7587579999999993e-07 137.33750000000001p 9.6859819999999996e-07 137.34999999999999p 9.6176060000000006e-07 137.36250000000001p 9.5539150000000008e-07 137.375p 9.4951190000000005e-07 137.38750000000002p 9.4413600000000003e-07 137.40000000000001p 9.3927069999999996e-07 137.41249999999999p 9.3491559999999998e-07 137.42499999999998p 9.3106310000000005e-07 137.4375p 9.2769849999999999e-07 137.44999999999999p 9.2480020000000001e-07 137.46250000000001p 9.2233949999999997e-07 137.47500000000002p 9.2028130000000004e-07
+ 137.48750000000001p 9.1858420000000005e-07 137.5p 9.1720049999999999e-07 137.51249999999999p 9.16077e-07 137.52500000000001p 9.1515499999999996e-07 137.53749999999999p 9.1437080000000004e-07 137.55000000000001p 9.136565e-07 137.5625p 9.1293989999999998e-07 137.57499999999999p 9.1214539999999996e-07 137.58749999999998p 9.1119430000000003e-07 137.59999999999999p 9.1000550000000002e-07 137.61250000000001p 9.0849590000000002e-07 137.625p 9.0658100000000004e-07 137.63750000000002p 9.0417570000000001e-07 137.65000000000001p 9.0119460000000005e-07 137.66249999999999p 8.9755240000000001e-07 137.67499999999998p 8.9316499999999996e-07 137.6875p 8.8794969999999998e-07 137.69999999999999p 8.8182579999999996e-07
+ 137.71250000000001p 8.7471529999999998e-07 137.72499999999999p 8.6654310000000005e-07 137.73750000000001p 8.5723789999999997e-07 137.75p 8.4673239999999998e-07 137.76249999999999p 8.3496380000000003e-07 137.77500000000001p 8.2187429999999997e-07 137.78749999999999p 8.0741149999999999e-07 137.80000000000001p 7.9152869999999999e-07 137.8125p 7.7418540000000002e-07 137.82500000000002p 7.5534739999999999e-07 137.83749999999998p 7.3498689999999997e-07 137.84999999999999p 7.1308340000000003e-07 137.86250000000001p 6.8962320000000002e-07 137.875p 6.6459979999999997e-07 137.88750000000002p 6.3801409999999998e-07 137.90000000000001p 6.0987439999999997e-07 137.91249999999999p 5.8019640000000004e-07 137.92499999999998p 5.4900320000000002e-07
+ 137.9375p 5.1632539999999995e-07 137.94999999999999p 4.8220079999999995e-07 137.96250000000001p 4.4667439999999999e-07 137.97499999999999p 4.0979849999999999e-07 137.98750000000001p 3.71632e-07 138p 3.3224060000000002e-07 138.01249999999999p 2.9169640000000002e-07 138.02500000000001p 2.500776e-07 138.03749999999999p 2.0746840000000001e-07 138.05000000000001p 1.6395840000000001e-07 138.0625p 1.1964249999999999e-07 138.07500000000002p 7.4620430000000001e-08 138.08749999999998p 2.8996159999999998e-08 138.09999999999999p -1.7122140000000001e-08 138.11250000000001p -6.3622739999999997e-08 138.125p -1.103908e-07 138.13750000000002p -1.5730869999999999e-07 138.15000000000001p -2.0425660000000001e-07
+ 138.16250000000002p -2.5111300000000001e-07 138.17499999999998p -2.9775480000000002e-07 138.1875p -3.4405839999999999e-07 138.19999999999999p -3.8989969999999999e-07 138.21250000000001p -4.3515480000000002e-07 138.22499999999999p -4.7970040000000001e-07 138.23750000000001p -5.2341439999999997e-07 138.25p -5.6617609999999999e-07 138.26249999999999p -6.0786699999999997e-07 138.27500000000001p -6.4837120000000004e-07 138.28749999999999p -6.8757570000000004e-07 138.30000000000001p -7.2537089999999997e-07 138.3125p -7.6165110000000001e-07 138.32500000000002p -7.9631489999999995e-07 138.33749999999998p -8.2926559999999999e-07 138.34999999999999p -8.6041149999999995e-07 138.36249999999998p -8.8966640000000002e-07 138.375p -9.1694979999999998e-07
+ 138.38750000000002p -9.4218739999999999e-07 138.40000000000001p -9.6531139999999995e-07 138.41250000000002p -9.862606e-07 138.42499999999998p -1.004981e-06 138.4375p -1.0214249999999999e-06 138.44999999999999p -1.0355530000000001e-06 138.46250000000001p -1.047333e-06 138.47499999999999p -1.0567410000000001e-06 138.48750000000001p -1.06376e-06 138.5p -1.0683809999999999e-06 138.51249999999999p -1.0706040000000001e-06 138.52500000000001p -1.0704360000000001e-06 138.53749999999999p -1.0678909999999999e-06 138.55000000000001p -1.0629940000000001e-06 138.5625p -1.055774e-06 138.57500000000002p -1.0462700000000001e-06 138.58749999999998p -1.0345279999999999e-06 138.59999999999999p -1.020601e-06
+ 138.61249999999998p -1.004549e-06 138.625p -9.864399000000001e-07 138.63750000000002p -9.663467999999999e-07 138.65000000000001p -9.443495e-07 138.66250000000002p -9.2053349999999999e-07 138.67499999999998p -8.9498979999999996e-07 138.6875p -8.678146e-07 138.69999999999999p -8.3910829999999998e-07 138.71250000000001p -8.0897579999999999e-07 138.72499999999999p -7.7752520000000001e-07 138.73750000000001p -7.4486820000000001e-07 138.75p -7.1111879999999997e-07 138.76249999999999p -6.7639309999999995e-07 138.77500000000001p -6.4080880000000002e-07 138.78749999999999p -6.0448460000000003e-07 138.80000000000001p -5.6753969999999998e-07 138.8125p -5.3009309999999997e-07 138.82500000000002p -4.9226299999999997e-07
+ 138.83749999999998p -4.5416679999999998e-07 138.84999999999999p -4.1591989999999999e-07 138.86249999999998p -3.7763550000000002e-07 138.875p -3.3942419999999999e-07 138.88749999999999p -3.0139329999999998e-07 138.90000000000001p -2.6364650000000002e-07 138.91250000000002p -2.262835e-07 138.92499999999998p -1.8939959999999999e-07 138.9375p -1.5308490000000001e-07 138.94999999999999p -1.1742499999999999e-07 138.96250000000001p -8.249955e-08 138.97499999999999p -4.8382819999999999e-08 138.98750000000001p -1.514313e-08 139p 1.715722e-08 139.01249999999999p 4.846206e-08 139.02500000000001p 7.8721459999999995e-08 139.03749999999999p 1.078918e-07 139.05000000000001p 1.3593560000000001e-07
+ 139.0625p 1.6282160000000001e-07 139.07500000000002p 1.8852479999999999e-07 139.08750000000001p 2.1302599999999999e-07 139.09999999999999p 2.3631190000000001e-07 139.11249999999998p 2.5837470000000001e-07 139.125p 2.7921200000000003e-07 139.13749999999999p 2.988264e-07 139.15000000000001p 3.1722539999999998e-07 139.16250000000002p 3.344207e-07 139.17499999999998p 3.5042809999999999e-07 139.1875p 3.6526729999999999e-07 139.19999999999999p 3.7896110000000002e-07 139.21250000000001p 3.9153499999999999e-07 139.22499999999999p 4.0301720000000003e-07 139.23750000000001p 4.1343789999999998e-07 139.25p 4.2282859999999999e-07 139.26249999999999p 4.312223e-07 139.27500000000001p 4.386524e-07
+ 139.28749999999999p 4.4515290000000002e-07 139.30000000000001p 4.5075749999999998e-07 139.3125p 4.5549950000000001e-07 139.32500000000002p 4.5941109999999998e-07 139.33750000000001p 4.6252360000000002e-07 139.34999999999999p 4.6486660000000001e-07 139.36249999999998p 4.6646790000000003e-07 139.375p 4.6735299999999999e-07 139.38749999999999p 4.6754540000000002e-07 139.40000000000001p 4.6706549999999999e-07 139.41249999999999p 4.6593160000000002e-07 139.42500000000001p 4.6415850000000001e-07 139.4375p 4.6175849999999999e-07 139.44999999999999p 4.587406e-07 139.46250000000001p 4.5511079999999999e-07 139.47499999999999p 4.5087200000000002e-07 139.48750000000001p 4.4602410000000002e-07 139.5p 4.4056420000000001e-07
+ 139.51249999999999p 4.3448629999999999e-07 139.52499999999998p 4.2778220000000002e-07 139.53749999999999p 4.2044090000000001e-07 139.55000000000001p 4.1244919999999997e-07 139.5625p 4.0379209999999999e-07 139.57500000000002p 3.944526e-07 139.58750000000001p 3.844125e-07 139.59999999999999p 3.7365249999999998e-07 139.61249999999998p 3.6215250000000001e-07 139.625p 3.4989210000000001e-07 139.63749999999999p 3.368507e-07 139.65000000000001p 3.230084e-07 139.66249999999999p 3.0834560000000001e-07 139.67500000000001p 2.928443e-07 139.6875p 2.7648769999999998e-07 139.69999999999999p 2.5926130000000001e-07 139.71250000000001p 2.4115260000000002e-07 139.72499999999999p 2.2215180000000001e-07
+ 139.73750000000001p 2.0225249999999999e-07 139.75p 1.814513e-07 139.76250000000002p 1.597488e-07 139.77499999999998p 1.371494e-07 139.78749999999999p 1.136619e-07 139.80000000000001p 8.9299899999999994e-08 139.8125p 6.4081399999999998e-08 139.82500000000002p 3.8029549999999999e-08 139.83750000000001p 1.117262e-08 139.84999999999999p -1.645589e-08 139.86249999999998p -4.4817169999999998e-08 139.875p -7.3867020000000002e-08 139.88749999999999p -1.035559e-07 139.90000000000001p -1.3382879999999999e-07 139.91249999999999p -1.646257e-07 139.92500000000001p -1.9588130000000001e-07 139.9375p -2.2752510000000001e-07 139.94999999999999p -2.5948209999999999e-07
+ 139.96250000000001p -2.9167270000000002e-07 139.97499999999999p -3.2401279999999999e-07 139.98750000000001p -3.5641450000000002e-07 140p -3.8878610000000002e-07 140.01250000000002p -4.210328e-07 140.02499999999998p -4.530567e-07 140.03749999999999p -4.8475760000000004e-07 140.05000000000001p -5.160333e-07 140.0625p -5.4677990000000004e-07 140.07500000000002p -5.7689270000000003e-07 140.08750000000001p -6.0626629999999996e-07 140.10000000000002p -6.3479530000000004e-07 140.11249999999998p -6.6237479999999996e-07 140.125p -6.8890109999999995e-07 140.13749999999999p -7.1427199999999995e-07 140.15000000000001p -7.3838729999999998e-07 140.16249999999999p -7.6114969999999998e-07 140.17500000000001p -7.8246469999999998e-07
+ 140.1875p -8.0224180000000003e-07 140.19999999999999p -8.2039449999999997e-07 140.21250000000001p -8.3684100000000005e-07 140.22499999999999p -8.5150429999999995e-07 140.23750000000001p -8.6431340000000004e-07 140.25p -8.7520269999999995e-07 140.26250000000002p -8.8411299999999997e-07 140.27499999999998p -8.9099189999999997e-07 140.28749999999999p -8.9579360000000004e-07 140.29999999999998p -8.9847950000000002e-07 140.3125p -8.9901849999999997e-07 140.32500000000002p -8.9738670000000001e-07 140.33750000000001p -8.935683e-07 140.35000000000002p -8.8755489999999996e-07 140.36249999999998p -8.7934610000000004e-07 140.375p -8.689494e-07 140.38749999999999p -8.563799e-07 140.40000000000001p -8.4166069999999998e-07
+ 140.41249999999999p -8.2482230000000003e-07 140.42500000000001p -8.0590279999999998e-07 140.4375p -7.8494759999999997e-07 140.44999999999999p -7.6200910000000005e-07 140.46250000000001p -7.371467e-07 140.47499999999999p -7.1042599999999999e-07 140.48750000000001p -6.8191899999999998e-07 140.5p -6.5170370000000002e-07 140.51250000000002p -6.1986330000000005e-07 140.52499999999998p -5.8648609999999999e-07 140.53749999999999p -5.5166509999999998e-07 140.54999999999998p -5.1549759999999995e-07 140.5625p -4.7808459999999996e-07 140.57500000000002p -4.395303e-07 140.58750000000001p -3.9994169999999999e-07 140.60000000000002p -3.5942820000000002e-07 140.61249999999998p -3.1810119999999998e-07 140.625p -2.7607309999999998e-07
+ 140.63749999999999p -2.3345739999999999e-07 140.65000000000001p -1.9036809999999999e-07 140.66249999999999p -1.469189e-07 140.67500000000001p -1.032231e-07 140.6875p -5.9393020000000001e-08 140.69999999999999p -1.5539500000000002e-08 140.71250000000001p 2.8228349999999999e-08 140.72499999999999p 7.1803659999999996e-08 140.73750000000001p 1.150821e-07 140.75p 1.5796250000000001e-07 140.76250000000002p 2.0034659999999999e-07 140.77500000000001p 2.4213989999999998e-07 140.78749999999999p 2.8325170000000002e-07 140.79999999999998p 3.2359559999999999e-07 140.8125p 3.6308910000000002e-07 140.82499999999999p 4.0165450000000002e-07 140.83750000000001p 4.3921880000000003e-07 140.85000000000002p 4.7571350000000001e-07
+ 140.86249999999998p 5.1107539999999998e-07 140.875p 5.4524610000000003e-07 140.88749999999999p 5.7817230000000003e-07 140.90000000000001p 6.098057e-07 140.91249999999999p 6.4010319999999998e-07 140.92500000000001p 6.6902670000000005e-07 140.9375p 6.9654320000000003e-07 140.94999999999999p 7.2262459999999995e-07 140.96250000000001p 7.4724779999999998e-07 140.97499999999999p 7.7039409999999995e-07 140.98750000000001p 7.9204989999999996e-07 141p 8.122058e-07 141.01250000000002p 8.3085679999999995e-07 141.02500000000001p 8.4800200000000003e-07 141.03749999999999p 8.6364470000000003e-07 141.04999999999998p 8.7779170000000005e-07 141.0625p 8.9045349999999997e-07 141.07499999999999p 9.0164400000000002e-07
+ 141.08750000000001p 9.1138020000000004e-07 141.10000000000002p 9.1968190000000005e-07 141.11250000000001p 9.2657169999999999e-07 141.125p 9.320748e-07 141.13749999999999p 9.3621830000000003e-07 141.15000000000001p 9.3903159999999999e-07 141.16249999999999p 9.4054570000000001e-07 141.17500000000001p 9.4079310000000002e-07 141.1875p 9.3980799999999999e-07 141.19999999999999p 9.3762519999999996e-07 141.21250000000001p 9.3428069999999997e-07 141.22499999999999p 9.2981129999999999e-07 141.23750000000001p 9.2425399999999999e-07 141.25p 9.1764650000000002e-07 141.26250000000002p 9.1002629999999998e-07 141.27500000000001p 9.014313e-07 141.28749999999999p 8.9189870000000003e-07 141.29999999999998p 8.8146599999999996e-07
+ 141.3125p 8.7016970000000004e-07 141.32499999999999p 8.5804619999999996e-07 141.33750000000001p 8.4513090000000003e-07 141.34999999999999p 8.3145859999999996e-07 141.36250000000001p 8.1706309999999995e-07 141.375p 8.0197739999999998e-07 141.38749999999999p 7.8623340000000002e-07 141.40000000000001p 7.6986200000000004e-07 141.41249999999999p 7.528929e-07 141.42500000000001p 7.3535460000000004e-07 141.4375p 7.1727450000000003e-07 141.44999999999999p 6.9867889999999999e-07 141.46249999999998p 6.7959279999999995e-07 141.47499999999999p 6.6003990000000003e-07 141.48750000000001p 6.4004280000000005e-07 141.5p 6.1962299999999996e-07 141.51250000000002p 5.9880080000000003e-07 141.52500000000001p 5.7759540000000003e-07
+ 141.53749999999999p 5.5602469999999997e-07 141.54999999999998p 5.3410599999999995e-07 141.5625p 5.1185529999999998e-07 141.57499999999999p 4.8928769999999998e-07 141.58750000000001p 4.6641769999999999e-07 141.59999999999999p 4.432588e-07 141.61250000000001p 4.1982369999999998e-07 141.625p 3.9612459999999999e-07 141.63749999999999p 3.7217329999999998e-07 141.65000000000001p 3.4798070000000002e-07 141.66249999999999p 3.235576e-07 141.67500000000001p 2.9891449999999999e-07 141.6875p 2.740614e-07 141.70000000000002p 2.4900830000000001e-07 141.71249999999998p 2.237653e-07 141.72499999999999p 1.983422e-07 141.73750000000001p 1.7274900000000001e-07 141.75p 1.4699590000000001e-07
+ 141.76250000000002p 1.2109340000000001e-07 141.77500000000001p 9.5052250000000003e-08 141.78749999999999p 6.8883560000000002e-08 141.79999999999998p 4.259899e-08 141.8125p 1.6210679999999999e-08 141.82499999999999p -1.0268610000000001e-08 141.83750000000001p -3.6825500000000001e-08 141.84999999999999p -6.3445889999999996e-08 141.86250000000001p -9.0114919999999998e-08 141.875p -1.1681700000000001e-07 141.88749999999999p -1.435356e-07 141.90000000000001p -1.702534e-07 141.91249999999999p -1.969524e-07 141.92500000000001p -2.2361319999999999e-07 141.9375p -2.5021610000000001e-07 141.95000000000002p -2.7674010000000002e-07 141.96249999999998p -3.0316340000000002e-07 141.97499999999999p -3.2946339999999999e-07
+ 141.98749999999998p -3.5561640000000002e-07 142p -3.8159820000000001e-07 142.01250000000002p -4.0738339999999998e-07 142.02500000000001p -4.3294610000000001e-07 142.03750000000002p -4.5825960000000001e-07 142.04999999999998p -4.8329660000000005e-07 142.0625p -5.0802889999999996e-07 142.07499999999999p -5.3242819999999999e-07 142.08750000000001p -5.564653e-07 142.09999999999999p -5.8011079999999996e-07 142.11250000000001p -6.0333489999999998e-07 142.125p -6.2610780000000005e-07 142.13749999999999p -6.4839930000000001e-07 142.15000000000001p -6.7017909999999995e-07 142.16249999999999p -6.9141730000000003e-07 142.17500000000001p -7.1208380000000003e-07 142.1875p -7.3214889999999998e-07 142.20000000000002p -7.5158330000000002e-07
+ 142.21249999999998p -7.7035819999999995e-07 142.22499999999999p -7.8844509999999996e-07 142.23749999999998p -8.0581659999999995e-07 142.25p -8.2244570000000003e-07 142.26250000000002p -8.3830649999999995e-07 142.27500000000001p -8.5337399999999998e-07 142.28750000000002p -8.676245e-07 142.29999999999998p -8.8103520000000001e-07 142.3125p -8.9358480000000003e-07 142.32499999999999p -9.0525330000000004e-07 142.33750000000001p -9.1602210000000001e-07 142.34999999999999p -9.2587420000000001e-07 142.36250000000001p -9.3479419999999996e-07 142.375p -9.4276849999999998e-07 142.38749999999999p -9.49785e-07 142.40000000000001p -9.5583359999999993e-07 142.41249999999999p -9.6090599999999994e-07 142.42500000000001p -9.6499580000000009e-07
+ 142.4375p -9.6809840000000001e-07 142.45000000000002p -9.7021129999999995e-07 142.46249999999998p -9.7133379999999992e-07 142.47499999999999p -9.714672999999999e-07 142.48749999999998p -9.7061519999999994e-07 142.5p -9.6878280000000002e-07 142.51250000000002p -9.6597720000000003e-07 142.52500000000001p -9.6220759999999991e-07 142.53750000000002p -9.5748520000000004e-07 142.54999999999998p -9.5182270000000001e-07 142.5625p -9.4523490000000004e-07 142.57499999999999p -9.3773820000000001e-07 142.58750000000001p -9.2935079999999998e-07 142.59999999999999p -9.2009240000000005e-07 142.61250000000001p -9.0998420000000004e-07 142.625p -8.9904910000000001e-07 142.63749999999999p -8.8731109999999999e-07 142.65000000000001p -8.7479570000000004e-07
+ 142.66249999999999p -8.6152930000000001e-07 142.67500000000001p -8.4753969999999995e-07 142.6875p -8.328554e-07 142.70000000000002p -8.1750599999999996e-07 142.71250000000001p -8.0152170000000002e-07 142.72499999999999p -7.8493329999999998e-07 142.73749999999998p -7.6777240000000002e-07 142.75p -7.5007049999999995e-07 142.76249999999999p -7.3185999999999999e-07 142.77500000000001p -7.13173e-07 142.78750000000002p -6.9404179999999995e-07 142.79999999999998p -6.7449870000000001e-07 142.8125p -6.5457569999999999e-07 142.82499999999999p -6.3430479999999995e-07 142.83750000000001p -6.1371710000000003e-07 142.84999999999999p -5.9284369999999998e-07 142.86250000000001p -5.7171470000000003e-07 142.875p -5.5035980000000003e-07
+ 142.88749999999999p -5.2880759999999996e-07 142.90000000000001p -5.070862e-07 142.91249999999999p -4.8522219999999999e-07 142.92500000000001p -4.6324169999999998e-07 142.9375p -4.4116929999999997e-07 142.95000000000002p -4.1902839999999998e-07 142.96250000000001p -3.9684149999999999e-07 142.97499999999999p -3.746295e-07 142.98749999999998p -3.5241189999999997e-07 143p -3.302072e-07 143.01249999999999p -3.0803199999999999e-07 143.02500000000001p -2.859019e-07 143.03750000000002p -2.6383089999999998e-07 143.05000000000001p -2.4183149999999998e-07 143.0625p -2.1991480000000001e-07 143.07499999999999p -1.980906e-07 143.08750000000001p -1.7636700000000001e-07 143.09999999999999p -1.5475119999999999e-07
+ 143.11250000000001p -1.3324860000000001e-07 143.125p -1.1186360000000001e-07 143.13749999999999p -9.0599230000000003e-08 143.15000000000001p -6.9457469999999995e-08 143.16249999999999p -4.843908e-08 143.17500000000001p -2.754386e-08 143.1875p -6.7706289999999999e-09 143.20000000000002p 1.388263e-08 143.21250000000001p 3.4418720000000002e-08 143.22499999999999p 5.48411e-08 143.23749999999998p 7.5153790000000005e-08 143.25p 9.5361270000000003e-08 143.26249999999999p 1.1546839999999999e-07 143.27500000000001p 1.354802e-07 143.28749999999999p 1.5540179999999999e-07 143.30000000000001p 1.7523850000000001e-07 143.3125p 1.9499530000000001e-07 143.32499999999999p 2.1467700000000001e-07
+ 143.33750000000001p 2.3428800000000001e-07 143.34999999999999p 2.5383250000000001e-07 143.36250000000001p 2.7331369999999998e-07 143.375p 2.9273429999999998e-07 143.38750000000002p 3.1209619999999998e-07 143.39999999999998p 3.3140049999999998e-07 143.41249999999999p 3.50647e-07 143.42500000000001p 3.6983449999999999e-07 143.4375p 3.8896070000000001e-07 143.45000000000002p 4.0802200000000003e-07 143.46250000000001p 4.2701330000000002e-07 143.47499999999999p 4.4592820000000001e-07 143.48749999999998p 4.6475869999999998e-07 143.5p 4.8349540000000005e-07 143.51249999999999p 5.0212729999999996e-07 143.52500000000001p 5.2064159999999996e-07 143.53749999999999p 5.3902419999999995e-07 143.55000000000001p 5.5725910000000002e-07
+ 143.5625p 5.7532879999999999e-07 143.57499999999999p 5.932141e-07 143.58750000000001p 6.1089410000000004e-07 143.59999999999999p 6.2834669999999998e-07 143.61250000000001p 6.4554790000000001e-07 143.625p 6.6247230000000001e-07 143.63750000000002p 6.7909330000000003e-07 143.64999999999998p 6.9538260000000003e-07 143.66249999999999p 7.1131099999999996e-07 143.67500000000001p 7.2684789999999998e-07 143.6875p 7.4196179999999997e-07 143.70000000000002p 7.5662019999999999e-07 143.71250000000001p 7.7078980000000005e-07 143.72500000000002p 7.8443650000000001e-07 143.73749999999998p 7.975256e-07 143.75p 8.1002229999999998e-07 143.76249999999999p 8.2189119999999997e-07 143.77500000000001p 8.3309679999999995e-07
+ 143.78749999999999p 8.4360370000000004e-07 143.80000000000001p 8.5337670000000003e-07 143.8125p 8.6238080000000001e-07 143.82499999999999p 8.7058149999999999e-07 143.83750000000001p 8.7794510000000001e-07 143.84999999999999p 8.844386e-07 143.86250000000001p 8.9003000000000004e-07 143.875p 8.9468819999999996e-07 143.88750000000002p 8.9838380000000005e-07 143.89999999999998p 9.0108829999999995e-07 143.91249999999999p 9.0277519999999999e-07 143.92499999999998p 9.0341950000000001e-07 143.9375p 9.0299800000000002e-07 143.95000000000002p 9.0148960000000004e-07 143.96250000000001p 8.9887500000000003e-07 143.97500000000002p 8.9513740000000005e-07 143.98749999999998p 8.9026210000000003e-07 144p 8.8423680000000002e-07
+ 144.01249999999999p 8.7705190000000005e-07 144.02500000000001p 8.686999e-07 144.03749999999999p 8.5917629999999997e-07 144.05000000000001p 8.484791e-07 144.0625p 8.3660910000000004e-07 144.07499999999999p 8.2356970000000003e-07 144.08750000000001p 8.093673e-07 144.09999999999999p 7.9401089999999998e-07 144.11250000000001p 7.7751230000000001e-07 144.125p 7.5988640000000003e-07 144.13750000000002p 7.4115039999999996e-07 144.14999999999998p 7.2132459999999996e-07 144.16249999999999p 7.0043200000000003e-07 144.17499999999998p 6.7849810000000004e-07 144.1875p 6.5555120000000003e-07 144.20000000000002p 6.3162199999999999e-07 144.21250000000001p 6.0674389999999995e-07 144.22500000000002p 5.8095260000000003e-07
+ 144.23749999999998p 5.5428599999999996e-07 144.25p 5.2678449999999997e-07 144.26249999999999p 4.9849050000000003e-07 144.27500000000001p 4.6944839999999998e-07 144.28749999999999p 4.3970460000000001e-07 144.30000000000001p 4.0930720000000001e-07 144.3125p 3.78306e-07 144.32499999999999p 3.4675250000000002e-07 144.33750000000001p 3.1469960000000001e-07 144.34999999999999p 2.8220109999999999e-07 144.36250000000001p 2.4931260000000001e-07 144.375p 2.1609009999999999e-07 144.38750000000002p 1.8259080000000001e-07 144.39999999999998p 1.4887259999999999e-07 144.41249999999999p 1.14994e-07 144.42499999999998p 8.1013640000000004e-08 144.4375p 4.6990849999999999e-08 144.44999999999999p 1.298487e-08
+ 144.46250000000001p -2.094502e-08 144.47500000000002p -5.4739680000000003e-08 144.48749999999998p -8.8340269999999996e-08 144.5p -1.2168839999999999e-07 144.51249999999999p -1.5472619999999999e-07 144.52500000000001p -1.873966e-07 144.53749999999999p -2.196434e-07 144.55000000000001p -2.5141120000000001e-07 144.5625p -2.8264590000000001e-07 144.57499999999999p -3.1329459999999998e-07 144.58750000000001p -3.4330569999999999e-07 144.59999999999999p -3.7262909999999999e-07 144.61250000000001p -4.0121640000000001e-07 144.625p -4.290209e-07 144.63750000000002p -4.559974e-07 144.65000000000001p -4.8210310000000003e-07 144.66249999999999p -5.0729680000000004e-07 144.67499999999998p -5.3153950000000005e-07
+ 144.6875p -5.5479459999999996e-07 144.69999999999999p -5.7702749999999996e-07 144.71250000000001p -5.9820589999999996e-07 144.72500000000002p -6.1830019999999996e-07 144.73749999999998p -6.3728290000000004e-07 144.75p -6.5512909999999998e-07 144.76249999999999p -6.7181660000000004e-07 144.77500000000001p -6.8732559999999997e-07 144.78749999999999p -7.01639e-07 144.80000000000001p -7.1474219999999999e-07 144.8125p -7.2662349999999997e-07 144.82499999999999p -7.3727339999999998e-07 144.83750000000001p -7.4668560000000005e-07 144.84999999999999p -7.5485609999999996e-07 144.86250000000001p -7.6178350000000003e-07 144.875p -7.6746909999999999e-07 144.88750000000002p -7.7191669999999999e-07 144.90000000000001p -7.7513270000000003e-07
+ 144.91249999999999p -7.7712600000000002e-07 144.92499999999998p -7.7790769999999998e-07 144.9375p -7.7749150000000005e-07 144.94999999999999p -7.7589310000000002e-07 144.96250000000001p -7.7313070000000004e-07 144.97500000000002p -7.6922450000000002e-07 144.98750000000001p -7.6419670000000002e-07 145p -7.5807140000000001e-07 145.01249999999999p -7.5087459999999996e-07 145.02500000000001p -7.4263410000000002e-07 145.03749999999999p -7.3337910000000004e-07 145.05000000000001p -7.2314060000000001e-07 145.0625p -7.1195070000000002e-07 145.07499999999999p -6.9984299999999998e-07 145.08749999999998p -6.8685210000000003e-07 145.09999999999999p -6.7301369999999999e-07 145.11250000000001p -6.5836449999999999e-07 145.125p -6.4294160000000005e-07
+ 145.13750000000002p -6.2678329999999996e-07 145.15000000000001p -6.0992810000000005e-07 145.16249999999999p -5.9241500000000003e-07 145.17499999999998p -5.7428319999999999e-07 145.1875p -5.5557230000000002e-07 145.19999999999999p -5.3632189999999998e-07 145.21250000000001p -5.1657150000000001e-07 145.22499999999999p -4.9636049999999999e-07 145.23750000000001p -4.7572820000000002e-07 145.25p -4.5471350000000002e-07 145.26249999999999p -4.3335489999999999e-07 145.27500000000001p -4.1169050000000002e-07 145.28749999999999p -3.8975779999999998e-07 145.30000000000001p -3.6759379999999999e-07 145.3125p -3.4523469999999998e-07 145.32500000000002p -3.227162e-07 145.33749999999998p -3.0007319999999997e-07 145.34999999999999p -2.7733979999999998e-07
+ 145.36250000000001p -2.5454930000000001e-07 145.375p -2.3173430000000001e-07 145.38750000000002p -2.0892649999999999e-07 145.40000000000001p -1.8615680000000001e-07 145.41249999999999p -1.6345530000000001e-07 145.42499999999998p -1.4085139999999999e-07 145.4375p -1.183736e-07 145.44999999999999p -9.6049549999999999e-08 145.46250000000001p -7.3906420000000002e-08 145.47499999999999p -5.1970520000000002e-08 145.48750000000001p -3.0267500000000003e-08 145.5p -8.8224070000000002e-09 145.51249999999999p 1.2340319999999999e-08 145.52500000000001p 3.3196799999999999e-08 145.53749999999999p 5.3723660000000003e-08 145.55000000000001p 7.3897989999999995e-08 145.5625p 9.3697330000000001e-08 145.57500000000002p 1.1309960000000001e-07
+ 145.58749999999998p 1.320831e-07 145.59999999999999p 1.5062640000000001e-07 145.61250000000001p 1.687084e-07 145.625p 1.8630830000000001e-07 145.63750000000002p 2.034055e-07 145.65000000000001p 2.199795e-07 145.66250000000002p 2.3601030000000001e-07 145.67499999999998p 2.5147789999999998e-07 145.6875p 2.6636260000000002e-07 145.69999999999999p 2.806448e-07 145.71250000000001p 2.943052e-07 145.72499999999999p 3.0732480000000002e-07 145.73750000000001p 3.196849e-07 145.75p 3.3136700000000001e-07 145.76249999999999p 3.4235310000000001e-07 145.77500000000001p 3.5262539999999999e-07 145.78749999999999p 3.6216680000000001e-07 145.80000000000001p 3.7096069999999998e-07
+ 145.8125p 3.7899100000000001e-07 145.82500000000002p 3.8624219999999998e-07 145.83749999999998p 3.9269990000000002e-07 145.84999999999999p 3.9835029999999999e-07 145.86249999999998p 4.031805e-07 145.875p 4.071789e-07 145.88750000000002p 4.103347e-07 145.90000000000001p 4.1263849999999998e-07 145.91250000000002p 4.1408229999999999e-07 145.92499999999998p 4.1465960000000001e-07 145.9375p 4.1436509999999998e-07 145.94999999999999p 4.1319559999999999e-07 145.96250000000001p 4.1114919999999998e-07 145.97499999999999p 4.0822619999999998e-07 145.98750000000001p 4.0442859999999998e-07 146p 3.9976059999999998e-07 146.01249999999999p 3.9422829999999998e-07 146.02500000000001p 3.878402e-07
+ 146.03749999999999p 3.806069e-07 146.05000000000001p 3.7254129999999998e-07 146.0625p 3.6365860000000002e-07 146.07500000000002p 3.539766e-07 146.08749999999998p 3.4351529999999999e-07 146.09999999999999p 3.3229719999999999e-07 146.11249999999998p 3.2034740000000002e-07 146.125p 3.0769319999999999e-07 146.13750000000002p 2.9436440000000002e-07 146.15000000000001p 2.803932e-07 146.16250000000002p 2.6581420000000001e-07 146.17499999999998p 2.5066409999999999e-07 146.1875p 2.349818e-07 146.19999999999999p 2.1880859999999999e-07 146.21250000000001p 2.021875e-07 146.22499999999999p 1.851634e-07 146.23750000000001p 1.6778329999999999e-07 146.25p 1.500953e-07
+ 146.26249999999999p 1.321494e-07 146.27500000000001p 1.139967e-07 146.28749999999999p 9.5689510000000001e-08 146.30000000000001p 7.7281009999999999e-08 146.3125p 5.882515e-08 146.32500000000002p 4.0376459999999998e-08 146.33749999999998p 2.198978e-08 146.34999999999999p 3.720065e-09 146.36249999999998p -1.437781e-08 146.375p -3.2249300000000003e-08 146.38749999999999p -4.984041e-08 146.40000000000001p -6.7097900000000004e-08 146.41250000000002p -8.3969549999999999e-08 146.42499999999998p -1.0040430000000001e-07 146.4375p -1.1635269999999999e-07 146.44999999999999p -1.317666e-07 146.46250000000001p -1.4660019999999999e-07 146.47499999999999p -1.608093e-07
+ 146.48750000000001p -1.7435220000000001e-07 146.5p -1.871896e-07 146.51249999999999p -1.9928479999999999e-07 146.52500000000001p -2.1060379999999999e-07 146.53749999999999p -2.211157e-07 146.55000000000001p -2.3079239999999999e-07 146.5625p -2.3960899999999999e-07 146.57500000000002p -2.475441e-07 146.58750000000001p -2.5457939999999999e-07 146.59999999999999p -2.607e-07 146.61249999999998p -2.6589460000000002e-07 146.625p -2.7015540000000002e-07 146.63749999999999p -2.7347789999999999e-07 146.65000000000001p -2.7586129999999999e-07 146.66250000000002p -2.7730820000000002e-07 146.67499999999998p -2.7782469999999999e-07 146.6875p -2.774201e-07 146.69999999999999p -2.761073e-07
+ 146.71250000000001p -2.7390209999999998e-07 146.72499999999999p -2.7082370000000001e-07 146.73750000000001p -2.6689410000000003e-07 146.75p -2.6213809999999998e-07 146.76249999999999p -2.5658349999999998e-07 146.77500000000001p -2.502603e-07 146.78749999999999p -2.4320120000000002e-07 146.80000000000001p -2.3544069999999999e-07 146.8125p -2.270156e-07 146.82500000000002p -2.1796449999999999e-07 146.83750000000001p -2.0832730000000001e-07 146.84999999999999p -1.981457e-07 146.86249999999998p -1.874622e-07 146.875p -1.7632049999999999e-07 146.88749999999999p -1.6476489999999999e-07 146.90000000000001p -1.5284029999999999e-07 146.91249999999999p -1.4059180000000001e-07 146.92500000000001p -1.280647e-07
+ 146.9375p -1.153042e-07 146.94999999999999p -1.023549e-07 146.96250000000001p -8.9261320000000004e-08 146.97499999999999p -7.606693e-08 146.98750000000001p -6.2814459999999997e-08 147p -4.9545530000000001e-08 147.01249999999999p -3.6300560000000001e-08 147.02499999999998p -2.3118579999999999e-08 147.03749999999999p -1.003709e-08 147.05000000000001p 2.9080240000000001e-09 147.0625p 1.568267e-08 147.07500000000002p 2.8254599999999999e-08 147.08750000000001p 4.0593530000000002e-08 147.09999999999999p 5.2671210000000003e-08 147.11249999999998p 6.4461480000000005e-08 147.125p 7.594032e-08 147.13749999999999p 8.7085909999999994e-08 147.15000000000001p 9.7878610000000001e-08
+ 147.16249999999999p 1.08301e-07 147.17500000000001p 1.18338e-07 147.1875p 1.279764e-07 147.19999999999999p 1.372056e-07 147.21250000000001p 1.4601679999999999e-07 147.22499999999999p 1.544035e-07 147.23750000000001p 1.6236100000000001e-07 147.25p 1.698869e-07 147.26250000000002p 1.7698029999999999e-07 147.27499999999998p 1.8364250000000001e-07 147.28749999999999p 1.8987620000000001e-07 147.30000000000001p 1.9568580000000001e-07 147.3125p 2.0107739999999999e-07 147.32500000000002p 2.0605819999999999e-07 147.33750000000001p 2.1063689999999999e-07 147.34999999999999p 2.1482340000000001e-07 147.36249999999998p 2.1862840000000001e-07 147.375p 2.220639e-07
+ 147.38749999999999p 2.2514239999999999e-07 147.40000000000001p 2.278773e-07 147.41249999999999p 2.3028250000000001e-07 147.42500000000001p 2.3237240000000001e-07 147.4375p 2.3416160000000001e-07 147.44999999999999p 2.3566510000000001e-07 147.46250000000001p 2.3689800000000001e-07 147.47499999999999p 2.3787519999999999e-07 147.48750000000001p 2.3861170000000002e-07 147.5p 2.3912220000000003e-07 147.51250000000002p 2.3942130000000001e-07 147.52499999999998p 2.395229e-07 147.53749999999999p 2.3944069999999998e-07 147.54999999999998p 2.3918769999999998e-07 147.5625p 2.3877639999999999e-07 147.57500000000002p 2.382186e-07 147.58750000000001p 2.3752519999999999e-07 147.60000000000002p 2.3670660000000001e-07
+ 147.61249999999998p 2.3577209999999999e-07 147.625p 2.3473040000000001e-07 147.63749999999999p 2.335892e-07 147.65000000000001p 2.3235499999999999e-07 147.66249999999999p 2.3103390000000001e-07 147.67500000000001p 2.296307e-07 147.6875p 2.2814940000000001e-07 147.69999999999999p 2.265929e-07 147.71250000000001p 2.249634e-07 147.72499999999999p 2.23262e-07 147.73750000000001p 2.2148900000000001e-07 147.75p 2.19644e-07 147.76250000000002p 2.1772550000000001e-07 147.77499999999998p 2.1573129999999999e-07 147.78749999999999p 2.1365850000000001e-07 147.79999999999998p 2.1150359999999999e-07 147.8125p 2.0926240000000001e-07 147.82500000000002p 2.069299e-07
+ 147.83750000000001p 2.045008e-07 147.85000000000002p 2.019693e-07 147.86249999999998p 1.9932909999999999e-07 147.875p 1.9657369999999999e-07 147.88749999999999p 1.936962e-07 147.90000000000001p 1.9068950000000001e-07 147.91249999999999p 1.875464e-07 147.92500000000001p 1.8425959999999999e-07 147.9375p 1.8082190000000001e-07 147.94999999999999p 1.7722579999999999e-07 147.96250000000001p 1.7346439999999999e-07 147.97499999999999p 1.6953070000000001e-07 147.98750000000001p 1.6541800000000001e-07 148p 1.6111990000000001e-07 148.01250000000002p 1.5663039999999999e-07 148.02499999999998p 1.51944e-07 148.03749999999999p 1.4705540000000001e-07 148.04999999999998p 1.4196019999999999e-07
+ 148.0625p 1.366543e-07 148.07500000000002p 1.3113429999999999e-07 148.08750000000001p 1.2539739999999999e-07 148.10000000000002p 1.194416e-07 148.11249999999998p 1.132655e-07 148.125p 1.068685e-07 148.13749999999999p 1.002507e-07 148.15000000000001p 9.3413000000000004e-08 148.16249999999999p 8.6357109999999999e-08 148.17500000000001p 7.9085469999999994e-08 148.1875p 7.1601350000000006e-08 148.19999999999999p 6.3908780000000003e-08 148.21250000000001p 5.6012579999999998e-08 148.22499999999999p 4.7918329999999999e-08 148.23750000000001p 3.963235e-08 148.25p 3.1161689999999999e-08 148.26250000000002p 2.2514100000000001e-08 148.27500000000001p 1.369799e-08
+ 148.28749999999999p 4.7224169999999998e-09 148.29999999999998p -4.402972e-09 148.3125p -1.3667959999999999e-08 148.32499999999999p -2.306183e-08 148.33750000000001p -3.2573359999999999e-08 148.35000000000002p -4.2190939999999998e-08 148.36249999999998p -5.190255e-08 148.375p -6.169588e-08 148.38749999999999p -7.1558300000000001e-08 148.40000000000001p -8.1476999999999996e-08 148.41249999999999p -9.1438979999999996e-08 148.42500000000001p -1.014311e-07 148.4375p -1.114403e-07 148.44999999999999p -1.214533e-07 148.46250000000001p -1.3145689999999999e-07 148.47499999999999p -1.4143820000000001e-07 148.48750000000001p -1.5138420000000001e-07 148.5p -1.6128220000000001e-07
+ 148.51250000000002p -1.7111970000000001e-07 148.52500000000001p -1.8088450000000001e-07 148.53749999999999p -1.9056470000000001e-07 148.54999999999998p -2.0014879999999999e-07 148.5625p -2.0962560000000001e-07 148.57499999999999p -2.1898439999999999e-07 148.58750000000001p -2.282148e-07 148.60000000000002p -2.37307e-07 148.61250000000001p -2.462517e-07 148.625p -2.5503999999999999e-07 148.63749999999999p -2.6366350000000001e-07 148.65000000000001p -2.7211449999999998e-07 148.66249999999999p -2.8038560000000001e-07 148.67500000000001p -2.8846999999999999e-07 148.6875p -2.9636149999999998e-07 148.69999999999999p -3.040544e-07 148.71250000000001p -3.115433e-07 148.72499999999999p -3.1882359999999998e-07
+ 148.73750000000001p -3.258909e-07 148.75p -3.327413e-07 148.76250000000002p -3.393714e-07 148.77500000000001p -3.457782e-07 148.78749999999999p -3.5195900000000001e-07 148.79999999999998p -3.579114e-07 148.8125p -3.6363339999999998e-07 148.82499999999999p -3.6912309999999998e-07 148.83750000000001p -3.7437910000000001e-07 148.84999999999999p -3.7939979999999999e-07 148.86250000000001p -3.8418409999999999e-07 148.875p -3.8873070000000001e-07 148.88749999999999p -3.9303880000000002e-07 148.90000000000001p -3.971071e-07 148.91249999999999p -4.009345e-07 148.92500000000001p -4.0452010000000002e-07 148.9375p -4.0786260000000001e-07 148.94999999999999p -4.1096049999999998e-07
+ 148.96249999999998p -4.1381249999999999e-07 148.97499999999999p -4.164168e-07 148.98750000000001p -4.1877150000000003e-07 149p -4.2087440000000001e-07 149.01250000000002p -4.2272309999999999e-07 149.02500000000001p -4.2431470000000002e-07 149.03749999999999p -4.2564629999999998e-07 149.04999999999998p -4.2671430000000002e-07 149.0625p -4.2751520000000001e-07 149.07499999999999p -4.2804460000000002e-07 149.08750000000001p -4.2829820000000003e-07 149.09999999999999p -4.2827109999999998e-07 149.11250000000001p -4.2795810000000002e-07 149.125p -4.2735360000000001e-07 149.13749999999999p -4.2645179999999998e-07 149.15000000000001p -4.2524649999999998e-07 149.16249999999999p -4.2373120000000001e-07 149.17500000000001p -4.2189900000000001e-07
+ 149.1875p -4.1974290000000001e-07 149.20000000000002p -4.1725559999999999e-07 149.21249999999998p -4.1442970000000001e-07 149.22499999999999p -4.1125749999999998e-07 149.23750000000001p -4.077315e-07 149.25p -4.0384370000000002e-07 149.26250000000002p -3.9958640000000001e-07 149.27500000000001p -3.9495179999999999e-07 149.28749999999999p -3.8993240000000002e-07 149.29999999999998p -3.8452050000000002e-07 149.3125p -3.7870880000000002e-07 149.32499999999999p -3.7249039999999999e-07 149.33750000000001p -3.6585839999999999e-07 149.34999999999999p -3.5880660000000002e-07 149.36250000000001p -3.5132889999999999e-07 149.375p -3.4342009999999998e-07 149.38749999999999p -3.350753e-07 149.40000000000001p -3.2629019999999998e-07
+ 149.41249999999999p -3.170614e-07 149.42500000000001p -3.0738609999999999e-07 149.4375p -2.9726219999999999e-07 149.45000000000002p -2.8668880000000002e-07 149.46249999999998p -2.7566550000000001e-07 149.47499999999999p -2.641932e-07 149.48749999999998p -2.5227350000000001e-07 149.5p -2.3990950000000002e-07 149.51250000000002p -2.2710480000000001e-07 149.52500000000001p -2.1386459999999999e-07 149.53750000000002p -2.0019520000000001e-07 149.54999999999998p -1.861038e-07 149.5625p -1.7159909999999999e-07 149.57499999999999p -1.5669089999999999e-07 149.58750000000001p -1.4139039999999999e-07 149.59999999999999p -1.2570990000000001e-07 149.61250000000001p -1.096629e-07 149.625p -9.3264400000000002e-08
+ 149.63749999999999p -7.6530440000000006e-08 149.65000000000001p -5.9478389999999997e-08 149.66249999999999p -4.21268e-08 149.67500000000001p -2.449545e-08 149.6875p -6.6052590000000001e-09 149.70000000000002p 1.1521710000000001e-08 149.71249999999998p 2.9862289999999999e-08 149.72499999999999p 4.8392290000000001e-08 149.73749999999998p 6.7086499999999997e-08 149.75p 8.5918770000000003e-08 149.76250000000002p 1.048621e-07 149.77500000000001p 1.2388849999999999e-07 149.78750000000002p 1.429695e-07 149.79999999999998p 1.6207579999999999e-07 149.8125p 1.8117730000000001e-07 149.82499999999999p 2.002437e-07 149.83750000000001p 2.19244e-07 149.84999999999999p 2.381469e-07
+ 149.86250000000001p 2.5692079999999999e-07 149.875p 2.7553389999999999e-07 149.88749999999999p 2.9395429999999999e-07 149.90000000000001p 3.1215e-07 149.91249999999999p 3.3008909999999998e-07 149.92500000000001p 3.4773979999999998e-07 149.9375p 3.6507049999999999e-07 149.95000000000002p 3.8205019999999999e-07 149.96249999999998p 3.986478e-07 149.97499999999999p 4.1483299999999999e-07 149.98749999999998p 4.3057610000000002e-07 150p 4.4584799999999998e-07 150.01249999999999p 4.6062019999999999e-07 150.02500000000001p 4.7486509999999998e-07 150.03750000000002p 4.8855600000000002e-07 150.04999999999998p 5.0166720000000003e-07 150.0625p 5.1417380000000002e-07 150.07499999999999p 5.2605230000000001e-07
+ 150.08750000000001p 5.3727989999999996e-07 150.09999999999999p 5.478355e-07 150.11250000000001p 5.5769879999999996e-07 150.125p 5.6685109999999999e-07 150.13749999999999p 5.7527490000000003e-07 150.15000000000001p 5.8295399999999997e-07 150.16249999999999p 5.8987379999999999e-07 150.17500000000001p 5.960209e-07 150.1875p 6.0138359999999999e-07 150.20000000000002p 6.0595139999999999e-07 150.21250000000001p 6.0971560000000001e-07 150.22499999999999p 6.1266890000000003e-07 150.23749999999998p 6.1480529999999998e-07 150.25p 6.1612059999999999e-07 150.26249999999999p 6.1661199999999996e-07 150.27500000000001p 6.162781e-07 150.28750000000002p 6.1511920000000003e-07 150.29999999999998p 6.1313710000000001e-07
+ 150.3125p 6.1033469999999999e-07 150.32499999999999p 6.0671680000000001e-07 150.33750000000001p 6.0228940000000002e-07 150.34999999999999p 5.9705989999999998e-07 150.36250000000001p 5.91037e-07 150.375p 5.842311e-07 150.38749999999999p 5.7665339999999996e-07 150.40000000000001p 5.683166e-07 150.41249999999999p 5.5923480000000001e-07 150.42500000000001p 5.4942299999999998e-07 150.4375p 5.3889740000000003e-07 150.45000000000002p 5.2767550000000001e-07 150.46250000000001p 5.157756e-07 150.47499999999999p 5.0321709999999999e-07 150.48749999999998p 4.900205e-07 150.5p 4.7620689999999998e-07 150.51249999999999p 4.6179860000000002e-07 150.52500000000001p 4.4681849999999999e-07
+ 150.53750000000002p 4.3129040000000001e-07 150.55000000000001p 4.1523860000000001e-07 150.5625p 3.986884e-07 150.57499999999999p 3.8166539999999999e-07 150.58750000000001p 3.641959e-07 150.59999999999999p 3.4630680000000002e-07 150.61250000000001p 3.280253e-07 150.625p 3.0937919999999999e-07 150.63749999999999p 2.9039640000000002e-07 150.65000000000001p 2.7110549999999998e-07 150.66249999999999p 2.5153500000000001e-07 150.67500000000001p 2.3171389999999999e-07 150.6875p 2.1167129999999999e-07 150.70000000000002p 1.9143650000000001e-07 150.71250000000001p 1.710387e-07 150.72499999999999p 1.5050729999999999e-07 150.73749999999998p 1.298718e-07 150.75p 1.0916149999999999e-07
+ 150.76249999999999p 8.8405719999999994e-08 150.77500000000001p 6.7633560000000001e-08 150.78749999999999p 4.6874070000000003e-08 150.80000000000001p 2.6156079999999998e-08 150.8125p 5.5081520000000001e-09 150.82499999999999p -1.5041390000000001e-08 150.83750000000001p -3.5464550000000002e-08 150.84999999999999p -5.5733690000000002e-08 150.86250000000001p -7.5821530000000005e-08 150.875p -9.5701240000000002e-08 150.88750000000002p -1.153464e-07 150.89999999999998p -1.347312e-07 150.91249999999999p -1.5383020000000001e-07 150.92500000000001p -1.726186e-07 150.9375p -1.910721e-07 150.95000000000002p -2.0916730000000001e-07 150.96250000000001p -2.268811e-07 150.97499999999999p -2.4419130000000002e-07
+ 150.98749999999998p -2.6107629999999998e-07 151p -2.7751530000000001e-07 151.01249999999999p -2.9348829999999999e-07 151.02500000000001p -3.0897609999999999e-07 151.03749999999999p -3.2396019999999998e-07 151.05000000000001p -3.384231e-07 151.0625p -3.52348e-07 151.07499999999999p -3.6571919999999998e-07 151.08750000000001p -3.785218e-07 151.09999999999999p -3.9074179999999998e-07 151.11250000000001p -4.0236629999999999e-07 151.125p -4.1338309999999998e-07 151.13750000000002p -4.237813e-07 151.14999999999998p -4.335508e-07 151.16249999999999p -4.4268250000000001e-07 151.17500000000001p -4.5116849999999999e-07 151.1875p -4.5900179999999999e-07 151.20000000000002p -4.6617650000000002e-07
+ 151.21250000000001p -4.7268760000000001e-07 151.22500000000002p -4.7853129999999999e-07 151.23749999999998p -4.8370479999999997e-07 151.25p -4.8820639999999997e-07 151.26249999999999p -4.9203539999999999e-07 151.27500000000001p -4.9519209999999997e-07 151.28749999999999p -4.976779e-07 151.30000000000001p -4.9949530000000004e-07 151.3125p -5.0064770000000005e-07 151.32499999999999p -5.0113949999999999e-07 151.33750000000001p -5.0097609999999996e-07 151.34999999999999p -5.001641e-07 151.36250000000001p -4.9871079999999999e-07 151.375p -4.9662460000000002e-07 151.38750000000002p -4.9391459999999996e-07 151.39999999999998p -4.9059110000000002e-07 151.41249999999999p -4.8666520000000001e-07 151.42499999999998p -4.8214860000000002e-07
+ 151.4375p -4.7705420000000004e-07 151.45000000000002p -4.7139539999999999e-07 151.46250000000001p -4.651866e-07 151.47500000000002p -4.5844280000000001e-07 151.48749999999998p -4.5117960000000003e-07 151.5p -4.434137e-07 151.51249999999999p -4.351619e-07 151.52500000000001p -4.26442e-07 151.53749999999999p -4.1727220000000002e-07 151.55000000000001p -4.076713e-07 151.5625p -3.9765849999999999e-07 151.57499999999999p -3.872537e-07 151.58750000000001p -3.7647700000000002e-07 151.59999999999999p -3.65349e-07 151.61250000000001p -3.538907e-07 151.625p -3.4212320000000001e-07 151.63750000000002p -3.3006809999999998e-07 151.64999999999998p -3.177473e-07
+ 151.66249999999999p -3.0518259999999999e-07 151.67499999999998p -2.9239640000000001e-07 151.6875p -2.7941079999999998e-07 151.70000000000002p -2.6624840000000001e-07 151.71250000000001p -2.5293160000000001e-07 151.72500000000002p -2.3948280000000002e-07 151.73749999999998p -2.259247e-07 151.75p -2.1227969999999999e-07 151.76249999999999p -1.985701e-07 151.77500000000001p -1.848184e-07 151.78749999999999p -1.710465e-07 151.80000000000001p -1.572765e-07 151.8125p -1.435302e-07 151.82499999999999p -1.2982899999999999e-07 151.83750000000001p -1.161942e-07 151.84999999999999p -1.026468e-07 151.86250000000001p -8.9207420000000001e-08 151.875p -7.5896200000000004e-08
+ 151.88750000000002p -6.2733039999999996e-08 151.89999999999998p -4.9737330000000003e-08 151.91249999999999p -3.6928030000000001e-08 151.92499999999998p -2.4323600000000001e-08 151.9375p -1.1941980000000001e-08 151.94999999999999p 1.9944779999999999e-10 151.96250000000001p 1.2083870000000001e-08 151.97500000000002p 2.369509e-08 151.98749999999998p 3.5017529999999999e-08 152p 4.6036299999999999e-08 152.01249999999999p 5.6737190000000001e-08 152.02500000000001p 6.7106700000000004e-08 152.03749999999999p 7.7132090000000001e-08 152.05000000000001p 8.680138e-08 152.0625p 9.6103389999999996e-08 152.07499999999999p 1.050277e-07 152.08750000000001p 1.1356490000000001e-07 152.09999999999999p 1.2170629999999999e-07
+ 152.11250000000001p 1.29444e-07 152.125p 1.3677120000000001e-07 152.13750000000002p 1.43682e-07 152.15000000000001p 1.501713e-07 152.16249999999999p 1.5623509999999999e-07 152.17499999999998p 1.6187019999999999e-07 152.1875p 1.6707449999999999e-07 152.19999999999999p 1.718469e-07 152.21250000000001p 1.761872e-07 152.22500000000002p 1.8009609999999999e-07 152.23749999999998p 1.835757e-07 152.25p 1.8662850000000001e-07 152.26249999999999p 1.892585e-07 152.27500000000001p 1.914704e-07 152.28749999999999p 1.9327000000000001e-07 152.30000000000001p 1.94664e-07 152.3125p 1.9565999999999999e-07 152.32499999999999p 1.962666e-07
+ 152.33750000000001p 1.9649329999999999e-07 152.34999999999999p 1.963505e-07 152.36250000000001p 1.9584920000000001e-07 152.375p 1.9500170000000001e-07 152.38750000000002p 1.9382050000000001e-07 152.40000000000001p 1.9231940000000001e-07 152.41249999999999p 1.905124e-07 152.42499999999998p 1.884145e-07 152.4375p 1.860412e-07 152.44999999999999p 1.8340850000000001e-07 152.46250000000001p 1.8053299999999999e-07 152.47500000000002p 1.774316e-07 152.48750000000001p 1.741217e-07 152.5p 1.706211e-07 152.51249999999999p 1.6694769999999999e-07 152.52500000000001p 1.6311969999999999e-07 152.53749999999999p 1.5915539999999999e-07 152.55000000000001p 1.5507320000000001e-07
+ 152.5625p 1.5089150000000001e-07 152.57499999999999p 1.4662859999999999e-07 152.58749999999998p 1.423027e-07 152.59999999999999p 1.3793180000000001e-07 152.61250000000001p 1.3353359999999999e-07 152.625p 1.291255e-07 152.63750000000002p 1.247246e-07 152.65000000000001p 1.2034729999999999e-07 152.66249999999999p 1.1600979999999999e-07 152.67499999999998p 1.117274e-07 152.6875p 1.0751499999999999e-07 152.69999999999999p 1.0338669999999999e-07 152.71250000000001p 9.9355810000000005e-08 152.72499999999999p 9.5434999999999994e-08 152.73750000000001p 9.1635990000000004e-08 152.75p 8.7969680000000003e-08 152.76249999999999p 8.444604e-08 152.77500000000001p 8.1074099999999994e-08
+ 152.78749999999999p 7.7861950000000003e-08 152.80000000000001p 7.4816669999999995e-08 152.8125p 7.1944330000000005e-08 152.82500000000002p 6.9249990000000005e-08 152.83749999999998p 6.6737699999999995e-08 152.84999999999999p 6.4410459999999993e-08 152.86250000000001p 6.2270260000000005e-08 152.875p 6.0318060000000004e-08 152.88750000000002p 5.8553819999999998e-08 152.90000000000001p 5.697654e-08 152.91249999999999p 5.5584209999999997e-08 152.92499999999998p 5.4373909999999999e-08 152.9375p 5.3341810000000001e-08 152.94999999999999p 5.2483219999999998e-08 152.96250000000001p 5.1792599999999998e-08 152.97499999999999p 5.126362e-08 152.98750000000001p 5.0889239999999997e-08 153p 5.0661690000000001e-08
+ 153.01249999999999p 5.0572599999999997e-08 153.02500000000001p 5.0612990000000001e-08 153.03749999999999p 5.0773380000000003e-08 153.05000000000001p 5.1043799999999999e-08 153.0625p 5.1413909999999997e-08 153.07500000000002p 5.1872990000000001e-08 153.08749999999998p 5.241009e-08 153.09999999999999p 5.3014009999999997e-08 153.11250000000001p 5.3673420000000002e-08 153.125p 5.4376919999999999e-08 153.13750000000002p 5.5113059999999998e-08 153.15000000000001p 5.5870450000000001e-08 153.16250000000002p 5.6637800000000003e-08 153.17499999999998p 5.7403980000000003e-08 153.1875p 5.8158100000000002e-08 153.19999999999999p 5.8889519999999999e-08 153.21250000000001p 5.9587939999999998e-08 153.22499999999999p 6.024344e-08
+ 153.23750000000001p 6.0846540000000001e-08 153.25p 6.1388210000000001e-08 153.26249999999999p 6.1859950000000003e-08 153.27500000000001p 6.2253799999999999e-08 153.28749999999999p 6.2562410000000006e-08 153.30000000000001p 6.2778999999999996e-08 153.3125p 6.2897480000000005e-08 153.32500000000002p 6.2912399999999996e-08 153.33749999999998p 6.2818979999999995e-08 153.34999999999999p 6.2613160000000004e-08 153.36249999999998p 6.2291600000000004e-08 153.375p 6.1851629999999998e-08 153.38750000000002p 6.1291340000000005e-08 153.40000000000001p 6.0609520000000004e-08 153.41250000000002p 5.9805680000000004e-08 153.42499999999998p 5.8880020000000002e-08 153.4375p 5.7833449999999997e-08 153.44999999999999p 5.6667540000000001e-08
+ 153.46250000000001p 5.5384540000000002e-08 153.47499999999999p 5.3987329999999998e-08 153.48750000000001p 5.2479390000000002e-08 153.5p 5.0864800000000002e-08 153.51249999999999p 4.9148209999999999e-08 153.52500000000001p 4.7334769999999999e-08 153.53749999999999p 4.5430140000000002e-08 153.55000000000001p 4.3440439999999999e-08 153.5625p 4.1372190000000002e-08 153.57500000000002p 3.9232330000000003e-08 153.58749999999998p 3.7028110000000001e-08 153.59999999999999p 3.4767089999999998e-08 153.61249999999998p 3.2457100000000003e-08 153.625p 3.0106189999999999e-08 153.63750000000002p 2.7722590000000001e-08 153.65000000000001p 2.531466e-08 153.66250000000002p 2.2890860000000001e-08 153.67499999999998p 2.04597e-08
+ 153.6875p 1.802971e-08 153.69999999999999p 1.5609399999999999e-08 153.71250000000001p 1.320719e-08 153.72499999999999p 1.0831429999999999e-08 153.73750000000001p 8.490295e-09 153.75p 6.1918110000000003e-09 153.76249999999999p 3.9437819999999996e-09 153.77500000000001p 1.7537720000000001e-09 153.78749999999999p -3.709291e-10 153.80000000000001p -2.4233329999999999e-09 153.8125p -4.3967819999999996e-09 153.82500000000002p -6.2849710000000004e-09 153.83750000000001p -8.0819770000000001e-09 153.84999999999999p -9.7822720000000002e-09 153.86249999999998p -1.1380749999999999e-08 153.875p -1.287274e-08 153.88749999999999p -1.425401e-08 153.90000000000001p -1.5520809999999999e-08
+ 153.91250000000002p -1.6669860000000001e-08 153.92499999999998p -1.769834e-08 153.9375p -1.860394e-08 153.94999999999999p -1.938485e-08 153.96250000000001p -2.003972e-08 153.97499999999999p -2.0567739999999999e-08 153.98750000000001p -2.096855e-08 154p -2.1242299999999999e-08 154.01249999999999p -2.1389629999999999e-08 154.02500000000001p -2.1411650000000001e-08 154.03749999999999p -2.1309930000000001e-08 154.05000000000001p -2.1086500000000002e-08 154.0625p -2.0743839999999999e-08 154.07500000000002p -2.0284870000000001e-08 154.08750000000001p -1.97129e-08 154.09999999999999p -1.9031659999999999e-08 154.11249999999998p -1.8245259999999999e-08 154.125p -1.735817e-08
+ 154.13749999999999p -1.637522e-08 154.15000000000001p -1.5301539999999999e-08 154.16250000000002p -1.414258e-08 154.17499999999998p -1.290408e-08 154.1875p -1.159203e-08 154.19999999999999p -1.0212659999999999e-08 154.21250000000001p -8.7724169999999997e-09 154.22499999999999p -7.2779440000000002e-09 154.23750000000001p -5.7360539999999999e-09 154.25p -4.1537070000000004e-09 154.26249999999999p -2.537988e-09 154.27500000000001p -8.9608530000000001e-10 154.28749999999999p 7.6473469999999995e-10 154.30000000000001p 2.4371469999999999e-09 154.3125p 4.1137890000000002e-09 154.32500000000002p 5.7872860000000002e-09 154.33750000000001p 7.4502649999999998e-09 154.34999999999999p 9.0953810000000004e-09
+ 154.36249999999998p 1.071533e-08 154.375p 1.2302879999999999e-08 154.38749999999999p 1.3850869999999999e-08 154.40000000000001p 1.5352230000000001e-08 154.41249999999999p 1.6800020000000001e-08 154.42500000000001p 1.8187420000000001e-08 154.4375p 1.9507760000000001e-08 154.44999999999999p 2.0754499999999999e-08 154.46250000000001p 2.1921300000000001e-08 154.47499999999999p 2.300199e-08 154.48750000000001p 2.3990580000000001e-08 154.5p 2.4881289999999999e-08 154.51249999999999p 2.5668549999999999e-08 154.52499999999998p 2.6346990000000001e-08 154.53749999999999p 2.6911479999999999e-08 154.55000000000001p 2.735712e-08 154.5625p 2.767924e-08 154.57500000000002p 2.7873409999999999e-08
+ 154.58750000000001p 2.793545e-08 154.59999999999999p 2.7861419999999999e-08 154.61249999999998p 2.7647650000000001e-08 154.625p 2.729071e-08 154.63749999999999p 2.6787419999999998e-08 154.65000000000001p 2.613488e-08 154.66249999999999p 2.533044e-08 154.67500000000001p 2.4371720000000002e-08 154.6875p 2.325658e-08 154.69999999999999p 2.198317e-08 154.71250000000001p 2.05499e-08 154.72499999999999p 1.8955440000000001e-08 154.73750000000001p 1.719875e-08 154.75p 1.527902e-08 154.76250000000002p 1.3195760000000001e-08 154.77499999999998p 1.094871e-08 154.78749999999999p 8.5379120000000002e-09 154.80000000000001p 5.9636770000000001e-09
+ 154.8125p 3.2265950000000001e-09 154.82500000000002p 3.2753730000000001e-10 154.83750000000001p -2.7323379999999999e-09 154.84999999999999p -5.9515839999999999e-09 154.86249999999998p -9.3284639999999999e-09 154.875p -1.2860939999999999e-08 154.88749999999999p -1.654669e-08 154.90000000000001p -2.038307e-08 154.91249999999999p -2.4367130000000001e-08 154.92500000000001p -2.849562e-08 154.9375p -3.2764960000000003e-08 154.94999999999999p -3.7171250000000003e-08 154.96250000000001p -4.1710259999999998e-08 154.97499999999999p -4.6377449999999997e-08 154.98750000000001p -5.11679e-08 155p -5.6076389999999997e-08 155.01250000000002p -6.1097339999999997e-08 155.02499999999998p -6.6224819999999995e-08
+ 155.03749999999999p -7.1452539999999997e-08 155.04999999999998p -7.6773870000000001e-08 155.0625p -8.218181e-08 155.07500000000002p -8.7669019999999996e-08 155.08750000000001p -9.3227789999999999e-08 155.10000000000002p -9.8850049999999998e-08 155.11249999999998p -1.045274e-07 155.125p -1.10251e-07 155.13749999999999p -1.160117e-07 155.15000000000001p -1.218002e-07 155.16249999999999p -1.2760640000000001e-07 155.17500000000001p -1.334205e-07 155.1875p -1.3923170000000001e-07 155.19999999999999p -1.4502939999999999e-07 155.21250000000001p -1.5080249999999999e-07 155.22499999999999p -1.565396e-07 155.23750000000001p -1.6222910000000001e-07 155.25p -1.6785899999999999e-07
+ 155.26250000000002p -1.734173e-07 155.27499999999998p -1.7889159999999999e-07 155.28749999999999p -1.8426939999999999e-07 155.29999999999998p -1.8953789999999999e-07 155.3125p -1.9468439999999999e-07 155.32500000000002p -1.9969580000000001e-07 155.33750000000001p -2.0455909999999999e-07 155.35000000000002p -2.0926119999999999e-07 155.36249999999998p -2.1378900000000001e-07 155.375p -2.1812930000000001e-07 155.38749999999999p -2.2226910000000001e-07 155.40000000000001p -2.2619539999999999e-07 155.41249999999999p -2.2989530000000001e-07 155.42500000000001p -2.3335610000000001e-07 155.4375p -2.3656520000000001e-07 155.44999999999999p -2.3951039999999997e-07 155.46250000000001p -2.421795e-07 155.47499999999999p -2.445609e-07
+ 155.48750000000001p -2.4664310000000001e-07 155.5p -2.4841529999999999e-07 155.51250000000002p -2.4986679999999999e-07 155.52499999999998p -2.5098749999999998e-07 155.53749999999999p -2.5176789999999999e-07 155.54999999999998p -2.5219889999999998e-07 155.5625p -2.5227210000000002e-07 155.57500000000002p -2.5197959999999999e-07 155.58750000000001p -2.5131419999999998e-07 155.60000000000002p -2.5026950000000002e-07 155.61249999999998p -2.4883970000000002e-07 155.625p -2.4701970000000002e-07 155.63749999999999p -2.4480529999999998e-07 155.65000000000001p -2.421931e-07 155.66249999999999p -2.3918040000000002e-07 155.67500000000001p -2.3576550000000001e-07 155.6875p -2.3194749999999999e-07 155.69999999999999p -2.2772640000000001e-07
+ 155.71250000000001p -2.2310289999999999e-07 155.72499999999999p -2.18079e-07 155.73750000000001p -2.126573e-07 155.75p -2.0684139999999999e-07 155.76250000000002p -2.0063590000000001e-07 155.77500000000001p -1.9404629999999999e-07 155.78749999999999p -1.8707879999999999e-07 155.79999999999998p -1.797409e-07 155.8125p -1.720406e-07 155.82499999999999p -1.63987e-07 155.83750000000001p -1.555901e-07 155.85000000000002p -1.468607e-07 155.86249999999998p -1.3781029999999999e-07 155.875p -1.2845129999999999e-07 155.88749999999999p -1.187969e-07 155.90000000000001p -1.088611e-07 155.91249999999999p -9.8658440000000004e-08 155.92500000000001p -8.8204230000000001e-08
+ 155.9375p -7.7514409999999994e-08 155.94999999999999p -6.6605499999999994e-08 155.96250000000001p -5.54946e-08 155.97499999999999p -4.4199309999999997e-08 155.98750000000001p -3.2737709999999999e-08 156p -2.1128279999999999e-08 156.01250000000002p -9.3899059999999999e-09 156.02500000000001p 2.458209e-09 156.03749999999999p 1.439658e-08 156.04999999999998p 2.6405470000000001e-08 156.0625p 3.8464980000000001e-08 156.07499999999999p 5.0555070000000001e-08 156.08750000000001p 6.2655599999999994e-08 156.10000000000002p 7.4746389999999998e-08 156.11250000000001p 8.6807289999999998e-08 156.125p 9.881817e-08 156.13749999999999p 1.1075900000000001e-07 156.15000000000001p 1.226101e-07
+ 156.16249999999999p 1.343515e-07 156.17500000000001p 1.45964e-07 156.1875p 1.5742839999999999e-07 156.19999999999999p 1.6872590000000001e-07 156.21250000000001p 1.7983790000000001e-07 156.22499999999999p 1.9074649999999999e-07 156.23750000000001p 2.0143390000000001e-07 156.25p 2.1188299999999999e-07 156.26250000000002p 2.220771e-07 156.27500000000001p 2.320001e-07 156.28749999999999p 2.4163630000000001e-07 156.29999999999998p 2.5097069999999998e-07 156.3125p 2.5998900000000001e-07 156.32499999999999p 2.686772e-07 156.33750000000001p 2.7702230000000001e-07 156.34999999999999p 2.850118e-07 156.36250000000001p 2.9263390000000001e-07 156.375p 2.998774e-07
+ 156.38749999999999p 3.067319e-07 156.40000000000001p 3.1318769999999998e-07 156.41249999999999p 3.192359e-07 156.42500000000001p 3.2486820000000001e-07 156.4375p 3.3007689999999998e-07 156.45000000000002p 3.348555e-07 156.46249999999998p 3.3919769999999999e-07 156.47499999999999p 3.4309819999999998e-07 156.48750000000001p 3.4655240000000001e-07 156.5p 3.4955650000000002e-07 156.51250000000002p 3.5210729999999999e-07 156.52500000000001p 3.5420230000000001e-07 156.53749999999999p 3.558398e-07 156.54999999999998p 3.5701879999999999e-07 156.5625p 3.5773890000000001e-07 156.57499999999999p 3.5800040000000002e-07 156.58750000000001p 3.5780450000000001e-07 156.59999999999999p 3.571526e-07
+ 156.61250000000001p 3.5604730000000001e-07 156.625p 3.544913e-07 156.63749999999999p 3.5248829999999998e-07 156.65000000000001p 3.5004249999999999e-07 156.66249999999999p 3.4715869999999999e-07 156.67500000000001p 3.4384219999999997e-07 156.6875p 3.4009890000000001e-07 156.70000000000002p 3.3593540000000002e-07 156.71249999999998p 3.3135870000000002e-07 156.72499999999999p 3.2637630000000001e-07 156.73750000000001p 3.209963e-07 156.75p 3.1522720000000001e-07 156.76250000000002p 3.090781e-07 156.77500000000001p 3.025584e-07 156.78749999999999p 2.956781e-07 156.79999999999998p 2.8844759999999999e-07 156.8125p 2.8087759999999999e-07 156.82499999999999p 2.7297939999999999e-07
+ 156.83750000000001p 2.6476450000000001e-07 156.84999999999999p 2.5624480000000002e-07 156.86250000000001p 2.4743269999999999e-07 156.875p 2.383407e-07 156.88749999999999p 2.2898179999999999e-07 156.90000000000001p 2.1936929999999999e-07 156.91249999999999p 2.0951659999999999e-07 156.92500000000001p 1.994375e-07 156.9375p 1.891462e-07 156.95000000000002p 1.786568e-07 156.96249999999998p 1.6798379999999999e-07 156.97499999999999p 1.571419e-07 156.98749999999998p 1.4614599999999999e-07 157p 1.3501099999999999e-07 157.01250000000002p 1.237521e-07 157.02500000000001p 1.123845e-07 157.03750000000002p 1.009236e-07 157.04999999999998p 8.9384720000000006e-08
+ 157.0625p 7.7783409999999994e-08 157.07499999999999p 6.6135129999999998e-08 157.08750000000001p 5.4455389999999999e-08 157.09999999999999p 4.2759670000000001e-08 157.11250000000001p 3.1063430000000003e-08 157.125p 1.938206e-08 157.13749999999999p 7.7308699999999998e-09 157.15000000000001p -3.8749330000000001e-09 157.16249999999999p -1.5420279999999998e-08 157.17500000000001p -2.6890229999999998e-08 157.1875p -3.8270059999999997e-08 157.20000000000002p -4.9545200000000002e-08 157.21249999999998p -6.0701339999999998e-08 157.22499999999999p -7.1724389999999999e-08 157.23749999999998p -8.2600530000000002e-08 157.25p -9.3316260000000003e-08 157.26250000000002p -1.038584e-07 157.27500000000001p -1.1421400000000001e-07
+ 157.28750000000002p -1.243706e-07 157.29999999999998p -1.34316e-07 157.3125p -1.4403859999999999e-07 157.32499999999999p -1.53527e-07 157.33750000000001p -1.627703e-07 157.34999999999999p -1.7175820000000001e-07 157.36250000000001p -1.8048059999999999e-07 157.375p -1.8892819999999999e-07 157.38749999999999p -1.9709190000000001e-07 157.40000000000001p -2.049634e-07 157.41249999999999p -2.1253469999999999e-07 157.42500000000001p -2.197986e-07 157.4375p -2.267482e-07 157.45000000000002p -2.3337729999999999e-07 157.46249999999998p -2.3968030000000002e-07 157.47499999999999p -2.4565199999999998e-07 157.48749999999998p -2.5128810000000001e-07 157.5p -2.5658469999999999e-07
+ 157.51249999999999p -2.6153840000000002e-07 157.52500000000001p -2.6614649999999999e-07 157.53750000000002p -2.7040700000000002e-07 157.54999999999998p -2.7431830000000001e-07 157.5625p -2.7787959999999998e-07 157.57499999999999p -2.810905e-07 157.58750000000001p -2.839513e-07 157.59999999999999p -2.8646269999999999e-07 157.61250000000001p -2.8862629999999998e-07 157.625p -2.9044380000000002e-07 157.63749999999999p -2.919178e-07 157.65000000000001p -2.9305139999999999e-07 157.66249999999999p -2.93848e-07 157.67500000000001p -2.9431180000000001e-07 157.6875p -2.9444710000000001e-07 157.70000000000002p -2.9425900000000001e-07 157.71250000000001p -2.9375300000000002e-07 157.72499999999999p -2.929349e-07
+ 157.73749999999998p -2.9181099999999999e-07 157.75p -2.9038799999999999e-07 157.76249999999999p -2.8867289999999999e-07 157.77500000000001p -2.8667309999999998e-07 157.78750000000002p -2.843963e-07 157.79999999999998p -2.8185060000000001e-07 157.8125p -2.7904430000000002e-07 157.82499999999999p -2.7598589999999998e-07 157.83750000000001p -2.7268430000000001e-07 157.84999999999999p -2.6914830000000003e-07 157.86250000000001p -2.6538730000000002e-07 157.875p -2.6141060000000002e-07 157.88749999999999p -2.572277e-07 157.90000000000001p -2.5284830000000002e-07 157.91249999999999p -2.4828190000000001e-07 157.92500000000001p -2.4353839999999999e-07 157.9375p -2.3862769999999998e-07 157.95000000000002p -2.3355949999999999e-07
+ 157.96250000000001p -2.2834380000000001e-07 157.97499999999999p -2.2299029999999999e-07 157.98749999999998p -2.175089e-07 158p -2.1190939999999999e-07 158.01249999999999p -2.062014e-07 158.02500000000001p -2.0039440000000001e-07 158.03750000000002p -1.94498e-07 158.05000000000001p -1.8852139999999999e-07 158.0625p -1.824739e-07 158.07499999999999p -1.7636460000000001e-07 158.08750000000001p -1.702021e-07 158.09999999999999p -1.6399519999999999e-07 158.11250000000001p -1.5775239999999999e-07 158.125p -1.5148189999999999e-07 158.13749999999999p -1.4519169999999999e-07 158.15000000000001p -1.388896e-07 158.16249999999999p -1.3258310000000001e-07 158.17500000000001p -1.2627940000000001e-07
+ 158.1875p -1.199856e-07 158.20000000000002p -1.137085e-07 158.21250000000001p -1.074544e-07 158.22499999999999p -1.0122960000000001e-07 158.23749999999998p -9.5039889999999994e-08 158.25p -8.8890929999999996e-08 158.26249999999999p -8.2787990000000003e-08 158.27500000000001p -7.6736090000000002e-08 158.28749999999999p -7.0739919999999998e-08 158.30000000000001p -6.4803899999999997e-08 158.3125p -5.8932130000000003e-08 158.32499999999999p -5.3128410000000003e-08 158.33750000000001p -4.7396270000000003e-08 158.34999999999999p -4.1738929999999998e-08 158.36250000000001p -3.6159300000000003e-08 158.375p -3.0660030000000001e-08 158.38750000000002p -2.524349e-08 158.39999999999998p -1.991175e-08
+ 158.41249999999999p -1.4666629999999999e-08 158.42500000000001p -9.5096570000000003e-09 158.4375p -4.4421330000000004e-09 158.45000000000002p 5.3491110000000001e-10 158.46250000000001p 5.4206810000000003e-09 158.47499999999999p 1.021462e-08 158.48749999999998p 1.4916390000000001e-08 158.5p 1.9525860000000001e-08 158.51249999999999p 2.4043140000000001e-08 158.52500000000001p 2.8468480000000001e-08 158.53749999999999p 3.2802349999999997e-08 158.55000000000001p 3.7045380000000001e-08 158.5625p 4.1198359999999998e-08 158.57499999999999p 4.5262220000000003e-08 158.58750000000001p 4.923804e-08 158.59999999999999p 5.312699e-08 158.61250000000001p 5.693037e-08 158.625p 6.0649589999999999e-08
+ 158.63750000000002p 6.4286100000000003e-08 158.64999999999998p 6.784144e-08 158.66249999999999p 7.1317209999999997e-08 158.67500000000001p 7.4715029999999994e-08 158.6875p 7.8036560000000005e-08 158.70000000000002p 8.1283469999999998e-08 158.71250000000001p 8.4457420000000001e-08 158.72500000000002p 8.7560060000000004e-08 158.73749999999998p 9.0593010000000006e-08 158.75p 9.3557849999999995e-08 158.76249999999999p 9.6456100000000006e-08 158.77500000000001p 9.9289229999999997e-08 158.78749999999999p 1.0205860000000001e-07 158.80000000000001p 1.047655e-07 158.8125p 1.0741120000000001e-07 158.82499999999999p 1.099967e-07 158.83750000000001p 1.125229e-07 158.84999999999999p 1.149908e-07
+ 158.86250000000001p 1.174009e-07 158.875p 1.1975390000000001e-07 158.88750000000002p 1.220501e-07 158.89999999999998p 1.2428970000000001e-07 158.91249999999999p 1.264729e-07 158.92499999999998p 1.2859950000000001e-07 158.9375p 1.3066929999999999e-07 158.95000000000002p 1.3268180000000001e-07 158.96250000000001p 1.3463640000000001e-07 158.97500000000002p 1.365323e-07 158.98749999999998p 1.3836859999999999e-07 159p 1.4014410000000001e-07 159.01249999999999p 1.4185739999999999e-07 159.02500000000001p 1.4350729999999999e-07 159.03749999999999p 1.450918e-07 159.05000000000001p 1.4660940000000001e-07 159.0625p 1.4805799999999999e-07 159.07499999999999p 1.4943559999999999e-07
+ 159.08750000000001p 1.5073989999999999e-07 159.09999999999999p 1.5196849999999999e-07 159.11250000000001p 1.5311900000000001e-07 159.125p 1.5418879999999999e-07 159.13750000000002p 1.5517529999999999e-07 159.14999999999998p 1.5607560000000001e-07 159.16249999999999p 1.5688699999999999e-07 159.17499999999998p 1.576065e-07 159.1875p 1.5823119999999999e-07 159.20000000000002p 1.5875809999999999e-07 159.21250000000001p 1.5918430000000001e-07 159.22500000000002p 1.5950679999999999e-07 159.23749999999998p 1.5972260000000001e-07 159.25p 1.5982880000000001e-07 159.26249999999999p 1.5982240000000001e-07 159.27500000000001p 1.5970070000000001e-07 159.28749999999999p 1.5946079999999999e-07 159.30000000000001p 1.5910010000000001e-07
+ 159.3125p 1.58616e-07 159.32499999999999p 1.580062e-07 159.33750000000001p 1.5726819999999999e-07 159.34999999999999p 1.5639990000000001e-07 159.36250000000001p 1.553993e-07 159.375p 1.5426459999999999e-07 159.38750000000002p 1.5299420000000001e-07 159.39999999999998p 1.515866e-07 159.41249999999999p 1.5004070000000001e-07 159.42499999999998p 1.483554e-07 159.4375p 1.4653e-07 159.44999999999999p 1.44564e-07 159.46250000000001p 1.424572e-07 159.47500000000002p 1.4020959999999999e-07 159.48749999999998p 1.3782149999999999e-07 159.5p 1.3529350000000001e-07 159.51249999999999p 1.3262640000000001e-07 159.52500000000001p 1.298215e-07
+ 159.53749999999999p 1.268801e-07 159.55000000000001p 1.2380399999999999e-07 159.5625p 1.205954e-07 159.57499999999999p 1.172564e-07 159.58750000000001p 1.137898e-07 159.59999999999999p 1.101986e-07 159.61250000000001p 1.06486e-07 159.625p 1.026555e-07 159.63750000000002p 9.8711139999999995e-08 159.65000000000001p 9.4656910000000003e-08 159.66249999999999p 9.0497299999999996e-08 159.67499999999998p 8.6237010000000003e-08 159.6875p 8.1881029999999993e-08 159.69999999999999p 7.7434620000000003e-08 159.71250000000001p 7.2903279999999998e-08 159.72500000000002p 6.8292770000000001e-08 159.73749999999998p 6.3609079999999996e-08 159.75p 5.8858430000000001e-08
+ 159.76249999999999p 5.4047270000000001e-08 159.77500000000001p 4.9182220000000001e-08 159.78749999999999p 4.4270119999999997e-08 159.80000000000001p 3.9317980000000002e-08 159.8125p 3.4332949999999998e-08 159.82499999999999p 2.9322349999999999e-08 159.83750000000001p 2.429364e-08 159.84999999999999p 1.925437e-08 159.86250000000001p 1.4212220000000001e-08 159.875p 9.1749160000000008e-09 159.88750000000002p 4.1502910000000001e-09 159.90000000000001p -8.5379370000000005e-10 159.91249999999999p -5.8294410000000004e-09 159.92499999999998p -1.076874e-08 159.9375p -1.566378e-08 159.94999999999999p -2.050667e-08 159.96250000000001p -2.5289569999999999e-08 159.97499999999999p -3.0004689999999997e-08
+ 159.98750000000001p -3.4644319999999999e-08 160p -3.920085e-08 160.01249999999999p -4.3666759999999999e-08 160.02500000000001p -4.803471e-08 160.03749999999999p -5.229745e-08 160.05000000000001p -5.6447950000000001e-08 160.0625p -6.0479349999999994e-08 160.07499999999999p -6.4384970000000001e-08 160.08749999999998p -6.8158390000000006e-08 160.09999999999999p -7.1793399999999995e-08 160.11250000000001p -7.5284059999999994e-08 160.125p -7.8624690000000005e-08 160.13750000000002p -8.1809899999999997e-08 160.15000000000001p -8.483459e-08 160.16249999999999p -8.7694000000000004e-08 160.17499999999998p -9.0383680000000001e-08 160.1875p -9.2899510000000001e-08 160.19999999999999p -9.5237740000000005e-08
+ 160.21250000000001p -9.7394989999999996e-08 160.22499999999999p -9.9368240000000004e-08 160.23750000000001p -1.011549e-07 160.25p -1.027526e-07 160.26249999999999p -1.041597e-07 160.27500000000001p -1.0537459999999999e-07 160.28749999999999p -1.063964e-07 160.30000000000001p -1.072244e-07 160.3125p -1.078586e-07 160.32500000000002p -1.082991e-07 160.33749999999998p -1.085466e-07 160.34999999999999p -1.0860220000000001e-07 160.36250000000001p -1.084675e-07 160.375p -1.081444e-07 160.38750000000002p -1.0763519999999999e-07 160.40000000000001p -1.069429e-07 160.41249999999999p -1.060705e-07 160.42499999999998p -1.050217e-07
+ 160.4375p -1.038006e-07 160.44999999999999p -1.024114e-07 160.46250000000001p -1.008589e-07 160.47499999999999p -9.9148389999999994e-08 160.48750000000001p -9.7285249999999994e-08 160.5p -9.5275359999999993e-08 160.51249999999999p -9.3124879999999997e-08 160.52500000000001p -9.0840290000000005e-08 160.53749999999999p -8.8428380000000005e-08 160.55000000000001p -8.5896219999999994e-08 160.5625p -8.3251130000000004e-08 160.57500000000002p -8.0500699999999998e-08 160.58749999999998p -7.7652720000000004e-08 160.59999999999999p -7.4715219999999995e-08 160.61250000000001p -7.1696410000000001e-08 160.625p -6.8604640000000002e-08 160.63750000000002p -6.5448449999999996e-08 160.65000000000001p -6.2236479999999996e-08
+ 160.66250000000002p -5.8977490000000003e-08 160.67499999999998p -5.5680300000000003e-08 160.6875p -5.2353820000000002e-08 160.69999999999999p -4.900699e-08 160.71250000000001p -4.564875e-08 160.72499999999999p -4.228806e-08 160.73750000000001p -3.8933830000000002e-08 160.75p -3.5594949999999999e-08 160.76249999999999p -3.2280210000000003e-08 160.77500000000001p -2.8998329999999999e-08 160.78749999999999p -2.5757899999999999e-08 160.80000000000001p -2.2567390000000001e-08 160.8125p -1.943511e-08 160.82500000000002p -1.636919e-08 160.83749999999998p -1.3377600000000001e-08 160.84999999999999p -1.0468049999999999e-08 160.86249999999998p -7.6480559999999997e-09 160.875p -4.9248780000000002e-09
+ 160.88750000000002p -2.3055120000000001e-09 160.90000000000001p 2.033259e-10 160.91250000000002p 2.5952110000000001e-09 160.92499999999998p 4.8640280000000004e-09 160.9375p 7.0039829999999998e-09 160.94999999999999p 9.0096190000000003e-09 160.96250000000001p 1.087582e-08 160.97499999999999p 1.259784e-08 160.98750000000001p 1.417128e-08 161p 1.559213e-08 161.01249999999999p 1.6856779999999999e-08 161.02500000000001p 1.7961979999999999e-08 161.03749999999999p 1.8904920000000001e-08 161.05000000000001p 1.968314e-08 161.0625p 2.0294649999999998e-08 161.07500000000002p 2.0737839999999999e-08 161.08749999999998p 2.1011519999999999e-08 161.09999999999999p 2.1114919999999998e-08
+ 161.11249999999998p 2.1047710000000001e-08 161.125p 2.080994e-08 161.13750000000002p 2.0402120000000002e-08 161.15000000000001p 1.9825169999999998e-08 161.16250000000002p 1.9080410000000001e-08 161.17499999999998p 1.8169590000000002e-08 161.1875p 1.709487e-08 161.19999999999999p 1.5858819999999999e-08 161.21250000000001p 1.44644e-08 161.22499999999999p 1.2914970000000001e-08 161.23750000000001p 1.121428e-08 161.25p 9.3664629999999996e-09 161.26249999999999p 7.3760199999999999e-09 161.27500000000001p 5.2478190000000003e-09 161.28749999999999p 2.9870790000000001e-09 161.30000000000001p 5.9936470000000004e-10 161.3125p -1.9094290000000002e-09 161.32500000000002p -4.5330849999999998e-09
+ 161.33750000000001p -7.2650790000000004e-09 161.34999999999999p -1.009859e-08 161.36249999999998p -1.3026530000000001e-08 161.375p -1.6041510000000002e-08 161.38749999999999p -1.9135940000000001e-08 161.40000000000001p -2.2301940000000001e-08 161.41250000000002p -2.553146e-08 161.42499999999998p -2.8816209999999999e-08 161.4375p -3.2147740000000001e-08 161.44999999999999p -3.5517409999999998e-08 161.46250000000001p -3.8916459999999997e-08 161.47499999999999p -4.233597e-08 161.48750000000001p -4.5766920000000003e-08 161.5p -4.9200220000000001e-08 161.51249999999999p -5.2626669999999999e-08 161.52500000000001p -5.6037049999999997e-08 161.53749999999999p -5.94221e-08 161.55000000000001p -6.2772540000000001e-08
+ 161.5625p -6.6079130000000001e-08 161.57500000000002p -6.9332629999999997e-08 161.58750000000001p -7.2523879999999996e-08 161.59999999999999p -7.5643790000000005e-08 161.61249999999998p -7.8683359999999999e-08 161.625p -8.1633720000000005e-08 161.63749999999999p -8.4486130000000001e-08 161.65000000000001p -8.7232029999999999e-08 161.66250000000002p -8.9863019999999995e-08 161.67499999999998p -9.2370929999999998e-08 161.6875p -9.4747799999999998e-08 161.69999999999999p -9.6985909999999997e-08 161.71250000000001p -9.9077820000000004e-08 161.72499999999999p -1.010164e-07 161.73750000000001p -1.027947e-07 161.75p -1.044062e-07 161.76249999999999p -1.0584479999999999e-07 161.77500000000001p -1.071046e-07
+ 161.78749999999999p -1.0818000000000001e-07 161.80000000000001p -1.090661e-07 161.8125p -1.097581e-07 161.82500000000002p -1.102517e-07 161.83750000000001p -1.105431e-07 161.84999999999999p -1.106289e-07 161.86249999999998p -1.10506e-07 161.875p -1.10172e-07 161.88749999999999p -1.0962480000000001e-07 161.90000000000001p -1.088627e-07 161.91249999999999p -1.078847e-07 161.92500000000001p -1.066902e-07 161.9375p -1.052788e-07 161.94999999999999p -1.0365100000000001e-07 161.96250000000001p -1.0180749999999999e-07 161.97499999999999p -9.9749610000000005e-08 161.98750000000001p -9.7479029999999999e-08 162p -9.4997979999999995e-08
+ 162.01249999999999p -9.2309130000000005e-08 162.02499999999998p -8.941561e-08 162.03749999999999p -8.6321010000000006e-08 162.05000000000001p -8.3029360000000004e-08 162.0625p -7.9545110000000004e-08 162.07500000000002p -7.5873139999999999e-08 162.08750000000001p -7.2018749999999998e-08 162.09999999999999p -6.7987619999999998e-08 162.11249999999998p -6.3785819999999995e-08 162.125p -5.9419780000000001e-08 162.13749999999999p -5.4896280000000001e-08 162.15000000000001p -5.0222459999999999e-08 162.16249999999999p -4.540574e-08 162.17500000000001p -4.0453860000000001e-08 162.1875p -3.5374830000000003e-08 162.19999999999999p -3.0176929999999997e-08 162.21250000000001p -2.486868e-08 162.22499999999999p -1.9458810000000001e-08
+ 162.23750000000001p -1.395626e-08 162.25p -8.3701460000000001e-09 162.26250000000002p -2.7097450000000001e-09 162.27499999999998p 3.015532e-09 162.28749999999999p 8.7961549999999996e-09 162.30000000000001p 1.4622500000000001e-08 162.3125p 2.0484869999999999e-08 162.32500000000002p 2.6373500000000001e-08 162.33750000000001p 3.2278619999999999e-08 162.34999999999999p 3.8190420000000001e-08 162.36249999999998p 4.4099120000000002e-08 162.375p 4.9994950000000003e-08 162.38749999999999p 5.5868190000000002e-08 162.40000000000001p 6.1709190000000001e-08 162.41249999999999p 6.7508389999999997e-08 162.42500000000001p 7.3256329999999997e-08 162.4375p 7.8943649999999996e-08 162.44999999999999p 8.4561140000000004e-08
+ 162.46250000000001p 9.0099759999999996e-08 162.47499999999999p 9.5550620000000004e-08 162.48750000000001p 1.00905e-07 162.5p 1.0615439999999999e-07 162.51250000000002p 1.112905e-07 162.52499999999998p 1.163053e-07 162.53749999999999p 1.211909e-07 162.54999999999998p 1.259397e-07 162.5625p 1.305444e-07 162.57500000000002p 1.3499790000000001e-07 162.58750000000001p 1.3929349999999999e-07 162.60000000000002p 1.4342460000000001e-07 162.61249999999998p 1.4738510000000001e-07 162.625p 1.5116909999999999e-07 162.63749999999999p 1.5477090000000001e-07 162.65000000000001p 1.5818519999999999e-07 162.66249999999999p 1.6140719999999999e-07 162.67500000000001p 1.644323e-07
+ 162.6875p 1.67256e-07 162.69999999999999p 1.698744e-07 162.71250000000001p 1.7228400000000001e-07 162.72499999999999p 1.744815e-07 162.73750000000001p 1.764638e-07 162.75p 1.7822839999999999e-07 162.76250000000002p 1.797731e-07 162.77499999999998p 1.810959e-07 162.78749999999999p 1.821953e-07 162.79999999999998p 1.8307000000000001e-07 162.8125p 1.8371919999999999e-07 162.82500000000002p 1.8414230000000001e-07 162.83750000000001p 1.843393e-07 162.85000000000002p 1.8431010000000001e-07 162.86249999999998p 1.8405529999999999e-07 162.875p 1.835757e-07 162.88749999999999p 1.8287239999999999e-07 162.90000000000001p 1.8194700000000001e-07
+ 162.91249999999999p 1.8080119999999999e-07 162.92500000000001p 1.794372e-07 162.9375p 1.7785730000000001e-07 162.94999999999999p 1.7606430000000001e-07 162.96250000000001p 1.740612e-07 162.97499999999999p 1.718513e-07 162.98750000000001p 1.6943829999999999e-07 163p 1.6682599999999999e-07 163.01250000000002p 1.6401849999999999e-07 163.02499999999998p 1.6102039999999999e-07 163.03749999999999p 1.5783629999999999e-07 163.04999999999998p 1.544711e-07 163.0625p 1.5092999999999999e-07 163.07500000000002p 1.4721840000000001e-07 163.08750000000001p 1.433418e-07 163.10000000000002p 1.393062e-07 163.11249999999998p 1.3511749999999999e-07 163.125p 1.3078189999999999e-07
+ 163.13749999999999p 1.2630580000000001e-07 163.15000000000001p 1.216958e-07 163.16249999999999p 1.1695849999999999e-07 163.17500000000001p 1.121007e-07 163.1875p 1.071296e-07 163.19999999999999p 1.0205200000000001e-07 163.21250000000001p 9.6875180000000003e-08 163.22499999999999p 9.1606430000000005e-08 163.23750000000001p 8.6253060000000004e-08 163.25p 8.0822470000000005e-08 163.26250000000002p 7.5322110000000006e-08 163.27500000000001p 6.9759450000000001e-08 163.28749999999999p 6.4142010000000003e-08 163.29999999999998p 5.8477259999999998e-08 163.3125p 5.2772729999999999e-08 163.32499999999999p 4.703588e-08 163.33750000000001p 4.1274140000000001e-08 163.35000000000002p 3.5494920000000002e-08
+ 163.36249999999998p 2.9705530000000001e-08 163.375p 2.3913230000000001e-08 163.38749999999999p 1.812519e-08 163.40000000000001p 1.234845e-08 163.41249999999999p 6.5899810000000003e-09 163.42500000000001p 8.5659120000000001e-10 163.4375p -4.845032e-09 163.44999999999999p -1.050835e-08 163.46250000000001p -1.6126999999999999e-08 163.47499999999999p -2.169476e-08 163.48750000000001p -2.720561e-08 163.5p -3.2653710000000003e-08 163.51250000000002p -3.8033429999999999e-08 163.52500000000001p -4.3339319999999998e-08 163.53749999999999p -4.8566170000000001e-08 163.54999999999998p -5.3708969999999998e-08 163.5625p -5.8762929999999999e-08 163.57499999999999p -6.3723520000000001e-08
+ 163.58750000000001p -6.8586420000000004e-08 163.60000000000002p -7.3347549999999998e-08 163.61250000000001p -7.8003079999999999e-08 163.625p -8.2549409999999999e-08 163.63749999999999p -8.6983200000000003e-08 163.65000000000001p -9.130136e-08 163.66249999999999p -9.5501019999999996e-08 163.67500000000001p -9.9579579999999994e-08 163.6875p -1.035347e-07 163.69999999999999p -1.0736420000000001e-07 163.71250000000001p -1.1106619999999999e-07 163.72499999999999p -1.146391e-07 163.73750000000001p -1.180815e-07 163.75p -1.213921e-07 163.76250000000002p -1.2457000000000001e-07 163.77500000000001p -1.2761450000000001e-07 163.78749999999999p -1.3052489999999999e-07 163.79999999999998p -1.3330100000000001e-07
+ 163.8125p -1.3594259999999999e-07 163.82499999999999p -1.384497e-07 163.83750000000001p -1.4082259999999999e-07 163.84999999999999p -1.4306159999999999e-07 163.86250000000001p -1.451672e-07 163.875p -1.4714019999999999e-07 163.88749999999999p -1.4898149999999999e-07 163.90000000000001p -1.5069189999999999e-07 163.91249999999999p -1.5227249999999999e-07 163.92500000000001p -1.5372470000000001e-07 163.9375p -1.5504960000000001e-07 163.95000000000002p -1.5624870000000001e-07 163.96249999999998p -1.573235e-07 163.97499999999999p -1.5827560000000001e-07 163.98750000000001p -1.5910650000000001e-07 164p -1.598181e-07 164.01250000000002p -1.604119e-07 164.02500000000001p -1.6088989999999999e-07
+ 164.03749999999999p -1.6125369999999999e-07 164.04999999999998p -1.6150529999999999e-07 164.0625p -1.6164640000000001e-07 164.07499999999999p -1.61679e-07 164.08750000000001p -1.6160480000000001e-07 164.09999999999999p -1.6142579999999999e-07 164.11250000000001p -1.611437e-07 164.125p -1.6076039999999999e-07 164.13749999999999p -1.602777e-07 164.15000000000001p -1.5969730000000001e-07 164.16249999999999p -1.5902090000000001e-07 164.17500000000001p -1.5825030000000001e-07 164.1875p -1.5738700000000001e-07 164.20000000000002p -1.564328e-07 164.21249999999998p -1.5538910000000001e-07 164.22499999999999p -1.5425749999999999e-07 164.23750000000001p -1.5303939999999999e-07 164.25p -1.5173630000000001e-07
+ 164.26250000000002p -1.5034950000000001e-07 164.27500000000001p -1.4888039999999999e-07 164.28749999999999p -1.473301e-07 164.29999999999998p -1.456999e-07 164.3125p -1.4399100000000001e-07 164.32499999999999p -1.4220439999999999e-07 164.33750000000001p -1.403413e-07 164.34999999999999p -1.384026e-07 164.36250000000001p -1.3638950000000001e-07 164.375p -1.3430270000000001e-07 164.38749999999999p -1.321432e-07 164.40000000000001p -1.2991189999999999e-07 164.41249999999999p -1.2760970000000001e-07 164.42500000000001p -1.2523739999999999e-07 164.4375p -1.2279570000000001e-07 164.45000000000002p -1.2028550000000001e-07 164.46249999999998p -1.177076e-07 164.47499999999999p -1.1506280000000001e-07
+ 164.48749999999998p -1.123518e-07 164.5p -1.095754e-07 164.51250000000002p -1.067343e-07 164.52500000000001p -1.038295e-07 164.53750000000002p -1.008616e-07 164.54999999999998p -9.7831640000000003e-08 164.5625p -9.4740319999999996e-08 164.57499999999999p -9.1588589999999995e-08 164.58750000000001p -8.8377370000000003e-08 164.59999999999999p -8.5107619999999995e-08 164.61250000000001p -8.1780360000000004e-08 164.625p -7.8396630000000005e-08 164.63749999999999p -7.4957549999999997e-08 164.65000000000001p -7.1464279999999994e-08 164.66249999999999p -6.7918030000000003e-08 164.67500000000001p -6.4320100000000002e-08 164.6875p -6.0671840000000004e-08 164.70000000000002p -5.6974660000000003e-08
+ 164.71249999999998p -5.3230049999999997e-08 164.72499999999999p -4.9439580000000003e-08 164.73749999999998p -4.5604899999999998e-08 164.75p -4.1727710000000002e-08 164.76250000000002p -3.7809840000000001e-08 164.77500000000001p -3.385315e-08 164.78750000000002p -2.9859620000000002e-08 164.79999999999998p -2.5831320000000001e-08 164.8125p -2.1770360000000001e-08 164.82499999999999p -1.7678999999999999e-08 164.83750000000001p -1.3559539999999999e-08 164.84999999999999p -9.4143809999999998e-09 164.86250000000001p -5.2460260000000003e-09 164.875p -1.0570510000000001e-09 164.88749999999999p 3.1498770000000002e-09 164.90000000000001p 7.3720049999999997e-09 164.91249999999999p 1.1606490000000001e-08 164.92500000000001p 1.5850420000000001e-08
+ 164.9375p 2.0100779999999998e-08 164.95000000000002p 2.4354500000000001e-08 164.96249999999998p 2.8608389999999999e-08 164.97499999999999p 3.2859229999999997e-08 164.98749999999998p 3.7103700000000003e-08 165p 4.1338419999999998e-08 165.01249999999999p 4.5559930000000003e-08 165.02500000000001p 4.9764710000000003e-08 165.03750000000002p 5.394918e-08 165.04999999999998p 5.8109699999999999e-08 165.0625p 6.2242579999999995e-08 165.07499999999999p 6.6344070000000004e-08 165.08750000000001p 7.0410390000000005e-08 165.09999999999999p 7.4437689999999995e-08 165.11250000000001p 7.8422119999999998e-08 165.125p 8.2359749999999997e-08 165.13749999999999p 8.6246669999999999e-08 165.15000000000001p 9.007891e-08
+ 165.16249999999999p 9.3852499999999999e-08 165.17500000000001p 9.7563459999999999e-08 165.1875p 1.012078e-07 165.20000000000002p 1.047815e-07 165.21250000000001p 1.082805e-07 165.22499999999999p 1.11701e-07 165.23749999999998p 1.150389e-07 165.25p 1.1829020000000001e-07 165.26249999999999p 1.2145110000000001e-07 165.27500000000001p 1.245177e-07 165.28750000000002p 1.2748600000000001e-07 165.29999999999998p 1.303524e-07 165.3125p 1.331131e-07 165.32499999999999p 1.357643e-07 165.33750000000001p 1.3830240000000001e-07 165.34999999999999p 1.4072400000000001e-07 165.36250000000001p 1.4302539999999999e-07 165.375p 1.452034e-07
+ 165.38749999999999p 1.4725460000000001e-07 165.40000000000001p 1.491758e-07 165.41249999999999p 1.5096390000000001e-07 165.42500000000001p 1.526159e-07 165.4375p 1.5412899999999999e-07 165.45000000000002p 1.555005e-07 165.46250000000001p 1.567276e-07 165.47499999999999p 1.5780789999999999e-07 165.48749999999998p 1.5873919999999999e-07 165.5p 1.5951910000000001e-07 165.51249999999999p 1.601458e-07 165.52500000000001p 1.606172e-07 165.53750000000002p 1.6093179999999999e-07 165.55000000000001p 1.6108799999999999e-07 165.5625p 1.6108440000000001e-07 165.57499999999999p 1.609199e-07 165.58750000000001p 1.605935e-07 165.59999999999999p 1.6010440000000001e-07
+ 165.61250000000001p 1.5945210000000001e-07 165.625p 1.586362e-07 165.63749999999999p 1.5765650000000001e-07 165.65000000000001p 1.5651310000000001e-07 165.66249999999999p 1.552062e-07 165.67500000000001p 1.5373639999999999e-07 165.6875p 1.521043e-07 165.70000000000002p 1.5031090000000001e-07 165.71250000000001p 1.4835730000000001e-07 165.72499999999999p 1.46245e-07 165.73749999999998p 1.439756e-07 165.75p 1.415509e-07 165.76249999999999p 1.389731e-07 165.77500000000001p 1.3624440000000001e-07 165.78749999999999p 1.3336760000000001e-07 165.80000000000001p 1.303453e-07 165.8125p 1.271807e-07 165.82499999999999p 1.2387710000000001e-07
+ 165.83750000000001p 1.2043789999999999e-07 165.84999999999999p 1.168669e-07 165.86250000000001p 1.131682e-07 165.875p 1.0934579999999999e-07 165.88750000000002p 1.054043e-07 165.89999999999998p 1.013483e-07 165.91249999999999p 9.7182740000000001e-08 165.92500000000001p 9.2912580000000005e-08 165.9375p 8.8543159999999999e-08 165.95000000000002p 8.4079940000000003e-08 165.96250000000001p 7.9528600000000002e-08 165.97499999999999p 7.4894980000000004e-08 165.98749999999998p 7.0185110000000005e-08 166p 6.5405170000000004e-08 166.01249999999999p 6.0561510000000006e-08 166.02500000000001p 5.5660620000000003e-08 166.03749999999999p 5.0709130000000003e-08 166.05000000000001p 4.5713799999999997e-08
+ 166.0625p 4.0681499999999999e-08 166.07499999999999p 3.56192e-08 166.08750000000001p 3.0533969999999998e-08 166.09999999999999p 2.5432950000000001e-08 166.11250000000001p 2.0323359999999998e-08 166.125p 1.5212449999999999e-08 166.13750000000002p 1.0107519999999999e-08 166.14999999999998p 5.0159129999999996e-09 166.16249999999999p -5.5047440000000002e-11 166.17500000000001p -5.0980269999999999e-09 166.1875p -1.010571e-08 166.20000000000002p -1.5070829999999999e-08 166.21250000000001p -1.9986149999999999e-08 166.22500000000002p -2.4844500000000001e-08 166.23749999999998p -2.963882e-08 166.25p -3.4362099999999999e-08 166.26249999999999p -3.9007480000000001e-08 166.27500000000001p -4.3568209999999998e-08
+ 166.28749999999999p -4.803768e-08 166.30000000000001p -5.2409450000000001e-08 166.3125p -5.6677240000000002e-08 166.32499999999999p -6.0834960000000002e-08 166.33750000000001p -6.4876730000000006e-08 166.34999999999999p -6.8796880000000005e-08 166.36250000000001p -7.2589960000000004e-08 166.375p -7.6250790000000005e-08 166.38750000000002p -7.9774410000000002e-08 166.39999999999998p -8.3156139999999999e-08 166.41249999999999p -8.6391600000000002e-08 166.42499999999998p -8.9476680000000005e-08 166.4375p -9.2407559999999995e-08 166.45000000000002p -9.5180750000000003e-08 166.46250000000001p -9.7793080000000007e-08 166.47500000000002p -1.002417e-07 166.48749999999998p -1.02524e-07 166.5p -1.04638e-07
+ 166.51249999999999p -1.065817e-07 166.52500000000001p -1.083536e-07 166.53749999999999p -1.099526e-07 166.55000000000001p -1.1137800000000001e-07 166.5625p -1.126294e-07 166.57499999999999p -1.137065e-07 166.58750000000001p -1.146099e-07 166.59999999999999p -1.1534e-07 166.61250000000001p -1.158979e-07 166.625p -1.16285e-07 166.63750000000002p -1.165029e-07 166.64999999999998p -1.165537e-07 166.66249999999999p -1.164397e-07 166.67499999999998p -1.161637e-07 166.6875p -1.157287e-07 166.70000000000002p -1.151379e-07 166.71250000000001p -1.14395e-07 166.72500000000002p -1.135039e-07
+ 166.73749999999998p -1.124688e-07 166.75p -1.112942e-07 166.76249999999999p -1.099847e-07 166.77500000000001p -1.0854519999999999e-07 166.78749999999999p -1.06981e-07 166.80000000000001p -1.0529749999999999e-07 166.8125p -1.0349999999999999e-07 166.82499999999999p -1.015945e-07 166.83750000000001p -9.9586859999999999e-08 166.84999999999999p -9.7483030000000003e-08 166.86250000000001p -9.5289249999999994e-08 166.875p -9.3011790000000005e-08 166.88750000000002p -9.0657040000000002e-08 166.89999999999998p -8.8231449999999996e-08 166.91249999999999p -8.5741549999999997e-08 166.92499999999998p -8.3193900000000005e-08 166.9375p -8.059508e-08 166.94999999999999p -7.7951700000000006e-08
+ 166.96250000000001p -7.5270330000000004e-08 166.97500000000002p -7.2557550000000002e-08 166.98749999999998p -6.9819870000000004e-08 167p -6.706376e-08 167.01249999999999p -6.4295619999999994e-08 167.02500000000001p -6.1521750000000006e-08 167.03749999999999p -5.8748349999999997e-08 167.05000000000001p -5.5981519999999997e-08 167.0625p -5.3227209999999998e-08 167.07499999999999p -5.0491229999999999e-08 167.08750000000001p -4.7779239999999998e-08 167.09999999999999p -4.5096750000000003e-08 167.11250000000001p -4.2449050000000001e-08 167.125p -3.9841280000000002e-08 167.13750000000002p -3.7278369999999997e-08 167.15000000000001p -3.4765029999999997e-08 167.16249999999999p -3.2305760000000001e-08 167.17499999999998p -2.9904850000000001e-08
+ 167.1875p -2.7566349999999999e-08 167.19999999999999p -2.529408e-08 167.21250000000001p -2.3091590000000001e-08 167.22500000000002p -2.096222e-08 167.23749999999998p -1.890904e-08 167.25p -1.6934880000000001e-08 167.26249999999999p -1.504229e-08 167.27500000000001p -1.323358e-08 167.28749999999999p -1.151081e-08 167.30000000000001p -9.8757470000000006e-09 167.3125p -8.3299310000000003e-09 167.32499999999999p -6.8746280000000001e-09 167.33750000000001p -5.5108460000000002e-09 167.34999999999999p -4.2393419999999998e-09 167.36250000000001p -3.060617e-09 167.375p -1.9749219999999999e-09 167.38750000000002p -9.822617e-10 167.40000000000001p -8.2399529999999995e-11
+ 167.41249999999999p 7.2514060000000003e-10 167.42499999999998p 1.4410669999999999e-09 167.4375p 2.0663169999999998e-09 167.44999999999999p 2.602047e-09 167.46250000000001p 3.0496320000000002e-09 167.47499999999999p 3.410654e-09 167.48750000000001p 3.6869000000000002e-09 167.5p 3.8803490000000002e-09 167.51249999999999p 3.9931709999999997e-09 167.52500000000001p 4.0277140000000004e-09 167.53749999999999p 3.9864990000000003e-09 167.55000000000001p 3.8722110000000001e-09 167.5625p 3.687691e-09 167.57499999999999p 3.4359289999999998e-09 167.58749999999998p 3.1200500000000002e-09 167.59999999999999p 2.7433119999999999e-09 167.61250000000001p 2.3090920000000002e-09 167.625p 1.8208809999999999e-09
+ 167.63750000000002p 1.282272e-09 167.65000000000001p 6.9695009999999999e-10 167.66249999999999p 6.8686569999999995e-11 167.67499999999998p -5.9867320000000005e-10 167.6875p -1.301218e-09 167.69999999999999p -2.0349809999999998e-09 167.71250000000001p -2.7959469999999999e-09 167.72499999999999p -3.5800650000000001e-09 167.73750000000001p -4.3832549999999997e-09 167.75p -5.2014190000000001e-09 167.76249999999999p -6.0304500000000004e-09 167.77500000000001p -6.8662399999999996e-09 167.78749999999999p -7.7046909999999993e-09 167.80000000000001p -8.5417220000000004e-09 167.8125p -9.3732800000000005e-09 167.82500000000002p -1.019535e-08 167.83749999999998p -1.1003959999999999e-08 167.84999999999999p -1.179519e-08
+ 167.86250000000001p -1.25652e-08 167.875p -1.3310179999999999e-08 167.88750000000002p -1.4026450000000001e-08 167.90000000000001p -1.4710379999999999e-08 167.91249999999999p -1.5358449999999999e-08 167.92499999999998p -1.596724e-08 167.9375p -1.6533440000000001e-08 167.94999999999999p -1.705386e-08 167.96250000000001p -1.7525440000000001e-08 167.97499999999999p -1.794524e-08 167.98750000000001p -1.8310460000000001e-08 168p -1.861845e-08 168.01249999999999p -1.886671e-08 168.02500000000001p -1.905288e-08 168.03749999999999p -1.9174780000000001e-08 168.05000000000001p -1.9230399999999999e-08 168.0625p -1.9217869999999999e-08 168.07500000000002p -1.9135529999999999e-08
+ 168.08749999999998p -1.8981869999999999e-08 168.09999999999999p -1.8755570000000001e-08 168.11250000000001p -1.8455509999999999e-08 168.125p -1.8080740000000001e-08 168.13750000000002p -1.763049e-08 168.15000000000001p -1.7104219999999999e-08 168.16250000000002p -1.650155e-08 168.17499999999998p -1.5822290000000001e-08 168.1875p -1.5066470000000002e-08 168.19999999999999p -1.423428e-08 168.21250000000001p -1.332615e-08 168.22499999999999p -1.2342659999999999e-08 168.23750000000001p -1.128459e-08 168.25p -1.0152940000000001e-08 168.26249999999999p -8.9488530000000007e-09 168.27500000000001p -7.6736889999999999e-09 168.28749999999999p -6.3289770000000001e-09 168.30000000000001p -4.9164269999999996e-09
+ 168.3125p -3.4379240000000001e-09 168.32500000000002p -1.8955219999999999e-09 168.33749999999998p -2.914417e-10 168.34999999999999p 1.371937e-09 168.36249999999998p 3.092079e-09 168.375p 4.8662980000000002e-09 168.38750000000002p 6.6917680000000001e-09 168.40000000000001p 8.5655230000000006e-09 168.41250000000002p 1.0484470000000001e-08 168.42499999999998p 1.24454e-08 168.4375p 1.444497e-08 168.44999999999999p 1.6479739999999999e-08 168.46250000000001p 1.8546180000000001e-08 168.47499999999999p 2.064066e-08 168.48750000000001p 2.275947e-08 168.5p 2.4898809999999999e-08 168.51249999999999p 2.7054839999999998e-08 168.52500000000001p 2.9223639999999999e-08
+ 168.53749999999999p 3.1401260000000001e-08 168.55000000000001p 3.3583689999999999e-08 168.5625p 3.5766910000000003e-08 168.57500000000002p 3.7946879999999997e-08 168.58749999999998p 4.011953e-08 168.59999999999999p 4.2280789999999999e-08 168.61249999999998p 4.4426620000000003e-08 168.625p 4.6552969999999997e-08 168.63750000000002p 4.8655830000000001e-08 168.65000000000001p 5.0731219999999997e-08 168.66250000000002p 5.2775190000000002e-08 168.67499999999998p 5.4783859999999998e-08 168.6875p 5.67534e-08 168.69999999999999p 5.8680050000000003e-08 168.71250000000001p 6.0560130000000003e-08 168.72499999999999p 6.2390040000000004e-08 168.73750000000001p 6.4166269999999994e-08 168.75p 6.5885419999999999e-08
+ 168.76249999999999p 6.754419e-08 168.77500000000001p 6.9139400000000003e-08 168.78749999999999p 7.0667970000000005e-08 168.80000000000001p 7.2126980000000001e-08 168.8125p 7.351363e-08 168.82500000000002p 7.4825239999999994e-08 168.83750000000001p 7.6059289999999999e-08 168.84999999999999p 7.7213430000000003e-08 168.86249999999998p 7.8285420000000004e-08 168.875p 7.9273220000000002e-08 168.88749999999999p 8.0174929999999999e-08 168.90000000000001p 8.0988819999999994e-08 168.91250000000002p 8.1713330000000004e-08 168.92499999999998p 8.2347059999999995e-08 168.9375p 8.2888809999999994e-08 168.94999999999999p 8.3337519999999994e-08 168.96250000000001p 8.3692350000000005e-08 168.97499999999999p 8.3952590000000006e-08
+ 168.98750000000001p 8.4117739999999996e-08 169p 8.4187469999999996e-08 169.01249999999999p 8.4161630000000004e-08 169.02500000000001p 8.4040230000000004e-08 169.03749999999999p 8.3823480000000003e-08 169.05000000000001p 8.3511739999999997e-08 169.0625p 8.3105570000000005e-08 169.07500000000002p 8.2605669999999999e-08 169.08750000000001p 8.2012909999999999e-08 169.09999999999999p 8.1328340000000001e-08 169.11249999999998p 8.0553160000000005e-08 169.125p 7.9688719999999997e-08 169.13749999999999p 7.8736509999999995e-08 169.15000000000001p 7.769819e-08 169.16250000000002p 7.6575539999999996e-08 169.17500000000001p 7.5370489999999997e-08 169.1875p 7.4085069999999994e-08 169.19999999999999p 7.2721449999999998e-08
+ 169.21250000000001p 7.128193e-08 169.22499999999999p 6.9768879999999996e-08 169.23750000000001p 6.8184809999999997e-08 169.25p 6.6532300000000006e-08 169.26249999999999p 6.4814019999999994e-08 169.27500000000001p 6.3032730000000006e-08 169.28749999999999p 6.1191240000000006e-08 169.30000000000001p 5.9292449999999997e-08 169.3125p 5.7339279999999998e-08 169.32500000000002p 5.5334740000000002e-08 169.33750000000001p 5.3281840000000002e-08 169.34999999999999p 5.1183640000000001e-08 169.36249999999998p 4.9043209999999999e-08 169.375p 4.6863659999999999e-08 169.38749999999999p 4.4648080000000003e-08 169.40000000000001p 4.2399560000000001e-08 169.41249999999999p 4.0121200000000003e-08 169.42500000000001p 3.7816050000000002e-08
+ 169.4375p 3.548717e-08 169.44999999999999p 3.3137569999999997e-08 169.46250000000001p 3.0770209999999998e-08 169.47499999999999p 2.8388029999999999e-08 169.48750000000001p 2.5993899999999999e-08 169.5p 2.3590610000000001e-08 169.51249999999999p 2.118094e-08 169.52499999999998p 1.8767539999999999e-08 169.53749999999999p 1.6353020000000001e-08 169.55000000000001p 1.3939890000000001e-08 169.5625p 1.1530579999999999e-08 169.57500000000002p 9.1274399999999992e-09 169.58750000000001p 6.7327069999999999e-09 169.59999999999999p 4.3485299999999997e-09 169.61249999999998p 1.976957e-09 169.625p -3.8006809999999998e-10 169.63749999999999p -2.7207060000000002e-09 169.65000000000001p -5.043223e-09
+ 169.66249999999999p -7.3459950000000001e-09 169.67500000000001p -9.6275039999999993e-09 169.6875p -1.1886340000000001e-08 169.69999999999999p -1.412121e-08 169.71250000000001p -1.633092e-08 169.72499999999999p -1.8514369999999998e-08 169.73750000000001p -2.0670589999999999e-08 169.75p -2.2798690000000002e-08 169.76250000000002p -2.489791e-08 169.77499999999998p -2.6967539999999999e-08 169.78749999999999p -2.9007019999999999e-08 169.80000000000001p -3.1015829999999997e-08 169.8125p -3.2993569999999999e-08 169.82500000000002p -3.4939900000000002e-08 169.83750000000001p -3.6854590000000003e-08 169.84999999999999p -3.8737430000000003e-08 169.86249999999998p -4.0588340000000002e-08 169.875p -4.2407249999999997e-08
+ 169.88749999999999p -4.419419e-08 169.90000000000001p -4.5949200000000001e-08 169.91249999999999p -4.76724e-08 169.92500000000001p -4.9363930000000002e-08 169.9375p -5.1023980000000001e-08 169.94999999999999p -5.2652750000000001e-08 169.96250000000001p -5.425048e-08 169.97499999999999p -5.5817419999999998e-08 169.98750000000001p -5.7353829999999997e-08)
R_LOAD OUT 0 10
I_IBIAS 0 IBIAS pwl(0p 0 1p 35u 2p 35u 170p 35u)
.tran 0.0125p 170p
.print P(BJs|XBQ) V(BJs|XBQ) I(BJs|XBQ)
.print P(BJL1|XBQ) V(BJL1|XBQ) I(BJL1|XBQ)
.print P(BJL2|XBQ) V(BJL2|XBQ) I(BJL2|XBQ)
.print V(IN) V(OUT) I(Lin|XBQ) I(L0|XBQ) I(L1|XBQ) I(L2|XBQ)
.print I(RB|XBQ) I(RJ1|XBQ) I(RJ2|XBQ) I(R_LOAD) I(I_IBIAS)
.print I(I_REPLAY)
.end
