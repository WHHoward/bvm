* 4-BVM + QB Series — JS=25uA (C1-optimized), R_shunt=10Ω
* Full signals including V(OUT_Q)
.include ../../circuits/bvm/bvm_cell.cir
.model jj25 jj(RTYPE=1, IC=25U, RN=10, R0=30, CAP=0.15P, VG=2.8M, DELV=0.1M)

XBVM0 WL0 BL0 SE0 SL_NODE BVM
XBVM1 WL1 BL1 SE1 SL_NODE BVM
XBVM2 WL2 BL2 SE2 SL_NODE BVM
XBVM3 WL3 BL3 SE3 SL_NODE BVM

* SERIES: SL -> jj320 -> QB
B_LD1 SL_NODE QB_IN jj320 area=1
L_IN_Q  QB_IN N_JS_IN_Q   0.8P
B_JS_Q  N_JS_IN_Q N_JS_OUT_Q  jj25 area=1
R_SH_Q  N_JS_IN_Q N_JS_OUT_Q  10
B_JL1_Q N_JS_OUT_Q 0           jj112 area=1
L_L1_Q  N_JS_OUT_Q N_MID_Q     3.91P
R_RB_Q  N_MID_Q   IBIAS_Q     8.5
L_L2_Q  N_MID_Q   N_PRE_OUT_Q  3.91P
B_JL2_Q N_PRE_OUT_Q 0          jj189 area=1
L_L0_Q  N_PRE_OUT_Q OUT_Q      1.323P
R_LOAD_Q OUT_Q 0 12.0
I_IBIAS_Q IBIAS_Q 0 DC 40U

* W0(10-20) W1(30-40) W2(50-60) W3(70-80)
* R1(110-120) R2(140-150) R3(170-180) R4(200-210)

I_WL0 0 WL0 pwl(0 0 9p 0
+ 10p 100U 20p 100U 21p 0
+ 110p 0 111p 100U 120p 100U 121p 0
+ 140p 0 141p 100U 150p 100U 151p 0
+ 170p 0 171p 100U 180p 100U 181p 0
+ 200p 0 201p 100U 210p 100U 211p 0
+ 230p 0)
I_BL0 0 BL0 pwl(0 0 9p 0
+ 10p 100U 20p 100U 21p 0
+ 110p 0 230p 0)
I_SE0 0 SE0 pwl(0 0
+ 110p 0 111p 100U 120p 100U 121p 0
+ 140p 0 141p 100U 150p 100U 151p 0
+ 170p 0 171p 100U 180p 100U 181p 0
+ 200p 0 201p 100U 210p 100U 211p 0
+ 230p 0)

I_WL1 0 WL1 pwl(0 0 29p 0
+ 30p 100U 40p 100U 41p 0
+ 140p 0 141p 100U 150p 100U 151p 0
+ 170p 0 171p 100U 180p 100U 181p 0
+ 200p 0 201p 100U 210p 100U 211p 0
+ 230p 0)
I_BL1 0 BL1 pwl(0 0 29p 0
+ 30p 100U 40p 100U 41p 0
+ 140p 0 230p 0)
I_SE1 0 SE1 pwl(0 0
+ 140p 0 141p 100U 150p 100U 151p 0
+ 170p 0 171p 100U 180p 100U 181p 0
+ 200p 0 201p 100U 210p 100U 211p 0
+ 230p 0)

I_WL2 0 WL2 pwl(0 0 49p 0
+ 50p 100U 60p 100U 61p 0
+ 170p 0 171p 100U 180p 100U 181p 0
+ 200p 0 201p 100U 210p 100U 211p 0
+ 230p 0)
I_BL2 0 BL2 pwl(0 0 49p 0
+ 50p 100U 60p 100U 61p 0
+ 170p 0 230p 0)
I_SE2 0 SE2 pwl(0 0
+ 170p 0 171p 100U 180p 100U 181p 0
+ 200p 0 201p 100U 210p 100U 211p 0
+ 230p 0)

I_WL3 0 WL3 pwl(0 0 69p 0
+ 70p 100U 80p 100U 81p 0
+ 200p 0 201p 100U 210p 100U 211p 0
+ 230p 0)
I_BL3 0 BL3 pwl(0 0 69p 0
+ 70p 100U 80p 100U 81p 0
+ 200p 0 230p 0)
I_SE3 0 SE3 pwl(0 0
+ 200p 0 201p 100U 210p 100U 211p 0
+ 230p 0)

.tran 0.2p 230p 0 0.4p 0 DST
.print P(B_JM1|XBVM0) P(B_JM1|XBVM1) P(B_JM1|XBVM2) P(B_JM1|XBVM3)
.print I(B_LD1) V(B_JS_Q) P(B_JS_Q) I(B_JS_Q) V(OUT_Q)
.end
