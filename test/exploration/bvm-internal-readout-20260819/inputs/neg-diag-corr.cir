* BVM Internal Readout Survey -- positive repeated READ + full storage-loop probes (diag)
* Init: S1-style -100U on WL+BL 10-21ps (historical S1 negative init)
* Read1: WL+SE -100U 96-105ps; Read2: WL+SE -100U 146-155ps (repeated)
* Load: R_LD=12 ohm (canonical internal R_SL matching)
* dt=0.0125p, tstop=220p (covers Read2 + post window)
.include jjmit.cir
.include bvm_cell.cir

XBVM1 WL1 BL1 SE1 SL1 BVM

R_LD SL1 0 12

I_WL1 0 WL1 pwl(0p 0 10p 0 11p -100U 20p -100U 21p 0 95p 0 96p -100U 105p -100U 106p 0 145p 0 146p -100U 155p -100U 156p 0 220p 0)
I_BL1 0 BL1 pwl(0p 0 10p 0 11p -100U 20p -100U 21p 0 220p 0)
I_SE1 0 SE1 pwl(0p 0 95p 0 96p -100U 105p -100U 106p 0 145p 0 146p -100U 155p -100U 156p 0 220p 0)

.tran 0.0125p 220p

.print P(B_JM1|XBVM1) V(B_JM1|XBVM1)
.print P(B_JM2|XBVM1) V(B_JM2|XBVM1)
.print P(B_JS1|XBVM1) V(B_JS1|XBVM1)
.print P(B_JS2|XBVM1) V(B_JS2|XBVM1)
.print V(N6|XBVM1) V(SL1)
.print I(L_M1|XBVM1) I(L_M2|XBVM1) I(L_S1|XBVM1) I(L_S2|XBVM1) I(L_S3|XBVM1)
.print I(L_M3|XBVM1) I(L_PM|XBVM1) I(L_PSL|XBVM1) I(L_SL|XBVM1)
.print I(I_WL1) I(I_BL1) I(I_SE1)
.end
