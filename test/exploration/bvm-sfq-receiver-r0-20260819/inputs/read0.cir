* BVM -> SFQ receiver R0 Exploration: logical0 + canonical +READ.
* Canonical BVM topology is included as an immutable snapshot; no internal edit.
.include jjmit.cir
.include bvm_cell.cir
.include sl_trigger.cir

XBVM1 WL1 BL1 SE1 SL1 BVM
XTRIG SL1 SL_TRIGGER

* logical 0 initialization: -100 uA WL+BL, 10-20 ps
I_WL1 0 WL1 pwl(0p 0 10p 0 11p -100U 20p -100U 21p 0 95p 0 96p +100U 105p +100U 106p 0 170p 0)
I_BL1 0 BL1 pwl(0p 0 10p 0 11p -100U 20p -100U 21p 0 170p 0)

* same canonical positive READ as read1
I_SE1 0 SE1 pwl(0p 0 95p 0 96p +100U 105p +100U 106p 0 170p 0)

.tran 0.0125p 170p

.print P(B_TRIG|XTRIG) V(B_TRIG|XTRIG) I(B_TRIG|XTRIG)
.print I(R_IN|XTRIG) I(I_TRIG_BIAS|XTRIG)
.print V(SL1) V(N6|XBVM1) I(L_SL|XBVM1) I(L_PSL|XBVM1)
.print P(B_JM1|XBVM1) V(B_JM1|XBVM1) P(B_JM2|XBVM1) V(B_JM2|XBVM1)
.print P(B_JS1|XBVM1) V(B_JS1|XBVM1) P(B_JS2|XBVM1) V(B_JS2|XBVM1)
.print I(L_S1|XBVM1) I(L_S2|XBVM1) I(L_S3|XBVM1) I(L_M3|XBVM1)
.print I(I_WL1) I(I_BL1) I(I_SE1)
.end
