* Direct-node simplification of uploaded deck(6).cir.
* Removed redundant ideal 0-V branch-current meters; joined their endpoints.
* Time sources, T1/CB/sJTL topology, components, .print and 0.01p timestep unchanged.
* Current-clock PWL from this UPLOADED file remains 170/370 ps, not later 180/380 ps.
* UNVALIDATED DESIGN-REVIEW DRAFT: CARRY5 11x13, two post-write1 reads, 8 SFQ clocks.
* Source: user-supplied D3/D4 trial deck with original CARRY5 data path preserved.
* Place this directory under test/exploration/bvm-4x4-diagonal-array-v1-20261009/.
* Only examine after a static JoSIM preflight; do not overwrite prior immutable runs.
* BVM 4x4 diagonal collection; physical seven-stage T1/CBU chain.
* Cell WL/BL are physically shared buses; SE is cell-local.
.include sources_frozen/00_jjmit.cir
.include sources_frozen/01_bvm_cell_0923.cir
.include sources_frozen/02_BQ_0928.cir
.include sources_frozen/03_sJTL_0923.cir
.include sources_frozen/04_CB_0928.cir
.include sources_frozen/05_MERGE.cir
.include sources_frozen/06_dcsfq2.cir
.include sources_frozen/07_jtl2.cir
.include stimulus.inc

.include sources_frozen/08_t1_cell_tunable.cir

* No THmitll_MERGE instances in this deck; Carry uses CB_0928 directly.
.include sources_frozen/09_DFF.cir
.include sources_frozen/10_d0_jtl_tunable.cir

XBVM_R1C1 WL_R1 BL_C1 SE_R1C1 SL_R1C1 BVM
XBQ_R1C1 SL_R1C1 MERGE_D3_L1 BQ
XBVM_R1C2 WL_R1 BL_C2 SE_R1C2 SL_R1C2 BVM
XBQ_R1C2 SL_R1C2 MERGE_D2_L1 BQ
XBVM_R1C3 WL_R1 BL_C3 SE_R1C3 SL_R1C3 BVM
XBQ_R1C3 SL_R1C3 MERGE_D1_L1 BQ
XBVM_R1C4 WL_R1 BL_C4 SE_R1C4 SL_R1C4 BVM
XBQ_R1C4 SL_R1C4 MERGE_D0_L1 BQ
XBVM_R2C1 WL_R2 BL_C1 SE_R2C1 SL_R2C1 BVM
XBQ_R2C1 SL_R2C1 MERGE_D4_L1 BQ
XBVM_R2C2 WL_R2 BL_C2 SE_R2C2 SL_R2C2 BVM
XBQ_R2C2 SL_R2C2 MERGE_D3_L2 BQ
XBVM_R2C3 WL_R2 BL_C3 SE_R2C3 SL_R2C3 BVM
XBQ_R2C3 SL_R2C3 MERGE_D2_L2 BQ
XBVM_R2C4 WL_R2 BL_C4 SE_R2C4 SL_R2C4 BVM
XBQ_R2C4 SL_R2C4 MERGE_D1_L2 BQ
XBVM_R3C1 WL_R3 BL_C1 SE_R3C1 SL_R3C1 BVM
XBQ_R3C1 SL_R3C1 MERGE_D5_L1 BQ
XBVM_R3C2 WL_R3 BL_C2 SE_R3C2 SL_R3C2 BVM
XBQ_R3C2 SL_R3C2 MERGE_D4_L2 BQ
XBVM_R3C3 WL_R3 BL_C3 SE_R3C3 SL_R3C3 BVM
XBQ_R3C3 SL_R3C3 MERGE_D3_L3 BQ
XBVM_R3C4 WL_R3 BL_C4 SE_R3C4 SL_R3C4 BVM
XBQ_R3C4 SL_R3C4 MERGE_D2_L3 BQ
XBVM_R4C1 WL_R4 BL_C1 SE_R4C1 SL_R4C1 BVM
XBQ_R4C1 SL_R4C1 MERGE_D6_L1 BQ
XBVM_R4C2 WL_R4 BL_C2 SE_R4C2 SL_R4C2 BVM
XBQ_R4C2 SL_R4C2 MERGE_D5_L2 BQ
XBVM_R4C3 WL_R4 BL_C3 SE_R4C3 SL_R4C3 BVM
XBQ_R4C3 SL_R4C3 MERGE_D4_L3 BQ
XBVM_R4C4 WL_R4 BL_C4 SE_R4C4 SL_R4C4 BVM
XBQ_R4C4 SL_R4C4 MERGE_D3_L4 BQ

XSJTL_D0_L1 MERGE_D0_L1 SJTL_OUT_D0_L1 sJTL
XCB_D0_L1 SJTL_OUT_D0_L1 DOUT_D0 CB

XSJTL_D1_L1 MERGE_D1_L1 SJTL_OUT_D1_L1 sJTL
XCB_D1_L1 SJTL_OUT_D1_L1 MERGE_D1_L2 CB
XSJTL_D1_L2 MERGE_D1_L2 SJTL_OUT_D1_L2 sJTL
XCB_D1_L2 SJTL_OUT_D1_L2 T1_I_D1 CB

XSJTL_D2_L1 MERGE_D2_L1 SJTL_OUT_D2_L1 sJTL
XCB_D2_L1 SJTL_OUT_D2_L1 MERGE_D2_L2 CB
XSJTL_D2_L2_S1 MERGE_D2_L2 SJTL_MID_D2_L2_S1 sJTL
XSJTL_D2_L2_S2 SJTL_MID_D2_L2_S1 SJTL_OUT_D2_L2 sJTL
XCB_D2_L2 SJTL_OUT_D2_L2 MERGE_D2_L3 CB
XSJTL_D2_L3 MERGE_D2_L3 SJTL_OUT_D2_L3 sJTL
XCB_D2_L3 SJTL_OUT_D2_L3 T1_I_D2 CB

XSJTL_D3_L1 MERGE_D3_L1 SJTL_OUT_D3_L1 sJTL
XCB_D3_L1 SJTL_OUT_D3_L1 MERGE_D3_L2 CB
XSJTL_D3_L2_S1 MERGE_D3_L2 SJTL_MID_D3_L2_S1 sJTL
XSJTL_D3_L2_S2 SJTL_MID_D3_L2_S1 SJTL_OUT_D3_L2 sJTL
XCB_D3_L2 SJTL_OUT_D3_L2 MERGE_D3_L3 CB
XSJTL_D3_L3_S1 MERGE_D3_L3 SJTL_MID_D3_L3_S1 sJTL
XSJTL_D3_L3_S2 SJTL_MID_D3_L3_S1 SJTL_OUT_D3_L3 sJTL
XCB_D3_L3 SJTL_OUT_D3_L3 MERGE_D3_L4 CB
XSJTL_D3_L4 MERGE_D3_L4 SJTL_OUT_D3_L4 sJTL
XCB_D3_L4 SJTL_OUT_D3_L4 T1_I_D3 CB

XSJTL_D4_L1 MERGE_D4_L1 SJTL_OUT_D4_L1 sJTL
XCB_D4_L1 SJTL_OUT_D4_L1 MERGE_D4_L2 CB
XSJTL_D4_L2_S1 MERGE_D4_L2 SJTL_MID_D4_L2_S1 sJTL
XSJTL_D4_L2_S2 SJTL_MID_D4_L2_S1 SJTL_OUT_D4_L2 sJTL
XCB_D4_L2 SJTL_OUT_D4_L2 MERGE_D4_L3 CB
XSJTL_D4_L3 MERGE_D4_L3 SJTL_OUT_D4_L3 sJTL
XCB_D4_L3 SJTL_OUT_D4_L3 T1_I_D4 CB

XSJTL_D5_L1 MERGE_D5_L1 SJTL_OUT_D5_L1 sJTL
XCB_D5_L1 SJTL_OUT_D5_L1 MERGE_D5_L2 CB
XSJTL_D5_L2 MERGE_D5_L2 SJTL_OUT_D5_L2 sJTL
XCB_D5_L2 SJTL_OUT_D5_L2 T1_I_D5 CB

XSJTL_D6_L1 MERGE_D6_L1 SJTL_OUT_D6_L1 sJTL
XCB_D6_L1 SJTL_OUT_D6_L1 T1_I_D6 CB
* XMERGE_D6 SJTL_OUT_D6_L1 CARRY_CB_IN_D6 T1_I_D6 THmitll_MERGE
* Physical ripple chain: D0-JTL -> T1_D0; Dk + C(k-1) -> CBU_Dk -> T1_Dk.
V_BIAS1_D0 N_BIAS1_D0 0 pwl(0 0 10p 1.8m)
V_BIAS2_D0 N_BIAS2_D0 0 pwl(0 0 10p 1.8m)
V_BIAS3_D0 N_BIAS3_D0 0 pwl(0 0 10p 1.8m)

XJTL_S_D0_1 S_D0 S_D0_OUT_1 jtl2
XJTL_S_D0_2 S_D0_OUT_1 S_D0_OUT jtl2
R_S_D0 S_D0_OUT 0 12

R_TRIG_CLK_D0 CLK_RAW_D0 CLK_D0_IN1 2
XDCSFQ_D0 CLK_D0_IN1 CLK_D0_IN2 dcsfq2
XJTL_IN_D0 CLK_D0_IN2 CLK_D0 jtl2
XT1_D0 T1_I_D0 CLK_D0 S_D0 C_D0 N_BIAS1_D0 N_BIAS2_D0 N_BIAS3_D0 T1
V_BIAS1_D1 N_BIAS1_D1 0 pwl(0 0 10p 1.8m)
V_BIAS2_D1 N_BIAS2_D1 0 pwl(0 0 10p 1.8m)
V_BIAS3_D1 N_BIAS3_D1 0 pwl(0 0 10p 1.8m)

XJTL_S_D1_1 S_D1 S_D1_OUT_1 jtl2
XJTL_S_D1_2 S_D1_OUT_1 S_D1_OUT jtl2
R_S_D1 S_D1_OUT 0 12

R_TRIG_CLK_D1 CLK_RAW_D1 CLK_D1_IN1 2
XDCSFQ_D1 CLK_D1_IN1 CLK_D1_IN2 dcsfq2
XJTL_IN_D1 CLK_D1_IN2 CLK_D1 jtl2
XT1_D1 T1_I_D1 CLK_D1 S_D1 C_D1 N_BIAS1_D1 N_BIAS2_D1 N_BIAS3_D1 T1
V_BIAS1_D2 N_BIAS1_D2 0 pwl(0 0 10p 1.8m)
V_BIAS2_D2 N_BIAS2_D2 0 pwl(0 0 10p 1.8m)
V_BIAS3_D2 N_BIAS3_D2 0 pwl(0 0 10p 1.8m)

XJTL_S_D2_1 S_D2 S_D2_OUT_1 jtl2
XJTL_S_D2_2 S_D2_OUT_1 S_D2_OUT jtl2
R_S_D2 S_D2_OUT 0 12

R_TRIG_CLK_D2 CLK_RAW_D2 CLK_D2_IN1 2
XDCSFQ_D2 CLK_D2_IN1 CLK_D2_IN2 dcsfq2
XJTL_IN_D2 CLK_D2_IN2 CLK_D2 jtl2
XT1_D2 T1_I_D2 CLK_D2 S_D2 C_D2 N_BIAS1_D2 N_BIAS2_D2 N_BIAS3_D2 T1
V_BIAS1_D3 N_BIAS1_D3 0 pwl(0 0 10p 1.8m)
V_BIAS2_D3 N_BIAS2_D3 0 pwl(0 0 10p 1.8m)
V_BIAS3_D3 N_BIAS3_D3 0 pwl(0 0 10p 1.8m)

XJTL_S_D3_1 S_D3 S_D3_OUT_1 jtl2
XJTL_S_D3_2 S_D3_OUT_1 S_D3_OUT jtl2
R_S_D3 S_D3_OUT 0 12

R_TRIG_CLK_D3 CLK_RAW_D3 CLK_D3_IN1 2
XDCSFQ_D3 CLK_D3_IN1 CLK_D3_IN2 dcsfq2
XJTL_IN_D3 CLK_D3_IN2 CLK_D3 jtl2
XT1_D3 T1_I_D3 CLK_D3 S_D3 C_D3 N_BIAS1_D3 N_BIAS2_D3 N_BIAS3_D3 T1
V_BIAS1_D4 N_BIAS1_D4 0 pwl(0 0 10p 1.8m)
V_BIAS2_D4 N_BIAS2_D4 0 pwl(0 0 10p 1.8m)
V_BIAS3_D4 N_BIAS3_D4 0 pwl(0 0 10p 1.8m)

XJTL_S_D4_1 S_D4 S_D4_OUT_1 jtl2
XJTL_S_D4_2 S_D4_OUT_1 S_D4_OUT jtl2
R_S_D4 S_D4_OUT 0 12

R_TRIG_CLK_D4 CLK_RAW_D4 CLK_D4_IN1 2
XDCSFQ_D4 CLK_D4_IN1 CLK_D4_IN2 dcsfq2
XJTL_IN_D4 CLK_D4_IN2 CLK_D4 jtl2
XT1_D4 T1_I_D4 CLK_D4 S_D4 C_D4 N_BIAS1_D4 N_BIAS2_D4 N_BIAS3_D4 T1
V_BIAS1_D5 N_BIAS1_D5 0 pwl(0 0 10p 1.8m)
V_BIAS2_D5 N_BIAS2_D5 0 pwl(0 0 10p 1.8m)
V_BIAS3_D5 N_BIAS3_D5 0 pwl(0 0 10p 1.8m)

XJTL_S_D5_1 S_D5 S_D5_OUT_1 jtl2
XJTL_S_D5_2 S_D5_OUT_1 S_D5_OUT jtl2
R_S_D5 S_D5_OUT 0 12

R_TRIG_CLK_D5 CLK_RAW_D5 CLK_D5_IN1 2
XDCSFQ_D5 CLK_D5_IN1 CLK_D5_IN2 dcsfq2
XJTL_IN_D5 CLK_D5_IN2 CLK_D5 jtl2
XT1_D5 T1_I_D5 CLK_D5 S_D5 C_D5 N_BIAS1_D5 N_BIAS2_D5 N_BIAS3_D5 T1
V_BIAS1_D6 N_BIAS1_D6 0 pwl(0 0 10p 1.8m)
V_BIAS2_D6 N_BIAS2_D6 0 pwl(0 0 10p 1.8m)
V_BIAS3_D6 N_BIAS3_D6 0 pwl(0 0 10p 1.8m)

XJTL_S_D6_1 S_D6 S_D6_OUT_1 jtl2
XJTL_S_D6_2 S_D6_OUT_1 S_D6_OUT jtl2
R_S_D6 S_D6_OUT 0 12

R_TRIG_CLK_D6 CLK_RAW_D6 CLK_D6_IN1 2
XDCSFQ_D6 CLK_D6_IN1 CLK_D6_IN2 dcsfq2
XJTL_IN_D6 CLK_D6_IN2 CLK_D6 jtl2
XT1_D6 T1_I_D6 CLK_D6 S_D6 DFF_IN N_BIAS1_D6 N_BIAS2_D6 N_BIAS3_D6 T1

* D0 physical entrance JTL; unused 0-V branch sensors removed.
XJTL_D0_1 DOUT_D0 T1_I_D0 D0_JTL

* Selected Carry branches: sJTL -> CB -> direct node junction; no series 0-V meters.
XSJTL_CARRY_D1 C_D0 CARRY_CB_IN_D1 sJTL
XCB_CARRY_D1 CARRY_CB_IN_D1 T1_I_D1 CB

XSJTL_CARRY_D2 C_D1 CARRY_CB_IN_D2 sJTL
XCB_CARRY_D2 CARRY_CB_IN_D2 T1_I_D2 CB

XSJTL_CARRY_D3 C_D2 CARRY_SJTL_MID_D3_S1 sJTL
XSJTL_CARRY_D3_S2 CARRY_SJTL_MID_D3_S1 CARRY_SJTL_MID_D3_S2 sJTL
XSJTL_CARRY_D3_S3 CARRY_SJTL_MID_D3_S2 CARRY_SJTL_MID_D3_S3 sJTL
XSJTL_CARRY_D3_S4 CARRY_SJTL_MID_D3_S3 CARRY_SJTL_MID_D3_S4 sJTL
XSJTL_CARRY_D3_S5 CARRY_SJTL_MID_D3_S4 CARRY_CB_IN_D3 sJTL
XCB_CARRY_D3 CARRY_CB_IN_D3 T1_I_D3 CB

XSJTL_CARRY_D4 C_D3 CARRY_CB_IN_D4 sJTL
XCB_CARRY_D4 CARRY_CB_IN_D4 T1_I_D4 CB

XSJTL_CARRY_D5 C_D4 CARRY_CB_IN_D5 sJTL
XCB_CARRY_D5 CARRY_CB_IN_D5 T1_I_D5 CB

XSJTL_CARRY_D6 C_D5 CARRY_CB_IN_D6 sJTL
XCB_CARRY_D6 CARRY_CB_IN_D6 T1_I_D6 CB

* C0-C5 directly drive the next CBU; C6 directly drives the DFF data input.
R_DFF_OUT DFF_O 0 12
XDFF DFF_IN CLK_DFF DFF_O THmitll_DFF
R_TRIG_CLK_DFF CLK_RAW_DFF CLK_DFF_IN1 2
XDCSFQ_DFF CLK_DFF_IN1 CLK_DFF_IN2 dcsfq2
XJTL_IN_DFF CLK_DFF_IN2 CLK_DFF jtl2

* Registered probes; P is raw radians.
* .print V(DOUT_D0)
* .print P(BJ1|XCB_D0_L1)
* .print V(BJ1|XCB_D0_L1)
* .print P(BJ2|XCB_D0_L1)
* .print V(BJ2|XCB_D0_L1)

* 实际SFQ时钟到达

* D3时钟链的内部JJ

* D3 T1输入、Carry与时钟JJ

* DFF数据输入

* BVM代表交叉点的状态观测

* ============================================
* V3: BVM STORAGE STATE PROBES
* ============================================

* Selected cell: R1C1
* S-Loop currents

* JJ phases

* Unselected cell on active WL: R1C3
* S-Loop currents

* JJ phases
.tran 0.01p 400p
.print V(S_D0_OUT)
.print V(S_D1_OUT)
.print V(S_D2_OUT)
.print V(S_D3_OUT)
.print V(S_D4_OUT)
.print V(S_D5_OUT)
.print V(S_D6_OUT)
.print V(DFF_O)
.end
