.include jjmit.cir
.include JTL_SCALED.cir
V_IN IN 0 pwl(0 0 10p 0 11p 1.5m 13p 1.5m 14p 0 170p 0)
R_IN IN N1 3
L_IN N1 SFQ_IN 0.5p
XJTL1 SFQ_IN JTL_MID THmitll_JTL_SCALED
XJTL2 JTL_MID JTL_OUT THmitll_JTL_SCALED
R_TERM JTL_OUT 0 4.6296296
.tran 0.0125p 170p
.print I(V_IN) V(SFQ_IN) V(JTL_MID) V(JTL_OUT) I(R_IN) I(L_IN) I(R_TERM)
.print P(B1|XJTL1) V(B1|XJTL1) I(B1|XJTL1) P(B2|XJTL1) V(B2|XJTL1) I(B2|XJTL1)
.print P(B1|XJTL2) V(B1|XJTL2) I(B1|XJTL2) P(B2|XJTL2) V(B2|XJTL2) I(B2|XJTL2)
.print I(L1|XJTL1) I(L2|XJTL1) I(L3|XJTL1) I(L4|XJTL1) I(IB1|XJTL1) I(RB1|XJTL1) I(RB2|XJTL1)
.print I(L1|XJTL2) I(L2|XJTL2) I(L3|XJTL2) I(L4|XJTL2) I(IB1|XJTL2) I(RB1|XJTL2) I(RB2|XJTL2)
.print V(JTL_MID) V(JTL_OUT) I(R_TERM) I(L1|XJTL1)
.end
