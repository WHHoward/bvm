* Coherently scaled THmitll diagnostic: s=54/250=0.216.
.subckt THmitll_JTL_SCALED a q
B1 1 2 jjmit area=0.54
B2 5 6 jjmit area=0.54
IB1 0 4 pwl(0 0 5p 75.6u)
LB1 4 3 10.8148148p
L1 a 1 9.5833333p
L2 1 3 9.6666667p
L3 3 5 9.6388889p
L4 5 q 9.5925926p
LP1 2 0 1.4523148p
LP2 6 0 1.4458333p
RB1 1 101 12.7035267
LRB1 101 0 9.4923074p
RB2 5 105 12.7035267
LRB2 105 0 9.4923074p
.ends
