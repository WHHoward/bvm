* Generated top-level deck; front-end snapshots and USER_CASE T1 output boundary.
* BVM array -> QB/CB/sJTL topology fixture
* Shared frozen junction model; needed by BVM and identical to component-local cards.
.model jjmit jj(rtype=1, vg=2.8mV, cap=0.07pF, r0=160, rN=16, icrit=0.1mA)

.include snapshot/sources/bvm_tunable.cir
.include snapshot/sources/BQ_tunable.cir
.include snapshot/sources/CB_tunable.cir
.include snapshot/sources/sJTL_tunable.cir
.include ../../../../../circuits/t1/t1_cell.cir
.include stimulus.inc

XBVM1 WL1 BL1 SE1 BVM1_SL BVM
XBQ1 BVM1_SL MERGE1 BQ
XSJTL1_01 MERGE1 L1_01 sJTL
XPOSTCB1 L1_01 MERGE2 CB
XBVM2 WL2 BL2 SE2 BVM2_SL BVM
XBQ2 BVM2_SL MERGE2 BQ
XSJTL2_01 MERGE2 L2_01 sJTL
XSJTL2_02 L2_01 L2_02 sJTL
XPOSTCB2 L2_02 MERGE3 CB
XBVM3 WL3 BL3 SE3 BVM3_SL BVM
XBQ3 BVM3_SL MERGE3 BQ
XSJTL3_01 MERGE3 L3_01 sJTL
XSJTL3_02 L3_01 L3_02 sJTL
XPOSTCB3 L3_02 MERGE4 CB
XBVM4 WL4 BL4 SE4 BVM4_SL BVM
XBQ4 BVM4_SL MERGE4 BQ
XSJTL4_01 MERGE4 L4_01 sJTL
XPOSTCB4 L4_01 FINAL_OUT CB

V_BIAS1 N_BIAS1 0 DC 1.8m
V_BIAS2 N_BIAS2 0 DC 1.8m
V_BIAS3 N_BIAS3 0 DC 1.8m
R_S S 0 12
R_C C 0 12
R_CLK_QUIET CLK 0 5
V_T1_LINK FINAL_OUT T1_I 0
XT1 T1_I CLK S C N_BIAS1 N_BIAS2 N_BIAS3 T1
.print I(I_WL1)
.print I(I_BL1)
.print I(I_SE1)
.print P(B_JM1|XBVM1)
.print V(B_JM1|XBVM1)
.print P(B_JM2|XBVM1)
.print V(B_JM2|XBVM1)
.print P(B_JS1|XBVM1)
.print V(B_JS1|XBVM1)
.print P(B_JS2|XBVM1)
.print V(B_JS2|XBVM1)
.print I(L_M1|XBVM1)
.print I(L_M2|XBVM1)
.print I(L_M3|XBVM1)
.print I(L_PM|XBVM1)
.print I(L_SL|XBVM1)
.print V(BVM1_SL)
.print P(BJ1|XBQ1)
.print V(BJ1|XBQ1)
.print P(BJ2|XBQ1)
.print V(BJ2|XBQ1)
.print P(BJ3|XBQ1)
.print V(BJ3|XBQ1)
.print I(LIN|XBQ1)
.print I(L1|XBQ1)
.print I(L2|XBQ1)
.print I(L3|XBQ1)
.print V(MERGE1)
.print I(I_WL2)
.print I(I_BL2)
.print I(I_SE2)
.print P(B_JM1|XBVM2)
.print V(B_JM1|XBVM2)
.print P(B_JM2|XBVM2)
.print V(B_JM2|XBVM2)
.print P(B_JS1|XBVM2)
.print V(B_JS1|XBVM2)
.print P(B_JS2|XBVM2)
.print V(B_JS2|XBVM2)
.print I(L_M1|XBVM2)
.print I(L_M2|XBVM2)
.print I(L_M3|XBVM2)
.print I(L_PM|XBVM2)
.print I(L_SL|XBVM2)
.print V(BVM2_SL)
.print P(BJ1|XBQ2)
.print V(BJ1|XBQ2)
.print P(BJ2|XBQ2)
.print V(BJ2|XBQ2)
.print P(BJ3|XBQ2)
.print V(BJ3|XBQ2)
.print I(LIN|XBQ2)
.print I(L1|XBQ2)
.print I(L2|XBQ2)
.print I(L3|XBQ2)
.print V(MERGE2)
.print I(I_WL3)
.print I(I_BL3)
.print I(I_SE3)
.print P(B_JM1|XBVM3)
.print V(B_JM1|XBVM3)
.print P(B_JM2|XBVM3)
.print V(B_JM2|XBVM3)
.print P(B_JS1|XBVM3)
.print V(B_JS1|XBVM3)
.print P(B_JS2|XBVM3)
.print V(B_JS2|XBVM3)
.print I(L_M1|XBVM3)
.print I(L_M2|XBVM3)
.print I(L_M3|XBVM3)
.print I(L_PM|XBVM3)
.print I(L_SL|XBVM3)
.print V(BVM3_SL)
.print P(BJ1|XBQ3)
.print V(BJ1|XBQ3)
.print P(BJ2|XBQ3)
.print V(BJ2|XBQ3)
.print P(BJ3|XBQ3)
.print V(BJ3|XBQ3)
.print I(LIN|XBQ3)
.print I(L1|XBQ3)
.print I(L2|XBQ3)
.print I(L3|XBQ3)
.print V(MERGE3)
.print I(I_WL4)
.print I(I_BL4)
.print I(I_SE4)
.print P(B_JM1|XBVM4)
.print V(B_JM1|XBVM4)
.print P(B_JM2|XBVM4)
.print V(B_JM2|XBVM4)
.print P(B_JS1|XBVM4)
.print V(B_JS1|XBVM4)
.print P(B_JS2|XBVM4)
.print V(B_JS2|XBVM4)
.print I(L_M1|XBVM4)
.print I(L_M2|XBVM4)
.print I(L_M3|XBVM4)
.print I(L_PM|XBVM4)
.print I(L_SL|XBVM4)
.print V(BVM4_SL)
.print P(BJ1|XBQ4)
.print V(BJ1|XBQ4)
.print P(BJ2|XBQ4)
.print V(BJ2|XBQ4)
.print P(BJ3|XBQ4)
.print V(BJ3|XBQ4)
.print I(LIN|XBQ4)
.print I(L1|XBQ4)
.print I(L2|XBQ4)
.print I(L3|XBQ4)
.print V(MERGE4)
.print P(BJ1|XPOSTCB1)
.print V(BJ1|XPOSTCB1)
.print P(BJ2|XPOSTCB1)
.print V(BJ2|XPOSTCB1)
.print I(L1|XPOSTCB1)
.print I(L4|XPOSTCB1)
.print V(L1_01)
.print P(BJ1|XSJTL1_01)
.print V(BJ1|XSJTL1_01)
.print I(L2|XSJTL1_01)
.print P(BJ1|XPOSTCB2)
.print V(BJ1|XPOSTCB2)
.print P(BJ2|XPOSTCB2)
.print V(BJ2|XPOSTCB2)
.print I(L1|XPOSTCB2)
.print I(L4|XPOSTCB2)
.print V(L2_02)
.print P(BJ1|XSJTL2_01)
.print V(BJ1|XSJTL2_01)
.print I(L2|XSJTL2_01)
.print V(L2_01)
.print P(BJ1|XSJTL2_02)
.print V(BJ1|XSJTL2_02)
.print I(L2|XSJTL2_02)
.print P(BJ1|XPOSTCB3)
.print V(BJ1|XPOSTCB3)
.print P(BJ2|XPOSTCB3)
.print V(BJ2|XPOSTCB3)
.print I(L1|XPOSTCB3)
.print I(L4|XPOSTCB3)
.print V(L3_02)
.print P(BJ1|XSJTL3_01)
.print V(BJ1|XSJTL3_01)
.print I(L2|XSJTL3_01)
.print V(L3_01)
.print P(BJ1|XSJTL3_02)
.print V(BJ1|XSJTL3_02)
.print I(L2|XSJTL3_02)
.print P(BJ1|XPOSTCB4)
.print V(BJ1|XPOSTCB4)
.print P(BJ2|XPOSTCB4)
.print V(BJ2|XPOSTCB4)
.print I(L1|XPOSTCB4)
.print I(L4|XPOSTCB4)
.print V(L4_01)
.print V(FINAL_OUT)
.print P(BJ1|XSJTL4_01)
.print V(BJ1|XSJTL4_01)
.print I(L2|XSJTL4_01)
.print V(T1_I)
.print V(CLK)
.print V(S)
.print V(C)
.print P(B_J1|XT1)
.print V(B_J1|XT1)
.print P(B_J7|XT1)
.print V(B_J7|XT1)
.print P(B_J9|XT1)
.print V(B_J9|XT1)
.print P(B_J11|XT1)
.print V(B_J11|XT1)
.print I(L1|XT1)
.print I(L3|XT1)
.print I(L11|XT1)
.print I(L14|XT1)
.print I(L17|XT1)
.tran 0.01p 200p
.end
