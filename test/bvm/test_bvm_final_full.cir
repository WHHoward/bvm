* BVM Final Full Truth Table — 1ps sharp edges, 50GHz
.include ../../circuits/bvm/bvm_cell.cir
XBVM1 WL1 BL1 SE1 SL1 BVM
B_LD1  SL1 nld1  jj320 area=1
B_LD2  nld1 nld2 jj320 area=1
B_LD3  nld2 nld3 jj320 area=1
B_LD4  nld3 nld4 jj320 area=1
B_LD5  nld4 nld5 jj320 area=1
B_LD6  nld5 nld6 jj320 area=1
B_LD7  nld6 nld7 jj320 area=1
B_LD8  nld7 nld8 jj320 area=1
B_LD9  nld8 nld9 jj320 area=1
B_LD10 nld9 nld10 jj320 area=1
B_LD11 nld10 nld11 jj320 area=1
B_LD12 nld11 0 jj320 area=1

* WL: 1ps edges, 10ps hold, 50GHz
I_WL1 0 WL1 pwl(0 0 9p 0
+ 10p 100U  20p 100U  21p 0
+ 50p 0 51p 100U  60p 100U  61p 0
+ 90p 0 91p 100U 100p 100U 101p 0
+ 130p 0 131p 100U 140p 100U 141p 0
+ 170p 0 171p -100U 180p -100U 181p 0
+ 210p 0 211p 100U 220p 100U 221p 0
+ 250p 0 251p 100U 260p 100U 261p 0
+ 280p 0)

* BL
I_BL1 0 BL1 pwl(0 0 9p 0
+ 10p 100U  20p 100U  21p 0
+ 50p 0 61p 0
+ 70p 0 71p 100U  80p 100U  81p 0
+ 90p 0 141p 0
+ 170p 0 171p -100U 180p -100U 181p 0
+ 210p 0 280p 0)

* SE
I_SE1 0 SE1 pwl(0 0
+ 90p 0 91p 100U 100p 100U 101p 0
+ 130p 0 131p 100U 140p 100U 141p 0
+ 210p 0 211p 100U 220p 100U 221p 0
+ 250p 0 251p 100U 260p 100U 261p 0
+ 280p 0)

.tran 0.25p 280p 0 0.5p 0 DST
.print I(I_WL1) I(I_BL1) I(I_SE1)
.print V(B_JM1|XBVM1) P(B_JM1|XBVM1)
.print I(L_M1|XBVM1)
.print P(B_JS1|XBVM1) P(B_JS2|XBVM1)
.print I(B_LD1)
.end
