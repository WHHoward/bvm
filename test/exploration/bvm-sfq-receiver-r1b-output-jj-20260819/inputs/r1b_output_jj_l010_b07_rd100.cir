* R1b: minimum output-JJ activation on the accepted R1a series pickup.
* No self-quench loop, output JTL, or T1 is present.
.subckt SERIES_PICKUP_OUTPUT IN

* Accepted R1a primary/secondary path is retained unchanged.
R_IN          IN          N_PICK      12.0
L_TX          N_PICK      N_TRIG       0.20p
B_TRIG        N_TRIG      0            jjmit area=0.50
I_TRIG_BIAS   0           N_TRIG       pwl(0p 0 2p 15U 80p 15U 140p 15U 170p 15U)

L_SEC         N_SEC       0             2.0p
R_SEC_LOAD    N_SEC       0            12.0
K_TX          L_TX        L_SEC        0.80

* Physics-informed output point:
* Ic=10uA, bias=7uA; read1 secondary current is expected to cross Ic
* while read0 remains subcritical before receiver loading is measured.
B_OUT         N_OUT       N_SEC         jjmit area=0.10
I_OUT_BIAS    0           N_OUT         pwl(0p 0 2p 7U 80p 7U 140p 7U 170p 7U)
R_OUT_DAMP    N_OUT       N_SEC        100.0

.ends SERIES_PICKUP_OUTPUT
