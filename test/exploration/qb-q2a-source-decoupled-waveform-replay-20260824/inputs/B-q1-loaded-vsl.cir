* QB-Q2A B-q1-loaded: ideal source replay; source snapshot=B-q1-loaded-vsl.csv
.include jjmit.cir
.include bq_cell.cir
XBQ IN OUT IBIAS BQ
V_REPLAY IN 0 pwl(0p 0 0.012500000000000001p 5.0667369999999999e-08 0.025000000000000001p 1.689035e-07 0.037499999999999999p 3.6015899999999999e-07 0.050000000000000003p 6.258251e-07 0.0625p 9.6569929999999992e-07 0.074999999999999997p 1.3788179999999999e-06 0.087500000000000008p 1.8637480000000001e-06 0.10000000000000001p 2.418706e-06 0.1125p 3.0416069999999998e-06 0.125p 3.7301070000000001e-06 0.13749999999999998p 4.4816270000000001e-06 0.14999999999999999p 5.293386e-06 0.16249999999999998p 6.1624219999999998e-06 0.17500000000000002p 7.0856210000000003e-06 0.1875p 8.059742e-06 0.20000000000000001p 9.0814379999999998e-06 0.21249999999999999p 1.0147280000000001e-05
+ 0.22500000000000001p 1.1253800000000001e-05 0.23749999999999999p 1.239746e-05 0.25p 1.3574729999999999e-05 0.26250000000000001p 1.478209e-05 0.27499999999999997p 1.6016010000000001e-05 0.28749999999999998p 1.7273049999999999e-05 0.29999999999999999p 1.8549779999999998e-05 0.3125p 1.9842870000000001e-05 0.32499999999999996p 2.1149060000000001e-05 0.33749999999999997p 2.2465189999999999e-05 0.35000000000000003p 2.3788210000000001e-05 0.36250000000000004p 2.5115189999999999e-05 0.375p 2.6443319999999999e-05 0.38750000000000001p 2.7769939999999999e-05 0.40000000000000002p 2.909251e-05 0.41250000000000003p 3.0408649999999999e-05 0.42499999999999999p 3.1716120000000001e-05 0.4375p 3.301284e-05
+ 0.45000000000000001p 3.4296879999999999e-05 0.46250000000000002p 3.5566460000000003e-05 0.47499999999999998p 3.6819980000000002e-05 0.48749999999999999p 3.8055970000000001e-05 0.5p 3.9273110000000003e-05 0.51249999999999996p 4.0470250000000001e-05 0.52500000000000002p 4.164638e-05 0.53749999999999998p 4.280062e-05 0.54999999999999993p 4.3932240000000002e-05 0.5625p 4.5040660000000001e-05 0.57499999999999996p 4.6125390000000003e-05 0.58750000000000002p 4.7186089999999998e-05 0.59999999999999998p 4.8222539999999997e-05 0.61249999999999993p 4.9234609999999999e-05 0.625p 5.0222290000000001e-05 0.63749999999999996p 5.1185649999999997e-05 0.64999999999999991p 5.2124879999999998e-05 0.66249999999999998p 5.3040210000000002e-05
+ 0.67499999999999993p 5.3931980000000003e-05 0.6875p 5.4800579999999997e-05 0.70000000000000007p 5.5646460000000001e-05 0.71250000000000002p 5.6470149999999997e-05 0.72500000000000009p 5.7272180000000002e-05 0.73750000000000004p 5.805317e-05 0.75p 5.8813729999999998e-05 0.76250000000000007p 5.9554540000000003e-05 0.77500000000000002p 6.0276270000000002e-05 0.78749999999999998p 6.0979610000000002e-05 0.80000000000000004p 6.1665270000000005e-05 0.8125p 6.2333970000000001e-05 0.82500000000000007p 6.2986419999999999e-05 0.83750000000000002p 6.3623320000000006e-05 0.84999999999999998p 6.4245380000000005e-05 0.86250000000000004p 6.4853290000000004e-05 0.875p 6.5447709999999994e-05 0.88749999999999996p 6.6029299999999995e-05
+ 0.90000000000000002p 6.6598709999999997e-05 0.91249999999999998p 6.7156530000000002e-05 0.92500000000000004p 6.7703349999999996e-05 0.9375p 6.8239720000000005e-05 0.94999999999999996p 6.8766189999999998e-05 0.96250000000000002p 6.9283239999999997e-05 0.97499999999999998p 6.9791349999999994e-05 0.98749999999999993p 7.0290940000000004e-05 1p 7.0782440000000005e-05 1.0125p 7.1215529999999998e-05 1.0249999999999999p 7.1573679999999994e-05 1.0374999999999999p 7.1851729999999997e-05 1.05p 7.2048579999999999e-05 1.0625p 7.2164680000000002e-05 1.075p 7.2201229999999998e-05 1.0874999999999999p 7.2159840000000003e-05 1.0999999999999999p 7.2042470000000005e-05 1.1125p 7.1851349999999998e-05
+ 1.125p 7.1588960000000006e-05 1.1375p 7.1257949999999998e-05 1.1499999999999999p 7.0861199999999998e-05 1.1624999999999999p 7.0401720000000002e-05 1.175p 6.988268e-05 1.1875p 6.9307350000000003e-05 1.2p 6.8679080000000003e-05 1.2124999999999999p 6.8001309999999996e-05 1.2249999999999999p 6.7277519999999995e-05 1.2374999999999998p 6.6511210000000002e-05 1.25p 6.5705910000000005e-05 1.2625p 6.4865120000000005e-05 1.2749999999999999p 6.3992320000000002e-05 1.2874999999999999p 6.3090969999999994e-05 1.2999999999999998p 6.216444e-05 1.3125p 6.1216059999999995e-05 1.325p 6.0249069999999997e-05 1.3374999999999999p 5.926661e-05
+ 1.3499999999999999p 5.8271730000000002e-05 1.3624999999999998p 5.7267369999999998e-05 1.375p 5.6256350000000002e-05 1.3875000000000002p 5.5241349999999999e-05 1.4000000000000001p 5.4224939999999999e-05 1.4125000000000001p 5.3209550000000003e-05 1.425p 5.2197470000000001e-05 1.4375p 5.1190850000000001e-05 1.4500000000000002p 5.0191700000000003e-05 1.4625000000000001p 4.920189e-05 1.4750000000000001p 4.8223139999999999e-05 1.4875p 4.7257050000000002e-05 1.5p 4.6305050000000001e-05 1.5125000000000002p 4.5368450000000001e-05 1.5250000000000001p 4.4448430000000002e-05 1.5375000000000001p 4.3546040000000002e-05 1.55p 4.26622e-05 1.5625p 4.1797690000000001e-05
+ 1.575p 4.095321e-05 1.5875000000000001p 4.0129319999999997e-05 1.6000000000000001p 3.9326490000000003e-05 1.6125p 3.8545089999999997e-05 1.625p 3.7785379999999998e-05 1.6375p 3.7047549999999997e-05 1.6500000000000001p 3.6331700000000003e-05 1.6625000000000001p 3.5637850000000003e-05 1.675p 3.4965970000000002e-05 1.6875p 3.4315949999999998e-05 1.7p 3.3687620000000001e-05 1.7125000000000001p 3.3080780000000002e-05 1.7250000000000001p 3.2495169999999998e-05 1.7375p 3.1930490000000001e-05 1.75p 3.1386410000000002e-05 1.7625p 3.0862570000000003e-05 1.7749999999999999p 3.0358600000000001e-05 1.7875000000000001p 2.9874099999999999e-05
+ 1.8p 2.9408649999999998e-05 1.8125p 2.8961840000000001e-05 1.825p 2.8533229999999999e-05 1.8375000000000001p 2.81224e-05 1.8625000000000003p 2.7352380000000001e-05 1.875p 2.6992349999999999e-05 1.8875000000000002p 2.664844e-05 1.8999999999999999p 2.6320239999999999e-05 1.9125000000000001p 2.600739e-05 1.925p 2.5709509999999999e-05 1.9375000000000002p 2.5426269999999999e-05 1.95p 2.5157329999999999e-05 1.9625000000000001p 2.4902379999999999e-05 1.9749999999999999p 2.4661139999999999e-05 1.9875000000000003p 2.443332e-05 2p 2.421867e-05 2.0125000000000002p 2.4016960000000001e-05 2.0249999999999999p 2.3827970000000001e-05
+ 2.0375000000000001p 2.3651490000000001e-05 2.0499999999999998p 2.3487340000000001e-05 2.0625p 2.333535e-05 2.0749999999999997p 2.3195369999999999e-05 2.0875000000000004p 2.3067249999999998e-05 2.1000000000000001p 2.2950869999999999e-05 2.1125000000000003p 2.2846090000000001e-05 2.125p 2.2752820000000001e-05 2.1375000000000002p 2.2670929999999999e-05 2.1499999999999999p 2.2600350000000001e-05 2.1625000000000001p 2.254095e-05 2.1749999999999998p 2.249266e-05 2.1875p 2.245538e-05 2.1999999999999997p 2.242902e-05 2.2124999999999999p 2.2413469999999999e-05 2.2250000000000001p 2.240863e-05 2.2375000000000003p 2.24144e-05 2.25p 2.243067e-05
+ 2.2625000000000002p 2.2457289999999999e-05 2.2749999999999999p 2.2494149999999999e-05 2.2875000000000001p 2.2541089999999999e-05 2.2999999999999998p 2.2597949999999999e-05 2.3125p 2.2664570000000001e-05 2.3249999999999997p 2.2740760000000001e-05 2.3374999999999999p 2.2826299999999999e-05 2.3500000000000001p 2.2920989999999999e-05 2.3625000000000003p 2.30246e-05 2.375p 2.3136849999999999e-05 2.3875000000000002p 2.3257490000000002e-05 2.3999999999999999p 2.3386229999999999e-05 2.4125000000000001p 2.3522759999999998e-05 2.4249999999999998p 2.3666749999999998e-05 2.4375p 2.3817869999999999e-05 2.4499999999999997p 2.3975740000000001e-05 2.4624999999999999p 2.4139999999999999e-05 2.4749999999999996p 2.4310239999999999e-05
+ 2.4875000000000003p 2.448606e-05 2.5p 2.4667020000000001e-05 2.5125000000000002p 2.4852670000000001e-05 2.5249999999999999p 2.5042570000000001e-05 2.5375000000000001p 2.5236219999999999e-05 2.5499999999999998p 2.543316e-05 2.5625p 2.563286e-05 2.5749999999999997p 2.5834840000000001e-05 2.5874999999999999p 2.6038559999999999e-05 2.5999999999999996p 2.624349e-05 2.6124999999999998p 2.6449100000000001e-05 2.625p 2.6654850000000001e-05 2.6375000000000002p 2.6860169999999999e-05 2.6499999999999999p 2.706453e-05 2.6625000000000001p 2.726736e-05 2.6749999999999998p 2.7468099999999999e-05 2.6875p 2.7666199999999999e-05 2.6999999999999997p 2.78611e-05
+ 2.7124999999999999p 2.8052249999999999e-05 2.7249999999999996p 2.8239090000000001e-05 2.7374999999999998p 2.842108e-05 2.75p 2.8597690000000002e-05 2.7625000000000002p 2.8768369999999998e-05 2.7750000000000004p 2.8932619999999999e-05 2.7875000000000001p 2.9089900000000001e-05 2.8000000000000003p 2.923974e-05 2.8125p 2.9381629999999999e-05 2.8250000000000002p 2.9515100000000001e-05 2.8374999999999999p 2.9639689999999999e-05 2.8500000000000001p 2.9754959999999999e-05 2.8624999999999998p 2.9860479999999998e-05 2.875p 2.9955830000000001e-05 2.8875000000000002p 3.004062e-05 2.9000000000000004p 3.011448e-05 2.9125000000000001p 3.017706e-05 2.9250000000000003p 3.0228020000000001e-05
+ 2.9375p 3.026705e-05 2.9500000000000002p 3.0293850000000001e-05 2.9624999999999999p 3.0308149999999999e-05 2.9750000000000001p 3.030972e-05 2.9874999999999998p 3.0298310000000002e-05 3p 3.0273740000000001e-05 3.0124999999999997p 3.0235830000000002e-05 3.0250000000000004p 3.0184409999999999e-05 3.0375000000000001p 3.0119359999999999e-05 3.0500000000000003p 3.004058e-05 3.0625p 2.994797e-05 3.0750000000000002p 2.9841480000000001e-05 3.0874999999999999p 2.972107e-05 3.1000000000000001p 2.9586730000000001e-05 3.1124999999999998p 2.9438480000000001e-05 3.125p 2.9276339999999999e-05 3.1374999999999997p 2.9100370000000001e-05 3.1499999999999999p 2.8910660000000001e-05
+ 3.1625000000000001p 2.8707299999999999e-05 3.1750000000000003p 2.8490419999999999e-05 3.1875p 2.8260160000000002e-05 3.2000000000000002p 2.8016699999999999e-05 3.2124999999999999p 2.776021e-05 3.2250000000000001p 2.7490919999999999e-05 3.2374999999999998p 2.7209029999999999e-05 3.25p 2.6914809999999999e-05 3.2624999999999997p 2.6608509999999998e-05 3.2749999999999999p 2.6290409999999999e-05 3.2875000000000001p 2.5960819999999999e-05 3.3000000000000003p 2.5620059999999999e-05 3.3125p 2.526845e-05 3.3250000000000002p 2.4906330000000001e-05 3.3374999999999999p 2.4534089999999999e-05 3.3500000000000001p 2.4152080000000001e-05 3.3624999999999998p 2.376069e-05 3.375p 2.336034e-05
+ 3.3874999999999997p 2.2951430000000001e-05 3.3999999999999999p 2.2534380000000001e-05 3.4124999999999996p 2.2109630000000001e-05 3.4250000000000003p 2.1677619999999999e-05 3.4375p 2.1238810000000001e-05 3.4500000000000002p 2.079365e-05 3.4624999999999999p 2.0342619999999999e-05 3.4750000000000001p 1.9886180000000001e-05 3.4874999999999998p 1.9424819999999999e-05 3.5p 1.8959020000000001e-05 3.5124999999999997p 1.8489270000000001e-05 3.5249999999999999p 1.801607e-05 3.5374999999999996p 1.7539909999999999e-05 3.5499999999999998p 1.7061280000000001e-05 3.5625p 1.6580699999999999e-05 3.5750000000000002p 1.6098659999999999e-05 3.5874999999999999p 1.5615670000000002e-05 3.6000000000000001p 1.513221e-05
+ 3.6124999999999998p 1.4648799999999999e-05 3.625p 1.416593e-05 3.6374999999999997p 1.3684089999999999e-05 3.6499999999999999p 1.320379e-05 3.6624999999999996p 1.27255e-05 3.6750000000000003p 1.224971e-05 3.6875p 1.177691e-05 3.7000000000000002p 1.1307560000000001e-05 3.7124999999999999p 1.0842129999999999e-05 3.7250000000000005p 1.03811e-05 3.7375000000000003p 9.9248989999999994e-06 3.75p 9.4739900000000004e-06 3.7624999999999997p 9.0288069999999998e-06 3.7750000000000004p 8.5897800000000006e-06 3.7875000000000001p 8.1573310000000005e-06 3.7999999999999998p 7.7318699999999992e-06 3.8124999999999996p 7.3137989999999999e-06 3.8250000000000002p 6.9035080000000003e-06
+ 3.8375000000000004p 6.5013779999999999e-06 3.8500000000000001p 6.1077760000000004e-06 3.8624999999999998p 5.7230579999999996e-06 3.8750000000000004p 5.3475689999999996e-06 3.8875000000000002p 4.9816400000000001e-06 3.8999999999999999p 4.6255909999999998e-06 3.9124999999999996p 4.2797260000000002e-06 3.9250000000000003p 3.944337e-06 3.9375p 3.6197019999999999e-06 3.9499999999999997p 3.306086e-06 3.9624999999999999p 3.0037370000000001e-06 3.9750000000000005p 2.7128889999999998e-06 3.9875000000000003p 2.4337629999999999e-06 4p 2.166564e-06 4.0124999999999993p 1.9114789999999999e-06 4.0250000000000004p 1.668683e-06 4.0375000000000005p 1.4383329999999999e-06 4.0499999999999998p 1.2205720000000001e-06
+ 4.0625p 1.0155259999999999e-06 4.0750000000000002p 8.2330459999999998e-07 4.0875000000000004p 6.4400129999999995e-07 4.0999999999999996p 4.7769400000000004e-07 4.1124999999999998p 3.2444400000000002e-07 4.125p 1.8429620000000001e-07 4.1375000000000002p 5.7279380000000002e-08 4.1499999999999995p -5.6594209999999998e-08 4.1624999999999996p -1.5732840000000001e-07 4.1750000000000007p -2.4494340000000002e-07 4.1875p -3.1947549999999998e-07 4.2000000000000002p -3.8097699999999998e-07 4.2124999999999995p -4.2951609999999999e-07 4.2250000000000005p -4.6517700000000001e-07 4.2374999999999998p -4.8805960000000002e-07 4.25p -4.9827889999999997e-07 4.2624999999999993p -4.9596580000000002e-07 4.2750000000000004p -4.8126570000000004e-07
+ 4.2874999999999996p -4.5433940000000002e-07 4.2999999999999998p -4.1536199999999998e-07 4.3125p -3.6452310000000001e-07 4.3250000000000002p -3.0202639999999998e-07 4.3375000000000004p -2.280893e-07 4.3499999999999996p -1.4294270000000001e-07 4.3624999999999998p -4.6830830000000003e-08 4.375p 5.9989579999999995e-08 4.3875000000000002p 1.7724920000000001e-07 4.3999999999999995p 3.0466669999999998e-07 4.4124999999999996p 4.4194909999999997e-07 4.4249999999999998p 5.8879210000000001e-07 4.4375p 7.4488079999999997e-07 4.4500000000000002p 9.0988969999999997e-07 4.4624999999999995p 1.083483e-06 4.4750000000000005p 1.265317e-06 4.4874999999999998p 1.455038e-06 4.5p 1.652282e-06
+ 4.5124999999999993p 1.85668e-06 4.5250000000000004p 2.0678540000000001e-06 4.5374999999999996p 2.2854199999999999e-06 4.5499999999999998p 2.5089860000000001e-06 4.5625p 2.7381550000000001e-06 4.5750000000000002p 2.9725240000000002e-06 4.5875000000000004p 3.211687e-06 4.5999999999999996p 3.455232e-06 4.6125000000000007p 3.7027440000000001e-06 4.625p 3.9538040000000003e-06 4.6375000000000002p 4.2079900000000003e-06 4.6499999999999995p 4.4648809999999999e-06 4.6625000000000005p 4.7240510000000004e-06 4.6749999999999998p 4.9850760000000001e-06 4.6875p 5.2475280000000001e-06 4.7000000000000002p 5.5109839999999998e-06 4.7125000000000004p 5.7750169999999996e-06 4.7250000000000005p 6.0392050000000001e-06
+ 4.7374999999999998p 6.3031260000000001e-06 4.75p 6.5663610000000003e-06 4.7625000000000002p 6.8284940000000002e-06 4.7750000000000004p 7.0891119999999999e-06 4.7874999999999996p 7.3478080000000004e-06 4.7999999999999998p 7.6041779999999998e-06 4.8125p 7.8578230000000008e-06 4.8250000000000002p 8.1083509999999994e-06 4.8375000000000004p 8.3553730000000008e-06 4.8499999999999996p 8.5985120000000003e-06 4.8625000000000007p 8.8373930000000003e-06 4.875p 9.0716520000000003e-06 4.8875000000000002p 9.3009310000000008e-06 4.8999999999999995p 9.5248829999999994e-06 4.9125000000000005p 9.7431660000000005e-06 4.9249999999999998p 9.9554520000000002e-06 4.9375p 1.016142e-05 4.9499999999999993p 1.036076e-05
+ 4.9625000000000004p 1.055317e-05 4.9750000000000005p 1.0738359999999999e-05 4.9874999999999998p 1.0916059999999999e-05 5p 1.1086e-05 5.0125000000000002p 1.124793e-05 5.0250000000000004p 1.1401599999999999e-05 5.0374999999999996p 1.154679e-05 5.0499999999999998p 1.168327e-05 5.0625p 1.1810850000000001e-05 5.0750000000000002p 1.1929340000000001e-05 5.0874999999999995p 1.2038560000000001e-05 5.0999999999999996p 1.213834e-05 5.1125000000000007p 1.2228539999999999e-05 5.125p 1.230902e-05 5.1375000000000002p 1.237966e-05 5.1499999999999995p 1.2440359999999999e-05 5.1625000000000005p 1.249101e-05 5.1749999999999998p 1.253155e-05
+ 5.1875p 1.256191e-05 5.1999999999999993p 1.258203e-05 5.2125000000000004p 1.2591880000000001e-05 5.2249999999999996p 1.259145e-05 5.2374999999999998p 1.2580719999999999e-05 5.25p 1.255971e-05 5.2625000000000002p 1.252842e-05 5.2750000000000004p 1.248691e-05 5.2874999999999996p 1.2435220000000001e-05 5.2999999999999998p 1.237341e-05 5.3125p 1.2301570000000001e-05 5.3250000000000002p 1.221978e-05 5.3374999999999995p 1.2128139999999999e-05 5.3499999999999996p 1.2026790000000001e-05 5.3624999999999998p 1.191584e-05 5.375p 1.1795429999999999e-05 5.3875000000000002p 1.166574e-05 5.3999999999999995p 1.1526919999999999e-05
+ 5.4125000000000005p 1.137916e-05 5.4249999999999998p 1.1222639999999999e-05 5.4375p 1.1057579999999999e-05 5.4499999999999993p 1.088418e-05 5.4625000000000004p 1.070268e-05 5.4749999999999996p 1.0513290000000001e-05 5.4874999999999998p 1.0316290000000001e-05 5.5p 1.011191e-05 5.5125000000000002p 9.9004150000000003e-06 5.5250000000000004p 9.6820899999999993e-06 5.5374999999999996p 9.4572109999999999e-06 5.5500000000000007p 9.2260680000000004e-06 5.5625p 8.9889579999999999e-06 5.5750000000000002p 8.7461859999999994e-06 5.5874999999999995p 8.4980610000000008e-06 5.6000000000000005p 8.2449020000000001e-06 5.6124999999999998p 7.9870309999999997e-06 5.625p 7.7247760000000003e-06
+ 5.6375000000000002p 7.4584709999999997e-06 5.6500000000000004p 7.1884529999999996e-06 5.6625000000000005p 6.9150639999999999e-06 5.6749999999999998p 6.6386469999999997e-06 5.6875p 6.3595519999999996e-06 5.7000000000000002p 6.078127e-06 5.7125000000000004p 5.7947249999999998e-06 5.7249999999999996p 5.5096989999999997e-06 5.7374999999999998p 5.2234039999999999e-06 5.75p 4.9361949999999999e-06 5.7625000000000002p 4.6484269999999999e-06 5.7750000000000004p 4.360454e-06 5.7874999999999996p 4.0726300000000002e-06 5.8000000000000007p 3.785307e-06 5.8125p 3.4988350000000002e-06 5.8250000000000002p 3.2135619999999998e-06 5.8374999999999995p 2.9298319999999999e-06 5.8500000000000005p 2.6479889999999998e-06
+ 5.8624999999999998p 2.368368e-06 5.875p 2.0913050000000001e-06 5.8874999999999993p 1.8171290000000001e-06 5.9000000000000004p 1.5461619999999999e-06 5.9125000000000005p 1.278725e-06 5.9249999999999998p 1.015129e-06 5.9375p 7.5568159999999998e-07 5.9500000000000002p 5.0068159999999999e-07 5.9625000000000004p 2.504219e-07 5.9749999999999996p 5.187881e-09 5.9874999999999998p -2.3474309999999999e-07 6p -4.691018e-07 6.0125000000000002p -6.9762730000000003e-07 6.0249999999999995p -9.2006750000000004e-07 6.0374999999999996p -1.1361790000000001e-06 6.0500000000000007p -1.3457300000000001e-06 6.0625p -1.5484939999999999e-06 6.0750000000000002p -1.7442589999999999e-06
+ 6.0874999999999995p -1.9328200000000001e-06 6.1000000000000005p -2.113984e-06 6.1124999999999998p -2.2875679999999999e-06 6.125p -2.4534009999999999e-06 6.1374999999999993p -2.6113209999999998e-06 6.1500000000000004p -2.7611780000000002e-06 6.1624999999999996p -2.9028349999999999e-06 6.1749999999999998p -3.0361649999999999e-06 6.1875p -3.1610509999999998e-06 6.2000000000000002p -3.2773919999999999e-06 6.2125000000000004p -3.3850950000000001e-06 6.2249999999999996p -3.4840800000000001e-06 6.2374999999999998p -3.5742789999999999e-06 6.25p -3.655638e-06 6.2625000000000002p -3.728111e-06 6.2749999999999995p -3.7916689999999998e-06 6.2874999999999996p -3.8462900000000001e-06 6.2999999999999998p -3.8919669999999999e-06
+ 6.3125p -3.9287049999999997e-06 6.3250000000000002p -3.9565189999999996e-06 6.3374999999999995p -3.9754390000000001e-06 6.3500000000000005p -3.9855040000000003e-06 6.3624999999999998p -3.986766e-06 6.375p -3.9792879999999998e-06 6.3875000000000002p -3.9631439999999997e-06 6.4000000000000004p -3.9384210000000002e-06 6.4124999999999996p -3.9052140000000003e-06 6.4249999999999998p -3.8636340000000003e-06 6.4375p -3.8137969999999999e-06 6.4500000000000002p -3.7558340000000002e-06 6.4625000000000004p -3.6898830000000002e-06 6.4749999999999996p -3.6160950000000001e-06 6.4875000000000007p -3.5346290000000002e-06 6.5p -3.4456550000000001e-06 6.5125000000000002p -3.3493490000000001e-06 6.5249999999999995p -3.2459009999999999e-06
+ 6.5375000000000005p -3.1355069999999999e-06 6.5499999999999998p -3.0183700000000002e-06 6.5625p -2.8947040000000001e-06 6.5750000000000002p -2.76473e-06 6.5875000000000004p -2.6286749999999999e-06 6.6000000000000005p -2.4867759999999998e-06 6.6124999999999998p -2.3392739999999999e-06 6.625p -2.186418e-06 6.6375000000000002p -2.0284619999999999e-06 6.6500000000000004p -1.8656669999999999e-06 6.6624999999999996p -1.6982980000000001e-06 6.6749999999999998p -1.526627e-06 6.6875p -1.350928e-06 6.7000000000000002p -1.17148e-06 6.7125000000000004p -9.8856829999999994e-07 6.7249999999999996p -8.024776e-07 6.7375000000000007p -6.1349810000000002e-07 6.75p -4.2192169999999998e-07
+ 6.7625000000000002p -2.280427e-07 6.7749999999999995p -3.2157239999999998e-08 6.7875000000000005p 1.654374e-07 6.7999999999999998p 3.6444299999999998e-07 6.8125p 5.6456059999999997e-07 6.8249999999999993p 7.6549139999999995e-07 6.8375000000000004p 9.6693669999999994e-07 6.8500000000000005p 1.1685990000000001e-06 6.8624999999999998p 1.3701799999999999e-06 6.875p 1.5713859999999999e-06 6.8875000000000002p 1.7719229999999999e-06 6.9000000000000004p 1.9714989999999999e-06 6.9124999999999996p 2.1698270000000001e-06 6.9249999999999998p 2.3666209999999999e-06 6.9375p 2.5615989999999999e-06 6.9500000000000002p 2.754482e-06 6.9624999999999995p 2.9449969999999999e-06 6.9749999999999996p 3.1328739999999998e-06
+ 6.9874999999999998p 3.3178479999999999e-06 7p 3.4996610000000001e-06 7.0125000000000002p 3.6780569999999999e-06 7.0249999999999995p 3.8527899999999999e-06 7.0375000000000005p 4.0236169999999997e-06 7.0499999999999998p 4.1903030000000002e-06 7.0625p 4.3526200000000002e-06 7.0749999999999993p 4.5103449999999996e-06 7.0875000000000004p 4.663265e-06 7.0999999999999996p 4.8111740000000003e-06 7.1124999999999998p 4.9538720000000002e-06 7.125p 5.0911689999999998e-06 7.1375000000000002p 5.2228829999999997e-06 7.1500000000000004p 5.3488390000000004e-06 7.1624999999999996p 5.468874e-06 7.1749999999999998p 5.5828309999999999e-06 7.1875p 5.6905629999999998e-06 7.2000000000000002p 5.7919310000000002e-06
+ 7.2124999999999995p 5.8868089999999997e-06 7.2249999999999996p 5.9750779999999996e-06 7.2374999999999998p 6.0566270000000003e-06 7.25p 6.1313589999999998e-06 7.2625000000000002p 6.1991840000000003e-06 7.2749999999999995p 6.2600220000000004e-06 7.2874999999999996p 6.3138039999999997e-06 7.2999999999999998p 6.3604710000000002e-06 7.3125000000000009p 6.3999740000000003e-06 7.3249999999999993p 6.4322739999999999e-06 7.3375000000000004p 6.4573419999999999e-06 7.3500000000000005p 6.47516e-06 7.3624999999999998p 6.4857189999999999e-06 7.375p 6.489021e-06 7.3874999999999993p 6.4850779999999998e-06 7.4000000000000004p 6.4739120000000003e-06 7.4125000000000005p 6.4555539999999997e-06 7.4249999999999998p 6.4300460000000003e-06
+ 7.4375p 6.3974400000000002e-06 7.4500000000000011p 6.3577969999999996e-06 7.4624999999999995p 6.3111870000000001e-06 7.4750000000000005p 6.2576900000000004e-06 7.4874999999999989p 6.1973970000000003e-06 7.5p 6.1304050000000001e-06 7.5125000000000002p 6.0568210000000001e-06 7.5249999999999995p 5.9767620000000003e-06 7.5375000000000005p 5.8903530000000001e-06 7.5500000000000007p 5.7977259999999999e-06 7.5625p 5.6990230000000004e-06 7.5750000000000002p 5.5943930000000002e-06 7.5874999999999995p 5.4839920000000001e-06 7.5999999999999996p 5.3679849999999999e-06 7.6125000000000007p 5.2465429999999998e-06 7.6249999999999991p 5.119844e-06 7.6375000000000002p 4.9880719999999998e-06 7.6500000000000004p 4.8514200000000004e-06
+ 7.6624999999999996p 4.7100840000000004e-06 7.6750000000000007p 4.5642679999999996e-06 7.6874999999999991p 4.4141790000000001e-06 7.7000000000000002p 4.2600309999999997e-06 7.7125000000000004p 4.102043e-06 7.7249999999999996p 3.940437e-06 7.7374999999999998p 3.775441e-06 7.7500000000000009p 3.607285e-06 7.7624999999999993p 3.4362050000000002e-06 7.7750000000000004p 3.2624369999999998e-06 7.7874999999999996p 3.086222e-06 7.7999999999999998p 2.9078029999999998e-06 7.8125000000000009p 2.727425e-06 7.8249999999999993p 2.5453349999999999e-06 7.8375000000000004p 2.3617810000000001e-06 7.8500000000000005p 2.1770129999999998e-06 7.8624999999999998p 1.991281e-06 7.875p 1.804835e-06
+ 7.8874999999999993p 1.6179269999999999e-06 7.8999999999999995p 1.4308060000000001e-06 7.9125000000000005p 1.243722e-06 7.9249999999999998p 1.056925e-06 7.9375p 8.7066029999999997e-07 7.9500000000000011p 6.8517510000000001e-07 7.9624999999999995p 5.0071279999999998e-07 7.9750000000000005p 3.1751489999999998e-07 7.9874999999999989p 1.3582000000000001e-07 8p -4.4135840000000001e-08 8.0125000000000011p -2.2212019999999999e-07 8.0249999999999986p -3.9790409999999998e-07 8.0374999999999996p -5.7126240000000002e-07 8.0500000000000007p -7.419743e-07 8.0625p -9.0982340000000003e-07 8.0750000000000011p -1.074598e-06 8.0874999999999986p -1.2360910000000001e-06 8.0999999999999996p -1.394102e-06
+ 8.1125000000000007p -1.548435e-06 8.125p -1.6988999999999999e-06 8.1374999999999993p -1.8453120000000001e-06 8.1500000000000004p -1.9874939999999999e-06 8.1624999999999996p -2.125276e-06 8.1750000000000007p -2.2584919999999998e-06 8.1875p -2.386985e-06 8.1999999999999993p -2.5106050000000001e-06 8.2125000000000004p -2.629208e-06 8.2249999999999996p -2.7426580000000001e-06 8.2375000000000007p -2.850827e-06 8.25p -2.9535959999999999e-06 8.2624999999999993p -3.050851e-06 8.2750000000000004p -3.1424869999999998e-06 8.2875000000000014p -3.2284089999999999e-06 8.2999999999999989p -3.3085280000000001e-06 8.3125p -3.3827630000000001e-06 8.3249999999999993p -3.4510449999999998e-06
+ 8.3375000000000004p -3.5133089999999999e-06 8.3500000000000014p -3.5695010000000001e-06 8.3624999999999989p -3.6195740000000002e-06 8.375p -3.6634919999999999e-06 8.3875000000000011p -3.7012249999999999e-06 8.4000000000000004p -3.7327529999999998e-06 8.4124999999999996p -3.7580639999999999e-06 8.4249999999999989p -3.7771549999999998e-06 8.4375p -3.7900320000000002e-06 8.4500000000000011p -3.7967079999999998e-06 8.4625000000000004p -3.7972050000000002e-06 8.4749999999999996p -3.7915539999999998e-06 8.4875000000000007p -3.7797940000000001e-06 8.5p -3.7619719999999998e-06 8.5125000000000011p -3.7381440000000002e-06 8.5249999999999986p -3.708372e-06 8.5374999999999996p -3.6727290000000002e-06 8.5500000000000007p -3.6312909999999998e-06
+ 8.5625p -3.5841469999999999e-06 8.5749999999999993p -3.5313910000000002e-06 8.5875000000000004p -3.473122e-06 8.5999999999999996p -3.40945e-06 8.6125000000000007p -3.340491e-06 8.625p -3.2663660000000001e-06 8.6374999999999993p -3.1872039999999999e-06 8.6500000000000004p -3.1031399999999998e-06 8.6624999999999996p -3.0143160000000001e-06 8.6750000000000007p -2.9208780000000001e-06 8.6875p -2.8229800000000002e-06 8.6999999999999993p -2.7207800000000001e-06 8.7125000000000004p -2.614441e-06 8.7249999999999996p -2.5041330000000002e-06 8.7375000000000007p -2.3900290000000002e-06 8.75p -2.272306e-06 8.7624999999999993p -2.151146e-06 8.7750000000000004p -2.026737e-06
+ 8.7875000000000014p -1.8992669999999999e-06 8.7999999999999989p -1.7689300000000001e-06 8.8125p -1.6359220000000001e-06 8.8249999999999993p -1.500443e-06 8.8375000000000004p -1.3626929999999999e-06 8.8499999999999996p -1.222878e-06 8.8624999999999989p -1.081203e-06 8.875p -9.3787609999999997e-07 8.8875000000000011p -7.9310629999999996e-07 8.9000000000000004p -6.4710409999999996e-07 8.9124999999999996p -5.0008060000000002e-07 8.9249999999999989p -3.5224749999999998e-07 8.9375p -2.0381660000000001e-07 8.9500000000000011p -5.5000000000000003e-08 8.9624999999999986p 9.3990889999999996e-08 8.9749999999999996p 2.429451e-07 8.9875000000000007p 3.9165250000000001e-07 9p 5.3990439999999998e-07
+ 9.0125000000000011p 6.8749330000000003e-07 9.0249999999999986p 8.3421370000000003e-07 9.0374999999999996p 9.798619e-07 9.0500000000000007p 1.1242369999999999e-06 9.0625p 1.2671389999999999e-06 9.0749999999999993p 1.4083740000000001e-06 9.0875000000000004p 1.547747e-06 9.0999999999999996p 1.68507e-06 9.1125000000000007p 1.820157e-06 9.125p 1.952826e-06 9.1374999999999993p 2.0828970000000001e-06 9.1500000000000004p 2.2101989999999998e-06 9.1624999999999996p 2.334561e-06 9.1750000000000007p 2.4558190000000002e-06 9.1875p 2.5738140000000002e-06 9.1999999999999993p 2.6883900000000001e-06 9.2125000000000004p 2.799399e-06 9.2250000000000014p 2.9066970000000002e-06
+ 9.2374999999999989p 3.010147e-06 9.25p 3.109615e-06 9.2624999999999993p 3.204976e-06 9.2750000000000004p 3.2961090000000001e-06 9.2875000000000014p 3.3829019999999999e-06 9.2999999999999989p 3.4652459999999999e-06 9.3125p 3.5430420000000001e-06 9.3250000000000011p 3.616194e-06 9.3375000000000004p 3.6846170000000001e-06 9.3499999999999996p 3.7482279999999999e-06 9.3624999999999989p 3.806955e-06 9.375p 3.8607320000000002e-06 9.3875000000000011p 3.909498e-06 9.4000000000000004p 3.9532020000000002e-06 9.4124999999999996p 3.991798e-06 9.4250000000000007p 4.0252489999999999e-06 9.4375p 4.0535240000000001e-06 9.4500000000000011p 4.0766000000000001e-06
+ 9.4624999999999986p 4.0944600000000001e-06 9.4749999999999996p 4.1070959999999999e-06 9.4875000000000007p 4.1145059999999999e-06 9.5p 4.1166959999999998e-06 9.5124999999999993p 4.1136779999999999e-06 9.5250000000000004p 4.105472e-06 9.5374999999999996p 4.0921059999999999e-06 9.5500000000000007p 4.073613e-06 9.5625p 4.0500350000000001e-06 9.5749999999999993p 4.0214180000000002e-06 9.5875000000000004p 3.9878189999999996e-06 9.5999999999999996p 3.949298e-06 9.6125000000000007p 3.9059220000000003e-06 9.625p 3.8577670000000003e-06 9.6374999999999993p 3.8049129999999999e-06 9.6500000000000004p 3.7474459999999999e-06 9.6624999999999996p 3.6854610000000001e-06 9.6750000000000007p 3.6190539999999998e-06
+ 9.6875p 3.5483310000000002e-06 9.6999999999999993p 3.4734020000000001e-06 9.7125000000000004p 3.3943829999999998e-06 9.7250000000000014p 3.3113930000000002e-06 9.7374999999999989p 3.2245600000000002e-06 9.75p 3.1340119999999999e-06 9.7624999999999993p 3.0398870000000002e-06 9.7750000000000004p 2.9423219999999999e-06 9.7874999999999996p 2.8414629999999999e-06 9.7999999999999989p 2.7374560000000001e-06 9.8125p 2.6304549999999999e-06 9.8250000000000011p 2.5206130000000002e-06 9.8375000000000004p 2.4080909999999998e-06 9.8499999999999996p 2.2930490000000002e-06 9.8624999999999989p 2.1756520000000001e-06 9.875p 2.0560680000000001e-06 9.8875000000000011p 1.9344660000000002e-06 9.8999999999999986p 1.811019e-06
+ 9.9124999999999996p 1.685899e-06 9.9250000000000007p 1.559283e-06 9.9375p 1.431348e-06 9.9500000000000011p 1.3022710000000001e-06 9.9624999999999986p 1.172232e-06 9.9749999999999996p 1.041411e-06 9.9875000000000007p 9.0998689999999999e-07 10p 7.7814069999999995e-07 10.012499999999999p 2.7644530000000001e-05 10.025p 1.7493799999999998e-05 10.0375p 1.6884759999999999e-05 10.050000000000001p 1.650197e-05 10.0625p 1.633531e-05 10.074999999999999p 1.637314e-05 10.0875p 1.6603360000000002e-05 10.1p 1.7013910000000001e-05 10.112500000000001p 1.7592830000000001e-05 10.125p 1.8328430000000001e-05
+ 10.137499999999999p 1.9209289999999998e-05 10.15p 2.0224309999999999e-05 10.162500000000001p 2.1362750000000001e-05 10.174999999999999p 2.2614240000000001e-05 10.1875p 2.3968820000000001e-05 10.199999999999999p 2.541694e-05 10.2125p 2.6949479999999999e-05 10.225000000000001p 2.8557789999999999e-05 10.237499999999999p 3.0233650000000001e-05 10.25p 3.1969289999999998e-05 10.262500000000001p 3.3757419999999998e-05 10.275p 3.559121e-05 10.2875p 3.7464259999999997e-05 10.299999999999999p 3.9370640000000002e-05 10.3125p 4.1304840000000001e-05 10.325000000000001p 4.3261789999999999e-05 10.3375p 4.5236830000000002e-05 10.35p 4.7225689999999997e-05
+ 10.362500000000001p 4.9224519999999997e-05 10.375p 5.122977e-05 10.387500000000001p 5.3238300000000002e-05 10.399999999999999p 5.5247259999999999e-05 10.4125p 5.7254099999999998e-05 10.425000000000001p 5.9256580000000003e-05 10.4375p 6.1252699999999997e-05 10.449999999999999p 6.3240710000000007e-05 10.4625p 6.5219070000000005e-05 10.475p 6.7186430000000007e-05 10.487500000000001p 6.9141609999999996e-05 10.5p 7.1083609999999999e-05 10.512499999999999p 7.3011520000000005e-05 10.525p 7.4924560000000001e-05 10.5375p 7.6822020000000006e-05 10.550000000000001p 7.8703280000000001e-05 10.5625p 8.0567760000000002e-05 10.574999999999999p 8.2414909999999997e-05
+ 10.5875p 8.4244200000000002e-05 10.6p 8.6055089999999995e-05 10.612500000000001p 8.7847050000000005e-05 10.625p 8.9619500000000005e-05 10.637499999999999p 9.1371839999999994e-05 10.65p 9.3103409999999994e-05 10.662500000000001p 9.4813489999999995e-05 10.674999999999999p 9.6501309999999998e-05 10.6875p 9.8166019999999996e-05 10.699999999999999p 9.9806680000000006e-05 10.7125p 0.0001014223 10.725p 0.0001030117 10.737499999999999p 0.0001045739 10.75p 0.00010610740000000001 10.762500000000001p 0.000107611 10.775p 0.0001090832 10.7875p 0.0001105224 10.799999999999999p 0.0001119272
+ 10.8125p 0.0001132957 10.825000000000001p 0.0001146263 10.837499999999999p 0.0001159171 10.85p 0.0001171663 10.862500000000001p 0.0001183719 10.875p 0.00011953199999999999 10.887500000000001p 0.00012064459999999999 10.899999999999999p 0.00012170759999999999 10.9125p 0.00012271910000000001 10.925000000000001p 0.00012367690000000001 10.9375p 0.00012457899999999999 10.949999999999999p 0.0001254234 10.9625p 0.000126208 10.975p 0.00012693089999999999 10.987500000000001p 0.00012758999999999999 11p 0.00012818359999999999 11.012499999999999p 0.0001017112 11.025p 0.0001121866
+ 11.0375p 0.0001130496 11.050000000000001p 0.00011361390000000001 11.0625p 0.0001138885 11.074999999999999p 0.00011388359999999999 11.0875p 0.0001136103 11.100000000000001p 0.00011307939999999999 11.112499999999999p 0.000112302 11.125p 0.000111289 11.137499999999999p 0.00011005099999999999 11.15p 0.00010859859999999999 11.162500000000001p 0.00010694199999999999 11.174999999999999p 0.0001050914 11.1875p 0.0001030564 11.200000000000001p 0.0001008466 11.2125p 9.8471260000000004e-05 11.225p 9.5939220000000006e-05 11.237499999999999p 9.3259100000000003e-05 11.25p 9.0439219999999994e-05
+ 11.262500000000001p 8.7487539999999995e-05 11.275p 8.441174e-05 11.2875p 8.1219179999999995e-05 11.300000000000001p 7.7916899999999999e-05 11.3125p 7.4511659999999997e-05 11.325000000000001p 7.1009919999999994e-05 11.337499999999999p 6.7417860000000001e-05 11.35p 6.3741399999999999e-05 11.362500000000001p 5.9986189999999998e-05 11.375p 5.6157640000000002e-05 11.387499999999999p 5.2260940000000002e-05 11.4p 4.8301060000000001e-05 11.4125p 4.4282780000000001e-05 11.425000000000001p 4.0210689999999997e-05 11.4375p 3.6089240000000003e-05 11.449999999999999p 3.1922699999999998e-05 11.4625p 2.7715230000000001e-05 11.475p 2.347087e-05
+ 11.487500000000001p 1.9193559999999999e-05 11.5p 1.488717e-05 11.512499999999999p 1.055549e-05 11.525p 6.2022630000000004e-06 11.5375p 1.8311999999999999e-06 11.550000000000001p -2.554023e-06 11.5625p -6.9497349999999996e-06 11.574999999999999p -1.1352269999999999e-05 11.5875p -1.575795e-05 11.600000000000001p -2.0163070000000001e-05 11.612499999999999p -2.4563910000000001e-05 11.625p -2.8956720000000001e-05 11.637499999999999p -3.3337680000000003e-05 11.65p -3.7702949999999998e-05 11.6625p -4.2048619999999997e-05 11.674999999999999p -4.6370750000000003e-05 11.6875p -5.066533e-05 11.700000000000001p -5.4928269999999998e-05
+ 11.7125p -5.9155459999999997e-05 11.725p -6.3342720000000001e-05 11.737499999999999p -6.7485809999999998e-05 11.75p -7.1580440000000006e-05 11.762500000000001p -7.5622289999999995e-05 11.774999999999999p -7.9606969999999997e-05 11.7875p -8.353008e-05 11.800000000000001p -8.7387169999999994e-05 11.8125p -9.1173780000000003e-05 11.825000000000001p -9.488543e-05 11.8375p -9.8517639999999996e-05 11.85p -0.0001020659 11.862500000000001p -0.00010552580000000001 11.875p -0.0001088928 11.887499999999999p -0.0001121626 11.9p -0.0001153307 11.9125p -0.0001183929 11.925000000000001p -0.0001213448
+ 11.9375p -0.00012418229999999999 11.949999999999999p -0.0001269013 11.9625p -0.00012949780000000001 11.975p -0.00013196789999999999 11.987500000000001p -0.00013430779999999999 12p -0.0001365138 12.012499999999999p -0.00013858260000000001 12.025p -0.00014051060000000001 12.037500000000001p -0.0001422947 12.049999999999999p -0.00014393190000000001 12.0625p -0.00014541930000000001 12.074999999999999p -0.00014675420000000001 12.0875p -0.0001479343 12.100000000000001p -0.0001489572 12.112499999999999p -0.0001498208 12.125p -0.00015052340000000001 12.137500000000001p -0.00015106329999999999 12.15p -0.0001514392
+ 12.1625p -0.00015164989999999999 12.174999999999999p -0.0001516945 12.1875p -0.00015157230000000001 12.200000000000001p -0.00015128289999999999 12.2125p -0.0001508262 12.225p -0.00015020220000000001 12.237500000000001p -0.0001494113 12.25p -0.00014845409999999999 12.262500000000001p -0.0001473313 12.274999999999999p -0.0001460442 12.2875p -0.00014459410000000001 12.300000000000001p -0.0001429825 12.3125p -0.0001412114 12.324999999999999p -0.00013928270000000001 12.3375p -0.00013719890000000001 12.35p -0.00013496259999999999 12.362500000000001p -0.00013257650000000001 12.375p -0.0001300436
+ 12.387499999999999p -0.0001273674 12.4p -0.00012455109999999999 12.4125p -0.00012159870000000001 12.425000000000001p -0.0001185138 12.4375p -0.00011530070000000001 12.449999999999999p -0.0001119636 12.4625p -0.000108507 12.475p -0.00010493550000000001 12.487500000000001p -0.000101254 12.5p -9.7467500000000002e-05 12.512499999999999p -9.3581009999999998e-05 12.525p -8.9599849999999999e-05 12.537500000000001p -8.5529410000000002e-05 12.549999999999999p -8.13752e-05 12.5625p -7.7142850000000006e-05 12.574999999999999p -7.2838100000000003e-05 12.5875p -6.8466760000000004e-05 12.6p -6.4034740000000001e-05
+ 12.612499999999999p -5.9548030000000002e-05 12.625p -5.5012649999999999e-05 12.637500000000001p -5.0434720000000002e-05 12.65p -4.5820360000000003e-05 12.6625p -4.1175740000000002e-05 12.674999999999999p -3.650708e-05 12.6875p -3.1820570000000003e-05 12.700000000000001p -2.7122420000000001e-05 12.712499999999999p -2.241886e-05 12.725p -1.771608e-05 12.737500000000001p -1.3020240000000001e-05 12.75p -8.3374930000000002e-06 12.762500000000001p -3.6739300000000001e-06 12.775p 9.6439979999999994e-07 12.7875p 5.5715069999999999e-06 12.800000000000001p 1.0141470000000001e-05 12.8125p 1.4668439999999999e-05 12.824999999999999p 1.9146660000000001e-05
+ 12.8375p 2.3570450000000001e-05 12.85p 2.793424e-05 12.862500000000001p 3.2232549999999997e-05 12.875p 3.6460049999999997e-05 12.887499999999999p 4.0611480000000001e-05 12.9p 4.4681729999999998e-05 12.9125p 4.866584e-05 12.925000000000001p 5.2558949999999999e-05 12.9375p 5.6356369999999999e-05 12.949999999999999p 6.005355e-05 12.9625p 6.36461e-05 12.975000000000001p 6.7129790000000002e-05 12.987499999999999p 7.0500540000000003e-05 13p 7.3754440000000003e-05 13.012499999999999p 7.6887779999999998e-05 13.025p 7.9896999999999998e-05 13.037500000000001p 8.2778719999999995e-05 13.049999999999999p 8.5529739999999998e-05
+ 13.0625p 8.814707e-05 13.075000000000001p 9.0627890000000006e-05 13.0875p 9.2969569999999996e-05 13.1p 9.5169670000000003e-05 13.112499999999999p 9.7225970000000005e-05 13.125p 9.9136409999999996e-05 13.137500000000001p 0.0001008992 13.15p 0.0001025126 13.1625p 0.00010397519999999999 13.175000000000001p 0.00010528579999999999 13.1875p 0.0001064433 13.200000000000001p 0.0001074469 13.212499999999999p 0.00010829599999999999 13.225p 0.00010899010000000001 13.237500000000001p 0.00010952889999999999 13.25p 0.0001099125 13.262499999999999p 0.00011014089999999999 13.275p 0.0001102146
+ 13.2875p 0.00011013410000000001 13.300000000000001p 0.00010990009999999999 13.3125p 0.00010951359999999999 13.324999999999999p 0.0001089757 13.3375p 0.0001082876 13.35p 0.000107451 13.362500000000001p 0.0001064673 13.375p 0.0001053386 13.387499999999999p 0.0001040668 13.4p 0.0001026541 13.4125p 0.0001011029 13.425000000000001p 9.9415670000000002e-05 13.4375p 9.7595109999999997e-05 13.449999999999999p 9.5644039999999997e-05 13.4625p 9.3565469999999995e-05 13.475000000000001p 9.1362500000000005e-05 13.487499999999999p 8.9038419999999999e-05 13.5p 8.6596619999999998e-05
+ 13.512499999999999p 8.4040630000000005e-05 13.525p 8.1374130000000006e-05 13.5375p 7.8600879999999993e-05 13.549999999999999p 7.5724779999999996e-05 13.5625p 7.2749829999999995e-05 13.575000000000001p 6.9680130000000006e-05 13.5875p 6.6519879999999998e-05 13.6p 6.3273380000000002e-05 13.612499999999999p 5.9945009999999997e-05 13.625p 5.6539210000000003e-05 13.637500000000001p 5.306053e-05 13.649999999999999p 4.9513559999999997e-05 13.6625p 4.5902970000000002e-05 13.675000000000001p 4.2233449999999998e-05 13.6875p 3.8509790000000001e-05 13.700000000000001p 3.4736780000000001e-05 13.7125p 3.0919279999999999e-05 13.725p 2.7062139999999999e-05
+ 13.737500000000001p 2.3170279999999999e-05 13.75p 1.9248600000000001e-05 13.762499999999999p 1.530204e-05 13.775p 1.1335530000000001e-05 13.7875p 7.3540040000000003e-06 13.800000000000001p 3.3623929999999998e-06 13.8125p -6.3438599999999995e-07 13.824999999999999p -4.6314320000000003e-06 13.8375p -8.6238690000000008e-06 13.85p -1.2606849999999999e-05 13.862500000000001p -1.6575550000000001e-05 13.875p -2.0525209999999999e-05 13.887499999999999p -2.445109e-05 13.9p -2.8348509999999999e-05 13.912500000000001p -3.2212860000000002e-05 13.924999999999999p -3.6039550000000003e-05 13.9375p -3.9824099999999997e-05 13.949999999999999p -4.3562069999999999e-05
+ 13.9625p -4.7249110000000002e-05 13.975p -5.0880949999999999e-05 13.987499999999999p -5.4453380000000001e-05 14p -5.796231e-05 14.012500000000001p -6.1403720000000004e-05 14.025p -6.4773700000000006e-05 14.0375p -6.8068420000000002e-05 14.049999999999999p -7.1284170000000002e-05 14.0625p -7.4417339999999999e-05 14.075000000000001p -7.7464430000000005e-05 14.0875p -8.0422060000000001e-05 14.1p -8.3286960000000001e-05 14.112500000000001p -8.6055980000000003e-05 14.125p -8.8726099999999997e-05 14.137500000000001p -9.1294419999999999e-05 14.149999999999999p -9.3758160000000004e-05 14.1625p -9.6114680000000002e-05 14.175000000000001p -9.8361479999999995e-05
+ 14.1875p -0.0001004962 14.199999999999999p -0.0001025165 14.2125p -0.0001044205 14.225p -0.00010620600000000001 14.237500000000001p -0.0001078714 14.25p -0.0001094149 14.262499999999999p -0.00011083500000000001 14.275p -0.00011213030000000001 14.2875p -0.0001132997 14.300000000000001p -0.000114342 14.3125p -0.0001152563 14.324999999999999p -0.0001160418 14.3375p -0.000116698 14.35p -0.0001172243 14.362500000000001p -0.0001176204 14.375p -0.0001178861 14.387499999999999p -0.00011802149999999999 14.4p -0.00011802670000000001
+ 14.412500000000001p -0.000117902 14.424999999999999p -0.0001176478 14.4375p -0.0001172647 14.449999999999999p -0.00011675350000000001 14.4625p -0.000116115 14.475p -0.00011535030000000001 14.487499999999999p -0.00011446069999999999 14.5p -0.00011344729999999999 14.512500000000001p -0.0001123118 14.525p -0.00011105569999999999 14.5375p -0.0001096808 14.549999999999999p -0.000108189 14.562500000000002p -0.0001065823 14.574999999999999p -0.000104863 14.587499999999999p -0.00010303329999999999 14.6p -0.0001010957 14.612500000000001p -9.9052650000000004e-05 14.625000000000002p -9.6906929999999994e-05
+ 14.637499999999999p -9.4661310000000002e-05 14.649999999999999p -9.2318700000000001e-05 14.6625p -8.988213e-05 14.675000000000001p -8.7354750000000002e-05 14.687500000000002p -8.4739780000000003e-05 14.700000000000001p -8.2040560000000006e-05 14.712499999999999p -7.9260539999999994e-05 14.725p -7.6403229999999996e-05 14.737500000000001p -7.3472249999999994e-05 14.75p -7.0471280000000003e-05 14.762500000000001p -6.7404110000000001e-05 14.774999999999999p -6.427456e-05 14.7875p -6.1086560000000003e-05 14.800000000000001p -5.7844060000000001e-05 14.8125p -5.455109e-05 14.825000000000001p -5.1211739999999999e-05 14.837499999999999p -4.7830110000000002e-05 14.85p -4.4410380000000003e-05
+ 14.862499999999999p -4.0956730000000002e-05 14.875p -3.7473399999999999e-05 14.887500000000001p -3.3964609999999997e-05 14.900000000000002p -3.0434649999999998e-05 14.9125p -2.6887770000000002e-05 14.924999999999999p -2.3328259999999999e-05 14.9375p -1.9760390000000001e-05 14.950000000000001p -1.6188430000000001e-05 14.962500000000002p -1.2616650000000001e-05 14.974999999999998p -9.0492800000000002e-06 14.987499999999999p -5.4905350000000001e-06 15p -1.9446040000000001e-06 15.012500000000001p 1.5843649999999999e-06 15.025p 5.0922600000000001e-06 15.037499999999998p 8.5750199999999998e-06 15.049999999999999p 1.2028630000000001e-05 15.0625p 1.544914e-05 15.075000000000001p 1.883265e-05
+ 15.0875p 2.2175350000000001e-05 15.100000000000001p 2.5473480000000001e-05 15.112499999999999p 2.8723360000000001e-05 15.125p 3.1921400000000002e-05 15.137499999999999p 3.5064090000000001e-05 15.15p 3.8148020000000003e-05 15.162500000000001p 4.1169879999999999e-05 15.174999999999999p 4.412643e-05 15.1875p 4.7014559999999999e-05 15.199999999999999p 4.9831260000000002e-05 15.2125p 5.2573620000000002e-05 15.225000000000001p 5.5238870000000002e-05 15.237499999999999p 5.7824339999999997e-05 15.249999999999998p 6.0327469999999999e-05 15.262499999999999p 6.274583e-05 15.275p 6.5077139999999997e-05 15.287500000000001p 6.7319209999999998e-05 15.300000000000001p 6.9470009999999998e-05
+ 15.312499999999998p 7.1527619999999997e-05 15.324999999999999p 7.3490269999999995e-05 15.3375p 7.5356319999999997e-05 15.350000000000001p 7.7124269999999994e-05 15.362500000000001p 7.8792749999999999e-05 15.374999999999998p 8.0360539999999993e-05 15.387499999999999p 8.1826559999999997e-05 15.4p 8.3189859999999998e-05 15.4125p 8.4449639999999995e-05 15.425000000000001p 8.5605239999999994e-05 15.437499999999998p 8.6656150000000002e-05 15.449999999999999p 8.7601980000000005e-05 15.4625p 8.844251e-05 15.475p 8.9177629999999993e-05 15.487500000000001p 8.9807390000000003e-05 15.500000000000002p 9.033198e-05 15.512499999999999p 9.0751719999999995e-05 15.524999999999999p 9.1067060000000005e-05
+ 15.5375p 9.1278600000000004e-05 15.550000000000001p 9.1387070000000003e-05 15.562500000000002p 9.1393320000000006e-05 15.574999999999999p 9.1298350000000003e-05 15.587499999999999p 9.1103270000000004e-05 15.6p 9.0809309999999999e-05 15.612500000000001p 9.0417850000000004e-05 15.625000000000002p 8.993037e-05 15.637500000000001p 8.9348460000000004e-05 15.649999999999999p 8.8673850000000001e-05 15.6625p 8.7908359999999997e-05 15.675000000000001p 8.7053930000000006e-05 15.6875p 8.6112590000000006e-05 15.700000000000001p 8.5086489999999999e-05 15.712499999999999p 8.3977860000000005e-05 15.725p 8.2789039999999999e-05 15.737500000000001p 8.1522460000000001e-05 15.75p 8.0180609999999997e-05
+ 15.762500000000001p 7.8766100000000005e-05 15.774999999999999p 7.7281589999999995e-05 15.7875p 7.5729829999999997e-05 15.799999999999999p 7.4113620000000003e-05 15.8125p 7.2435859999999999e-05 15.825000000000001p 7.0699470000000001e-05 15.837500000000002p 6.8907460000000001e-05 15.85p 6.7062859999999995e-05 15.862499999999999p 6.5168779999999997e-05 15.875p 6.3228349999999996e-05 15.887500000000001p 6.1244739999999996e-05 15.900000000000002p 5.9221169999999999e-05 15.912499999999998p 5.7160860000000001e-05 15.924999999999999p 5.5067079999999999e-05 15.9375p 5.2943089999999997e-05 15.950000000000001p 5.0792199999999998e-05 15.9625p 4.86177e-05 15.974999999999998p 4.6422889999999998e-05
+ 15.987499999999999p 4.4211069999999999e-05 16p 4.1985540000000003e-05 16.012499999999999p 3.9749590000000002e-05 16.025000000000002p 3.7506480000000003e-05 16.037500000000001p 3.5259470000000001e-05 16.049999999999997p 3.3011769999999999e-05 16.0625p 3.0766599999999998e-05 16.074999999999999p 2.85271e-05 16.087500000000002p 2.6296409999999998e-05 16.100000000000001p 2.4077609999999999e-05 16.112499999999997p 2.1873729999999999e-05 16.125p 1.9687769999999999e-05 16.137499999999999p 1.752264e-05 16.150000000000002p 1.5381219999999999e-05 16.162500000000001p 1.3266330000000001e-05 16.174999999999997p 1.1180690000000001e-05 16.1875p 9.1269920000000007e-06 16.199999999999999p 7.1078269999999996e-06
+ 16.212499999999999p 5.1257169999999997e-06 16.225000000000001p 3.1831040000000002e-06 16.237500000000001p 1.282347e-06 16.25p -5.7428090000000001e-07 16.262499999999999p -2.3845970000000001e-06 16.274999999999999p -4.146507e-06 16.287500000000001p -5.8580149999999999e-06 16.300000000000001p -7.5172160000000002e-06 16.3125p -9.1223069999999999e-06 16.324999999999999p -1.067158e-05 16.337499999999999p -1.2163440000000001e-05 16.350000000000001p -1.359639e-05 16.362500000000001p -1.496902e-05 16.375p -1.6280060000000001e-05 16.387499999999999p -1.7528320000000001e-05 16.399999999999999p -1.871273e-05 16.412500000000001p -1.9832320000000001e-05 16.425000000000001p -2.0886239999999999e-05
+ 16.4375p -2.187374e-05 16.449999999999999p -2.2794189999999999e-05 16.462499999999999p -2.3647049999999999e-05 16.475000000000001p -2.443192e-05 16.487500000000001p -2.5148490000000001e-05 16.5p -2.579655e-05 16.512499999999999p -2.637601e-05 16.524999999999999p -2.6886890000000001e-05 16.537500000000001p -2.732931e-05 16.550000000000001p -2.77035e-05 16.5625p -2.8009779999999999e-05 16.575000000000003p -2.8248589999999998e-05 16.587499999999999p -2.8420460000000001e-05 16.599999999999998p -2.8526019999999999e-05 16.612500000000001p -2.8566010000000001e-05 16.625p -2.8541250000000001e-05 16.637500000000003p -2.845266e-05 16.649999999999999p -2.8301239999999999e-05
+ 16.662499999999998p -2.808811e-05 16.675000000000001p -2.7814430000000001e-05 16.6875p -2.7481500000000001e-05 16.700000000000003p -2.7090650000000001e-05 16.712499999999999p -2.6643330000000002e-05 16.724999999999998p -2.6141030000000001e-05 16.737500000000001p -2.5585360000000001e-05 16.75p -2.4977960000000001e-05 16.762499999999999p -2.4320549999999999e-05 16.775000000000002p -2.3614929999999999e-05 16.787499999999998p -2.2862950000000001e-05 16.800000000000001p -2.206651e-05 16.8125p -2.12276e-05 16.824999999999999p -2.0348230000000002e-05 16.837500000000002p -1.943046e-05 16.849999999999998p -1.847643e-05 16.862500000000001p -1.7488289999999999e-05 16.875p -1.6468249999999999e-05
+ 16.887499999999999p -1.541853e-05 16.900000000000002p -1.434143e-05 16.912499999999998p -1.3239230000000001e-05 16.925000000000001p -1.211427e-05 16.9375p -1.0968899999999999e-05 16.949999999999999p -9.8054909999999999e-06 16.962500000000002p -8.6264299999999997e-06 16.975000000000001p -7.4341179999999998e-06 16.987499999999997p -6.230964e-06 17p -5.0193850000000004e-06 17.012499999999999p -3.8017960000000001e-06 17.025000000000002p -2.5806139999999999e-06 17.037500000000001p -1.3582500000000001e-06 17.049999999999997p -1.371072e-07 17.0625p 1.0804230000000001e-06 17.074999999999999p 2.2919629999999999e-06 17.087500000000002p 3.4951549999999998e-06 17.100000000000001p 4.6876629999999996e-06
+ 17.112499999999997p 5.867174e-06 17.125p 7.0314040000000002e-06 17.137499999999999p 8.1780989999999994e-06 17.149999999999999p 9.3050430000000008e-06 17.162500000000001p 1.041005e-05 17.175000000000001p 1.149099e-05 17.1875p 1.2545749999999999e-05 17.199999999999999p 1.357229e-05 17.212499999999999p 1.45686e-05 17.225000000000001p 1.553273e-05 17.237500000000001p 1.646279e-05 17.25p 1.7356929999999998e-05 17.262499999999999p 1.8213379999999999e-05 17.274999999999999p 1.9030420000000001e-05 17.287500000000001p 1.9806379999999999e-05 17.300000000000001p 2.0539689999999998e-05 17.3125p 2.1228830000000001e-05 17.324999999999999p 2.187234e-05
+ 17.337499999999999p 2.2468850000000001e-05 17.350000000000001p 2.301705e-05 17.362500000000001p 2.3515730000000001e-05 17.375p 2.3963730000000001e-05 17.387499999999999p 2.4359979999999999e-05 17.399999999999999p 2.4703500000000002e-05 17.412500000000001p 2.499339e-05 17.425000000000001p 2.5228809999999999e-05 17.4375p 2.5409029999999999e-05 17.449999999999999p 2.5533390000000001e-05 17.462499999999999p 2.5601340000000001e-05 17.475000000000001p 2.5612390000000002e-05 17.487500000000001p 2.5566149999999999e-05 17.5p 2.546232e-05 17.512500000000003p 2.5300670000000001e-05 17.524999999999999p 2.5081089999999999e-05 17.537499999999998p 2.4803529999999999e-05 17.550000000000001p 2.446805e-05
+ 17.5625p 2.4074780000000001e-05 17.575000000000003p 2.3623949999999999e-05 17.587499999999999p 2.3115870000000001e-05 17.599999999999998p 2.2550959999999999e-05 17.612500000000001p 2.192969e-05 17.625p 2.1252629999999999e-05 17.637500000000003p 2.0520459999999998e-05 17.649999999999999p 1.9733910000000002e-05 17.662499999999998p 1.8893809999999999e-05 17.675000000000001p 1.800106e-05 17.6875p 1.7056649999999999e-05 17.699999999999999p 1.6061649999999999e-05 17.712500000000002p 1.5017200000000001e-05 17.724999999999998p 1.3924509999999999e-05 17.737500000000001p 1.2784889999999999e-05 17.75p 1.159968e-05 17.762499999999999p 1.0370319999999999e-05 17.775000000000002p 9.0983179999999999e-06
+ 17.787499999999998p 7.7852240000000003e-06 17.800000000000001p 6.4326699999999999e-06 17.8125p 5.0423409999999996e-06 17.824999999999999p 3.6159820000000001e-06 17.837500000000002p 2.1553930000000002e-06 17.849999999999998p 6.624244e-07 17.862500000000001p -8.6102059999999997e-07 17.875p -2.412993e-06 17.887499999999999p -3.9914990000000004e-06 17.900000000000002p -5.5945039999999997e-06 17.912500000000001p -7.2199339999999998e-06 17.924999999999997p -8.8656800000000008e-06 17.9375p -1.05296e-05 17.949999999999999p -1.220952e-05 17.962500000000002p -1.390324e-05 17.975000000000001p -1.5608540000000001e-05 17.987499999999997p -1.7323179999999999e-05 18p -1.9044900000000001e-05
+ 18.012499999999999p -2.0771430000000001e-05 18.025000000000002p -2.250047e-05 18.037500000000001p -2.4229730000000002e-05 18.049999999999997p -2.5956930000000001e-05 18.0625p -2.7679740000000001e-05 18.074999999999999p -2.939589e-05 18.087499999999999p -3.1103070000000002e-05 18.100000000000001p -3.2798990000000002e-05 18.112500000000001p -3.4481379999999997e-05 18.125p -3.6147979999999999e-05 18.137499999999999p -3.7796539999999999e-05 18.149999999999999p -3.9424829999999998e-05 18.162500000000001p -4.1030650000000003e-05 18.175000000000001p -4.2611819999999999e-05 18.1875p -4.4166189999999997e-05 18.199999999999999p -4.5691629999999997e-05 18.212499999999999p -4.7186060000000003e-05 18.225000000000001p -4.8647440000000001e-05
+ 18.237500000000001p -5.0073739999999997e-05 18.25p -5.1462999999999998e-05 18.262499999999999p -5.2813299999999998e-05 18.274999999999999p -5.4122739999999999e-05 18.287500000000001p -5.5389510000000003e-05 18.300000000000001p -5.6611830000000001e-05 18.3125p -5.778796e-05 18.324999999999999p -5.891624e-05 18.337499999999999p -5.9995050000000001e-05 18.350000000000001p -6.1022839999999997e-05 18.362500000000001p -6.1998129999999994e-05 18.375p -6.2919470000000004e-05 18.387499999999999p -6.3785519999999996e-05 18.399999999999999p -6.4594959999999998e-05 18.412500000000001p -6.5346589999999995e-05 18.425000000000001p -6.6039239999999999e-05 18.4375p -6.6671820000000002e-05 18.450000000000003p -6.7243320000000002e-05
+ 18.462499999999999p -6.775281e-05 18.474999999999998p -6.8199420000000004e-05 18.487500000000001p -6.858236e-05 18.5p -6.8900940000000006e-05 18.512500000000003p -6.9154510000000004e-05 18.524999999999999p -6.9342529999999998e-05 18.537499999999998p -6.9464519999999993e-05 18.550000000000001p -6.9520100000000005e-05 18.5625p -6.9508949999999998e-05 18.575000000000003p -6.9430849999999996e-05 18.587499999999999p -6.9285660000000004e-05 18.599999999999998p -6.9073300000000002e-05 18.612500000000001p -6.8793800000000005e-05 18.625p -6.8447249999999994e-05 18.637499999999999p -6.8033849999999996e-05 18.650000000000002p -6.755385e-05 18.662499999999998p -6.7007610000000006e-05 18.675000000000001p -6.6395540000000001e-05
+ 18.6875p -6.5718169999999995e-05 18.699999999999999p -6.4976070000000001e-05 18.712500000000002p -6.4169929999999999e-05 18.724999999999998p -6.330048e-05 18.737500000000001p -6.2368559999999995e-05 18.75p -6.1375070000000006e-05 18.762499999999999p -6.032099e-05 18.775000000000002p -5.9207379999999997e-05 18.787499999999998p -5.8035360000000001e-05 18.800000000000001p -5.6806140000000001e-05 18.8125p -5.5520989999999998e-05 18.824999999999999p -5.418126e-05 18.837500000000002p -5.2788360000000002e-05 18.850000000000001p -5.1343759999999998e-05 18.862499999999997p -4.9849019999999998e-05 18.875p -4.8305720000000002e-05 18.887499999999999p -4.671555e-05 18.900000000000002p -4.5080219999999997e-05
+ 18.912500000000001p -4.3401530000000003e-05 18.924999999999997p -4.1681290000000003e-05 18.9375p -3.9921410000000001e-05 18.949999999999999p -3.8123829999999998e-05 18.962500000000002p -3.6290530000000003e-05 18.975000000000001p -3.4423540000000003e-05 18.987499999999997p -3.252494e-05 19p -3.0596850000000002e-05 19.012499999999999p -2.8641410000000001e-05 19.024999999999999p -2.6660810000000001e-05 19.037500000000001p -2.4657280000000001e-05 19.050000000000001p -2.263307e-05 19.0625p -2.0590440000000001e-05 19.074999999999999p -1.853169e-05 19.087499999999999p -1.645916e-05 19.100000000000001p -1.437517e-05 19.112500000000001p -1.228207e-05 19.125p -1.018224e-05
+ 19.137499999999999p -8.0780320000000005e-06 19.149999999999999p -5.9718379999999999e-06 19.162500000000001p -3.8660360000000001e-06 19.175000000000001p -1.763005e-06 19.1875p 3.3487669999999999e-07 19.199999999999999p 2.4252390000000001e-06 19.212499999999999p 4.5057220000000001e-06 19.225000000000001p 6.573975e-06 19.237500000000001p 8.6276660000000008e-06 19.25p 1.066448e-05 19.262499999999999p 1.268212e-05 19.274999999999999p 1.467833e-05 19.287500000000001p 1.6650860000000001e-05 19.300000000000001p 1.8597489999999999e-05 19.3125p 2.0516050000000002e-05 19.324999999999999p 2.2404399999999998e-05 19.337499999999999p 2.4260439999999998e-05 19.350000000000001p 2.6082090000000002e-05
+ 19.362500000000001p 2.7867339999999999e-05 19.375p 2.9614209999999999e-05 19.387500000000003p 3.1320789999999999e-05 19.399999999999999p 3.2985190000000003e-05 19.412499999999998p 3.4605589999999999e-05 19.425000000000001p 3.6180229999999998e-05 19.4375p 3.7707399999999997e-05 19.450000000000003p 3.9185459999999997e-05 19.462499999999999p 4.0612799999999998e-05 19.474999999999998p 4.1987909999999999e-05 19.487500000000001p 4.3309329999999998e-05 19.5p 4.4575679999999999e-05 19.512500000000003p 4.5785609999999998e-05 19.524999999999999p 4.6937880000000002e-05 19.537499999999998p 4.8031310000000003e-05 19.550000000000001p 4.9064789999999998e-05 19.5625p 5.0037280000000001e-05 19.574999999999999p 5.0947810000000001e-05
+ 19.587500000000002p 5.1795510000000003e-05 19.599999999999998p 5.2579549999999997e-05 19.612500000000001p 5.329921e-05 19.625p 5.3953840000000001e-05 19.637499999999999p 5.4542839999999998e-05 19.650000000000002p 5.5065729999999999e-05 19.662499999999998p 5.552208e-05 19.675000000000001p 5.5911559999999999e-05 19.6875p 5.6233890000000003e-05 19.699999999999999p 5.6488900000000001e-05 19.712500000000002p 5.6676479999999997e-05 19.724999999999998p 5.6796609999999998e-05 19.737500000000001p 5.6849340000000001e-05 19.75p 5.68348e-05 19.762499999999999p 5.6753190000000003e-05 19.775000000000002p 5.6604799999999997e-05 19.787500000000001p 5.6389979999999999e-05 19.799999999999997p 5.610918e-05
+ 19.8125p 5.5762900000000001e-05 19.824999999999999p 5.5351720000000002e-05 19.837500000000002p 5.4876300000000002e-05 19.850000000000001p 5.4337350000000002e-05 19.862499999999997p 5.3735669999999999e-05 19.875p 5.3072119999999998e-05 19.887499999999999p 5.2347630000000002e-05 19.900000000000002p 5.156318e-05 19.912500000000001p 5.0719839999999998e-05 19.924999999999997p 4.9818719999999999e-05 19.9375p 4.8860999999999999e-05 19.949999999999999p 4.784791e-05 19.962499999999999p 4.678074e-05 19.975000000000001p 4.5660849999999998e-05 19.987500000000001p 4.4489620000000003e-05 20p 4.3268520000000002e-05 20.012499999999999p 1.500055e-05 20.024999999999999p 2.3702799999999999e-05
+ 20.037500000000001p 2.2818209999999998e-05 20.050000000000001p 2.1664009999999999e-05 20.0625p 2.025216e-05 20.074999999999999p 1.859615e-05 20.087499999999999p 1.6709950000000001e-05 20.100000000000001p 1.460757e-05 20.112500000000001p 1.230287e-05 20.125p 9.8095070000000007e-06 20.137499999999999p 7.1408829999999998e-06 20.149999999999999p 4.3100850000000003e-06 20.162500000000001p 1.329863e-06 20.175000000000001p -1.787398e-06 20.1875p -5.0297070000000003e-06 20.199999999999999p -8.3854799999999999e-06 20.212499999999999p -1.1843569999999999e-05 20.225000000000001p -1.539325e-05 20.237500000000001p -1.9024279999999999e-05 20.25p -2.2726850000000001e-05
+ 20.262499999999999p -2.6491630000000001e-05 20.274999999999999p -3.0309730000000001e-05 20.287500000000001p -3.4172750000000002e-05 20.300000000000001p -3.807272e-05 20.3125p -4.200216e-05 20.325000000000003p -4.5953969999999999e-05 20.337499999999999p -4.9921530000000002e-05 20.349999999999998p -5.3898620000000001e-05 20.362500000000001p -5.7879420000000002e-05 20.375p -6.1858479999999996e-05 20.387500000000003p -6.5830749999999996e-05 20.399999999999999p -6.9791490000000004e-05 20.412499999999998p -7.3736319999999995e-05 20.425000000000001p -7.7661159999999998e-05 20.4375p -8.1562200000000003e-05 20.450000000000003p -8.5435919999999994e-05 20.462499999999999p -8.927904e-05 20.474999999999998p -9.3088499999999995e-05
+ 20.487500000000001p -9.6861429999999996e-05 20.5p -0.0001005952 20.512499999999999p -0.0001042872 20.525000000000002p -0.0001079351 20.537499999999998p -0.00011153670000000001 20.550000000000001p -0.0001150898 20.5625p -0.0001185923 20.574999999999999p -0.0001220423 20.587500000000002p -0.00012543769999999999 20.599999999999998p -0.00012877670000000001 20.612500000000001p -0.00013205739999999999 20.625p -0.00013527790000000001 20.637499999999999p -0.00013843629999999999 20.650000000000002p -0.00014153080000000001 20.662499999999998p -0.00014455929999999999 20.675000000000001p -0.00014752 20.6875p -0.0001504109 20.699999999999999p -0.00015322999999999999
+ 20.712500000000002p -0.00015597509999999999 20.725000000000001p -0.00015864420000000001 20.737499999999997p -0.0001612351 20.75p -0.00016374569999999999 20.762499999999999p -0.00016617349999999999 20.775000000000002p -0.00016851649999999999 20.787500000000001p -0.0001707721 20.799999999999997p -0.000172938 20.8125p -0.00017501180000000001 20.824999999999999p -0.00017699090000000001 20.837500000000002p -0.0001788731 20.850000000000001p -0.00018065569999999999 20.862499999999997p -0.0001823362 20.875p -0.0001839121 20.887499999999999p -0.00018538110000000001 20.899999999999999p -0.00018674039999999999 20.912500000000001p -0.00018798790000000001 20.925000000000001p -0.00018912089999999999
+ 20.9375p -0.00019013720000000001 20.949999999999999p -0.00019103450000000001 20.962499999999999p -0.0001918105 20.975000000000001p -0.00019246310000000001 20.987500000000001p -0.0001929903 21p -0.0001933901 21.012499999999999p -0.00016666209999999999 21.024999999999999p -0.00017682019999999999 21.037500000000001p -0.0001773043 21.050000000000001p -0.00017742840000000001 21.0625p -0.00017720149999999999 21.074999999999999p -0.00017663450000000001 21.087499999999999p -0.0001757385 21.100000000000001p -0.00017452519999999999 21.112500000000001p -0.00017300590000000001 21.125p -0.00017119220000000001 21.137499999999999p -0.00016909539999999999 21.149999999999999p -0.0001667269
+ 21.162500000000001p -0.00016409770000000001 21.175000000000001p -0.00016121890000000001 21.1875p -0.00015810100000000001 21.199999999999999p -0.0001547548 21.212499999999999p -0.0001511905 21.225000000000001p -0.00014741830000000001 21.237500000000001p -0.00014344790000000001 21.25p -0.00013928909999999999 21.262500000000003p -0.0001349512 21.274999999999999p -0.00013044329999999999 21.287499999999998p -0.00012577439999999999 21.300000000000001p -0.0001209531 21.3125p -0.00011598769999999999 21.325000000000003p -0.0001108866 21.337499999999999p -0.0001056576 21.349999999999998p -0.0001003085 21.362500000000001p -9.4846910000000002e-05 21.375p -8.9280139999999995e-05
+ 21.387500000000003p -8.3615390000000005e-05 21.399999999999999p -7.7859709999999997e-05 21.412499999999998p -7.2019980000000004e-05 21.425000000000001p -6.6102929999999996e-05 21.4375p -6.0115199999999997e-05 21.449999999999999p -5.4063300000000001e-05 21.462500000000002p -4.7953639999999997e-05 21.474999999999998p -4.1792580000000002e-05 21.487500000000001p -3.5586380000000001e-05 21.5p -2.934126e-05 21.512499999999999p -2.3063379999999999e-05 21.525000000000002p -1.67589e-05 21.537499999999998p -1.0433909999999999e-05 21.550000000000001p -4.0945259999999998e-06 21.5625p 2.253158e-06 21.574999999999999p 8.6030420000000004e-06 21.587500000000002p 1.494902e-05 21.599999999999998p 2.1284960000000001e-05
+ 21.612500000000001p 2.760474e-05 21.625p 3.390217e-05 21.637499999999999p 4.0171079999999998e-05 21.650000000000002p 4.6405249999999998e-05 21.662500000000001p 5.2598439999999997e-05 21.674999999999997p 5.8744389999999999e-05 21.6875p 6.4836810000000003e-05 21.699999999999999p 7.0869400000000003e-05 21.712500000000002p 7.6835829999999996e-05 21.725000000000001p 8.2729790000000001e-05 21.737499999999997p 8.8544939999999996e-05 21.75p 9.4274959999999998e-05 21.762499999999999p 9.9913519999999999e-05 21.775000000000002p 0.0001054543 21.787500000000001p 0.00011089120000000001 21.799999999999997p 0.0001162177 21.8125p 0.0001214279 21.824999999999999p 0.00012651559999999999
+ 21.837499999999999p 0.00013147469999999999 21.850000000000001p 0.00013629930000000001 21.862500000000001p 0.0001409835 21.875p 0.00014552160000000001 21.887499999999999p 0.000149908 21.899999999999999p 0.0001541371 21.912500000000001p 0.00015820370000000001 21.925000000000001p 0.0001621025 21.9375p 0.00016582850000000001 21.949999999999999p 0.00016937690000000001 21.962499999999999p 0.0001727431 21.975000000000001p 0.0001759226 21.987500000000001p 0.00017891120000000001 22p 0.0001817051 22.012499999999999p 0.0001843003 22.024999999999999p 0.00018669349999999999 22.037500000000001p 0.00018888149999999999 22.050000000000001p 0.0001908612
+ 22.0625p 0.00019263010000000001 22.074999999999999p 0.00019418570000000001 22.087499999999999p 0.00019552600000000001 22.100000000000001p 0.0001966491 22.112500000000001p 0.00019755369999999999 22.125p 0.0001982384 22.137499999999999p 0.00019870249999999999 22.149999999999999p 0.00019894539999999999 22.162500000000001p 0.00019896700000000001 22.175000000000001p 0.00019876719999999999 22.1875p 0.00019834670000000001 22.200000000000003p 0.00019770599999999999 22.212499999999999p 0.0001968463 22.224999999999998p 0.00019576899999999999 22.237500000000001p 0.0001944758 22.25p 0.00019296879999999999 22.262500000000003p 0.00019125030000000001 22.274999999999999p 0.0001893229
+ 22.287499999999998p 0.00018718979999999999 22.300000000000001p 0.00018485410000000001 22.3125p 0.00018231949999999999 22.325000000000003p 0.00017958970000000001 22.337499999999999p 0.00017666890000000001 22.349999999999998p 0.00017356159999999999 22.362500000000001p 0.00017027240000000001 22.375p 0.0001668063 22.387499999999999p 0.00016316839999999999 22.400000000000002p 0.00015936410000000001 22.412499999999998p 0.00015539920000000001 22.425000000000001p 0.00015127939999999999 22.4375p 0.0001470109 22.449999999999999p 0.00014259980000000001 22.462500000000002p 0.00013805269999999999 22.474999999999998p 0.0001333761 22.487500000000001p 0.00012857680000000001 22.5p 0.00012366180000000001
+ 22.512499999999999p 0.000118638 22.525000000000002p 0.00011351259999999999 22.537499999999998p 0.000108293 22.550000000000001p 0.0001029865 22.5625p 9.7600489999999994e-05 22.574999999999999p 9.214259e-05 22.587500000000002p 8.6620370000000006e-05 22.600000000000001p 8.1041460000000004e-05 22.612499999999997p 7.5413530000000001e-05 22.625p 6.9744279999999994e-05 22.637499999999999p 6.4041409999999994e-05 22.650000000000002p 5.8312629999999997e-05 22.662500000000001p 5.2565629999999999e-05 22.674999999999997p 4.6808060000000001e-05 22.6875p 4.1047580000000002e-05 22.699999999999999p 3.5291750000000003e-05 22.712500000000002p 2.954811e-05 22.725000000000001p 2.3824119999999999e-05
+ 22.737500000000001p 1.8127159999999999e-05 22.75p 1.246454e-05 22.762499999999999p 6.843455e-06 22.774999999999999p 1.271001e-06 22.787500000000001p -4.2458390000000001e-06 22.800000000000001p -9.7002030000000006e-06 22.8125p -1.508536e-05 22.824999999999999p -2.0394720000000001e-05 22.837499999999999p -2.5621839999999999e-05 22.850000000000001p -3.0760419999999999e-05 22.862500000000001p -3.580432e-05 22.875p -4.0747590000000002e-05 22.887499999999999p -4.5584429999999999e-05 22.899999999999999p -5.0309209999999997e-05 22.912500000000001p -5.4916500000000002e-05 22.925000000000001p -5.940106e-05 22.9375p -6.3757839999999997e-05 22.949999999999999p -6.7981969999999999e-05
+ 22.962499999999999p -7.2068810000000004e-05 22.975000000000001p -7.6013920000000002e-05 22.987500000000001p -7.9813040000000006e-05 23p -8.3462170000000007e-05 23.012499999999999p -8.6957499999999995e-05 23.024999999999999p -9.0295430000000005e-05 23.037500000000001p -9.3472600000000004e-05 23.050000000000001p -9.6485870000000002e-05 23.0625p -9.9332319999999999e-05 23.074999999999999p -0.0001020093 23.087499999999999p -0.0001045143 23.100000000000001p -0.0001068451 23.112500000000001p -0.0001089997 23.125p -0.0001109764 23.137500000000003p -0.0001127736 23.149999999999999p -0.00011438999999999999 23.162499999999998p -0.0001158246 23.175000000000001p -0.0001170766
+ 23.1875p -0.0001181454 23.200000000000003p -0.0001190305 23.212499999999999p -0.000119732 23.224999999999998p -0.0001202499 23.237500000000001p -0.0001205845 23.25p -0.00012073640000000001 23.262500000000003p -0.0001207065 23.274999999999999p -0.00012049580000000001 23.287499999999998p -0.0001201054 23.300000000000001p -0.000119537 23.3125p -0.0001187921 23.324999999999999p -0.0001178728 23.337500000000002p -0.00011678120000000001 23.349999999999998p -0.0001155195 23.362500000000001p -0.00011409049999999999 23.375p -0.0001124967 23.387499999999999p -0.0001107413 23.400000000000002p -0.0001088273
+ 23.412499999999998p -0.0001067582 23.425000000000001p -0.00010453740000000001 23.4375p -0.0001021687 23.449999999999999p -9.9656090000000002e-05 23.462500000000002p -9.7003570000000005e-05 23.474999999999998p -9.4215419999999994e-05 23.487500000000001p -9.1296050000000005e-05 23.5p -8.8250059999999994e-05 23.512499999999999p -8.5082169999999995e-05 23.525000000000002p -8.1797259999999994e-05 23.537500000000001p -7.8400330000000004e-05 23.549999999999997p -7.4896540000000006e-05 23.5625p -7.1291160000000003e-05 23.574999999999999p -6.7589570000000005e-05 23.587500000000002p -6.3797270000000005e-05 23.600000000000001p -5.991987e-05 23.612499999999997p -5.5963050000000003e-05 23.625p -5.1932599999999998e-05
+ 23.637499999999999p -4.7834380000000003e-05 23.650000000000002p -4.3674329999999998e-05 23.662500000000001p -3.9458429999999997e-05 23.675000000000001p -3.5192740000000002e-05 23.6875p -3.0883339999999999e-05 23.699999999999999p -2.653637e-05 23.712499999999999p -2.2157979999999999e-05 23.725000000000001p -1.7754360000000001e-05 23.737500000000001p -1.3331690000000001e-05 23.75p -8.8961689999999998e-06 23.762499999999999p -4.4539730000000004e-06 23.774999999999999p -1.127421e-08 23.787500000000001p 4.4257809999999997e-06 23.800000000000001p 8.8510789999999999e-06 23.8125p 1.325855e-05 23.824999999999999p 1.7642159999999999e-05 23.837499999999999p 2.1995960000000001e-05 23.850000000000001p 2.6314049999999999e-05
+ 23.862500000000001p 3.0590589999999997e-05 23.875p 3.4819839999999998e-05 23.887499999999999p 3.8996160000000002e-05 23.899999999999999p 4.311398e-05 23.912500000000001p 4.7167850000000003e-05 23.925000000000001p 5.1152439999999998e-05 23.9375p 5.5062519999999998e-05 23.949999999999999p 5.8892989999999999e-05 23.962499999999999p 6.2638910000000002e-05 23.975000000000001p 6.6295430000000004e-05 23.987500000000001p 6.985789e-05 24p 7.3321749999999996e-05 24.012499999999999p 7.6682639999999999e-05 24.024999999999999p 7.993636e-05 24.037500000000001p 8.3078849999999998e-05 24.050000000000001p 8.6106249999999996e-05 24.0625p 8.9014860000000004e-05 24.075000000000003p 9.1801159999999995e-05
+ 24.087499999999999p 9.4461830000000006e-05 24.099999999999998p 9.6993709999999993e-05 24.112500000000001p 9.9393849999999994e-05 24.125p 0.0001016595 24.137500000000003p 0.0001037881 24.149999999999999p 0.0001057772 24.162499999999998p 0.0001076248 24.175000000000001p 0.0001093289 24.1875p 0.0001108876 24.200000000000003p 0.0001122995 24.212499999999999p 0.0001135632 24.224999999999998p 0.0001146776 24.237500000000001p 0.0001156418 24.25p 0.000116455 24.262499999999999p 0.0001171168 24.275000000000002p 0.0001176268 24.287499999999998p 0.000117985 24.300000000000001p 0.0001181915
+ 24.3125p 0.00011824659999999999 24.324999999999999p 0.0001181508 24.337500000000002p 0.0001179049 24.349999999999998p 0.0001175098 24.362500000000001p 0.0001169667 24.375p 0.0001162768 24.387499999999999p 0.0001154417 24.400000000000002p 0.00011446320000000001 24.412499999999998p 0.000113343 24.425000000000001p 0.00011208340000000001 24.4375p 0.0001106865 24.449999999999999p 0.0001091549 24.462500000000002p 0.0001074911 24.475000000000001p 0.0001056979 24.487499999999997p 0.0001037783 24.5p 0.0001017355 24.512499999999999p 9.9572570000000001e-05 24.525000000000002p 9.7293069999999996e-05
+ 24.537500000000001p 9.4900529999999999e-05 24.549999999999997p 9.2398659999999997e-05 24.5625p 8.9791300000000002e-05 24.574999999999999p 8.7082420000000006e-05 24.587500000000002p 8.4276119999999999e-05 24.600000000000001p 8.1376590000000002e-05 24.612500000000001p 7.8388169999999994e-05 24.625p 7.5315269999999998e-05 24.637499999999999p 7.2162419999999993e-05 24.649999999999999p 6.8934240000000004e-05 24.662500000000001p 6.5635410000000006e-05 24.675000000000001p 6.2270709999999994e-05 24.6875p 5.8845000000000003e-05 24.699999999999999p 5.5363179999999997e-05 24.712499999999999p 5.1830219999999999e-05 24.725000000000001p 4.8251139999999999e-05 24.737500000000001p 4.4630989999999999e-05 24.75p 4.0974869999999998e-05
+ 24.762499999999999p 3.728791e-05 24.774999999999999p 3.357525e-05 24.787500000000001p 2.9842039999999999e-05 24.800000000000001p 2.6093460000000001e-05 24.8125p 2.2334669999999999e-05 24.824999999999999p 1.857082e-05 24.837499999999999p 1.4807050000000001e-05 24.850000000000001p 1.104848e-05 24.862500000000001p 7.3002080000000002e-06 24.875p 3.5672779999999999e-06 24.887499999999999p -1.4529959999999999e-07 24.899999999999999p -3.832563e-06 24.912500000000001p -7.4896110000000003e-06 24.925000000000001p -1.11116e-05 24.9375p -1.4693769999999999e-05 24.949999999999999p -1.8231420000000001e-05 24.962499999999999p -2.1719930000000001e-05 24.975000000000001p -2.5154799999999998e-05
+ 24.987500000000001p -2.8531579999999998e-05 25p -3.1845940000000002e-05 25.012500000000003p -3.5093679999999998e-05 25.024999999999999p -3.8270660000000003e-05 25.037499999999998p -4.1372899999999998e-05 25.050000000000001p -4.4396520000000002e-05 25.0625p -4.7337760000000003e-05 25.075000000000003p -5.0193009999999999e-05 25.087499999999999p -5.2958779999999997e-05 25.099999999999998p -5.5631719999999999e-05 25.112500000000001p -5.8208629999999999e-05 25.125p -6.0686439999999998e-05 25.137500000000003p -6.3062250000000004e-05 25.149999999999999p -6.5333289999999999e-05 25.162499999999998p -6.7496970000000006e-05 25.175000000000001p -6.9550840000000001e-05 25.1875p -7.1492610000000001e-05 25.199999999999999p -7.3320169999999994e-05
+ 25.212500000000002p -7.5031560000000006e-05 25.224999999999998p -7.6624990000000005e-05 25.237500000000001p -7.8098840000000001e-05 25.25p -7.9451660000000001e-05 25.262499999999999p -8.0682159999999995e-05 25.275000000000002p -8.1789240000000002e-05 25.287499999999998p -8.2771959999999997e-05 25.300000000000001p -8.3629559999999994e-05 25.3125p -8.4361440000000005e-05 25.324999999999999p -8.4967190000000001e-05 25.337500000000002p -8.5446559999999993e-05 25.349999999999998p -8.5799470000000002e-05 25.362500000000001p -8.6026019999999994e-05 25.375p -8.6126470000000001e-05 25.387499999999999p -8.610127e-05 25.400000000000002p -8.5951020000000006e-05 25.412500000000001p -8.5676480000000004e-05 25.424999999999997p -8.5278599999999994e-05
+ 25.4375p -8.4758459999999996e-05 25.449999999999999p -8.4117330000000004e-05 25.462500000000002p -8.3356609999999995e-05 25.475000000000001p -8.2477899999999999e-05 25.487499999999997p -8.1482899999999999e-05 25.5p -8.0373490000000005e-05 25.512499999999999p -7.9151699999999996e-05 25.525000000000002p -7.7819690000000002e-05 25.537500000000001p -7.6379769999999995e-05 25.550000000000001p -7.4834389999999996e-05 25.5625p -7.3186109999999994e-05 25.574999999999999p -7.1437650000000005e-05 25.587499999999999p -6.9591829999999995e-05 25.600000000000001p -6.7651619999999996e-05 25.612500000000001p -6.5620080000000004e-05 25.625p -6.3500399999999999e-05 25.637499999999999p -6.1295859999999994e-05 25.649999999999999p -5.9009860000000003e-05
+ 25.662500000000001p -5.6645899999999999e-05 25.675000000000001p -5.4207550000000002e-05 25.6875p -5.1698489999999999e-05 25.699999999999999p -4.9122490000000002e-05 25.712499999999999p -4.6483370000000001e-05 25.725000000000001p -4.3785049999999998e-05 25.737500000000001p -4.1031490000000001e-05 25.75p -3.8226740000000001e-05 25.762499999999999p -3.5374889999999998e-05 25.774999999999999p -3.2480069999999999e-05 25.787500000000001p -2.9546489999999998e-05 25.800000000000001p -2.6578349999999999e-05 25.8125p -2.3579919999999999e-05 25.824999999999999p -2.0555489999999999e-05 25.837499999999999p -1.7509349999999999e-05 25.850000000000001p -1.444583e-05 25.862500000000001p -1.136926e-05 25.875p -8.2839709999999996e-06
+ 25.887499999999999p -5.1942880000000001e-06 25.899999999999999p -2.1045310000000001e-06 25.912500000000001p 9.8099300000000003e-07 25.925000000000001p 4.0580020000000004e-06 25.9375p 7.122238e-06 25.950000000000003p 1.016948e-05 25.962499999999999p 1.319553e-05 25.974999999999998p 1.619626e-05 25.987500000000001p 1.9167580000000001e-05 26p 2.210544e-05 26.012500000000003p 2.5005869999999998e-05 26.024999999999999p 2.7864950000000002e-05 26.037499999999998p 3.0678849999999999e-05 26.050000000000001p 3.3443810000000001e-05 26.0625p 3.615614e-05 26.075000000000003p 3.8812239999999997e-05 26.087499999999999p 4.1408610000000003e-05 26.099999999999998p 4.3941840000000003e-05
+ 26.112500000000001p 4.6408610000000002e-05 26.125p 4.8805730000000001e-05 26.137499999999999p 5.1130079999999999e-05 26.150000000000002p 5.3378680000000003e-05 26.162499999999998p 5.5548660000000003e-05 26.175000000000001p 5.7637270000000003e-05 26.1875p 5.964186e-05 26.199999999999999p 6.1559949999999997e-05 26.212500000000002p 6.3389139999999995e-05 26.224999999999998p 6.5127190000000001e-05 26.237500000000001p 6.6771990000000003e-05 26.25p 6.8321559999999997e-05 26.262499999999999p 6.9774060000000004e-05 26.275000000000002p 7.11278e-05 26.287499999999998p 7.2381209999999998e-05 26.300000000000001p 7.3532879999999994e-05 26.3125p 7.4581549999999994e-05 26.324999999999999p 7.5526090000000001e-05
+ 26.337500000000002p 7.6365520000000001e-05 26.350000000000001p 7.7099020000000003e-05 26.362499999999997p 7.7725900000000001e-05 26.375p 7.8245629999999997e-05 26.387499999999999p 7.8657839999999994e-05 26.400000000000002p 7.8962269999999999e-05 26.412500000000001p 7.9158859999999996e-05 26.424999999999997p 7.9247639999999999e-05 26.4375p 7.9228839999999999e-05 26.449999999999999p 7.9102810000000005e-05 26.462500000000002p 7.8870049999999999e-05 26.475000000000001p 7.8531189999999997e-05 26.487500000000001p 7.8087020000000001e-05 26.5p 7.7538469999999994e-05 26.512499999999999p 7.6886599999999997e-05 26.524999999999999p 7.6132609999999997e-05 26.537500000000001p 7.5277839999999995e-05 26.550000000000001p 7.4323769999999999e-05
+ 26.5625p 7.3271969999999997e-05 26.574999999999999p 7.2124200000000003e-05 26.587499999999999p 7.0882279999999996e-05 26.600000000000001p 6.9548209999999993e-05 26.612500000000001p 6.8124070000000005e-05 26.625p 6.6612069999999997e-05 26.637499999999999p 6.5014529999999994e-05 26.649999999999999p 6.3333880000000006e-05 26.662500000000001p 6.1572650000000004e-05 26.675000000000001p 5.9733479999999999e-05 26.6875p 5.7819099999999997e-05 26.699999999999999p 5.5832350000000001e-05 26.712499999999999p 5.3776129999999997e-05 26.725000000000001p 5.1653449999999999e-05 26.737500000000001p 4.9467389999999999e-05 26.75p 4.7221110000000002e-05 26.762499999999999p 4.4917850000000002e-05 26.774999999999999p 4.2560900000000001e-05
+ 26.787500000000001p 4.0153639999999997e-05 26.800000000000001p 3.7699459999999998e-05 26.8125p 3.5201869999999997e-05 26.824999999999999p 3.2664370000000003e-05 26.837499999999999p 3.0090530000000001e-05 26.850000000000001p 2.748396e-05 26.862500000000001p 2.4848310000000001e-05 26.875p 2.2187229999999999e-05 26.887500000000003p 1.9504430000000001e-05 26.899999999999999p 1.6803620000000001e-05 26.912499999999998p 1.408851e-05 26.925000000000001p 1.1362850000000001e-05 26.9375p 8.6303699999999992e-06 26.950000000000003p 5.8948099999999997e-06 26.962499999999999p 3.159898e-06 26.974999999999998p 4.2935249999999998e-07 26.987500000000001p -2.293126e-06 27p -5.0038579999999998e-06
+ 27.012500000000003p -7.6991890000000007e-06 27.024999999999999p -1.0375499999999999e-05 27.037499999999998p -1.3029200000000001e-05 27.050000000000001p -1.5656759999999999e-05 27.0625p -1.825466e-05 27.074999999999999p -2.0819480000000001e-05 27.087500000000002p -2.33478e-05 27.099999999999998p -2.5836299999999999e-05 27.112500000000001p -2.8281710000000001e-05 27.125p -3.0680830000000001e-05 27.137499999999999p -3.3030529999999997e-05 27.150000000000002p -3.5327760000000001e-05 27.162499999999998p -3.7569540000000003e-05 27.175000000000001p -3.9752990000000003e-05 27.1875p -4.1875310000000003e-05 27.199999999999999p -4.3933800000000003e-05 27.212500000000002p -4.5925820000000001e-05 27.224999999999998p -4.7848880000000001e-05
+ 27.237500000000001p -4.970056e-05 27.25p -5.1478540000000001e-05 27.262499999999999p -5.3180619999999998e-05 27.275000000000002p -5.4804710000000001e-05 27.287500000000001p -5.634882e-05 27.299999999999997p -5.7811099999999999e-05 27.3125p -5.918979e-05 27.324999999999999p -6.0483250000000001e-05 27.337500000000002p -6.1689979999999999e-05 27.350000000000001p -6.2808579999999999e-05 27.362499999999997p -6.3837790000000007e-05 27.375p -6.4776479999999998e-05 27.387499999999999p -6.5623619999999994e-05 27.400000000000002p -6.6378320000000002e-05 27.412500000000001p -6.7039829999999997e-05 27.425000000000001p -6.7607520000000001e-05 27.4375p -6.8080880000000006e-05 27.449999999999999p -6.845954e-05
+ 27.462499999999999p -6.8743259999999993e-05 27.475000000000001p -6.8931910000000004e-05 27.487500000000001p -6.9025520000000007e-05 27.5p -6.9024219999999997e-05 27.512499999999999p -6.8928289999999995e-05 27.524999999999999p -6.8738109999999999e-05 27.537500000000001p -6.8454219999999994e-05 27.550000000000001p -6.8077269999999997e-05 27.5625p -6.7608009999999994e-05 27.574999999999999p -6.7047349999999994e-05 27.587499999999999p -6.63963e-05 27.600000000000001p -6.5655989999999995e-05 27.612500000000001p -6.4827670000000001e-05 27.625p -6.3912700000000002e-05 27.637499999999999p -6.2912569999999996e-05 27.649999999999999p -6.1828859999999997e-05 27.662500000000001p -6.0663269999999997e-05 27.675000000000001p -5.9417589999999998e-05
+ 27.6875p -5.8093729999999998e-05 27.699999999999999p -5.6693690000000002e-05 27.712499999999999p -5.5219580000000001e-05 27.725000000000001p -5.3673569999999998e-05 27.737500000000001p -5.2057959999999999e-05 27.75p -5.037512e-05 27.762499999999999p -4.8627500000000002e-05 27.774999999999999p -4.6817619999999998e-05 27.787500000000001p -4.4948109999999998e-05 27.800000000000001p -4.3021639999999998e-05 27.8125p -4.1040949999999999e-05 27.825000000000003p -3.9008879999999997e-05 27.837499999999999p -3.6928290000000003e-05 27.849999999999998p -3.4802109999999997e-05 27.862500000000001p -3.263333e-05 27.875p -3.0424969999999999e-05 27.887500000000003p -2.818013e-05 27.899999999999999p -2.5901910000000001e-05
+ 27.912499999999998p -2.3593470000000002e-05 27.925000000000001p -2.1257980000000001e-05 27.9375p -1.889867e-05 27.949999999999999p -1.6518759999999999e-05 27.962499999999999p -1.41215e-05 27.974999999999998p -1.171015e-05 27.987500000000001p -9.2879880000000004e-06 28p -6.8582900000000002e-06 28.012499999999999p -4.4243309999999999e-06 28.025000000000002p -1.9893850000000002e-06 28.037499999999998p 4.4328749999999998e-07 28.050000000000001p 2.870435e-06 28.0625p 5.2888260000000004e-06 28.074999999999999p 7.6952489999999995e-06 28.087500000000002p 1.008652e-05 28.099999999999998p 1.2459489999999999e-05 28.112500000000001p 1.481103e-05 28.125p 1.7138069999999999e-05
+ 28.137499999999999p 1.943757e-05 28.150000000000002p 2.1706539999999999e-05 28.162499999999998p 2.3942040000000002e-05 28.175000000000001p 2.6141180000000002e-05 28.1875p 2.8301130000000001e-05 28.199999999999999p 3.0419140000000001e-05 28.212500000000002p 3.2492500000000001e-05 28.225000000000001p 3.4518570000000003e-05 28.237499999999997p 3.6494810000000002e-05 28.25p 3.841872e-05 28.262499999999999p 4.0287899999999998e-05 28.275000000000002p 4.2100030000000002e-05 28.287500000000001p 4.3852869999999999e-05 28.299999999999997p 4.5544260000000001e-05 28.3125p 4.7172139999999998e-05 28.324999999999999p 4.8734540000000002e-05 28.337500000000002p 5.0229580000000003e-05 28.350000000000001p 5.1655469999999998e-05
+ 28.362500000000001p 5.301055e-05 28.375p 5.4293209999999998e-05 28.387499999999999p 5.5501999999999998e-05 28.399999999999999p 5.6635509999999997e-05 28.412500000000001p 5.7692499999999997e-05 28.425000000000001p 5.8671780000000002e-05 28.4375p 5.9572299999999999e-05 28.449999999999999p 6.0393119999999998e-05 28.462499999999999p 6.1133389999999999e-05 28.475000000000001p 6.1792379999999993e-05 28.487500000000001p 6.2369470000000004e-05 28.5p 6.2864159999999997e-05 28.512499999999999p 6.3276039999999998e-05 28.524999999999999p 6.3604840000000001e-05 28.537500000000001p 6.3850370000000006e-05 28.550000000000001p 6.4012569999999996e-05 28.5625p 6.4091490000000001e-05 28.574999999999999p 6.4087290000000005e-05
+ 28.587499999999999p 6.400023e-05 28.600000000000001p 6.3830689999999998e-05 28.612500000000001p 6.3579150000000006e-05 28.625p 6.3246199999999998e-05 28.637499999999999p 6.2832539999999995e-05 28.649999999999999p 6.2338969999999999e-05 28.662500000000001p 6.1766390000000005e-05 28.675000000000001p 6.1115800000000002e-05 28.6875p 6.038831e-05 28.699999999999999p 5.9585120000000001e-05 28.712499999999999p 5.8707520000000001e-05 28.725000000000001p 5.7756910000000003e-05 28.737500000000001p 5.6734770000000002e-05 28.75p 5.5642659999999999e-05 28.762500000000003p 5.4482250000000002e-05 28.774999999999999p 5.3255279999999997e-05 28.787499999999998p 5.1963570000000003e-05 28.800000000000001p 5.0609019999999997e-05
+ 28.8125p 4.9193609999999997e-05 28.825000000000003p 4.7719400000000003e-05 28.837499999999999p 4.61885e-05 28.849999999999998p 4.4603110000000001e-05 28.862500000000001p 4.2965479999999999e-05 28.875p 4.1277920000000001e-05 28.887499999999999p 3.9542799999999997e-05 28.899999999999999p 3.776255e-05 28.912499999999998p 3.5939650000000001e-05 28.925000000000001p 3.407663e-05 28.9375p 3.2176040000000001e-05 28.949999999999999p 3.02405e-05 28.962500000000002p 2.8272650000000001e-05 28.974999999999998p 2.6275180000000001e-05 28.987500000000001p 2.425078e-05 29p 2.2202199999999999e-05 29.012499999999999p 2.0132189999999999e-05 29.025000000000002p 1.804353e-05
+ 29.037499999999998p 1.5939009999999998e-05 29.050000000000001p 1.3821419999999999e-05 29.0625p 1.1693570000000001e-05 29.074999999999999p 9.5582779999999994e-06 29.087500000000002p 7.4183520000000004e-06 29.099999999999998p 5.2766009999999998e-06 29.112500000000001p 3.1358219999999999e-06 29.125000000000004p 9.9880469999999997e-07 29.137499999999999p -1.1316769999999999e-06 29.149999999999999p -3.2528699999999998e-06 29.162500000000001p -5.3620389999999997e-06 29.174999999999997p -7.4564780000000003e-06 29.187500000000004p -9.5335090000000007e-06 29.199999999999999p -1.159049e-05 29.212499999999999p -1.36248e-05 29.225000000000001p -1.5633880000000002e-05 29.237499999999997p -1.76152e-05 29.250000000000004p -1.9566270000000001e-05
+ 29.262499999999999p -2.1484669999999999e-05 29.274999999999999p -2.3368010000000001e-05 29.287500000000001p -2.521396e-05 29.299999999999997p -2.7020270000000001e-05 29.312500000000004p -2.8784699999999999e-05 29.324999999999999p -3.0505129999999999e-05 29.337499999999999p -3.2179479999999998e-05 29.350000000000001p -3.3805730000000003e-05 29.362499999999997p -3.5381939999999997e-05 29.375000000000004p -3.6906239999999999e-05 29.387499999999999p -3.8376849999999998e-05 29.400000000000002p -3.9792039999999997e-05 29.412500000000001p -4.1150189999999997e-05 29.424999999999997p -4.2449739999999997e-05 29.4375p -4.3689210000000002e-05 29.449999999999999p -4.4867229999999998e-05 29.462500000000002p -4.5982490000000002e-05 29.475000000000001p -4.7033780000000002e-05
+ 29.487499999999997p -4.8019970000000002e-05 29.5p -4.8940029999999998e-05 29.512499999999999p -4.9793019999999997e-05 29.525000000000002p -5.0578080000000001e-05 29.537500000000001p -5.1294459999999999e-05 29.549999999999997p -5.1941490000000003e-05 29.5625p -5.2518610000000003e-05 29.574999999999999p -5.3025319999999997e-05 29.587500000000002p -5.346126e-05 29.600000000000001p -5.3826129999999998e-05 29.612499999999997p -5.4119739999999999e-05 29.625p -5.4341990000000002e-05 29.637499999999999p -5.449288e-05 29.650000000000002p -5.4572489999999999e-05 29.662500000000001p -5.4581019999999999e-05 29.674999999999997p -5.451874e-05 29.6875p -5.4386009999999998e-05 29.699999999999999p -5.4183289999999999e-05
+ 29.712500000000002p -5.3911150000000003e-05 29.724999999999998p -5.3570209999999998e-05 29.737499999999997p -5.3161220000000003e-05 29.75p -5.2684969999999999e-05 29.762499999999999p -5.2142380000000003e-05 29.775000000000002p -5.153442e-05 29.787499999999998p -5.086217e-05 29.800000000000004p -5.0126780000000001e-05 29.8125p -4.9329470000000001e-05 29.824999999999999p -4.8471550000000002e-05 29.837500000000002p -4.7554389999999999e-05 29.849999999999998p -4.657945e-05 29.862500000000004p -4.5548250000000002e-05 29.875p -4.4462380000000002e-05 29.887499999999999p -4.3323499999999999e-05 29.900000000000002p -4.2133330000000001e-05 29.912499999999998p -4.0893660000000002e-05 29.925000000000004p -3.9606310000000001e-05
+ 29.9375p -3.8273189999999997e-05 29.949999999999996p -3.6896249999999998e-05 29.962500000000002p -3.5477479999999999e-05 29.974999999999998p -3.4018940000000003e-05 29.987500000000001p -3.2522699999999999e-05 30p -3.0990920000000003e-05 30.012499999999996p -2.9425740000000001e-05 30.025000000000002p -2.7829390000000001e-05 30.037499999999998p -2.6204099999999999e-05 30.050000000000001p -2.4552140000000001e-05 30.0625p -2.2875799999999999e-05 30.074999999999996p -2.1177409999999999e-05 30.087500000000002p -1.945928e-05 30.099999999999998p -1.7723790000000001e-05 30.112500000000001p -1.5973290000000001e-05 30.125p -1.4210160000000001e-05 30.137500000000003p -1.243678e-05 30.150000000000002p -1.065555e-05
+ 30.162499999999998p -8.8688459999999997e-06 30.175000000000001p -7.0790530000000003e-06 30.1875p -5.2885500000000004e-06 30.200000000000003p -3.4997059999999999e-06 30.212500000000002p -1.7148770000000001e-06 30.224999999999998p 6.3595050000000004e-08 30.237500000000001p 1.833389e-06 30.25p 3.5922040000000002e-06 30.262500000000003p 5.3377639999999998e-06 30.274999999999999p 7.06782e-06 30.287499999999998p 8.7801549999999996e-06 30.300000000000001p 1.047259e-05 30.3125p 1.2142959999999999e-05 30.325000000000003p 1.378918e-05 30.337499999999999p 1.5409159999999999e-05 30.349999999999998p 1.7000890000000001e-05 30.362500000000001p 1.856239e-05 30.375p 2.0091739999999999e-05
+ 30.387500000000003p 2.1587049999999999e-05 30.399999999999999p 2.3046510000000001e-05 30.412499999999998p 2.4468360000000002e-05 30.425000000000001p 2.5850870000000001e-05 30.4375p 2.7192419999999999e-05 30.450000000000003p 2.849141e-05 30.462499999999999p 2.9746329999999999e-05 30.474999999999998p 3.095571e-05 30.487500000000001p 3.2118179999999999e-05 30.499999999999996p 3.3232419999999999e-05 30.512500000000003p 3.4297179999999999e-05 30.524999999999999p 3.5311290000000001e-05 30.537500000000001p 3.6273640000000001e-05 30.550000000000001p 3.7183210000000001e-05 30.562499999999996p 3.8039040000000002e-05 30.575000000000003p 3.8840269999999999e-05 30.587499999999999p 3.9586099999999997e-05 30.600000000000001p 4.0275799999999998e-05
+ 30.612500000000001p 4.0908729999999999e-05 30.624999999999996p 4.1484340000000001e-05 30.637500000000003p 4.2002129999999998e-05 30.649999999999999p 4.2461720000000002e-05 30.662500000000001p 4.2862769999999997e-05 30.675000000000001p 4.320504e-05 30.687499999999996p 4.348837e-05 30.700000000000003p 4.3712669999999997e-05 30.712499999999999p 4.3877949999999999e-05 30.725000000000001p 4.3984279999999997e-05 30.737500000000001p 4.4031810000000002e-05 30.749999999999996p 4.4020770000000002e-05 30.762499999999999p 4.395148e-05 30.774999999999999p 4.3824330000000002e-05 30.787500000000001p 4.363977e-05 30.800000000000001p 4.3398339999999997e-05 30.812499999999996p 4.3100650000000002e-05 30.824999999999999p 4.2747390000000003e-05
+ 30.837499999999999p 4.2339319999999998e-05 30.850000000000001p 4.1877250000000003e-05 30.862500000000001p 4.1362090000000001e-05 30.874999999999996p 4.0794789999999997e-05 30.887499999999999p 4.0176380000000002e-05 30.899999999999999p 3.9507959999999999e-05 30.912500000000001p 3.8790669999999999e-05 30.925000000000001p 3.8025719999999999e-05 30.937500000000004p 3.721439e-05 30.949999999999999p 3.6358010000000001e-05 30.962499999999999p 3.5457960000000002e-05 30.975000000000001p 3.4515669999999997e-05 30.987500000000001p 3.3532619999999999e-05 31.000000000000004p 3.2510359999999997e-05 31.012499999999999p 3.1450450000000003e-05 31.024999999999999p 3.035452e-05 31.037500000000001p 2.9224229999999999e-05 31.049999999999997p 2.806128e-05
+ 31.062500000000004p 2.686741e-05 31.074999999999999p 2.5644390000000001e-05 31.087499999999999p 2.4394010000000001e-05 31.100000000000001p 2.3118119999999999e-05 31.112499999999997p 2.1818550000000001e-05 31.125000000000004p 2.0497200000000001e-05 31.137499999999999p 1.9155960000000001e-05 31.149999999999999p 1.7796749999999999e-05 31.162500000000001p 1.6421499999999999e-05 31.174999999999997p 1.503216e-05 31.187500000000004p 1.363068e-05 31.199999999999999p 1.221901e-05 31.212499999999999p 1.0799140000000001e-05 31.225000000000001p 9.3730270000000004e-06 31.237499999999997p 7.9426379999999998e-06 31.250000000000004p 6.5099369999999997e-06 31.262499999999999p 5.0768829999999998e-06 31.275000000000002p 3.6454260000000002e-06
+ 31.287500000000001p 2.217502e-06 31.299999999999997p 7.9503660000000001e-07 31.3125p -6.2006359999999999e-07 31.324999999999999p -2.0259099999999998e-06 31.337500000000002p -3.4206360000000001e-06 31.350000000000001p -4.8023980000000003e-06 31.362499999999997p -6.16938e-06 31.375p -7.5197939999999998e-06 31.387499999999999p -8.8518819999999998e-06 31.400000000000002p -1.0163920000000001e-05 31.412500000000001p -1.1454219999999999e-05 31.424999999999997p -1.272114e-05 31.4375p -1.396305e-05 31.449999999999999p -1.51784e-05 31.462500000000002p -1.6365650000000001e-05 31.475000000000001p -1.752332e-05 31.487499999999997p -1.8649989999999999e-05 31.5p -1.9744260000000001e-05
+ 31.512499999999999p -2.0804809999999998e-05 31.525000000000002p -2.183035e-05 31.537500000000001p -2.2819660000000002e-05 31.549999999999997p -2.3771559999999998e-05 31.5625p -2.4684950000000002e-05 31.574999999999999p -2.555875e-05 31.587500000000002p -2.6391979999999999e-05 31.599999999999998p -2.7183690000000001e-05 31.612499999999997p -2.793302e-05 31.625p -2.863913e-05 31.637499999999999p -2.9301289999999999e-05 31.650000000000002p -2.991881e-05 31.662499999999998p -3.049105e-05 31.675000000000004p -3.1017469999999997e-05 31.6875p -3.1497559999999999e-05 31.699999999999999p -3.1930909999999997e-05 31.712500000000002p -3.2317139999999999e-05 31.724999999999998p -3.2655969999999998e-05
+ 31.737500000000004p -3.294717e-05 31.75p -3.3190569999999998e-05 31.762499999999999p -3.3386080000000001e-05 31.775000000000002p -3.3533659999999998e-05 31.787499999999998p -3.3633359999999999e-05 31.800000000000004p -3.3685279999999999e-05 31.8125p -3.3689590000000003e-05 31.824999999999996p -3.3646509999999998e-05 31.837500000000002p -3.3556339999999999e-05 31.849999999999998p -3.3419449999999997e-05 31.862500000000001p -3.3236250000000002e-05 31.875p -3.300723e-05 31.887499999999996p -3.2732930000000002e-05 31.900000000000002p -3.2413960000000002e-05 31.912499999999998p -3.2050990000000001e-05 31.925000000000001p -3.1644730000000001e-05 31.9375p -3.1195960000000001e-05 31.949999999999996p -3.0705520000000001e-05
+ 31.962500000000002p -3.01743e-05 31.974999999999998p -2.9603219999999999e-05 31.987500000000001p -2.8993289999999998e-05 32p -2.8345540000000001e-05 32.012500000000003p -2.7661059999999999e-05 32.024999999999999p -2.694098e-05 32.037500000000001p -2.6186479999999999e-05 32.050000000000004p -2.539878e-05 32.0625p -2.4579129999999999e-05 32.075000000000003p -2.3728849999999999e-05 32.087499999999999p -2.2849259999999999e-05 32.099999999999994p -2.194174e-05 32.112500000000004p -2.1007680000000001e-05 32.125p -2.0048520000000001e-05 32.137500000000003p -1.9065730000000002e-05 32.149999999999999p -1.8060790000000001e-05 32.162499999999994p -1.703521e-05 32.175000000000004p -1.5990540000000002e-05
+ 32.1875p -1.492832e-05 32.200000000000003p -1.385013e-05 32.212499999999999p -1.275756e-05 32.224999999999994p -1.16522e-05 32.237500000000004p -1.053568e-05 32.25p -9.4096039999999998e-06 32.262500000000003p -8.2756099999999999e-06 32.274999999999999p -7.1353269999999998e-06 32.287499999999994p -5.9903879999999999e-06 32.300000000000004p -4.8424270000000001e-06 32.3125p -3.6930719999999999e-06 32.325000000000003p -2.5439509999999998e-06 32.337499999999999p -1.396682e-06 32.349999999999994p -2.5287309999999998e-07 32.362499999999997p 8.8587749999999997e-07 32.375p 2.017986e-06 32.387500000000003p 3.1418839999999999e-06 32.399999999999999p 4.2560219999999998e-06
+ 32.412500000000001p 5.3588689999999998e-06 32.424999999999997p 6.448917e-06 32.4375p 7.5246809999999998e-06 32.450000000000003p 8.5847040000000003e-06 32.462499999999999p 9.6275549999999993e-06 32.475000000000001p 1.0651830000000001e-05 32.487499999999997p 1.165617e-05 32.5p 1.263923e-05 32.512500000000003p 1.359971e-05 32.524999999999999p 1.453635e-05 32.537500000000001p 1.544792e-05 32.549999999999997p 1.633323e-05 32.5625p 1.7191149999999999e-05 32.575000000000003p 1.8020569999999999e-05 32.587499999999999p 1.8820420000000002e-05 32.600000000000001p 1.9589710000000001e-05 32.612499999999997p 2.0327459999999999e-05 32.625p 2.103276e-05
+ 32.637500000000003p 2.1704739999999998e-05 32.649999999999999p 2.234257e-05 32.662500000000001p 2.2945489999999998e-05 32.674999999999997p 2.3512780000000002e-05 32.6875p 2.404378e-05 32.700000000000003p 2.4537869999999999e-05 32.712499999999999p 2.499451e-05 32.725000000000001p 2.5413180000000001e-05 32.737499999999997p 2.5793439999999999e-05 32.75p 2.6134889999999999e-05 32.762500000000003p 2.6437200000000002e-05 32.774999999999999p 2.6700080000000001e-05 32.787500000000001p 2.6923320000000002e-05 32.799999999999997p 2.7106730000000001e-05 32.8125p 2.7250209999999999e-05 32.825000000000003p 2.7353699999999999e-05 32.837499999999999p 2.7417190000000002e-05 32.850000000000001p 2.744075e-05
+ 32.862499999999997p 2.742448e-05 32.875p 2.7368550000000001e-05 32.887500000000003p 2.727317e-05 32.899999999999999p 2.7138619999999999e-05 32.912500000000001p 2.6965229999999999e-05 32.924999999999997p 2.6753370000000002e-05 32.9375p 2.650348e-05 32.950000000000003p 2.621604e-05 32.962499999999999p 2.5891590000000001e-05 32.975000000000001p 2.553071e-05 32.987499999999997p 2.5134020000000002e-05 33p 2.4702230000000001e-05 33.012500000000003p 2.4236029999999998e-05 33.024999999999999p 2.373622e-05 33.037500000000001p 2.320361e-05 33.049999999999997p 2.2639050000000001e-05 33.0625p 2.204345e-05 33.075000000000003p 2.1417739999999999e-05
+ 33.087499999999999p 2.0762910000000001e-05 33.100000000000001p 2.0079969999999999e-05 33.112499999999997p 1.9369980000000001e-05 33.125p 1.8634009999999999e-05 33.137500000000003p 1.787319e-05 33.150000000000006p 1.708868e-05 33.162500000000001p 1.628164e-05 33.174999999999997p 1.5453279999999999e-05 33.1875p 1.4604840000000001e-05 33.199999999999996p 1.3737580000000001e-05 33.212500000000006p 1.2852760000000001e-05 33.225000000000001p 1.1951699999999999e-05 33.237499999999997p 1.10357e-05 33.25p 1.01061e-05 33.262499999999996p 9.164252e-06 33.275000000000006p 8.2115139999999992e-06 33.287500000000001p 7.2492599999999999e-06 33.299999999999997p 6.2788690000000003e-06
+ 33.3125p 5.3017319999999996e-06 33.324999999999996p 4.3192409999999997e-06 33.337500000000006p 3.3327939999999999e-06 33.350000000000001p 2.343788e-06 33.362499999999997p 1.353622e-06 33.375p 3.6368949999999998e-07 33.387499999999996p -6.2461749999999997e-07 33.400000000000006p -1.609915e-06 33.412500000000001p -2.5908269999999999e-06 33.424999999999997p -3.5659870000000001e-06 33.4375p -4.5340409999999998e-06 33.449999999999996p -5.4936490000000001e-06 33.462499999999999p -6.4434860000000003e-06 33.475000000000001p -7.3822430000000004e-06 33.487499999999997p -8.3086330000000007e-06 33.5p -9.2213859999999995e-06 33.512499999999996p -1.011926e-05 33.524999999999999p -1.1001030000000001e-05
+ 33.537500000000001p -1.18655e-05 33.550000000000004p -1.2711509999999999e-05 33.5625p -1.35379e-05 33.574999999999996p -1.434358e-05 33.587499999999999p -1.512747e-05 33.600000000000001p -1.588852e-05 33.612500000000004p -1.662572e-05 33.625p -1.7338089999999999e-05 33.637499999999996p -1.80247e-05 33.649999999999999p -1.8684650000000001e-05 33.662500000000001p -1.931707e-05 33.675000000000004p -1.9921150000000002e-05 33.6875p -2.0496109999999999e-05 33.699999999999996p -2.1041200000000001e-05 33.712499999999999p -2.1555750000000001e-05 33.725000000000001p -2.203909e-05 33.737500000000004p -2.2490619999999999e-05 33.75p -2.2909780000000001e-05
+ 33.762499999999996p -2.3296049999999999e-05 33.774999999999999p -2.3648979999999999e-05 33.787500000000001p -2.3968140000000001e-05 33.800000000000004p -2.425315e-05 33.8125p -2.4503700000000001e-05 33.824999999999996p -2.471951e-05 33.837499999999999p -2.4900339999999999e-05 33.850000000000001p -2.5046019999999998e-05 33.862500000000004p -2.515642e-05 33.875p -2.523145e-05 33.887500000000003p -2.5271089999999999e-05 33.899999999999999p -2.5275349999999998e-05 33.912500000000001p -2.5244290000000001e-05 33.925000000000004p -2.5178030000000001e-05 33.9375p -2.5076729999999999e-05 33.950000000000003p -2.4940589999999999e-05 33.962499999999999p -2.4769869999999999e-05 33.974999999999994p -2.4564870000000001e-05
+ 33.987500000000004p -2.432595e-05 34p -2.4053489999999999e-05 34.012500000000003p -2.374794e-05 34.024999999999999p -2.3409769999999999e-05 34.037499999999994p -2.303952e-05 34.050000000000004p -2.2637759999999999e-05 34.0625p -2.2205090000000001e-05 34.075000000000003p -2.1742160000000001e-05 34.087499999999999p -2.1249679999999999e-05 34.099999999999994p -2.072836e-05 34.112500000000004p -2.017898e-05 34.125p -1.960235e-05 34.137500000000003p -1.8999289999999999e-05 34.149999999999999p -1.8370689999999999e-05 34.162499999999994p -1.7717450000000001e-05 34.175000000000004p -1.7040500000000001e-05 34.1875p -1.634083e-05 34.200000000000003p -1.561942e-05
+ 34.212499999999999p -1.487729e-05 34.224999999999994p -1.4115500000000001e-05 34.237499999999997p -1.333512e-05 34.25p -1.2537249999999999e-05 34.262500000000003p -1.1722999999999999e-05 34.274999999999999p -1.089352e-05 34.287500000000001p -1.004995e-05 34.299999999999997p -9.1934639999999992e-06 34.3125p -8.3252559999999994e-06 34.325000000000003p -7.446522e-06 34.337499999999999p -6.5584730000000003e-06 34.350000000000001p -5.6623279999999999e-06 34.362499999999997p -4.7593170000000002e-06 34.375p -3.850674e-06 34.387500000000003p -2.9376390000000001e-06 34.399999999999999p -2.0214549999999999e-06 34.412500000000001p -1.103364e-06 34.424999999999997p -1.8461129999999999e-07
+ 34.4375p 7.3356269999999996e-07 34.450000000000003p 1.64992e-06 34.462499999999999p 2.5632299999999999e-06 34.475000000000001p 3.4722649999999999e-06 34.487499999999997p 4.3758109999999998e-06 34.5p 5.2726619999999997e-06 34.512500000000003p 6.1616219999999998e-06 34.524999999999999p 7.041513e-06 34.537500000000001p 7.9111680000000006e-06 34.549999999999997p 8.7694389999999994e-06 34.5625p 9.6151950000000004e-06 34.575000000000003p 1.0447329999999999e-05 34.587499999999999p 1.126474e-05 34.600000000000001p 1.206637e-05 34.612499999999997p 1.285118e-05 34.625p 1.361813e-05 34.637500000000003p 1.4366260000000001e-05 34.649999999999999p 1.5094570000000001e-05
+ 34.662500000000001p 1.580216e-05 34.674999999999997p 1.6488090000000002e-05 34.6875p 1.7151510000000001e-05 34.700000000000003p 1.7791579999999999e-05 34.712499999999999p 1.8407470000000001e-05 34.725000000000001p 1.899843e-05 34.737499999999997p 1.95637e-05 34.75p 2.0102589999999999e-05 34.762500000000003p 2.0614429999999999e-05 34.774999999999999p 2.1098600000000002e-05 34.787500000000001p 2.1554499999999998e-05 34.799999999999997p 2.1981579999999998e-05 34.8125p 2.237934e-05 34.825000000000003p 2.2747300000000002e-05 34.837499999999999p 2.3085039999999999e-05 34.850000000000001p 2.339216e-05 34.862499999999997p 2.366832e-05 34.875p 2.3913220000000001e-05
+ 34.887500000000003p 2.412659e-05 34.899999999999999p 2.430822e-05 34.912500000000001p 2.445793e-05 34.924999999999997p 2.4575580000000001e-05 34.9375p 2.4661089999999999e-05 34.950000000000003p 2.4714399999999998e-05 34.962499999999999p 2.4735510000000001e-05 34.975000000000001p 2.4724460000000001e-05 34.987499999999997p 2.4681329999999999e-05 35p 2.4606240000000001e-05 35.012500000000003p 2.4499350000000001e-05 35.025000000000006p 2.436087e-05 35.037500000000001p 2.4191049999999999e-05 35.049999999999997p 2.3990170000000001e-05 35.0625p 2.375856e-05 35.074999999999996p 2.3496600000000001e-05 35.087500000000006p 2.320467e-05 35.100000000000001p 2.2883240000000001e-05
+ 35.112499999999997p 2.2532780000000001e-05 35.125p 2.2153819999999999e-05 35.137499999999996p 2.17469e-05 35.150000000000006p 2.1312620000000001e-05 35.162500000000001p 2.0851609999999999e-05 35.174999999999997p 2.0364519999999999e-05 35.1875p 1.9852039999999998e-05 35.199999999999996p 1.93149e-05 35.212500000000006p 1.875385e-05 35.225000000000001p 1.8169670000000001e-05 35.237499999999997p 1.756318e-05 35.25p 1.6935210000000001e-05 35.262499999999996p 1.6286619999999999e-05 35.275000000000006p 1.561831e-05 35.287500000000001p 1.4931180000000001e-05 35.299999999999997p 1.422616e-05 35.3125p 1.3504230000000001e-05 35.324999999999996p 1.276633e-05
+ 35.337499999999999p 1.201348e-05 35.350000000000001p 1.124667e-05 35.362499999999997p 1.0466940000000001e-05 35.375p 9.6753170000000002e-06 35.387499999999996p 8.8728560000000007e-06 35.399999999999999p 8.0606190000000007e-06 35.412500000000001p 7.2396769999999999e-06 35.425000000000004p 6.4111119999999998e-06 35.4375p 5.5760100000000003e-06 35.449999999999996p 4.7354639999999997e-06 35.462499999999999p 3.8905700000000001e-06 35.475000000000001p 3.0424279999999998e-06 35.487500000000004p 2.1921379999999999e-06 35.5p 1.3407980000000001e-06 35.512499999999996p 4.8950800000000004e-07 35.524999999999999p -3.6063830000000001e-07 35.537500000000001p -1.2085510000000001e-06 35.550000000000004p -2.0531450000000001e-06
+ 35.5625p -2.8933450000000001e-06 35.574999999999996p -3.7280839999999999e-06 35.587499999999999p -4.5563029999999998e-06 35.600000000000001p -5.3769579999999996e-06 35.612500000000004p -6.1890149999999997e-06 35.625p -6.9914550000000001e-06 35.637499999999996p -7.7832769999999992e-06 35.649999999999999p -8.5634940000000005e-06 35.662500000000001p -9.3311370000000007e-06 35.675000000000004p -1.008526e-05 35.6875p -1.0824930000000001e-05 35.699999999999996p -1.1549240000000001e-05 35.712499999999999p -1.2257309999999999e-05 35.725000000000001p -1.294828e-05 35.737500000000004p -1.362131e-05 35.75p -1.427559e-05 35.762500000000003p -1.491034e-05 35.774999999999999p -1.5524810000000002e-05
+ 35.787500000000001p -1.6118259999999998e-05 35.800000000000004p -1.6690000000000001e-05 35.8125p -1.723936e-05 35.825000000000003p -1.776572e-05 35.837499999999999p -1.826845e-05 35.849999999999994p -1.8746999999999999e-05 35.862500000000004p -1.9200819999999999e-05 35.875p -1.9629409999999999e-05 35.887500000000003p -2.0032300000000001e-05 35.899999999999999p -2.0409050000000001e-05 35.912499999999994p -2.0759270000000001e-05 35.925000000000004p -2.1082579999999999e-05 35.9375p -2.137866e-05 35.950000000000003p -2.164722e-05 35.962499999999999p -2.1888009999999998e-05 35.974999999999994p -2.210079e-05 35.987500000000004p -2.2285399999999998e-05 36p -2.2441680000000001e-05
+ 36.012500000000003p -2.256953e-05 36.024999999999999p -2.266887e-05 36.037499999999994p -2.273968e-05 36.050000000000004p -2.278195e-05 36.0625p -2.2795730000000001e-05 36.075000000000003p -2.2781100000000001e-05 36.087499999999999p -2.2738159999999999e-05 36.099999999999994p -2.266707e-05 36.112499999999997p -2.2568009999999999e-05 36.125p -2.2441209999999999e-05 36.137500000000003p -2.2286909999999999e-05 36.149999999999999p -2.2105410000000001e-05 36.162500000000001p -2.189704e-05 36.174999999999997p -2.1662160000000001e-05 36.1875p -2.1401150000000001e-05 36.200000000000003p -2.1114439999999998e-05 36.212499999999999p -2.0802480000000001e-05 36.225000000000001p -2.0465770000000001e-05
+ 36.237499999999997p -2.0104809999999998e-05 36.25p -1.9720159999999999e-05 36.262500000000003p -1.9312400000000002e-05 36.274999999999999p -1.8882110000000001e-05 36.287500000000001p -1.8429940000000001e-05 36.299999999999997p -1.7956539999999999e-05 36.3125p -1.746259e-05 36.325000000000003p -1.6948789999999999e-05 36.337499999999999p -1.6415879999999998e-05 36.350000000000001p -1.5864600000000001e-05 36.362499999999997p -1.5295729999999999e-05 36.375p -1.471005e-05 36.387500000000003p -1.410837e-05 36.399999999999999p -1.349153e-05 36.412500000000001p -1.286036e-05 36.424999999999997p -1.2215729999999999e-05 36.4375p -1.15585e-05 36.450000000000003p -1.0889569999999999e-05
+ 36.462499999999999p -1.020983e-05 36.475000000000001p -9.5201849999999997e-06 36.487499999999997p -8.8215589999999999e-06 36.5p -8.1148750000000008e-06 36.512500000000003p -7.4010650000000003e-06 36.524999999999999p -6.6810659999999998e-06 36.537500000000001p -5.9558209999999997e-06 36.549999999999997p -5.2262729999999997e-06 36.5625p -4.4933699999999996e-06 36.575000000000003p -3.758059e-06 36.587499999999999p -3.0212859999999998e-06 36.600000000000001p -2.2839939999999999e-06 36.612499999999997p -1.5471260000000001e-06 36.625p -8.1161700000000003e-07 36.637500000000003p -7.8398640000000004e-08 36.649999999999999p 6.5160519999999995e-07 36.662500000000001p 1.377479e-06 36.674999999999997p 2.0983150000000001e-06
+ 36.6875p 2.8132189999999999e-06 36.700000000000003p 3.5213040000000002e-06 36.712499999999999p 4.2216999999999997e-06 36.725000000000001p 4.9135469999999999e-06 36.737499999999997p 5.5960030000000002e-06 36.75p 6.2682390000000004e-06 36.762500000000003p 6.9294449999999999e-06 36.774999999999999p 7.5788290000000003e-06 36.787500000000001p 8.2156160000000002e-06 36.799999999999997p 8.8390520000000002e-06 36.8125p 9.4484030000000008e-06 36.825000000000003p 1.0042960000000001e-05 36.837499999999999p 1.062203e-05 36.850000000000001p 1.118495e-05 36.862499999999997p 1.173107e-05 36.875p 1.225979e-05 36.887499999999996p 1.2770500000000001e-05 36.900000000000006p 1.326264e-05
+ 36.912500000000001p 1.373568e-05 36.924999999999997p 1.4189099999999999e-05 36.9375p 1.462241e-05 36.949999999999996p 1.5035169999999999e-05 36.962500000000006p 1.5426939999999999e-05 36.975000000000001p 1.5797340000000001e-05 36.987499999999997p 1.614598e-05 37p 1.6472540000000001e-05 37.012499999999996p 1.6776709999999999e-05 37.025000000000006p 1.7058209999999999e-05 37.037500000000001p 1.73168e-05 37.049999999999997p 1.7552259999999999e-05 37.0625p 1.776441e-05 37.074999999999996p 1.7953089999999999e-05 37.087500000000006p 1.8118199999999999e-05 37.100000000000001p 1.825964e-05 37.112499999999997p 1.837734e-05 37.125p 1.8471300000000001e-05
+ 37.137499999999996p 1.8541499999999999e-05 37.150000000000006p 1.8587990000000002e-05 37.162500000000001p 1.861083e-05 37.174999999999997p 1.8610129999999999e-05 37.1875p 1.8586000000000001e-05 37.199999999999996p 1.853861e-05 37.212499999999999p 1.846814e-05 37.225000000000001p 1.837481e-05 37.237499999999997p 1.825887e-05 37.25p 1.812059e-05 37.262499999999996p 1.7960269999999999e-05 37.274999999999999p 1.7778240000000001e-05 37.287500000000001p 1.757485e-05 37.300000000000004p 1.7350489999999999e-05 37.3125p 1.7105569999999999e-05 37.324999999999996p 1.684051e-05 37.337499999999999p 1.655578e-05 37.350000000000001p 1.625186e-05
+ 37.362500000000004p 1.5929239999999999e-05 37.375p 1.5588450000000001e-05 37.387499999999996p 1.5230039999999999e-05 37.399999999999999p 1.485458e-05 37.412500000000001p 1.446264e-05 37.425000000000004p 1.4054840000000001e-05 37.4375p 1.3631800000000001e-05 37.449999999999996p 1.319415e-05 37.462499999999999p 1.2742550000000001e-05 37.475000000000001p 1.227766e-05 37.487500000000004p 1.180018e-05 37.5p 1.13108e-05 37.512499999999996p 1.0810230000000001e-05 37.524999999999999p 1.029918e-05 37.537500000000001p 9.7783850000000001e-06 37.550000000000004p 9.2485839999999994e-06 37.5625p 8.7105230000000003e-06 37.574999999999996p 8.1649550000000008e-06
+ 37.587499999999999p 7.6126380000000004e-06 37.600000000000001p 7.0543350000000003e-06 37.612500000000004p 6.490815e-06 37.625p 5.9228460000000003e-06 37.637500000000003p 5.3512020000000002e-06 37.649999999999999p 4.7766530000000001e-06 37.662500000000001p 4.1999729999999999e-06 37.675000000000004p 3.6219309999999998e-06 37.6875p 3.043296e-06 37.700000000000003p 2.464833e-06 37.712499999999999p 1.8872999999999999e-06 37.724999999999994p 1.311453e-06 37.737500000000004p 7.3804079999999995e-07 37.75p 1.6780319999999999e-07 37.762500000000003p -3.9852720000000002e-07 37.774999999999999p -9.6022709999999998e-07 37.787499999999994p -1.516584e-06 37.800000000000004p -2.066896e-06
+ 37.8125p -2.6104730000000001e-06 37.825000000000003p -3.1466379999999999e-06 37.837499999999999p -3.6747289999999999e-06 37.849999999999994p -4.1940970000000003e-06 37.862500000000004p -4.7041079999999998e-06 37.875p -5.2041459999999999e-06 37.887500000000003p -5.6936099999999999e-06 37.899999999999999p -6.1719180000000002e-06 37.912499999999994p -6.6385040000000002e-06 37.925000000000004p -7.0928239999999999e-06 37.9375p -7.5343519999999998e-06 37.950000000000003p -7.9625819999999997e-06 37.962499999999999p -8.3770279999999995e-06 37.974999999999994p -8.7772279999999995e-06 37.987499999999997p -9.1627389999999996e-06 38p -9.5331410000000008e-06 38.012500000000003p -9.8880389999999992e-06 38.024999999999999p -1.022706e-05
+ 38.037500000000001p -1.054985e-05 38.049999999999997p -1.085608e-05 38.0625p -1.1145459999999999e-05 38.075000000000003p -1.1417700000000001e-05 38.087499999999999p -1.167256e-05 38.100000000000001p -1.1909800000000001e-05 38.112499999999997p -1.212922e-05 38.125p -1.233064e-05 38.137500000000003p -1.251392e-05 38.149999999999999p -1.267893e-05 38.162500000000001p -1.282555e-05 38.174999999999997p -1.295373e-05 38.1875p -1.306341e-05 38.200000000000003p -1.315456e-05 38.212499999999999p -1.322719e-05 38.225000000000001p -1.3281320000000001e-05 38.237499999999997p -1.3317e-05 38.25p -1.3334309999999999e-05
+ 38.262500000000003p -1.333335e-05 38.274999999999999p -1.331424e-05 38.287500000000001p -1.3277130000000001e-05 38.299999999999997p -1.32222e-05 38.3125p -1.314964e-05 38.325000000000003p -1.305966e-05 38.337499999999999p -1.2952510000000001e-05 38.350000000000001p -1.282846e-05 38.362499999999997p -1.268779e-05 38.375p -1.25308e-05 38.387500000000003p -1.235782e-05 38.399999999999999p -1.21692e-05 38.412500000000001p -1.19653e-05 38.424999999999997p -1.1746510000000001e-05 38.4375p -1.151324e-05 38.450000000000003p -1.12659e-05 38.462499999999999p -1.1004930000000001e-05 38.475000000000001p -1.073079e-05
+ 38.487499999999997p -1.0443939999999999e-05 38.5p -1.014487e-05 38.512500000000003p -9.8340859999999996e-06 38.524999999999999p -9.5120899999999993e-06 38.537500000000001p -9.1794099999999996e-06 38.549999999999997p -8.8365820000000002e-06 38.5625p -8.484154e-06 38.575000000000003p -8.1226829999999995e-06 38.587499999999999p -7.7527359999999996e-06 38.600000000000001p -7.3748890000000002e-06 38.612499999999997p -6.989724e-06 38.625p -6.5978319999999998e-06 38.637500000000003p -6.1998079999999997e-06 38.649999999999999p -5.7962539999999999e-06 38.662500000000001p -5.3877750000000003e-06 38.674999999999997p -4.9749810000000003e-06 38.6875p -4.5584810000000002e-06 38.700000000000003p -4.1388909999999998e-06
+ 38.712499999999999p -3.7168230000000001e-06 38.725000000000001p -3.2928909999999998e-06 38.737499999999997p -2.8677099999999999e-06 38.75p -2.44189e-06 38.762499999999996p -2.0160400000000001e-06 38.775000000000006p -1.590766e-06 38.787500000000001p -1.166669e-06 38.799999999999997p -7.4434670000000001e-07 38.8125p -3.2438860000000001e-07 38.824999999999996p 9.2620860000000001e-08 38.837500000000006p 5.0610500000000004e-07 38.850000000000001p 9.1549520000000002e-07 38.862499999999997p 1.3202319999999999e-06 38.875p 1.7197649999999999e-06 38.887499999999996p 2.113554e-06 38.900000000000006p 2.5010720000000001e-06 38.912500000000001p 2.8818000000000001e-06 38.924999999999997p 3.2552350000000001e-06
+ 38.9375p 3.6208839999999999e-06 38.949999999999996p 3.9782700000000001e-06 38.962500000000006p 4.3269299999999996e-06 38.975000000000001p 4.6664139999999999e-06 38.987499999999997p 4.9962889999999998e-06 39p 5.3161370000000002e-06 39.012499999999996p 5.6255569999999998e-06 39.025000000000006p 5.9241660000000003e-06 39.037500000000001p 6.2115959999999998e-06 39.049999999999997p 6.4874989999999999e-06 39.0625p 6.7515429999999998e-06 39.074999999999996p 7.0034160000000002e-06 39.087499999999999p 7.2428259999999998e-06 39.100000000000001p 7.4694979999999997e-06 39.112500000000004p 7.683177e-06 39.125p 7.8836289999999995e-06 39.137499999999996p 8.0706390000000003e-06 39.149999999999999p 8.2440139999999993e-06
+ 39.162500000000001p 8.4035780000000001e-06 39.175000000000004p 8.5491799999999997e-06 39.1875p 8.6806850000000004e-06 39.199999999999996p 8.7979829999999996e-06 39.212499999999999p 8.9009830000000002e-06 39.225000000000001p 8.9896139999999994e-06 39.237500000000004p 9.0638279999999994e-06 39.25p 9.1235949999999998e-06 39.262499999999996p 9.1689100000000003e-06 39.274999999999999p 9.1997850000000002e-06 39.287500000000001p 9.2162539999999993e-06 39.300000000000004p 9.2183719999999998e-06 39.3125p 9.2062130000000006e-06 39.324999999999996p 9.1798740000000005e-06 39.337499999999999p 9.1394669999999992e-06 39.350000000000001p 9.0851289999999998e-06 39.362500000000004p 9.0170130000000008e-06 39.375p 8.9352929999999998e-06
+ 39.387499999999996p 8.840159e-06 39.399999999999999p 8.7318229999999996e-06 39.412500000000001p 8.6105119999999995e-06 39.425000000000004p 8.4764739999999998e-06 39.4375p 8.3299699999999995e-06 39.449999999999996p 8.1712810000000005e-06 39.462499999999999p 8.0007040000000004e-06 39.475000000000001p 7.8185499999999999e-06 39.487500000000004p 7.6251470000000003e-06 39.5p 7.4208369999999997e-06 39.512500000000003p 7.2059769999999997e-06 39.524999999999999p 6.9809380000000001e-06 39.537500000000001p 6.7461020000000001e-06 39.550000000000004p 6.5018649999999996e-06 39.5625p 6.2486370000000002e-06 39.575000000000003p 5.9868349999999999e-06 39.587499999999999p 5.7168890000000002e-06 39.599999999999994p 5.4392399999999998e-06
+ 39.612500000000004p 5.1543360000000001e-06 39.625p 4.862636e-06 39.637500000000003p 4.5646060000000001e-06 39.649999999999999p 4.2607179999999998e-06 39.662499999999994p 3.951453e-06 39.675000000000004p 3.6372960000000002e-06 39.6875p 3.3187379999999999e-06 39.700000000000003p 2.996275e-06 39.712499999999999p 2.670406e-06 39.724999999999994p 2.341633e-06 39.737500000000004p 2.010461e-06 39.75p 1.6773959999999999e-06 39.762500000000003p 1.3429460000000001e-06 39.774999999999999p 1.0076169999999999e-06 39.787499999999994p 6.7191569999999996e-07 39.800000000000004p 3.3634860000000002e-07 39.8125p 1.418692e-09 39.825000000000003p -3.3237320000000002e-07
+ 39.837499999999999p -6.6452959999999996e-07 39.849999999999994p -9.9455719999999993e-07 39.862499999999997p -1.3219669999999999e-06 39.875p -1.646277e-06 39.887500000000003p -1.967009e-06 39.899999999999999p -2.2836929999999999e-06 39.912500000000001p -2.5958659999999999e-06 39.924999999999997p -2.9030739999999999e-06 39.9375p -3.2048689999999998e-06 39.950000000000003p -3.500816e-06 39.962499999999999p -3.790486e-06 39.975000000000001p -4.0734629999999997e-06 39.987499999999997p -4.3493419999999999e-06 40p -4.6177279999999998e-06 40.012500000000003p -4.8782390000000002e-06 40.024999999999999p -5.1305040000000004e-06 40.037500000000001p -5.3741690000000003e-06 40.049999999999997p -5.6088880000000003e-06
+ 40.0625p -5.8343329999999996e-06 40.075000000000003p -6.0501879999999998e-06 40.087499999999999p -6.2561540000000003e-06 40.100000000000001p -6.451946e-06 40.112499999999997p -6.637293e-06 40.125p -6.8119419999999998e-06 40.137500000000003p -6.9756559999999996e-06 40.149999999999999p -7.1282120000000001e-06 40.162500000000001p -7.269406e-06 40.174999999999997p -7.3990510000000002e-06 40.1875p -7.5169760000000004e-06 40.200000000000003p -7.6230279999999996e-06 40.212499999999999p -7.7170700000000006e-06 40.225000000000001p -7.7989859999999994e-06 40.237499999999997p -7.8686729999999992e-06 40.25p -7.9260509999999995e-06 40.262500000000003p -7.9710530000000004e-06 40.274999999999999p -8.0036340000000004e-06
+ 40.287500000000001p -8.0237650000000002e-06 40.299999999999997p -8.0314340000000004e-06 40.3125p -8.0266500000000005e-06 40.325000000000003p -8.0094360000000001e-06 40.337499999999999p -7.9798370000000006e-06 40.350000000000001p -7.9379110000000008e-06 40.362499999999997p -7.8837379999999994e-06 40.375p -7.8174120000000002e-06 40.387500000000003p -7.7390460000000008e-06 40.399999999999999p -7.64877e-06 40.412500000000001p -7.5467299999999997e-06 40.424999999999997p -7.4330879999999997e-06 40.4375p -7.308024e-06 40.450000000000003p -7.1717329999999997e-06 40.462499999999999p -7.0244260000000003e-06 40.475000000000001p -6.8663279999999997e-06 40.487499999999997p -6.697681e-06 40.5p -6.5187400000000002e-06
+ 40.512500000000003p -6.3297739999999996e-06 40.524999999999999p -6.1310679999999996e-06 40.537500000000001p -5.9229179999999997e-06 40.549999999999997p -5.7056339999999997e-06 40.5625p -5.4795379999999996e-06 40.575000000000003p -5.2449639999999996e-06 40.587499999999999p -5.0022570000000002e-06 40.600000000000001p -4.7517749999999999e-06 40.612499999999997p -4.4938839999999998e-06 40.625p -4.2289609999999996e-06 40.637499999999996p -3.9573920000000002e-06 40.650000000000006p -3.679572e-06 40.662500000000001p -3.3959040000000001e-06 40.674999999999997p -3.1067989999999998e-06 40.6875p -2.8126739999999999e-06 40.699999999999996p -2.513954e-06 40.712500000000006p -2.2110699999999999e-06 40.725000000000001p -1.904455e-06
+ 40.737499999999997p -1.5945510000000001e-06 40.75p -1.281801e-06 40.762499999999996p -9.6665129999999994e-07 40.775000000000006p -6.4955319999999995e-07 40.787500000000001p -3.3095830000000002e-07 40.799999999999997p -1.1320169999999999e-08 40.8125p 3.0890690000000001e-07 40.824999999999996p 6.2926830000000005e-07 40.837500000000006p 9.4930989999999998e-07 40.850000000000001p 1.2685790000000001e-06 40.862499999999997p 1.586623e-06 40.875p 1.9029940000000001e-06 40.887499999999996p 2.2172449999999999e-06 40.900000000000006p 2.5289340000000001e-06 40.912500000000001p 2.8376210000000001e-06 40.924999999999997p 3.1428740000000001e-06 40.9375p 3.4442629999999998e-06 40.949999999999996p 3.741367e-06
+ 40.962499999999999p 4.0337680000000002e-06 40.975000000000001p 4.3210569999999999e-06 40.987500000000004p 4.6028329999999996e-06 41p 4.8787030000000003e-06 41.012499999999996p 5.1482799999999998e-06 41.024999999999999p 5.4111900000000001e-06 41.037500000000001p 5.6670670000000001e-06 41.050000000000004p 5.9155530000000003e-06 41.0625p 6.1563050000000002e-06 41.074999999999996p 6.3889860000000002e-06 41.087499999999999p 6.6132749999999998e-06 41.100000000000001p 6.8288599999999997e-06 41.112500000000004p 7.0354429999999997e-06 41.125p 7.2327360000000004e-06 41.137499999999996p 7.4204680000000003e-06 41.149999999999999p 7.5983770000000004e-06 41.162500000000001p 7.7662190000000006e-06 41.175000000000004p 7.9237610000000002e-06
+ 41.1875p 8.0707860000000008e-06 41.199999999999996p 8.2070889999999996e-06 41.212499999999999p 8.3324839999999998e-06 41.225000000000001p 8.4467959999999992e-06 41.237500000000004p 8.5498670000000007e-06 41.25p 8.641556e-06 41.262499999999996p 8.7217339999999995e-06 41.274999999999999p 8.7902909999999999e-06 41.287500000000001p 8.8471310000000002e-06 41.300000000000004p 8.8921739999999999e-06 41.3125p 8.9253579999999994e-06 41.324999999999996p 8.9466350000000008e-06 41.337499999999999p 8.9559729999999998e-06 41.350000000000001p 8.9533579999999998e-06 41.362500000000004p 8.9387910000000003e-06 41.375p 8.9122879999999999e-06 41.387500000000003p 8.873883e-06 41.399999999999999p 8.8236260000000008e-06
+ 41.412500000000001p 8.7615799999999996e-06 41.425000000000004p 8.6878270000000006e-06 41.4375p 8.6024639999999992e-06 41.450000000000003p 8.5056009999999997e-06 41.462499999999999p 8.3973660000000006e-06 41.474999999999994p 8.2779019999999996e-06 41.487500000000004p 8.1473650000000002e-06 41.5p 8.0059260000000002e-06 41.512500000000003p 7.8537730000000004e-06 41.524999999999999p 7.6911039999999992e-06 41.537499999999994p 7.5181339999999997e-06 41.550000000000004p 7.3350899999999996e-06 41.5625p 7.1422129999999997e-06 41.575000000000003p 6.9397550000000003e-06 41.587499999999999p 6.727983e-06 41.599999999999994p 6.5071739999999998e-06 41.612500000000004p 6.2776179999999999e-06 41.625p 6.0396160000000002e-06
+ 41.637500000000003p 5.7934780000000003e-06 41.649999999999999p 5.539528e-06 41.662499999999994p 5.2780960000000002e-06 41.675000000000004p 5.0095250000000001e-06 41.6875p 4.7341649999999996e-06 41.700000000000003p 4.4523749999999999e-06 41.712499999999999p 4.1645219999999999e-06 41.724999999999994p 3.8709800000000002e-06 41.737499999999997p 3.5721320000000001e-06 41.75p 3.268365e-06 41.762500000000003p 2.960074e-06 41.774999999999999p 2.6476580000000002e-06 41.787500000000001p 2.3315219999999998e-06 41.799999999999997p 2.0120759999999999e-06 41.8125p 1.6897309999999999e-06 41.825000000000003p 1.364904e-06 41.837499999999999p 1.038015e-06 41.850000000000001p 7.0948310000000005e-07
+ 41.862499999999997p 3.7973220000000001e-07 41.875p 4.9185880000000003e-08 41.887500000000003p -2.8173169999999999e-07 41.899999999999999p -6.1259629999999999e-07 41.912500000000001p -9.4298430000000002e-07 41.924999999999997p -1.272473e-06 41.9375p -1.6006430000000001e-06 41.950000000000003p -1.9270739999999999e-06 41.962499999999999p -2.2513509999999999e-06 41.975000000000001p -2.5730620000000002e-06 41.987499999999997p -2.8917979999999999e-06 42p -3.207156e-06 42.012500000000003p -3.518736e-06 42.024999999999999p -3.826144e-06 42.037500000000001p -4.128994e-06 42.049999999999997p -4.4269020000000004e-06 42.0625p -4.7194960000000002e-06 42.075000000000003p -5.0064089999999997e-06
+ 42.087499999999999p -5.2872799999999996e-06 42.100000000000001p -5.5617590000000002e-06 42.112499999999997p -5.8295050000000002e-06 42.125p -6.0901840000000001e-06 42.137500000000003p -6.3434720000000004e-06 42.149999999999999p -6.589057e-06 42.162500000000001p -6.8266360000000001e-06 42.174999999999997p -7.0559160000000001e-06 42.1875p -7.2766160000000004e-06 42.200000000000003p -7.4884659999999999e-06 42.212499999999999p -7.6912089999999998e-06 42.225000000000001p -7.8845989999999996e-06 42.237499999999997p -8.0684019999999993e-06 42.25p -8.2423980000000004e-06 42.262500000000003p -8.4063779999999995e-06 42.274999999999999p -8.5601479999999992e-06 42.287500000000001p -8.7035260000000001e-06 42.299999999999997p -8.8363440000000008e-06
+ 42.3125p -8.9584500000000006e-06 42.325000000000003p -9.069701e-06 42.337499999999999p -9.1699720000000004e-06 42.350000000000001p -9.2591519999999997e-06 42.362499999999997p -9.3371420000000007e-06 42.375p -9.4038600000000005e-06 42.387500000000003p -9.4592370000000004e-06 42.399999999999999p -9.5032189999999994e-06 42.412500000000001p -9.5357659999999997e-06 42.424999999999997p -9.5568529999999997e-06 42.4375p -9.5664700000000002e-06 42.450000000000003p -9.5646210000000007e-06 42.462499999999999p -9.5513249999999996e-06 42.475000000000001p -9.5266150000000006e-06 42.487499999999997p -9.490539e-06 42.5p -9.4431579999999998e-06 42.512499999999996p -9.3845479999999993e-06 42.525000000000006p -9.3147999999999993e-06
+ 42.537500000000001p -9.2340169999999999e-06 42.549999999999997p -9.1423170000000004e-06 42.5625p -9.0398309999999992e-06 42.574999999999996p -8.9267050000000008e-06 42.587500000000006p -8.8030950000000001e-06 42.600000000000001p -8.6691710000000006e-06 42.612499999999997p -8.525118e-06 42.625p -8.3711300000000006e-06 42.637499999999996p -8.2074160000000008e-06 42.650000000000006p -8.0341940000000003e-06 42.662500000000001p -7.851694e-06 42.674999999999997p -7.6601600000000005e-06 42.6875p -7.4598439999999997e-06 42.699999999999996p -7.2510079999999999e-06 42.712500000000006p -7.033926e-06 42.725000000000001p -6.8088809999999998e-06 42.737499999999997p -6.5761639999999997e-06 42.75p -6.3360769999999998e-06
+ 42.762499999999996p -6.0889299999999998e-06 42.775000000000006p -5.8350390000000001e-06 42.787500000000001p -5.5747299999999997e-06 42.799999999999997p -5.3083350000000004e-06 42.8125p -5.0361930000000002e-06 42.824999999999996p -4.7586499999999997e-06 42.837499999999999p -4.4760570000000001e-06 42.850000000000001p -4.1887710000000003e-06 42.862500000000004p -3.8971520000000001e-06 42.875p -3.6015659999999999e-06 42.887499999999996p -3.3023839999999999e-06 42.899999999999999p -2.9999790000000001e-06 42.912500000000001p -2.6947260000000001e-06 42.925000000000004p -2.3870039999999999e-06 42.9375p -2.077194e-06 42.949999999999996p -1.7656779999999999e-06 42.962499999999999p -1.4528380000000001e-06 42.975000000000001p -1.139059e-06
+ 42.987500000000004p -8.2472280000000003e-07 43p -5.102136e-07 43.012499999999996p -1.9591299999999999e-07 43.024999999999999p 1.1779849999999999e-07 43.037500000000001p 4.3054240000000001e-07 43.050000000000004p 7.4194259999999999e-07 43.0625p 1.0516260000000001e-06 43.074999999999996p 1.359222e-06 43.087499999999999p 1.664366e-06 43.100000000000001p 1.9666949999999998e-06 43.112500000000004p 2.2658520000000001e-06 43.125p 2.5614869999999998e-06 43.137499999999996p 2.853251e-06 43.149999999999999p 3.1408059999999998e-06 43.162500000000001p 3.423817e-06 43.175000000000004p 3.701958e-06 43.1875p 3.9749090000000003e-06 43.199999999999996p 4.2423580000000004e-06
+ 43.212499999999999p 4.5040009999999998e-06 43.225000000000001p 4.7595410000000004e-06 43.237500000000004p 5.008693e-06 43.25p 5.2511770000000002e-06 43.262500000000003p 5.4867259999999998e-06 43.274999999999999p 5.71508e-06 43.287499999999994p 5.935991e-06 43.300000000000004p 6.1492180000000004e-06 43.3125p 6.3545349999999998e-06 43.325000000000003p 6.5517229999999999e-06 43.337499999999999p 6.7405759999999996e-06 43.349999999999994p 6.9208979999999996e-06 43.362500000000004p 7.0925049999999998e-06 43.375p 7.2552249999999996e-06 43.387500000000003p 7.4088969999999996e-06 43.399999999999999p 7.5533719999999996e-06 43.412499999999994p 7.6885139999999993e-06 43.425000000000004p 7.814198e-06
+ 43.4375p 7.9303109999999994e-06 43.450000000000003p 8.0367539999999999e-06 43.462499999999999p 8.1334400000000002e-06 43.474999999999994p 8.2202930000000007e-06 43.487500000000004p 8.2972519999999997e-06 43.5p 8.3642659999999992e-06 43.512500000000003p 8.4212979999999997e-06 43.524999999999999p 8.4683240000000005e-06 43.537499999999994p 8.5053309999999995e-06 43.550000000000004p 8.5323219999999998e-06 43.5625p 8.5493070000000004e-06 43.575000000000003p 8.5563130000000003e-06 43.587499999999999p 8.5533779999999999e-06 43.599999999999994p 8.5405510000000001e-06 43.612499999999997p 8.5178949999999999e-06 43.625p 8.4854830000000005e-06 43.637500000000003p 8.4434010000000006e-06 43.649999999999999p 8.3917469999999999e-06
+ 43.662500000000001p 8.3306299999999999e-06 43.674999999999997p 8.2601689999999995e-06 43.6875p 8.1804970000000008e-06 43.700000000000003p 8.0917540000000002e-06 43.712499999999999p 7.9940949999999999e-06 43.725000000000001p 7.8876810000000004e-06 43.737499999999997p 7.7726870000000004e-06 43.75p 7.6492949999999994e-06 43.762500000000003p 7.5176980000000004e-06 43.774999999999999p 7.3780980000000001e-06 43.787500000000001p 7.2307059999999998e-06 43.799999999999997p 7.0757410000000004e-06 43.8125p 6.9134319999999998e-06 43.825000000000003p 6.7440129999999999e-06 43.837499999999999p 6.5677300000000002e-06 43.850000000000001p 6.3848310000000001e-06 43.862499999999997p 6.195577e-06 43.875p 6.0002300000000001e-06
+ 43.887500000000003p 5.7990620000000003e-06 43.899999999999999p 5.5923489999999997e-06 43.912500000000001p 5.3803729999999997e-06 43.924999999999997p 5.1634210000000003e-06 43.9375p 4.9417840000000003e-06 43.950000000000003p 4.7157600000000004e-06 43.962499999999999p 4.4856470000000001e-06 43.975000000000001p 4.2517500000000004e-06 43.987499999999997p 4.0143739999999998e-06 44p 3.7738289999999999e-06 44.012500000000003p 3.5304250000000002e-06 44.024999999999999p 3.2844770000000001e-06 44.037500000000001p 3.0362989999999998e-06 44.049999999999997p 2.7862059999999998e-06 44.0625p 2.5345149999999998e-06 44.075000000000003p 2.281542e-06 44.087499999999999p 2.0276030000000002e-06 44.100000000000001p 1.773014e-06
+ 44.112499999999997p 1.5180900000000001e-06 44.125p 1.263144e-06 44.137500000000003p 1.008486e-06 44.149999999999999p 7.544274e-07 44.162500000000001p 5.0127319999999995e-07 44.174999999999997p 2.4932740000000001e-07 44.1875p -1.1096659999999999e-09 44.200000000000003p -2.4974159999999999e-07 44.212499999999999p -4.9627580000000001e-07 44.225000000000001p -7.4042429999999999e-07 44.237499999999997p -9.8190390000000004e-07 44.25p -1.2204359999999999e-06 44.262500000000003p -1.455749e-06 44.274999999999999p -1.6875750000000001e-06 44.287500000000001p -1.9156540000000001e-06 44.299999999999997p -2.1397309999999998e-06 44.3125p -2.3595579999999999e-06 44.325000000000003p -2.5748939999999999e-06
+ 44.337499999999999p -2.7855069999999998e-06 44.350000000000001p -2.991169e-06 44.362499999999997p -3.1916629999999999e-06 44.375p -3.3867780000000002e-06 44.387499999999996p -3.5763119999999999e-06 44.400000000000006p -3.7600710000000001e-06 44.412500000000001p -3.9378699999999996e-06 44.424999999999997p -4.1095339999999999e-06 44.4375p -4.2748930000000004e-06 44.449999999999996p -4.4337919999999996e-06 44.462500000000006p -4.5860800000000003e-06 44.475000000000001p -4.7316179999999998e-06 44.487499999999997p -4.8702770000000002e-06 44.5p -5.0019369999999999e-06 44.512499999999996p -5.126486e-06 44.525000000000006p -5.2438249999999997e-06 44.537500000000001p -5.3538630000000001e-06 44.549999999999997p -5.4565189999999997e-06
+ 44.5625p -5.5517240000000004e-06 44.574999999999996p -5.6394160000000002e-06 44.587500000000006p -5.7195449999999998e-06 44.600000000000001p -5.7920720000000001e-06 44.612499999999997p -5.8569660000000003e-06 44.625p -5.914207e-06 44.637499999999996p -5.963784e-06 44.650000000000006p -6.0056989999999997e-06 44.662500000000001p -6.0399600000000004e-06 44.674999999999997p -6.0665880000000002e-06 44.6875p -6.0856120000000001e-06 44.699999999999996p -6.0970710000000003e-06 44.712499999999999p -6.1010139999999997e-06 44.725000000000001p -6.0974990000000002e-06 44.737500000000004p -6.0865930000000003e-06 44.75p -6.0683729999999997e-06 44.762499999999996p -6.0429250000000003e-06 44.774999999999999p -6.0103419999999998e-06
+ 44.787500000000001p -5.9707280000000002e-06 44.800000000000004p -5.9241940000000002e-06 44.8125p -5.8708599999999997e-06 44.824999999999996p -5.8108530000000003e-06 44.837499999999999p -5.7443089999999998e-06 44.850000000000001p -5.6713710000000003e-06 44.862500000000004p -5.5921899999999997e-06 44.875p -5.5069219999999999e-06 44.887499999999996p -5.4157319999999997e-06 44.899999999999999p -5.3187920000000004e-06 44.912500000000001p -5.2162780000000002e-06 44.925000000000004p -5.1083730000000004e-06 44.9375p -4.995267e-06 44.949999999999996p -4.8771530000000003e-06 44.962499999999999p -4.7542320000000002e-06 44.975000000000001p -4.6267070000000001e-06 44.987500000000004p -4.4947880000000002e-06 45p -4.358688e-06
+ 45.012499999999996p -4.2186240000000004e-06 45.024999999999999p -4.0748170000000002e-06 45.037500000000001p -3.9274900000000002e-06 45.050000000000004p -3.776871e-06 45.0625p -3.62319e-06 45.074999999999996p -3.4666770000000002e-06 45.087499999999999p -3.3075679999999999e-06 45.100000000000001p -3.146097e-06 45.112500000000004p -2.9825010000000001e-06 45.125p -2.8170190000000002e-06 45.137500000000003p -2.6498879999999999e-06 45.149999999999999p -2.4813470000000001e-06 45.162499999999994p -2.3116360000000002e-06 45.175000000000004p -2.1409929999999999e-06 45.1875p -1.969656e-06 45.200000000000003p -1.797861e-06 45.212499999999999p -1.6258439999999999e-06 45.224999999999994p -1.45384e-06
+ 45.237500000000004p -1.282079e-06 45.25p -1.110793e-06 45.262500000000003p -9.4020890000000001e-07 45.274999999999999p -7.7055069999999997e-07 45.287499999999994p -6.0204029999999999e-07 45.300000000000004p -4.3489569999999998e-07 45.3125p -2.6933149999999998e-07 45.325000000000003p -1.055581e-07 45.337499999999999p 5.6218000000000001e-08 45.349999999999994p 2.1579500000000001e-07 45.362500000000004p 3.7297560000000002e-07 45.375p 5.2756749999999999e-07 45.387500000000003p 6.7938369999999996e-07 45.399999999999999p 8.2824240000000003e-07 45.412499999999994p 9.7396749999999996e-07 45.425000000000004p 1.1163889999999999e-06 45.4375p 1.255342e-06 45.450000000000003p 1.390668e-06
+ 45.462499999999999p 1.5222170000000001e-06 45.475000000000001p 1.649843e-06 45.487499999999997p 1.773407e-06 45.5p 1.8927779999999999e-06 45.512500000000003p 2.0078309999999999e-06 45.524999999999999p 2.11845e-06 45.537500000000001p 2.2245219999999998e-06 45.549999999999997p 2.3259469999999999e-06 45.5625p 2.422627e-06 45.575000000000003p 2.514476e-06 45.587499999999999p 2.6014140000000002e-06 45.600000000000001p 2.6833659999999999e-06 45.612499999999997p 2.7602689999999998e-06 45.625p 2.8320659999999999e-06 45.637500000000003p 2.898706e-06 45.649999999999999p 2.9601479999999999e-06 45.662500000000001p 3.0163600000000002e-06 45.674999999999997p 3.067313e-06
+ 45.6875p 3.1129919999999999e-06 45.700000000000003p 3.1533840000000001e-06 45.712499999999999p 3.1884869999999999e-06 45.725000000000001p 3.2183070000000002e-06 45.737499999999997p 3.242856e-06 45.75p 3.2621550000000001e-06 45.762500000000003p 3.2762300000000001e-06 45.774999999999999p 3.2851169999999999e-06 45.787500000000001p 3.2888580000000001e-06 45.799999999999997p 3.287504e-06 45.8125p 3.2811100000000001e-06 45.825000000000003p 3.2697400000000001e-06 45.837499999999999p 3.2534649999999999e-06 45.850000000000001p 3.232362e-06 45.862499999999997p 3.2065140000000001e-06 45.875p 3.1760109999999998e-06 45.887500000000003p 3.1409490000000002e-06 45.899999999999999p 3.1014309999999999e-06
+ 45.912500000000001p 3.0575649999999998e-06 45.924999999999997p 3.0094630000000002e-06 45.9375p 2.9572459999999998e-06 45.950000000000003p 2.901036e-06 45.962499999999999p 2.8409650000000001e-06 45.975000000000001p 2.7771649999999999e-06 45.987499999999997p 2.7097749999999998e-06 46p 2.638938e-06 46.012500000000003p 2.5648009999999998e-06 46.024999999999999p 2.4875150000000001e-06 46.037500000000001p 2.4072349999999999e-06 46.049999999999997p 2.3241189999999998e-06 46.0625p 2.2383269999999999e-06 46.075000000000003p 2.150024e-06 46.087499999999999p 2.0593759999999999e-06 46.100000000000001p 1.9665510000000001e-06 46.112499999999997p 1.871722e-06 46.125p 1.7750599999999999e-06
+ 46.137500000000003p 1.676741e-06 46.149999999999999p 1.5769389999999999e-06 46.162500000000001p 1.475832e-06 46.174999999999997p 1.373598e-06 46.1875p 1.2704130000000001e-06 46.200000000000003p 1.166456e-06 46.212499999999999p 1.0619059999999999e-06 46.225000000000001p 9.5694069999999994e-07 46.237499999999997p 8.51737e-07 46.25p 7.464719e-07 46.262499999999996p 6.4132070000000003e-07 46.275000000000006p 5.364576e-07 46.287500000000001p 4.3205540000000001e-07 46.299999999999997p 3.2828469999999997e-07 46.3125p 2.2531449999999999e-07 46.324999999999996p 1.2331100000000001e-07 46.337500000000006p 2.2438289999999999e-08 46.350000000000001p -7.7142559999999997e-08
+ 46.362499999999997p -1.7527340000000001e-07 46.375p -2.717992e-07 46.387499999999996p -3.6656859999999998e-07 46.400000000000006p -4.5943350000000002e-07 46.412500000000001p -5.5025009999999999e-07 46.424999999999997p -6.3887820000000005e-07 46.4375p -7.2518210000000003e-07 46.449999999999996p -8.090305e-07 46.462500000000006p -8.9029640000000004e-07 46.475000000000001p -9.6885800000000006e-07 46.487499999999997p -1.0445980000000001e-06 46.5p -1.117404e-06 46.512499999999996p -1.1871700000000001e-06 46.525000000000006p -1.253794e-06 46.537500000000001p -1.3171799999999999e-06 46.549999999999997p -1.3772379999999999e-06 46.5625p -1.4338820000000001e-06 46.574999999999996p -1.487034e-06
+ 46.587499999999999p -1.536621e-06 46.600000000000001p -1.5825760000000001e-06 46.612500000000004p -1.6248370000000001e-06 46.625p -1.663351e-06 46.637499999999996p -1.698067e-06 46.649999999999999p -1.7289450000000001e-06 46.662500000000001p -1.755947e-06 46.675000000000004p -1.779045e-06 46.6875p -1.7982129999999999e-06 46.699999999999996p -1.813436e-06 46.712499999999999p -1.8247019999999999e-06 46.725000000000001p -1.8320059999999999e-06 46.737500000000004p -1.835352e-06 46.75p -1.834746e-06 46.762499999999996p -1.8302019999999999e-06 46.774999999999999p -1.821743e-06 46.787500000000001p -1.809394e-06 46.800000000000004p -1.7931869999999999e-06
+ 46.8125p -1.7731630000000001e-06 46.824999999999996p -1.749366e-06 46.837499999999999p -1.721846e-06 46.850000000000001p -1.6906599999999999e-06 46.862500000000004p -1.6558699999999999e-06 46.875p -1.6175430000000001e-06 46.887499999999996p -1.575753e-06 46.899999999999999p -1.5305790000000001e-06 46.912500000000001p -1.4821040000000001e-06 46.925000000000004p -1.4304159999999999e-06 46.9375p -1.375609e-06 46.949999999999996p -1.317781e-06 46.962499999999999p -1.2570359999999999e-06 46.975000000000001p -1.193481e-06 46.987500000000004p -1.1272260000000001e-06 47p -1.058389e-06 47.012500000000003p -9.8708740000000008e-07 47.024999999999999p -9.1344569999999998e-07
+ 47.037499999999994p -8.3759019999999996e-07 47.050000000000004p -7.5965089999999999e-07 47.0625p -6.7976109999999996e-07 47.075000000000003p -5.9805660000000005e-07 47.087499999999999p -5.1467639999999996e-07 47.099999999999994p -4.297614e-07 47.112500000000004p -3.4345529999999998e-07 47.125p -2.559035e-07 47.137500000000003p -1.672533e-07 47.149999999999999p -7.7653810000000001e-08 47.162499999999994p 1.274478e-08 47.175000000000004p 1.0379100000000001e-07 47.1875p 1.9533229999999999e-07 47.200000000000003p 2.8721570000000002e-07 47.212499999999999p 3.7928770000000002e-07 47.224999999999994p 4.7139430000000002e-07 47.237500000000004p 5.6338169999999998e-07 47.25p 6.5509639999999995e-07
+ 47.262500000000003p 7.4638499999999997e-07 47.274999999999999p 8.3709519999999995e-07 47.287499999999994p 9.2707529999999996e-07 47.300000000000004p 1.0161750000000001e-06 47.3125p 1.1042440000000001e-06 47.325000000000003p 1.1911360000000001e-06 47.337499999999999p 1.2767049999999999e-06 47.350000000000001p 1.3608059999999999e-06 47.362499999999997p 1.443298e-06 47.375p 1.524042e-06 47.387500000000003p 1.602901e-06 47.399999999999999p 1.6797410000000001e-06 47.412500000000001p 1.7544300000000001e-06 47.424999999999997p 1.8268419999999999e-06 47.4375p 1.8968509999999999e-06 47.450000000000003p 1.9643369999999999e-06 47.462499999999999p 2.0291819999999999e-06 47.475000000000001p 2.0912739999999999e-06
+ 47.487499999999997p 2.150502e-06 47.5p 2.206762e-06 47.512500000000003p 2.2599530000000001e-06 47.524999999999999p 2.3099780000000001e-06 47.537500000000001p 2.3567459999999998e-06 47.549999999999997p 2.4001690000000001e-06 47.5625p 2.4401670000000001e-06 47.575000000000003p 2.4766609999999999e-06 47.587499999999999p 2.5095790000000001e-06 47.600000000000001p 2.538856e-06 47.612499999999997p 2.5644279999999999e-06 47.625p 2.586241e-06 47.637500000000003p 2.6042430000000001e-06 47.649999999999999p 2.6183890000000001e-06 47.662500000000001p 2.62864e-06 47.674999999999997p 2.634962e-06 47.6875p 2.637326e-06 47.700000000000003p 2.6357090000000001e-06
+ 47.712499999999999p 2.6300959999999999e-06 47.725000000000001p 2.6204750000000001e-06 47.737499999999997p 2.60684e-06 47.75p 2.5891930000000001e-06 47.762500000000003p 2.5675399999999998e-06 47.774999999999999p 2.5418930000000002e-06 47.787500000000001p 2.5122700000000001e-06 47.799999999999997p 2.4786939999999999e-06 47.8125p 2.4411950000000001e-06 47.825000000000003p 2.3998089999999999e-06 47.837499999999999p 2.3545749999999998e-06 47.850000000000001p 2.30554e-06 47.862499999999997p 2.2527559999999999e-06 47.875p 2.1962799999999999e-06 47.887500000000003p 2.1361749999999999e-06 47.899999999999999p 2.0725079999999999e-06 47.912500000000001p 2.0053519999999998e-06 47.924999999999997p 1.9347860000000001e-06
+ 47.9375p 1.860892e-06 47.950000000000003p 1.7837570000000001e-06 47.962499999999999p 1.7034760000000001e-06 47.975000000000001p 1.6201439999999999e-06 47.987499999999997p 1.5338639999999999e-06 48p 1.444741e-06 48.012500000000003p 1.352885e-06 48.024999999999999p 1.258411e-06 48.037500000000001p 1.1614359999999999e-06 48.049999999999997p 1.0620820000000001e-06 48.0625p 9.6047410000000002e-07 48.075000000000003p 8.5674129999999998e-07 48.087499999999999p 7.5101510000000002e-07 48.100000000000001p 6.4343020000000002e-07 48.112499999999997p 5.3412429999999995e-07 48.125p 4.232376e-07 48.137499999999996p 3.1091280000000002e-07 48.150000000000006p 1.9729480000000001e-07
+ 48.162500000000001p 8.2530589999999995e-08 48.174999999999997p -3.3230929999999999e-08 48.1875p -1.498393e-07 48.199999999999996p -2.6714250000000001e-07 48.212500000000006p -3.849874e-07 48.225000000000001p -5.032197e-07 48.237499999999997p -6.2168430000000003e-07 48.25p -7.4022549999999999e-07 48.262499999999996p -8.5868719999999998e-07 48.275000000000006p -9.7691319999999994e-07 48.287500000000001p -1.0947469999999999e-06 48.299999999999997p -1.2120330000000001e-06 48.3125p -1.328614e-06 48.324999999999996p -1.4443370000000001e-06 48.337500000000006p -1.5590470000000001e-06 48.350000000000001p -1.67259e-06 48.362499999999997p -1.7848160000000001e-06 48.375p -1.895573e-06
+ 48.387499999999996p -2.004712e-06 48.400000000000006p -2.1120880000000002e-06 48.412500000000001p -2.2175540000000002e-06 48.424999999999997p -2.3209690000000001e-06 48.4375p -2.4221920000000001e-06 48.449999999999996p -2.5210859999999999e-06 48.462499999999999p -2.6175159999999999e-06 48.475000000000001p -2.7113499999999999e-06 48.487500000000004p -2.8024590000000002e-06 48.5p -2.890719e-06 48.512499999999996p -2.9760080000000002e-06 48.524999999999999p -3.0582070000000002e-06 48.537500000000001p -3.1372019999999999e-06 48.550000000000004p -3.2128820000000001e-06 48.5625p -3.2851429999999998e-06 48.574999999999996p -3.3538809999999999e-06 48.587499999999999p -3.418999e-06 48.600000000000001p -3.4804039999999999e-06
+ 48.612500000000004p -3.5380069999999998e-06 48.625p -3.5917249999999999e-06 48.637499999999996p -3.6414789999999998e-06 48.649999999999999p -3.6871950000000001e-06 48.662500000000001p -3.7288039999999999e-06 48.675000000000004p -3.7662419999999999e-06 48.6875p -3.7994509999999999e-06 48.699999999999996p -3.8283780000000003e-06 48.712499999999999p -3.8529750000000002e-06 48.725000000000001p -3.8731999999999996e-06 48.737500000000004p -3.8890149999999997e-06 48.75p -3.9003889999999999e-06 48.762499999999996p -3.907297e-06 48.774999999999999p -3.9097190000000003e-06 48.787500000000001p -3.9076389999999997e-06 48.800000000000004p -3.9010490000000003e-06 48.8125p -3.8899459999999998e-06 48.824999999999996p -3.8743320000000004e-06
+ 48.837499999999999p -3.8542149999999997e-06 48.850000000000001p -3.8296090000000002e-06 48.862500000000004p -3.8005330000000001e-06 48.875p -3.7670129999999998e-06 48.887500000000003p -3.7290790000000001e-06 48.899999999999999p -3.6867659999999999e-06 48.912499999999994p -3.6401169999999999e-06 48.925000000000004p -3.5891780000000001e-06 48.9375p -3.5340010000000002e-06 48.950000000000003p -3.4746449999999999e-06 48.962499999999999p -3.4111720000000001e-06 48.974999999999994p -3.3436500000000002e-06 48.987500000000004p -3.2721520000000001e-06 49p -3.1967549999999999e-06 49.012500000000003p -3.1175440000000002e-06 49.024999999999999p -3.0346039999999998e-06 49.037499999999994p -2.9480290000000001e-06 49.050000000000004p -2.857915e-06
+ 49.0625p -2.764362e-06 49.075000000000003p -2.6674769999999999e-06 49.087499999999999p -2.567369e-06 49.099999999999994p -2.4641510000000002e-06 49.112500000000004p -2.3579389999999999e-06 49.125p -2.2488559999999998e-06 49.137500000000003p -2.1370259999999999e-06 49.149999999999999p -2.0225749999999999e-06 49.162499999999994p -1.905636e-06 49.175000000000004p -1.786341e-06 49.1875p -1.6648290000000001e-06 49.200000000000003p -1.5412379999999999e-06 49.212499999999999p -1.4157099999999999e-06 49.225000000000001p -1.28839e-06 49.237499999999997p -1.1594240000000001e-06 49.25p -1.028962e-06 49.262500000000003p -8.9715160000000004e-07 49.274999999999999p -7.6414630000000005e-07
+ 49.287500000000001p -6.3009899999999998e-07 49.299999999999997p -4.9516410000000004e-07 49.3125p -3.594968e-07 49.325000000000003p -2.2325350000000001e-07 49.337499999999999p -8.6590929999999995e-08 49.350000000000001p 5.033365e-08 49.362499999999997p 1.873628e-07 49.375p 3.2433889999999998e-07 49.387500000000003p 4.6110480000000001e-07 49.399999999999999p 5.9750349999999999e-07 49.412500000000001p 7.3337860000000002e-07 49.424999999999997p 8.6857429999999998e-07 49.4375p 1.0029359999999999e-06 49.450000000000003p 1.1363100000000001e-06 49.462499999999999p 1.268545e-06 49.475000000000001p 1.399488e-06 49.487499999999997p 1.5289920000000001e-06 49.5p 1.656909e-06
+ 49.512500000000003p 1.783095e-06 49.524999999999999p 1.9074050000000001e-06 49.537500000000001p 2.029699e-06 49.549999999999997p 2.14984e-06 49.5625p 2.2676929999999999e-06 49.575000000000003p 2.3831239999999999e-06 49.587499999999999p 2.4960049999999998e-06 49.600000000000001p 2.6062090000000002e-06 49.612499999999997p 2.7136140000000001e-06 49.625p 2.8181000000000002e-06 49.637500000000003p 2.9195519999999999e-06 49.649999999999999p 3.017858e-06 49.662500000000001p 3.1129089999999999e-06 49.674999999999997p 3.2046030000000001e-06 49.6875p 3.2928379999999998e-06 49.700000000000003p 3.37752e-06 49.712499999999999p 3.4585570000000001e-06 49.725000000000001p 3.5358620000000001e-06
+ 49.737499999999997p 3.6093529999999999e-06 49.75p 3.678953e-06 49.762500000000003p 3.7445880000000002e-06 49.774999999999999p 3.806191e-06 49.787500000000001p 3.8636980000000003e-06 49.799999999999997p 3.9170510000000003e-06 49.8125p 3.9661970000000004e-06 49.825000000000003p 4.0110880000000001e-06 49.837499999999999p 4.0516789999999997e-06 49.850000000000001p 4.0879339999999999e-06 49.862499999999997p 4.1198199999999996e-06 49.875p 4.1473080000000003e-06 49.887500000000003p 4.1703760000000001e-06 49.899999999999999p 4.1890080000000003e-06 49.912500000000001p 4.2031910000000002e-06 49.924999999999997p 4.212918e-06 49.9375p 4.2181880000000002e-06 49.950000000000003p 4.2190039999999999e-06
+ 49.962499999999999p 4.2153750000000003e-06 49.975000000000001p 4.207316e-06 49.987499999999997p 4.1948449999999998e-06 50p 4.1779859999999997e-06 50.012499999999996p 4.1567689999999999e-06 50.025000000000006p 4.1312280000000003e-06 50.037500000000001p 4.1014030000000001e-06 50.049999999999997p 4.0673360000000002e-06 50.0625p 4.0290769999999997e-06 50.074999999999996p 3.9866799999999998e-06 50.087500000000006p 3.9402029999999999e-06 50.100000000000001p 3.8897089999999998e-06 50.112499999999997p 3.8352640000000002e-06 50.125p 3.77694e-06 50.137499999999996p 3.714814e-06 50.150000000000006p 3.6489649999999998e-06 50.162500000000001p 3.5794770000000002e-06 50.174999999999997p 3.506439e-06
+ 50.1875p 3.4299419999999999e-06 50.199999999999996p 3.3500819999999998e-06 50.212500000000006p 3.2669579999999999e-06 50.225000000000001p 3.180672e-06 50.237499999999997p 3.0913299999999999e-06 50.25p 2.9990419999999999e-06 50.262499999999996p 2.9039190000000002e-06 50.275000000000006p 2.8060750000000001e-06 50.287500000000001p 2.70563e-06 50.299999999999997p 2.6027009999999999e-06 50.3125p 2.497414e-06 50.324999999999996p 2.3898910000000002e-06 50.337499999999999p 2.2802589999999999e-06 50.350000000000001p 2.1686490000000002e-06 50.362500000000004p 2.0551890000000002e-06 50.375p 1.9400130000000002e-06 50.387499999999996p 1.823254e-06 50.399999999999999p 1.705046e-06
+ 50.412500000000001p 1.585526e-06 50.425000000000004p 1.4648309999999999e-06 50.4375p 1.3430980000000001e-06 50.449999999999996p 1.2204650000000001e-06 50.462499999999999p 1.0970710000000001e-06 50.475000000000001p 9.7305570000000008e-07 50.487500000000004p 8.4855719999999998e-07 50.5p 7.2371470000000002e-07 50.512499999999996p 5.9866680000000004e-07 50.524999999999999p 4.7355190000000001e-07 50.537500000000001p 3.4850770000000001e-07 50.550000000000004p 2.2367110000000001e-07 50.5625p 9.9178200000000001e-08 50.574999999999996p -2.4836010000000001e-08 50.587499999999999p -1.482377e-07 50.600000000000001p -2.7089460000000002e-07 50.612500000000004p -3.9267560000000002e-07 50.625p -5.1345160000000002e-07
+ 50.637499999999996p -6.3309519999999998e-07 50.649999999999999p -7.5148100000000003e-07 50.662500000000001p -8.6848550000000005e-07 50.675000000000004p -9.8398789999999996e-07 50.6875p -1.0978690000000001e-06 50.699999999999996p -1.210013e-06 50.712499999999999p -1.3203070000000001e-06 50.725000000000001p -1.428639e-06 50.737500000000004p -1.534902e-06 50.75p -1.63899e-06 50.762500000000003p -1.740802e-06 50.774999999999999p -1.840239e-06 50.787499999999994p -1.937206e-06 50.800000000000004p -2.0316109999999998e-06 50.8125p -2.1233660000000002e-06 50.825000000000003p -2.2123859999999998e-06 50.837499999999999p -2.2985889999999998e-06 50.849999999999994p -2.381898e-06
+ 50.862500000000004p -2.4622400000000002e-06 50.875p -2.5395450000000002e-06 50.887500000000003p -2.6137469999999999e-06 50.899999999999999p -2.6847849999999999e-06 50.912499999999994p -2.7526000000000001e-06 50.925000000000004p -2.8171399999999999e-06 50.9375p -2.8783539999999998e-06 50.950000000000003p -2.9361979999999999e-06 50.962499999999999p -2.9906300000000002e-06 50.974999999999994p -3.041613e-06 50.987500000000004p -3.0891159999999998e-06 51p -3.1331090000000002e-06 51.012500000000003p -3.1735690000000002e-06 51.024999999999999p -3.2104760000000002e-06 51.037499999999994p -3.2438140000000001e-06 51.050000000000004p -3.273572e-06 51.0625p -3.2997430000000001e-06 51.075000000000003p -3.3223240000000002e-06
+ 51.087499999999999p -3.3413169999999999e-06 51.100000000000001p -3.3567270000000001e-06 51.112499999999997p -3.3685649999999999e-06 51.125p -3.3768430000000001e-06 51.137500000000003p -3.3815810000000001e-06 51.149999999999999p -3.3827989999999998e-06 51.162500000000001p -3.3805239999999999e-06 51.174999999999997p -3.3747850000000001e-06 51.1875p -3.3656169999999998e-06 51.200000000000003p -3.3530560000000002e-06 51.212499999999999p -3.3371440000000001e-06 51.225000000000001p -3.3179250000000001e-06 51.237499999999997p -3.2954479999999999e-06 51.25p -3.2697650000000001e-06 51.262500000000003p -3.2409300000000002e-06 51.274999999999999p -3.2090020000000002e-06 51.287500000000001p -3.1740419999999999e-06 51.299999999999997p -3.1361150000000001e-06
+ 51.3125p -3.0952890000000002e-06 51.325000000000003p -3.051635e-06 51.337499999999999p -3.0052250000000001e-06 51.350000000000001p -2.9561349999999999e-06 51.362499999999997p -2.904444e-06 51.375p -2.8502330000000001e-06 51.387500000000003p -2.7935859999999999e-06 51.399999999999999p -2.7345869999999999e-06 51.412500000000001p -2.6733240000000001e-06 51.424999999999997p -2.6098859999999998e-06 51.4375p -2.5443649999999998e-06 51.450000000000003p -2.476854e-06 51.462499999999999p -2.4074469999999998e-06 51.475000000000001p -2.33624e-06 51.487499999999997p -2.2633309999999998e-06 51.5p -2.188817e-06 51.512500000000003p -2.1127990000000001e-06 51.524999999999999p -2.035377e-06
+ 51.537500000000001p -1.956651e-06 51.549999999999997p -1.876724e-06 51.5625p -1.795698e-06 51.575000000000003p -1.7136749999999999e-06 51.587499999999999p -1.6307590000000001e-06 51.600000000000001p -1.5470529999999999e-06 51.612499999999997p -1.4626589999999999e-06 51.625p -1.37768e-06 51.637500000000003p -1.292219e-06 51.649999999999999p -1.206378e-06 51.662500000000001p -1.120259e-06 51.674999999999997p -1.033963e-06 51.6875p -9.4758990000000004e-07 51.700000000000003p -8.6123880000000004e-07 51.712499999999999p -7.7500819999999998e-07 51.725000000000001p -6.8899529999999999e-07 51.737499999999997p -6.0329589999999996e-07 51.75p -5.1800469999999996e-07
+ 51.762500000000003p -4.3321460000000001e-07 51.774999999999999p -3.4901729999999998e-07 51.787500000000001p -2.6550240000000001e-07 51.799999999999997p -1.8275809999999999e-07 51.8125p -1.008706e-07 51.825000000000003p -1.9923940000000001e-08 51.837500000000006p 5.9999639999999999e-08 51.850000000000001p 1.3882020000000001e-07 51.862499999999997p 2.164599e-07 51.875p 2.9284340000000002e-07 51.887499999999996p 3.6789759999999998e-07 51.900000000000006p 4.4155189999999999e-07 51.912500000000001p 5.1373829999999997e-07 51.924999999999997p 5.8439129999999996e-07 51.9375p 6.5344800000000002e-07 51.949999999999996p 7.2084850000000001e-07 51.962500000000006p 7.8653539999999999e-07 51.975000000000001p 8.5045409999999999e-07
+ 51.987499999999997p 9.1255309999999997e-07 52p 9.7278360000000004e-07 52.012499999999996p 1.0311e-06 52.025000000000006p 1.0874590000000001e-06 52.037500000000001p 1.141821e-06 52.049999999999997p 1.194149e-06 52.0625p 1.24441e-06 52.074999999999996p 1.292573e-06 52.087500000000006p 1.338609e-06 52.100000000000001p 1.382495e-06 52.112499999999997p 1.4242099999999999e-06 52.125p 1.4637339999999999e-06 52.137499999999996p 1.5010520000000001e-06 52.150000000000006p 1.536152e-06 52.162500000000001p 1.569025e-06 52.174999999999997p 1.599665e-06 52.1875p 1.6280670000000001e-06 52.199999999999996p 1.654233e-06
+ 52.212499999999999p 1.678165e-06 52.225000000000001p 1.699869e-06 52.237500000000004p 1.7193519999999999e-06 52.25p 1.7366259999999999e-06 52.262499999999996p 1.7517060000000001e-06 52.274999999999999p 1.764608e-06 52.287500000000001p 1.7753519999999999e-06 52.300000000000004p 1.783961e-06 52.3125p 1.790458e-06 52.324999999999996p 1.794871e-06 52.337499999999999p 1.7972299999999999e-06 52.350000000000001p 1.7975670000000001e-06 52.362500000000004p 1.7959160000000001e-06 52.375p 1.792315e-06 52.387499999999996p 1.786801e-06 52.399999999999999p 1.7794169999999999e-06 52.412500000000001p 1.7702039999999999e-06 52.425000000000004p 1.759208e-06
+ 52.4375p 1.7464750000000001e-06 52.449999999999996p 1.7320549999999999e-06 52.462499999999999p 1.7159960000000001e-06 52.475000000000001p 1.6983520000000001e-06 52.487500000000004p 1.6791740000000001e-06 52.5p 1.6585179999999999e-06 52.512499999999996p 1.6364389999999999e-06 52.524999999999999p 1.6129949999999999e-06 52.537500000000001p 1.588244e-06 52.550000000000004p 1.562245e-06 52.5625p 1.535058e-06 52.574999999999996p 1.5067450000000001e-06 52.587499999999999p 1.477367e-06 52.600000000000001p 1.4469859999999999e-06 52.612500000000004p 1.4156649999999999e-06 52.625p 1.3834669999999999e-06 52.637500000000003p 1.3504569999999999e-06 52.649999999999999p 1.316698e-06
+ 52.662499999999994p 1.282254e-06 52.675000000000004p 1.247189e-06 52.6875p 1.2115669999999999e-06 52.700000000000003p 1.175452e-06 52.712499999999999p 1.138907e-06 52.724999999999994p 1.1019960000000001e-06 52.737500000000004p 1.0647820000000001e-06 52.75p 1.027327e-06 52.762500000000003p 9.8969190000000008e-07 52.774999999999999p 9.5193879999999997e-07 52.787499999999994p 9.1412749999999998e-07 52.800000000000004p 8.7631739999999999e-07 52.8125p 8.3856700000000005e-07 52.825000000000003p 8.0093369999999999e-07 52.837499999999999p 7.6347369999999997e-07 52.849999999999994p 7.2624220000000001e-07 52.862500000000004p 6.8929309999999997e-07 52.875p 6.5267890000000003e-07
+ 52.887500000000003p 6.1645079999999998e-07 52.899999999999999p 5.8065850000000002e-07 52.912499999999994p 5.4535030000000003e-07 52.925000000000004p 5.105727e-07 52.9375p 4.7637080000000001e-07 52.950000000000003p 4.4278780000000002e-07 52.962499999999999p 4.0986539999999999e-07 52.975000000000001p 3.7764329999999999e-07 52.987499999999997p 3.461596e-07 53p 3.1545020000000002e-07 53.012500000000003p 2.855495e-07 53.024999999999999p 2.5648960000000002e-07 53.037500000000001p 2.2830079999999999e-07 53.049999999999997p 2.0101139999999999e-07 53.0625p 1.746475e-07 53.075000000000003p 1.4923350000000001e-07 53.087499999999999p 1.247913e-07 53.100000000000001p 1.0134099999999999e-07
+ 53.112499999999997p 7.8900499999999999e-08 53.125p 5.7485609999999997e-08 53.137500000000003p 3.7110010000000003e-08 53.149999999999999p 1.778527e-08 53.162500000000001p -4.791612e-10 53.174999999999997p -1.767594e-08 53.1875p -3.379984e-08 53.200000000000003p -4.8847719999999998e-08 53.212499999999999p -6.2818519999999994e-08 53.225000000000001p -7.5713260000000001e-08 53.237499999999997p -8.7534980000000003e-08 53.25p -9.828877e-08 53.262500000000003p -1.079817e-07 53.274999999999999p -1.166228e-07 53.287500000000001p -1.2422299999999999e-07 53.299999999999997p -1.3079520000000001e-07 53.3125p -1.3635419999999999e-07 53.325000000000003p -1.4091640000000001e-07
+ 53.337499999999999p -1.4450030000000001e-07 53.350000000000001p -1.471259e-07 53.362499999999997p -1.4881490000000001e-07 53.375p -1.495907e-07 53.387500000000003p -1.4947840000000001e-07 53.399999999999999p -1.4850429999999999e-07 53.412500000000001p -1.4669649999999999e-07 53.424999999999997p -1.4408430000000001e-07 53.4375p -1.406984e-07 53.450000000000003p -1.3657100000000001e-07 53.462499999999999p -1.3173519999999999e-07 53.475000000000001p -1.262254e-07 53.487499999999997p -1.2007709999999999e-07 53.5p -1.133268e-07 53.512500000000003p -1.06012e-07 53.524999999999999p -9.8171030000000002e-08 53.537500000000001p -8.9843040000000005e-08 53.549999999999997p -8.1067909999999999e-08
+ 53.5625p -7.1886180000000004e-08 53.575000000000003p -6.2338979999999994e-08 53.587499999999999p -5.2467950000000001e-08 53.600000000000001p -4.2315159999999997e-08 53.612499999999997p -3.1923029999999997e-08 53.625p -2.1334270000000001e-08 53.637500000000003p -1.0591800000000001e-08 53.649999999999999p 2.613671e-10 53.662500000000001p 1.1182130000000001e-08 53.674999999999997p 2.2127430000000002e-08 53.6875p 3.3054320000000002e-08 53.700000000000003p 4.3920030000000002e-08 53.712500000000006p 5.4682030000000003e-08 53.725000000000001p 6.5298130000000002e-08 53.737499999999997p 7.5726549999999996e-08 53.75p 8.5925969999999995e-08 53.762499999999996p 9.5855639999999999e-08 53.775000000000006p 1.054754e-07
+ 53.787500000000001p 1.147458e-07 53.799999999999997p 1.2362820000000001e-07 53.8125p 1.320847e-07 53.824999999999996p 1.400782e-07 53.837500000000006p 1.4757280000000001e-07 53.850000000000001p 1.545336e-07 53.862499999999997p 1.6092639999999999e-07 53.875p 1.667186e-07 53.887499999999996p 1.7187850000000001e-07 53.900000000000006p 1.7637580000000001e-07 53.912500000000001p 1.8018140000000001e-07 53.924999999999997p 1.8326769999999999e-07 53.9375p 1.8560830000000001e-07 53.949999999999996p 1.8717840000000001e-07 53.962500000000006p 1.879545e-07 53.975000000000001p 1.87915e-07 53.987499999999997p 1.8703940000000001e-07 54p 1.8530919999999999e-07
+ 54.012499999999996p 1.827073e-07 54.025000000000006p 1.7921829999999999e-07 54.037500000000001p 1.7482870000000001e-07 54.049999999999997p 1.6952649999999999e-07 54.0625p 1.6330140000000001e-07 54.074999999999996p 1.5614520000000001e-07 54.087499999999999p 1.4805119999999999e-07 54.100000000000001p 1.3901449999999999e-07 54.112500000000004p 1.2903210000000001e-07 54.125p 1.181028e-07 54.137499999999996p 1.062274e-07 54.149999999999999p 9.3408159999999996e-08 54.162500000000001p 7.9649469999999998e-08 54.175000000000004p 6.4957439999999999e-08 54.1875p 4.934001e-08 54.199999999999996p 3.2806950000000001e-08 54.212499999999999p 1.536982e-08 54.225000000000001p -2.9580190000000002e-09
+ 54.237500000000004p -2.216144e-08 54.25p -4.222356e-08 54.262499999999996p -6.3125759999999995e-08 54.274999999999999p -8.4847719999999997e-08 54.287500000000001p -1.0736740000000001e-07 54.300000000000004p -1.3066119999999999e-07 54.3125p -1.547038e-07 54.324999999999996p -1.794684e-07 54.337499999999999p -2.0492650000000001e-07 54.350000000000001p -2.310482e-07 54.362500000000004p -2.5780219999999998e-07 54.375p -2.8515570000000001e-07 54.387499999999996p -3.1307440000000001e-07 54.399999999999999p -3.4152289999999999e-07 54.412500000000001p -3.7046440000000002e-07 54.425000000000004p -3.9986100000000001e-07 54.4375p -4.2967340000000001e-07 54.449999999999996p -4.5986139999999999e-07
+ 54.462499999999999p -4.9038360000000001e-07 54.475000000000001p -5.211977e-07 54.487500000000004p -5.522606e-07 54.5p -5.8352800000000004e-07 54.512500000000003p -6.1495499999999996e-07 54.524999999999999p -6.4649599999999997e-07 54.537499999999994p -6.7810459999999997e-07 54.550000000000004p -7.097339e-07 54.5625p -7.4133649999999995e-07 54.575000000000003p -7.7286430000000003e-07 54.587499999999999p -8.0426899999999996e-07 54.599999999999994p -8.3550200000000004e-07 54.612500000000004p -8.6651440000000002e-07 54.625p -8.9725709999999999e-07 54.637500000000003p -9.276807e-07 54.649999999999999p -9.5773629999999992e-07 54.662499999999994p -9.8737439999999995e-07 54.675000000000004p -1.0165459999999999e-06
+ 54.6875p -1.045202e-06 54.700000000000003p -1.073295e-06 54.712499999999999p -1.1007750000000001e-06 54.724999999999994p -1.1275950000000001e-06 54.737500000000004p -1.153707e-06 54.75p -1.179065e-06 54.762500000000003p -1.203622e-06 54.774999999999999p -1.2273329999999999e-06 54.787499999999994p -1.2501520000000001e-06 54.800000000000004p -1.272037e-06 54.8125p -1.2929430000000001e-06 54.825000000000003p -1.3128289999999999e-06 54.837499999999999p -1.3316540000000001e-06 54.850000000000001p -1.3493769999999999e-06 54.862499999999997p -1.3659600000000001e-06 54.875p -1.3813649999999999e-06 54.887500000000003p -1.3955560000000001e-06 54.899999999999999p -1.4084980000000001e-06
+ 54.912500000000001p -1.4201570000000001e-06 54.924999999999997p -1.4305009999999999e-06 54.9375p -1.4394989999999999e-06 54.950000000000003p -1.4471220000000001e-06 54.962499999999999p -1.453343e-06 54.975000000000001p -1.458136e-06 54.987499999999997p -1.4614750000000001e-06 55p -1.4633400000000001e-06 55.012500000000003p -1.4637090000000001e-06 55.024999999999999p -1.462563e-06 55.037500000000001p -1.459885e-06 55.049999999999997p -1.4556600000000001e-06 55.0625p -1.449874e-06 55.075000000000003p -1.442517e-06 55.087499999999999p -1.4335779999999999e-06 55.100000000000001p -1.4230509999999999e-06 55.112499999999997p -1.4109290000000001e-06 55.125p -1.397209e-06
+ 55.137500000000003p -1.38189e-06 55.149999999999999p -1.3649729999999999e-06 55.162500000000001p -1.3464590000000001e-06 55.174999999999997p -1.3263539999999999e-06 55.1875p -1.3046650000000001e-06 55.200000000000003p -1.2813990000000001e-06 55.212499999999999p -1.256569e-06 55.225000000000001p -1.2301869999999999e-06 55.237499999999997p -1.2022670000000001e-06 55.25p -1.1728269999999999e-06 55.262500000000003p -1.1418860000000001e-06 55.274999999999999p -1.109464e-06 55.287500000000001p -1.075586e-06 55.299999999999997p -1.040275e-06 55.3125p -1.0035579999999999e-06 55.325000000000003p -9.6546420000000006e-07 55.337499999999999p -9.2602450000000005e-07 55.350000000000001p -8.8527110000000001e-07
+ 55.362499999999997p -8.4323830000000005e-07 55.375p -7.9996219999999996e-07 55.387500000000003p -7.5548060000000004e-07 55.399999999999999p -7.0983309999999997e-07 55.412500000000001p -6.6306080000000005e-07 55.424999999999997p -6.1520639999999998e-07 55.4375p -5.6631440000000002e-07 55.450000000000003p -5.1643059999999998e-07 55.462499999999999p -4.6560230000000002e-07 55.475000000000001p -4.1387819999999998e-07 55.487499999999997p -3.6130840000000002e-07 55.5p -3.0794409999999999e-07 55.512500000000003p -2.5383809999999999e-07 55.524999999999999p -1.9904410000000001e-07 55.537500000000001p -1.4361689999999999e-07 55.549999999999997p -8.7612390000000003e-08 55.5625p -3.108748e-08 55.575000000000003p 2.590005e-08
+ 55.587500000000006p 8.3291580000000001e-08 55.600000000000001p 1.4102770000000001e-07 55.612499999999997p 1.9904839999999999e-07 55.625p 2.5729279999999999e-07 55.637499999999996p 3.1569980000000002e-07 55.650000000000006p 3.742075e-07 55.662500000000001p 4.3275379999999997e-07 55.674999999999997p 4.9127620000000002e-07 55.6875p 5.4971200000000002e-07 55.699999999999996p 6.0799819999999997e-07 55.712500000000006p 6.6607170000000001e-07 55.725000000000001p 7.2386960000000001e-07 55.737499999999997p 7.8132869999999997e-07 55.75p 8.3838620000000001e-07 55.762499999999996p 8.9497929999999999e-07 55.775000000000006p 9.5104569999999995e-07 55.787500000000001p 1.006523e-06 55.799999999999997p 1.06135e-06
+ 55.8125p 1.1154660000000001e-06 55.824999999999996p 1.168809e-06 55.837500000000006p 1.221321e-06 55.850000000000001p 1.27294e-06 55.862499999999997p 1.323611e-06 55.875p 1.373274e-06 55.887499999999996p 1.421873e-06 55.899999999999999p 1.469353e-06 55.912500000000001p 1.5156590000000001e-06 55.924999999999997p 1.5607379999999999e-06 55.9375p 1.604537e-06 55.949999999999996p 1.647006e-06 55.962499999999999p 1.6880950000000001e-06 55.975000000000001p 1.7277560000000001e-06 55.987500000000004p 1.765943e-06 56p 1.8026089999999999e-06 56.012499999999996p 1.8377119999999999e-06 56.024999999999999p 1.871209e-06
+ 56.037500000000001p 1.90306e-06 56.050000000000004p 1.9332270000000001e-06 56.0625p 1.9616719999999999e-06 56.074999999999996p 1.9883609999999999e-06 56.087499999999999p 2.01326e-06 56.100000000000001p 2.0363380000000001e-06 56.112500000000004p 2.0575650000000001e-06 56.125p 2.0769150000000002e-06 56.137499999999996p 2.094362e-06 56.149999999999999p 2.1098819999999998e-06 56.162500000000001p 2.1234549999999999e-06 56.175000000000004p 2.1350599999999998e-06 56.1875p 2.1446819999999999e-06 56.199999999999996p 2.1523039999999998e-06 56.212499999999999p 2.1579149999999999e-06 56.225000000000001p 2.1615029999999998e-06 56.237500000000004p 2.1630610000000001e-06 56.25p 2.162581e-06
+ 56.262499999999996p 2.1600609999999998e-06 56.274999999999999p 2.1554979999999999e-06 56.287500000000001p 2.1488920000000001e-06 56.300000000000004p 2.1402459999999999e-06 56.3125p 2.129565e-06 56.324999999999996p 2.1168569999999999e-06 56.337499999999999p 2.1021289999999999e-06 56.350000000000001p 2.085395e-06 56.362500000000004p 2.066666e-06 56.375p 2.0459600000000001e-06 56.387500000000003p 2.0232930000000002e-06 56.399999999999999p 1.9986860000000001e-06 56.412499999999994p 1.9721620000000002e-06 56.425000000000004p 1.9437429999999998e-06 56.4375p 1.9134580000000001e-06 56.450000000000003p 1.8813319999999999e-06 56.462499999999999p 1.847398e-06 56.474999999999994p 1.811687e-06
+ 56.487500000000004p 1.774234e-06 56.5p 1.735073e-06 56.512500000000003p 1.694244e-06 56.524999999999999p 1.651785e-06 56.537499999999994p 1.6077380000000001e-06 56.550000000000004p 1.5621470000000001e-06 56.5625p 1.5150539999999999e-06 56.575000000000003p 1.4665080000000001e-06 56.587499999999999p 1.416556e-06 56.599999999999994p 1.3652460000000001e-06 56.612500000000004p 1.3126309999999999e-06 56.625p 1.2587609999999999e-06 56.637500000000003p 1.2036899999999999e-06 56.649999999999999p 1.1474729999999999e-06 56.662499999999994p 1.0901660000000001e-06 56.675000000000004p 1.0318250000000001e-06 56.6875p 9.7250930000000007e-07 56.700000000000003p 9.1227689999999999e-07
+ 56.712499999999999p 8.5118799999999999e-07 56.725000000000001p 7.893035e-07 56.737499999999997p 7.2668479999999999e-07 56.75p 6.6339439999999999e-07 56.762500000000003p 5.9949500000000001e-07 56.774999999999999p 5.3505019999999995e-07 56.787500000000001p 4.7012399999999998e-07 56.799999999999997p 4.0478089999999998e-07 56.8125p 3.3908570000000002e-07 56.825000000000003p 2.7310339999999998e-07 56.837499999999999p 2.068994e-07 56.850000000000001p 1.405392e-07 56.862499999999997p 7.408814e-08 56.875p 7.6118900000000003e-09 56.887500000000003p -5.8824149999999999e-08 56.899999999999999p -1.2515470000000001e-07 56.912500000000001p -1.9131459999999999e-07 56.924999999999997p -2.572392e-07
+ 56.9375p -3.2286400000000002e-07 56.950000000000003p -3.881249e-07 56.962499999999999p -4.529586e-07 56.975000000000001p -5.173021e-07 56.987499999999997p -5.8109299999999995e-07 57p -6.4426989999999999e-07 57.012500000000003p -7.0677189999999998e-07 57.024999999999999p -7.6853909999999999e-07 57.037500000000001p -8.295123e-07 57.049999999999997p -8.896335e-07 57.0625p -9.4884559999999995e-07 57.075000000000003p -1.0070920000000001e-06 57.087499999999999p -1.064319e-06 57.100000000000001p -1.120473e-06 57.112499999999997p -1.1755e-06 57.125p -1.2293499999999999e-06 57.137500000000003p -1.2819730000000001e-06 57.149999999999999p -1.333321e-06
+ 57.162500000000001p -1.383347e-06 57.174999999999997p -1.4320049999999999e-06 57.1875p -1.4792519999999999e-06 57.200000000000003p -1.525046e-06 57.212499999999999p -1.5693449999999999e-06 57.225000000000001p -1.6121119999999999e-06 57.237499999999997p -1.6533079999999999e-06 57.25p -1.6928980000000001e-06 57.262500000000003p -1.7308499999999999e-06 57.274999999999999p -1.7671289999999999e-06 57.287500000000001p -1.8017080000000001e-06 57.299999999999997p -1.8345570000000001e-06 57.3125p -1.8656500000000001e-06 57.325000000000003p -1.8949630000000001e-06 57.337499999999999p -1.9224739999999999e-06 57.350000000000001p -1.9481609999999998e-06 57.362499999999997p -1.9720069999999999e-06 57.375p -1.9939940000000001e-06
+ 57.387500000000003p -2.0141080000000001e-06 57.399999999999999p -2.032337e-06 57.412500000000001p -2.0486690000000002e-06 57.424999999999997p -2.0630960000000001e-06 57.4375p -2.075612e-06 57.450000000000003p -2.0862119999999999e-06 57.462500000000006p -2.0948930000000001e-06 57.475000000000001p -2.1016540000000001e-06 57.487499999999997p -2.1064970000000002e-06 57.5p -2.1094250000000001e-06 57.512499999999996p -2.1104429999999999e-06 57.525000000000006p -2.1095580000000002e-06 57.537500000000001p -2.1067800000000002e-06 57.549999999999997p -2.1021190000000001e-06 57.5625p -2.095588e-06 57.574999999999996p -2.0872020000000002e-06 57.587500000000006p -2.076978e-06 57.600000000000001p -2.064934e-06
+ 57.612499999999997p -2.0510890000000001e-06 57.625p -2.0354660000000002e-06 57.637499999999996p -2.0180879999999999e-06 57.650000000000006p -1.9989809999999999e-06 57.662500000000001p -1.9781709999999998e-06 57.674999999999997p -1.9556879999999998e-06 57.6875p -1.93156e-06 57.699999999999996p -1.9058189999999999e-06 57.712500000000006p -1.8784990000000001e-06 57.725000000000001p -1.8496339999999999e-06 57.737499999999997p -1.8192600000000001e-06 57.75p -1.787414e-06 57.762499999999996p -1.7541339999999999e-06 57.774999999999999p -1.71946e-06 57.787500000000001p -1.6834339999999999e-06 57.799999999999997p -1.6460969999999999e-06 57.8125p -1.607491e-06 57.824999999999996p -1.5676630000000001e-06
+ 57.837499999999999p -1.526656e-06 57.850000000000001p -1.484516e-06 57.862500000000004p -1.441291e-06 57.875p -1.3970280000000001e-06 57.887499999999996p -1.3517760000000001e-06 57.899999999999999p -1.305584e-06 57.912500000000001p -1.2585019999999999e-06 57.925000000000004p -1.210579e-06 57.9375p -1.161868e-06 57.949999999999996p -1.112419e-06 57.962499999999999p -1.062284e-06 57.975000000000001p -1.011515e-06 57.987500000000004p -9.601651999999999e-07 58p -9.0828619999999997e-07 58.012499999999996p -8.5593100000000004e-07 58.024999999999999p -8.0315270000000004e-07 58.037500000000001p -7.5000389999999998e-07 58.050000000000004p -6.9653769999999998e-07
+ 58.0625p -6.4280689999999995e-07 58.074999999999996p -5.8886400000000005e-07 58.087499999999999p -5.3476170000000003e-07 58.100000000000001p -4.8055209999999999e-07 58.112500000000004p -4.262872e-07 58.125p -3.7201870000000001e-07 58.137499999999996p -3.1779759999999998e-07 58.149999999999999p -2.6367480000000003e-07 58.162500000000001p -2.097004e-07 58.175000000000004p -1.5592410000000001e-07 58.1875p -1.0239490000000001e-07 58.199999999999996p -4.9161269999999999e-08 58.212499999999991p 3.729203e-09 58.225000000000001p 5.6229590000000003e-08 58.237500000000004p 1.0829380000000001e-07 58.250000000000007p 1.5987650000000001e-07 58.262499999999996p 2.109334e-07 58.274999999999999p 2.61421e-07
+ 58.287500000000001p 3.1129679999999997e-07 58.299999999999997p 3.605194e-07 58.3125p 4.0904839999999999e-07 58.325000000000003p 4.5684439999999998e-07 58.337499999999991p 5.0386920000000003e-07 58.349999999999994p 5.5008570000000004e-07 58.362500000000004p 5.9545799999999996e-07 58.375000000000007p 6.3995140000000001e-07 58.387499999999996p 6.835324e-07 58.399999999999999p 7.2616889999999998e-07 58.412500000000001p 7.6782990000000002e-07 58.424999999999997p 8.0848580000000002e-07 58.4375p 8.4810830000000002e-07 58.450000000000003p 8.8667040000000001e-07 58.462500000000006p 9.2414660000000003e-07 58.474999999999994p 9.6051249999999998e-07 58.487500000000004p 9.9574549999999993e-07 58.500000000000007p 1.0298240000000001e-06
+ 58.512499999999996p 1.0627279999999999e-06 58.524999999999999p 1.0944390000000001e-06 58.537500000000001p 1.1249400000000001e-06 58.549999999999997p 1.1542150000000001e-06 58.5625p 1.182249e-06 58.575000000000003p 1.20903e-06 58.587500000000006p 1.234547e-06 58.599999999999994p 1.258789e-06 58.612499999999997p 1.281747e-06 58.625000000000007p 1.3034150000000001e-06 58.637499999999996p 1.323787e-06 58.649999999999999p 1.342858e-06 58.662500000000001p 1.360625e-06 58.674999999999997p 1.377087e-06 58.6875p 1.3922429999999999e-06 58.700000000000003p 1.406094e-06 58.712500000000006p 1.418644e-06 58.724999999999994p 1.4298949999999999e-06
+ 58.737499999999997p 1.4398529999999999e-06 58.750000000000007p 1.448524e-06 58.762499999999996p 1.4559150000000001e-06 58.774999999999999p 1.4620360000000001e-06 58.787500000000001p 1.466895e-06 58.800000000000004p 1.4705050000000001e-06 58.8125p 1.4728779999999999e-06 58.825000000000003p 1.4740270000000001e-06 58.837500000000006p 1.4739659999999999e-06 58.849999999999994p 1.472711e-06 58.862499999999997p 1.470279e-06 58.875p 1.4666859999999999e-06 58.887499999999996p 1.4619529999999999e-06 58.899999999999999p 1.4560980000000001e-06 58.912500000000001p 1.4491410000000001e-06 58.925000000000004p 1.4411029999999999e-06 58.9375p 1.432008e-06 58.950000000000003p 1.4218760000000001e-06
+ 58.962500000000006p 1.410733e-06 58.974999999999994p 1.3986020000000001e-06 58.987499999999997p 1.3855079999999999e-06 59p 1.3714760000000001e-06 59.012499999999996p 1.3565329999999999e-06 59.024999999999999p 1.3407060000000001e-06 59.037500000000001p 1.3240210000000001e-06 59.050000000000004p 1.3065060000000001e-06 59.062499999999993p 1.2881889999999999e-06 59.075000000000003p 1.269099e-06 59.087500000000006p 1.2492649999999999e-06 59.099999999999994p 1.228716e-06 59.112499999999997p 1.20748e-06 59.125p 1.185588e-06 59.13750000000001p 1.1630699999999999e-06 59.149999999999999p 1.1399549999999999e-06 59.162500000000001p 1.1162739999999999e-06 59.175000000000004p 1.092057e-06
+ 59.187499999999993p 1.067333e-06 59.200000000000003p 1.042134e-06 59.212500000000006p 1.016489e-06 59.224999999999994p 9.9042890000000009e-07 59.237499999999997p 9.6398299999999996e-07 59.25p 9.3718139999999997e-07 59.262500000000003p 9.1005379999999999e-07 59.274999999999999p 8.8262969999999998e-07 59.287500000000001p 8.5493820000000004e-07 59.300000000000004p 8.2700839999999996e-07 59.312499999999993p 7.9886879999999999e-07 59.325000000000003p 7.705477e-07 59.337500000000006p 7.4207299999999995e-07 59.349999999999994p 7.1347230000000003e-07 59.362499999999997p 6.8477269999999996e-07 59.375p 6.5600090000000003e-07 59.387500000000003p 6.2718290000000002e-07 59.399999999999999p 5.9834450000000001e-07
+ 59.412500000000001p 5.6951080000000001e-07 59.425000000000004p 5.4070639999999999e-07 59.437499999999993p 5.1195540000000003e-07 59.449999999999996p 4.8328110000000004e-07 59.462500000000006p 4.5470649999999998e-07 59.474999999999994p 4.2625359999999998e-07 59.487499999999997p 3.9794420000000002e-07 59.5p 3.6979900000000001e-07 59.512500000000003p 3.4183830000000002e-07 59.524999999999999p 3.140816e-07 59.537500000000001p 2.865478e-07 59.550000000000004p 2.5925499999999997e-07 59.562499999999993p 2.322207e-07 59.574999999999996p 2.0546140000000001e-07 59.587500000000006p 1.789933e-07 59.600000000000009p 1.528313e-07 59.612499999999997p 1.2699009999999999e-07 59.625p 1.014834e-07
+ 59.637500000000003p 7.6324049999999998e-08 59.649999999999999p 5.1524329999999998e-08 59.662500000000001p 2.709569e-08 59.675000000000004p 3.048822e-09 59.687499999999993p -2.0606299999999999e-08 59.699999999999996p -4.3860479999999998e-08 59.712499999999999p -6.6705239999999998e-08 59.725000000000009p -8.9132860000000003e-08 59.737499999999997p -1.111363e-07 59.75p -1.327094e-07 59.762500000000003p -1.5384640000000001e-07 59.774999999999999p -1.7454260000000001e-07 59.787500000000001p -1.9479380000000001e-07 59.800000000000004p -2.1459639999999999e-07 59.812499999999993p -2.339477e-07 59.824999999999996p -2.5284560000000002e-07 59.837499999999999p -2.7128840000000001e-07 59.850000000000009p -2.892753e-07
+ 59.862499999999997p -3.0680599999999997e-07 59.875p -3.2388089999999999e-07 59.887500000000003p -3.405008e-07 59.899999999999991p -3.5666719999999998e-07 59.912500000000001p -3.7238200000000001e-07 59.925000000000004p -3.8764790000000001e-07 59.937500000000007p -4.024677e-07 59.949999999999996p -4.1684509999999999e-07 59.962499999999999p -4.3078390000000001e-07 59.975000000000001p -4.4428860000000002e-07 59.987499999999997p -4.5736400000000002e-07 60p -4.7001530000000002e-07 60.012500000000003p -4.8224810000000001e-07 60.024999999999991p -4.940684e-07 60.037500000000001p -5.0548250000000001e-07 60.050000000000004p -5.1649679999999999e-07 60.062500000000007p -5.271183e-07 60.074999999999996p -5.3735420000000002e-07
+ 60.087499999999999p -5.4721170000000001e-07 60.100000000000001p -5.5669849999999996e-07 60.112499999999997p -5.6582239999999999e-07 60.125p -5.7459109999999998e-07 60.137500000000003p -5.8301289999999996e-07 60.149999999999991p -5.9109600000000004e-07 60.162499999999994p -5.9884849999999995e-07 60.175000000000004p -6.0627899999999997e-07 60.187500000000007p -6.1339569999999999e-07 60.199999999999996p -6.2020719999999997e-07 60.212499999999999p -6.267219e-07 60.225000000000001p -6.3294820000000005e-07 60.237499999999997p -6.3889449999999999e-07 60.25p -6.4456920000000002e-07 60.262500000000003p -6.4998059999999995e-07 60.275000000000006p -6.5513670000000002e-07 60.287499999999994p -6.6004559999999996e-07 60.300000000000004p -6.6471529999999998e-07
+ 60.312500000000007p -6.6915349999999997e-07 60.324999999999996p -6.7336779999999996e-07 60.337499999999999p -6.7736540000000003e-07 60.350000000000001p -6.8115370000000001e-07 60.362499999999997p -6.8473959999999995e-07 60.375p -6.8812969999999998e-07 60.387500000000003p -6.9133059999999999e-07 60.400000000000006p -6.9434830000000005e-07 60.412499999999994p -6.9718890000000004e-07 60.425000000000004p -6.9985790000000003e-07 60.437500000000007p -7.0236050000000001e-07 60.449999999999996p -7.0470190000000001e-07 60.462499999999999p -7.0688659999999995e-07 60.475000000000001p -7.08919e-07 60.487499999999997p -7.1080300000000002e-07 60.5p -7.1254229999999998e-07 60.512500000000003p -7.1414009999999995e-07 60.525000000000006p -7.1559929999999998e-07
+ 60.537499999999994p -7.1692240000000001e-07 60.549999999999997p -7.181116e-07 60.562500000000007p -7.191687e-07 60.574999999999996p -7.2009499999999996e-07 60.587499999999999p -7.2089159999999997e-07 60.600000000000001p -7.2155900000000004e-07 60.612499999999997p -7.2209749999999997e-07 60.625p -7.2250700000000005e-07 60.637500000000003p -7.2278700000000005e-07 60.650000000000006p -7.2293659999999999e-07 60.662499999999994p -7.2295450000000002e-07 60.674999999999997p -7.2283910000000005e-07 60.687500000000007p -7.2258829999999999e-07 60.699999999999996p -7.221999e-07 60.712499999999999p -7.2167120000000004e-07 60.725000000000001p -7.2099900000000004e-07 60.737500000000004p -7.2018010000000003e-07 60.75p -7.1921069999999999e-07
+ 60.762500000000003p -7.1808689999999997e-07 60.775000000000006p -7.1680429999999999e-07 60.787499999999994p -7.1535840000000004e-07 60.799999999999997p -7.1374419999999997e-07 60.8125p -7.1195660000000003e-07 60.824999999999996p -7.099902e-07 60.837499999999999p -7.0783949999999995e-07 60.850000000000001p -7.0549839999999998e-07 60.862500000000004p -7.0296110000000001e-07 60.875p -7.0022120000000002e-07 60.887500000000003p -6.9727240000000002e-07 60.900000000000006p -6.9410790000000002e-07 60.912499999999994p -6.9072120000000005e-07 60.924999999999997p -6.8710539999999995e-07 60.9375p -6.8325340000000003e-07 60.949999999999996p -6.7915830000000003e-07 60.962499999999999p -6.7481300000000002e-07 60.975000000000001p -6.7021039999999999e-07
+ 60.987500000000004p -6.6534309999999997e-07 60.999999999999993p -6.6020409999999999e-07 61.012500000000003p -6.5478619999999998e-07 61.025000000000006p -6.4908210000000003e-07 61.037499999999994p -6.430849e-07 61.049999999999997p -6.3678740000000002e-07 61.0625p -6.3018279999999999e-07 61.075000000000003p -6.2326419999999997e-07 61.087499999999999p -6.1602479999999997e-07 61.100000000000001p -6.0845819999999997e-07 61.112500000000004p -6.0055800000000002e-07 61.124999999999993p -5.9231789999999995e-07 61.137500000000003p -5.8373209999999999e-07 61.150000000000006p -5.7479459999999998e-07 61.162499999999994p -5.6550009999999997e-07 61.174999999999997p -5.5584329999999999e-07 61.1875p -5.4581929999999995e-07 61.200000000000003p -5.3542339999999996e-07
+ 61.212499999999999p -5.2465120000000004e-07 61.225000000000001p -5.1349889999999997e-07 61.237500000000004p -5.0196279999999997e-07 61.249999999999993p -4.9003960000000004e-07 61.262499999999996p -4.7772649999999999e-07 61.275000000000006p -4.6502109999999998e-07 61.287499999999994p -4.5192129999999999e-07 61.299999999999997p -4.3842550000000002e-07 61.3125p -4.2453260000000001e-07 61.325000000000003p -4.10242e-07 61.337499999999999p -3.9555340000000002e-07 61.350000000000001p -3.8046709999999998e-07 61.362500000000004p -3.6498399999999998e-07 61.374999999999993p -3.4910529999999998e-07 61.387499999999996p -3.3283289999999998e-07 61.400000000000006p -3.1616910000000002e-07 61.412500000000009p -2.9911690000000003e-07 61.424999999999997p -2.8167969999999999e-07
+ 61.4375p -2.6386150000000002e-07 61.450000000000003p -2.4566679999999999e-07 61.462499999999999p -2.271009e-07 61.475000000000001p -2.0816940000000001e-07 61.487500000000004p -1.888787e-07 61.499999999999993p -1.6923550000000001e-07 61.512499999999996p -1.4924729999999999e-07 61.524999999999999p -1.2892209999999999e-07 61.537500000000009p -1.0826860000000001e-07 61.549999999999997p -8.7295890000000001e-08 61.5625p -6.6013739999999995e-08 61.575000000000003p -4.4432499999999998e-08 61.587499999999999p -2.2563070000000001e-08 61.600000000000001p -4.169218e-10 61.612500000000004p 2.1993909999999999e-08 61.624999999999993p 4.465683e-08 61.637499999999996p 6.7558690000000003e-08 61.649999999999999p 9.0685830000000001e-08
+ 61.662500000000009p 1.14024e-07 61.674999999999997p 1.3755850000000001e-07 61.6875p 1.6127410000000001e-07 61.700000000000003p 1.8515499999999999e-07 61.712499999999991p 2.09185e-07 61.725000000000001p 2.333474e-07 61.737500000000004p 2.5762499999999998e-07 61.749999999999993p 2.8200029999999999e-07 61.762499999999996p 3.0645499999999997e-07 61.774999999999999p 3.3097089999999999e-07 61.787500000000009p 3.5552899999999998e-07 61.799999999999997p 3.8011010000000003e-07 61.8125p 4.0469460000000002e-07 61.825000000000003p 4.2926259999999998e-07 61.837499999999991p 4.5379380000000001e-07 61.850000000000001p 4.7826769999999998e-07 61.862500000000004p 5.0266350000000002e-07 61.875000000000007p 5.2695990000000001e-07
+ 61.887499999999996p 5.5113579999999996e-07 61.899999999999999p 5.7516950000000002e-07 61.912500000000001p 5.9903939999999999e-07 61.924999999999997p 6.2272339999999995e-07 61.9375p 6.4619970000000003e-07 61.950000000000003p 6.6944610000000004e-07 61.962499999999991p 6.9244019999999996e-07 61.975000000000001p 7.1515980000000002e-07 61.987500000000004p 7.3758260000000003e-07 62.000000000000007p 7.5968609999999998e-07 62.012499999999996p 7.8144810000000004e-07 62.024999999999999p 8.0284610000000001e-07 62.037500000000001p 8.2385799999999996e-07 62.049999999999997p 8.4446159999999996e-07 62.0625p 8.6463479999999998e-07 62.075000000000003p 8.8435580000000002e-07 62.087499999999991p 9.0360289999999995e-07 62.099999999999994p 9.2235449999999996e-07
+ 62.112500000000004p 9.4058920000000004e-07 62.125000000000007p 9.5828619999999991e-07 62.137499999999996p 9.754246000000001e-07 62.149999999999999p 9.9198399999999997e-07 62.162500000000001p 1.0079440000000001e-06 62.174999999999997p 1.023286e-06 62.1875p 1.037989e-06 62.200000000000003p 1.0520339999999999e-06 62.212500000000006p 1.0654039999999999e-06 62.224999999999994p 1.078081e-06 62.237500000000004p 1.0900459999999999e-06 62.250000000000007p 1.1012820000000001e-06 62.262499999999996p 1.111774e-06 62.274999999999999p 1.1215040000000001e-06 62.287500000000001p 1.1304579999999999e-06 62.299999999999997p 1.138622e-06 62.3125p 1.145979e-06 62.325000000000003p 1.1525190000000001e-06
+ 62.337500000000006p 1.1582260000000001e-06 62.349999999999994p 1.1630900000000001e-06 62.362499999999997p 1.167099e-06 62.375000000000007p 1.1702419999999999e-06 62.387499999999996p 1.172509e-06 62.399999999999999p 1.1738910000000001e-06 62.412500000000001p 1.174379e-06 62.424999999999997p 1.173966e-06 62.4375p 1.172646e-06 62.450000000000003p 1.1704109999999999e-06 62.462500000000006p 1.1672569999999999e-06 62.474999999999994p 1.16318e-06 62.487499999999997p 1.1581749999999999e-06 62.500000000000007p 1.152241e-06 62.512499999999996p 1.1453760000000001e-06 62.524999999999999p 1.1375779999999999e-06 62.537500000000001p 1.1288479999999999e-06 62.550000000000004p 1.1191870000000001e-06
+ 62.5625p 1.108597e-06 62.575000000000003p 1.0970790000000001e-06 62.587500000000006p 1.0846379999999999e-06 62.599999999999994p 1.0712790000000001e-06 62.612499999999997p 1.057007e-06 62.625p 1.0418280000000001e-06 62.637499999999996p 1.0257490000000001e-06 62.649999999999999p 1.008779e-06 62.662500000000001p 9.9092709999999996e-07 62.675000000000004p 9.7220270000000004e-07 62.6875p 9.5261689999999999e-07 62.700000000000003p 9.3218149999999996e-07 62.712500000000006p 9.1090910000000001e-07 62.724999999999994p 8.8881330000000004e-07 62.737499999999997p 8.6590840000000002e-07 62.75p 8.4220969999999999e-07 62.762499999999996p 8.1773319999999997e-07 62.774999999999999p 7.9249600000000003e-07
+ 62.787500000000001p 7.6651560000000004e-07 62.800000000000004p 7.3981060000000001e-07 62.812499999999993p 7.1240040000000002e-07 62.825000000000003p 6.8430490000000005e-07 62.837500000000006p 6.5554510000000003e-07 62.849999999999994p 6.2614259999999998e-07 62.862499999999997p 5.9611950000000001e-07 62.875p 5.6549889999999996e-07 62.88750000000001p 5.3430450000000003e-07 62.899999999999999p 5.0256050000000004e-07 62.912500000000001p 4.7029200000000001e-07 62.925000000000004p 4.3752439999999999e-07 62.937499999999993p 4.0428389999999998e-07 62.950000000000003p 3.705972e-07 62.962500000000006p 3.364916e-07 62.974999999999994p 3.0199480000000001e-07 62.987499999999997p 2.6713500000000002e-07 63p 2.3194090000000001e-07
+ 63.012500000000003p 1.9644160000000001e-07 63.024999999999999p 1.6066669999999999e-07 63.037500000000001p 1.2464599999999999e-07 63.050000000000004p 8.8409860000000004e-08 63.062499999999993p 5.1988709999999997e-08 63.075000000000003p 1.5413419999999999e-08 63.087500000000006p -2.1284909999999999e-08 63.099999999999994p -5.8074989999999999e-08 63.112499999999997p -9.4925300000000001e-08 63.125p -1.3180419999999999e-07 63.137500000000003p -1.6867990000000001e-07 63.149999999999999p -2.0552049999999999e-07 63.162500000000001p -2.4229399999999999e-07 63.175000000000004p -2.7896849999999997e-07 63.187499999999993p -3.1551190000000001e-07 63.199999999999996p -3.5189239999999998e-07 63.212500000000006p -3.8807800000000002e-07 63.224999999999994p -4.2403690000000001e-07
+ 63.237499999999997p -4.597375e-07 63.25p -4.9514819999999997e-07 63.262500000000003p -5.3023769999999998e-07 63.274999999999999p -5.6497500000000004e-07 63.287500000000001p -5.9932910000000002e-07 63.300000000000004p -6.3326959999999998e-07 63.312499999999993p -6.6676609999999997e-07 63.324999999999996p -6.9978890000000003e-07 63.337500000000006p -7.323083e-07 63.350000000000009p -7.6429530000000003e-07 63.362499999999997p -7.9572119999999999e-07 63.375p -8.2655790000000002e-07 63.387500000000003p -8.5677750000000001e-07 63.399999999999999p -8.8635299999999997e-07 63.412500000000001p -9.1525759999999998e-07 63.425000000000004p -9.4346540000000001e-07 63.437499999999993p -9.7095090000000008e-07 63.449999999999996p -9.9768929999999993e-07
+ 63.462499999999999p -1.0236560000000001e-06 63.475000000000009p -1.048829e-06 63.487499999999997p -1.0731839999999999e-06 63.5p -1.096699e-06 63.512500000000003p -1.119354e-06 63.524999999999999p -1.1411270000000001e-06 63.537500000000001p -1.161999e-06 63.550000000000004p -1.181951e-06 63.562499999999993p -1.2009649999999999e-06 63.574999999999996p -1.2190239999999999e-06 63.587499999999999p -1.236111e-06 63.600000000000009p -1.2522099999999999e-06 63.612499999999997p -1.267309e-06 63.625p -1.2813910000000001e-06 63.637500000000003p -1.294446e-06 63.649999999999991p -1.3064600000000001e-06 63.662500000000001p -1.3174239999999999e-06 63.675000000000004p -1.3273270000000001e-06
+ 63.687500000000007p -1.336161e-06 63.699999999999996p -1.343917e-06 63.712499999999999p -1.3505879999999999e-06 63.725000000000001p -1.356169e-06 63.737499999999997p -1.3606539999999999e-06 63.75p -1.3640410000000001e-06 63.762500000000003p -1.366325e-06 63.774999999999991p -1.3675039999999999e-06 63.787500000000001p -1.3675790000000001e-06 63.800000000000004p -1.366548e-06 63.812500000000007p -1.364413e-06 63.824999999999996p -1.361177e-06 63.837499999999999p -1.356842e-06 63.850000000000001p -1.351412e-06 63.862499999999997p -1.344892e-06 63.875p -1.337289e-06 63.887500000000003p -1.3286099999999999e-06 63.899999999999991p -1.318862e-06
+ 63.912499999999994p -1.308055e-06 63.925000000000004p -1.2961979999999999e-06 63.937500000000007p -1.283304e-06 63.949999999999996p -1.269382e-06 63.962499999999999p -1.254447e-06 63.975000000000001p -1.238512e-06 63.987499999999997p -1.221591e-06 64p -1.2037e-06 64.012500000000003p -1.1848549999999999e-06 64.025000000000006p -1.165074e-06 64.037499999999994p -1.1443739999999999e-06 64.049999999999997p -1.122774e-06 64.0625p -1.1002939999999999e-06 64.075000000000003p -1.076954e-06 64.087500000000006p -1.052774e-06 64.100000000000009p -1.027778e-06 64.112499999999997p -1.001987e-06 64.125p -9.7542470000000004e-07
+ 64.137500000000003p -9.4811459999999999e-07 64.150000000000006p -9.2008119999999998e-07 64.162499999999994p -8.9134959999999998e-07 64.174999999999997p -8.619454e-07 64.1875p -8.3189489999999995e-07 64.199999999999989p -8.0122460000000003e-07 64.212500000000006p -7.6996179999999996e-07 64.225000000000009p -7.381341e-07 64.237499999999997p -7.0576969999999997e-07 64.25p -6.7289699999999997e-07 64.262500000000003p -6.3954490000000001e-07 64.275000000000006p -6.0574269999999997e-07 64.287499999999994p -5.7151999999999997e-07 64.299999999999997p -5.3690660000000001e-07 64.3125p -5.019326e-07 64.324999999999989p -4.666285e-07 64.337500000000006p -4.310248e-07 64.350000000000009p -3.9515230000000002e-07
+ 64.362499999999997p -3.5904179999999998e-07 64.375p -3.2272449999999999e-07 64.387500000000003p -2.8623129999999999e-07 64.400000000000006p -2.4959349999999999e-07 64.412499999999994p -2.128423e-07 64.424999999999997p -1.7600879999999999e-07 64.4375p -1.391243e-07 64.449999999999989p -1.022197e-07 64.462499999999991p -6.5326119999999997e-08 64.475000000000009p -2.8474419999999999e-08 64.487500000000011p 8.3046589999999994e-09 64.5p 4.4980580000000003e-08 64.512500000000003p 8.1522999999999995e-08 64.525000000000006p 1.179018e-07 64.537499999999994p 1.5408709999999999e-07 64.549999999999997p 1.9004940000000001e-07 64.5625p 2.2575949999999999e-07 64.574999999999989p 2.6118839999999999e-07
+ 64.587499999999991p 2.9630760000000001e-07 64.600000000000009p 3.3108900000000001e-07 64.612500000000011p 3.6550479999999998e-07 64.625p 3.9952779999999999e-07 64.637500000000003p 4.3313109999999998e-07 64.650000000000006p 4.6628859999999998e-07 64.662499999999994p 4.9897420000000002e-07 64.674999999999997p 5.3116289999999998e-07 64.6875p 5.6282980000000003e-07 64.699999999999989p 5.9395079999999999e-07 64.712499999999991p 6.2450229999999999e-07 64.724999999999994p 6.5446159999999998e-07 64.737500000000011p 6.8380610000000002e-07 64.75p 7.1251430000000005e-07 64.762500000000003p 7.4056529999999996e-07 64.775000000000006p 7.6793860000000004e-07 64.787499999999994p 7.9461470000000005e-07 64.799999999999997p 8.2057479999999999e-07
+ 64.8125p 8.4580059999999997e-07 64.825000000000003p 8.7027469999999997e-07 64.837499999999991p 8.9398039999999998e-07 64.849999999999994p 9.1690200000000001e-07 64.862500000000011p 9.390241e-07 64.875p 9.6033239999999994e-07 64.887500000000003p 9.8081350000000005e-07 64.900000000000006p 1.000454e-06 64.912499999999994p 1.019243e-06 64.924999999999997p 1.037169e-06 64.9375p 1.0542209999999999e-06 64.950000000000003p 1.0703900000000001e-06 64.962499999999991p 1.085668e-06 64.974999999999994p 1.1000460000000001e-06 64.987500000000011p 1.1135170000000001e-06 65p 1.1260750000000001e-06 65.012500000000003p 1.1377149999999999e-06 65.025000000000006p 1.1484319999999999e-06
+ 65.037499999999994p 1.158223e-06 65.049999999999997p 1.167084e-06 65.0625p 1.1750139999999999e-06 65.075000000000003p 1.182011e-06 65.087499999999991p 1.1880750000000001e-06 65.099999999999994p 1.193206e-06 65.112499999999997p 1.1974059999999999e-06 65.125p 1.2006749999999999e-06 65.137500000000003p 1.203018e-06 65.150000000000006p 1.204437e-06 65.162500000000009p 1.2049370000000001e-06 65.174999999999997p 1.2045230000000001e-06 65.1875p 1.2032e-06 65.200000000000003p 1.200975e-06 65.212499999999991p 1.1978560000000001e-06 65.224999999999994p 1.19385e-06 65.237499999999997p 1.1889660000000001e-06 65.25p 1.1832130000000001e-06
+ 65.262500000000003p 1.1766009999999999e-06 65.275000000000006p 1.1691420000000001e-06 65.287500000000009p 1.1608449999999999e-06 65.299999999999997p 1.1517239999999999e-06 65.3125p 1.14179e-06 65.325000000000003p 1.1310569999999999e-06 65.337499999999991p 1.119538e-06 65.349999999999994p 1.107248e-06 65.362499999999997p 1.0942010000000001e-06 65.375p 1.080413e-06 65.387500000000003p 1.065899e-06 65.400000000000006p 1.0506759999999999e-06 65.412500000000009p 1.03476e-06 65.424999999999997p 1.018169e-06 65.4375p 1.0009189999999999e-06 65.450000000000003p 9.8303050000000005e-07 65.462499999999991p 9.6451990000000002e-07 65.474999999999994p 9.4540659999999999e-07
+ 65.487499999999997p 9.2570939999999999e-07 65.5p 9.0544789999999995e-07 65.512500000000003p 8.8464170000000004e-07 65.525000000000006p 8.6331059999999997e-07 65.537500000000009p 8.414751e-07 65.549999999999997p 8.1915529999999998e-07 65.5625p 7.9637210000000002e-07 65.575000000000003p 7.7314629999999998e-07 65.587499999999991p 7.4949879999999997e-07 65.599999999999994p 7.2545089999999996e-07 65.612499999999997p 7.0102370000000004e-07 65.625p 6.7623889999999995e-07 65.637500000000003p 6.5111770000000004e-07 65.650000000000006p 6.2568189999999999e-07 65.662500000000009p 5.9995290000000001e-07 65.674999999999997p 5.7395249999999999e-07 65.6875p 5.477022e-07 65.700000000000003p 5.2122380000000002e-07
+ 65.712499999999991p 4.9453869999999998e-07 65.724999999999994p 4.676687e-07 65.737499999999997p 4.4063510000000002e-07 65.75p 4.134593e-07 65.762500000000003p 3.8616270000000001e-07 65.775000000000006p 3.5876639999999999e-07 65.787500000000009p 3.3129139999999999e-07 65.799999999999997p 3.0375870000000001e-07 65.8125p 2.7618890000000002e-07 65.825000000000003p 2.486026e-07 65.837499999999991p 2.2102e-07 65.849999999999994p 1.934612e-07 65.862499999999997p 1.6594609999999999e-07 65.875p 1.384943e-07 65.887500000000003p 1.111251e-07 65.900000000000006p 8.3857590000000004e-08 65.912500000000009p 5.671053e-08 65.924999999999997p 2.9702379999999999e-08
+ 65.9375p 2.8512970000000001e-09 65.950000000000003p -2.3824910000000001e-08 65.962500000000006p -5.0308749999999997e-08 65.974999999999994p -7.658309e-08 65.987499999999997p -1.0263110000000001e-07 66p -1.2843649999999999e-07 66.012499999999989p -1.5398319999999999e-07 66.025000000000006p -1.7925550000000001e-07 66.037500000000009p -2.0423819999999999e-07 66.049999999999997p -2.289164e-07 66.0625p -2.5327580000000001e-07 66.075000000000003p -2.7730220000000001e-07 66.087500000000006p -3.0098209999999998e-07 66.099999999999994p -3.2430229999999999e-07 66.112499999999997p -3.4725009999999998e-07 66.125p -3.6981299999999998e-07 66.137499999999989p -3.9197939999999999e-07 66.150000000000006p -4.1373759999999997e-07
+ 66.162500000000009p -4.3507679999999999e-07 66.174999999999997p -4.5598640000000001e-07 66.1875p -4.7645639999999998e-07 66.200000000000003p -4.9647689999999999e-07 66.212500000000006p -5.1603900000000003e-07 66.224999999999994p -5.3513379999999997e-07 66.237499999999997p -5.5375299999999997e-07 66.25p -5.7188889999999995e-07 66.262499999999989p -5.8953400000000002e-07 66.275000000000006p -6.0668129999999998e-07 66.287500000000009p -6.2332449999999996e-07 66.300000000000011p -6.3945740000000003e-07 66.3125p -6.5507439999999998e-07 66.325000000000003p -6.7017040000000005e-07 66.337500000000006p -6.8474059999999998e-07 66.349999999999994p -6.9878069999999996e-07 66.362499999999997p -7.1228689999999996e-07 66.375p -7.2525560000000005e-07
+ 66.387499999999989p -7.3768380000000005e-07 66.399999999999991p -7.4956899999999998e-07 66.412500000000009p -7.609087e-07 66.425000000000011p -7.7170139999999995e-07 66.4375p -7.8194540000000003e-07 66.450000000000003p -7.9163969999999998e-07 66.462500000000006p -8.0078380000000002e-07 66.474999999999994p -8.0937720000000002e-07 66.487499999999997p -8.1742000000000002e-07 66.5p -8.2491279999999999e-07 66.512499999999989p -8.3185610000000003e-07 66.524999999999991p -8.3825130000000004e-07 66.537500000000009p -8.4409969999999997e-07 66.550000000000011p -8.4940309999999999e-07 66.5625p -8.541636e-07 66.575000000000003p -8.5838369999999996e-07 66.587500000000006p -8.6206599999999999e-07 66.599999999999994p -8.6521350000000005e-07
+ 66.612499999999997p -8.6782959999999999e-07 66.625p -8.6991780000000001e-07 66.637500000000003p -8.7148190000000003e-07 66.649999999999991p -8.7252610000000003e-07 66.662499999999994p -8.7305469999999995e-07 66.675000000000011p -8.7307220000000001e-07 66.6875p -8.7258349999999999e-07 66.700000000000003p -8.7159349999999998e-07 66.712500000000006p -8.7010770000000002e-07 66.724999999999994p -8.6813130000000004e-07 66.737499999999997p -8.6567020000000003e-07 66.75p -8.6273e-07 66.762500000000003p -8.5931680000000003e-07 66.774999999999991p -8.5543679999999997e-07 66.787499999999994p -8.5109639999999996e-07 66.800000000000011p -8.4630210000000005e-07 66.8125p -8.4106040000000001e-07 66.825000000000003p -8.3537830000000003e-07
+ 66.837500000000006p -8.2926249999999997e-07 66.849999999999994p -8.2272010000000004e-07 66.862499999999997p -8.1575839999999996e-07 66.875p -8.0838449999999996e-07 66.887500000000003p -8.0060570000000004e-07 66.899999999999991p -7.9242960000000004e-07 66.912499999999994p -7.8386369999999995e-07 66.924999999999997p -7.7491549999999999e-07 66.9375p -7.6559279999999995e-07 66.950000000000003p -7.559032e-07 66.962500000000006p -7.4585459999999998e-07 66.974999999999994p -7.3545489999999997e-07 66.987499999999997p -7.2471189999999999e-07 67p -7.1363350000000001e-07 67.012500000000003p -7.0222779999999997e-07 67.024999999999991p -6.9050270000000005e-07 67.037499999999994p -6.7846629999999999e-07 67.049999999999997p -6.6612670000000004e-07
+ 67.0625p -6.5349179999999998e-07 67.075000000000003p -6.4056979999999999e-07 67.087500000000006p -6.2736880000000003e-07 67.100000000000009p -6.138968e-07 67.112499999999997p -6.0016189999999995e-07 67.125p -5.8617219999999995e-07 67.137500000000003p -5.7193589999999998e-07 67.149999999999991p -5.574609e-07 67.162499999999994p -5.4275529999999997e-07 67.174999999999997p -5.2782729999999998e-07 67.1875p -5.1268469999999996e-07 67.200000000000003p -4.9733559999999995e-07 67.212500000000006p -4.8178810000000002e-07 67.225000000000009p -4.6605000000000002e-07 67.237499999999997p -4.5012930000000002e-07 67.25p -4.3403399999999998e-07 67.262500000000003p -4.1777190000000002e-07 67.274999999999991p -4.0135100000000001e-07
+ 67.287499999999994p -3.8477890000000002e-07 67.299999999999997p -3.6806360000000001e-07 67.3125p -3.5121290000000002e-07 67.325000000000003p -3.3423440000000002e-07 67.337500000000006p -3.1713599999999999e-07 67.350000000000009p -2.9992530000000001e-07 67.362499999999997p -2.8260990000000002e-07 67.375p -2.651976e-07 67.387500000000003p -2.4769600000000002e-07 67.399999999999991p -2.301126e-07 67.412499999999994p -2.1245500000000001e-07 67.424999999999997p -1.947307e-07 67.4375p -1.7694719999999999e-07 67.450000000000003p -1.5911209999999999e-07 67.462500000000006p -1.4123279999999999e-07 67.475000000000009p -1.2331680000000001e-07 67.487499999999997p -1.0537140000000001e-07 67.5p -8.7404099999999998e-08
+ 67.512500000000003p -6.9422250000000005e-08 67.524999999999991p -5.1433230000000002e-08 67.537499999999994p -3.3444389999999997e-08 67.549999999999997p -1.546308e-08 67.5625p 2.503381e-09 67.575000000000003p 2.0447679999999999e-08 67.587500000000006p 3.836251e-08 67.600000000000009p 5.6240590000000002e-08 67.612499999999997p 7.4074609999999995e-08 67.625p 9.1857319999999996e-08 67.637500000000003p 1.095814e-07 67.649999999999991p 1.2723969999999999e-07 67.662499999999994p 1.4482479999999999e-07 67.674999999999997p 1.623296e-07 67.6875p 1.797467e-07 67.700000000000003p 1.9706890000000001e-07 67.712500000000006p 2.1428899999999999e-07 67.725000000000009p 2.3139980000000001e-07
+ 67.737499999999997p 2.4839389999999998e-07 67.75p 2.6526409999999998e-07 67.762500000000003p 2.8200320000000002e-07 67.775000000000006p 2.986039e-07 67.787499999999994p 3.1505909999999998e-07 67.799999999999997p 3.3136140000000002e-07 67.8125p 3.4750359999999999e-07 67.825000000000003p 3.6347849999999998e-07 67.837500000000006p 3.7927879999999998e-07 67.850000000000009p 3.9489730000000002e-07 67.862499999999997p 4.1032689999999997e-07 67.875p 4.2556019999999999e-07 67.887500000000003p 4.405901e-07 67.900000000000006p 4.5540940000000002e-07 67.912499999999994p 4.700108e-07 67.924999999999997p 4.8438729999999996e-07 67.9375p 4.9853169999999998e-07 67.949999999999989p 5.1243680000000004e-07
+ 67.962500000000006p 5.2609550000000001e-07 67.975000000000009p 5.3950069999999998e-07 67.987499999999997p 5.5264539999999995e-07 68p 5.6552259999999995e-07 68.012500000000003p 5.7812519999999995e-07 68.025000000000006p 5.9044630000000002e-07 68.037499999999994p 6.0247889999999996e-07 68.049999999999997p 6.1421619999999998e-07 68.0625p 6.2565139999999999e-07 68.074999999999989p 6.3677760000000004e-07 68.087500000000006p 6.4758820000000003e-07 68.100000000000009p 6.5807649999999998e-07 68.112499999999997p 6.6823590000000001e-07 68.125p 6.7805990000000003e-07 68.137500000000003p 6.8754199999999998e-07 68.150000000000006p 6.9667600000000001e-07 68.162499999999994p 7.0545539999999996e-07 68.174999999999997p 7.1387410000000002e-07
+ 68.1875p 7.2192610000000005e-07 68.199999999999989p 7.2960539999999997e-07 68.212499999999991p 7.3690600000000005e-07 68.225000000000009p 7.4382220000000004e-07 68.237500000000011p 7.5034830000000002e-07 68.25p 7.5647900000000003e-07 68.262500000000003p 7.6220869999999999e-07 68.275000000000006p 7.6753219999999998e-07 68.287499999999994p 7.7244440000000003e-07 68.299999999999997p 7.7694049999999998e-07 68.3125p 7.8101550000000002e-07 68.324999999999989p 7.8466490000000003e-07 68.337499999999991p 7.8788419999999997e-07 68.350000000000009p 7.9066910000000004e-07 68.362500000000011p 7.9301560000000002e-07 68.375p 7.949197e-07 68.387500000000003p 7.9637770000000001e-07 68.400000000000006p 7.973862e-07
+ 68.412499999999994p 7.9794169999999998e-07 68.424999999999997p 7.9804139999999996e-07 68.4375p 7.9768220000000002e-07 68.449999999999989p 7.9686159999999998e-07 68.462499999999991p 7.955771e-07 68.474999999999994p 7.938267e-07 68.487500000000011p 7.9160840000000005e-07 68.5p 7.8892050000000001e-07 68.512500000000003p 7.8576170000000004e-07 68.525000000000006p 7.8213089999999996e-07 68.537499999999994p 7.7802709999999995e-07 68.549999999999997p 7.734498e-07 68.5625p 7.6839860000000003e-07 68.575000000000003p 7.6287370000000003e-07 68.587499999999991p 7.568751e-07 68.599999999999994p 7.5040350000000004e-07 68.612500000000011p 7.4345980000000003e-07 68.625p 7.3604519999999998e-07
+ 68.637500000000003p 7.2816099999999995e-07 68.650000000000006p 7.1980909999999995e-07 68.662499999999994p 7.1099159999999997e-07 68.674999999999997p 7.0171090000000004e-07 68.6875p 6.9196980000000004e-07 68.700000000000003p 6.8177129999999995e-07 68.712499999999991p 6.7111889999999997e-07 68.724999999999994p 6.6001620000000004e-07 68.737500000000011p 6.4846729999999998e-07 68.75p 6.3647659999999999e-07 68.762500000000003p 6.2404890000000001e-07 68.775000000000006p 6.1118919999999997e-07 68.787499999999994p 5.9790289999999996e-07 68.799999999999997p 5.8419570000000002e-07 68.8125p 5.7007370000000005e-07 68.825000000000003p 5.5554340000000001e-07 68.837499999999991p 5.4061149999999996e-07 68.849999999999994p 5.2528510000000003e-07
+ 68.862499999999997p 5.0957159999999996e-07 68.875p 4.9347870000000004e-07 68.887500000000003p 4.7701459999999997e-07 68.900000000000006p 4.6018770000000001e-07 68.912500000000009p 4.4300669999999999e-07 68.924999999999997p 4.2548070000000002e-07 68.9375p 4.0761910000000001e-07 68.950000000000003p 3.8943159999999999e-07 68.962499999999991p 3.7092829999999997e-07 68.974999999999994p 3.521194e-07 68.987499999999997p 3.3301570000000002e-07 69p 3.1362799999999998e-07 69.012500000000003p 2.9396760000000001e-07 69.025000000000006p 2.7404599999999999e-07 69.037500000000009p 2.5387500000000002e-07 69.049999999999997p 2.3346670000000001e-07 69.0625p 2.128335e-07 69.075000000000003p 1.9198800000000001e-07
+ 69.087499999999991p 1.70943e-07 69.099999999999994p 1.4971159999999999e-07 69.112499999999997p 1.2830729999999999e-07 69.125p 1.067436e-07 69.137500000000003p 8.5034230000000006e-08 69.150000000000006p 6.3193319999999998e-08 69.162500000000009p 4.1235050000000001e-08 69.174999999999997p 1.9173839999999999e-08 69.1875p -2.9757070000000001e-09 69.200000000000003p -2.5198819999999998e-08 69.212499999999991p -4.7480570000000002e-08 69.224999999999994p -6.9805860000000005e-08 69.237499999999997p -9.2159469999999996e-08 69.25p -1.14526e-07 69.262500000000003p -1.368901e-07 69.275000000000006p -1.592361e-07 69.287500000000009p -1.8154819999999999e-07 69.299999999999997p -2.0381090000000001e-07
+ 69.3125p -2.2600820000000001e-07 69.325000000000003p -2.4812430000000001e-07 69.337499999999991p -2.7014320000000002e-07 69.349999999999994p -2.920489e-07 69.362499999999997p -3.1382560000000003e-07 69.375p -3.3545720000000002e-07 69.387500000000003p -3.5692780000000002e-07 69.400000000000006p -3.7822130000000001e-07 69.412500000000009p -3.9932190000000002e-07 69.424999999999997p -4.202137e-07 69.4375p -4.408809e-07 69.450000000000003p -4.6130780000000001e-07 69.462499999999991p -4.8147869999999999e-07 69.474999999999994p -5.0137810000000005e-07 69.487499999999997p -5.2099059999999996e-07 69.5p -5.4030090000000002e-07 69.512500000000003p -5.5929389999999999e-07 69.525000000000006p -5.7795450000000003e-07
+ 69.537500000000009p -5.9626799999999998e-07 69.549999999999997p -6.1421969999999997e-07 69.5625p -6.3179519999999998e-07 69.575000000000003p -6.489804e-07 69.587499999999991p -6.6576120000000001e-07 69.599999999999994p -6.8212380000000004e-07 69.612499999999997p -6.9805490000000002e-07 69.625p -7.1354110000000004e-07 69.637500000000003p -7.285695e-07 69.650000000000006p -7.4312750000000005e-07 69.662500000000009p -7.5720269999999998e-07 69.674999999999997p -7.7078309999999999e-07 69.6875p -7.83857e-07 69.700000000000003p -7.9641300000000005e-07 69.712500000000006p -8.0844010000000005e-07 69.724999999999994p -8.1992760000000004e-07 69.737499999999997p -8.3086529999999997e-07 69.75p -8.412432e-07
+ 69.762499999999989p -8.5105200000000004e-07 69.775000000000006p -8.6028240000000005e-07 69.787500000000009p -8.6892570000000001e-07 69.799999999999997p -8.7697390000000001e-07 69.8125p -8.8441890000000001e-07 69.825000000000003p -8.9125350000000003e-07 69.837500000000006p -8.974707e-07 69.849999999999994p -9.0306409999999998e-07 69.862499999999997p -9.0802750000000005e-07 69.875p -9.1235560000000003e-07 69.887499999999989p -9.160432e-07 69.900000000000006p -9.1908579999999996e-07 69.912500000000009p -9.2147929999999997e-07 69.924999999999997p -9.2322009999999997e-07 69.9375p -9.243052e-07 69.950000000000003p -9.2473200000000005e-07 69.962500000000006p -9.2449849999999996e-07 69.974999999999994p -9.2360300000000002e-07
+ 69.987499999999997p -9.2204469999999997e-07 70p -9.1982290000000002e-07 70.012499999999989p -9.1693779999999996e-07 70.025000000000006p -9.1338979999999996e-07 70.037500000000009p -9.0918010000000004e-07 70.050000000000011p -9.0431029999999995e-07 70.0625p -8.9878250000000002e-07 70.075000000000003p -8.9259950000000002e-07 70.087500000000006p -8.8576430000000005e-07 70.099999999999994p -8.782807e-07 70.112499999999997p -8.7015300000000002e-07 70.125p -8.6138599999999996e-07 70.137499999999989p -8.5198490000000002e-07 70.149999999999991p -8.4195560000000003e-07 70.162500000000009p -8.3130430000000002e-07 70.175000000000011p -8.2003810000000002e-07 70.1875p -8.0816409999999995e-07 70.200000000000003p -7.9569030000000003e-07
+ 70.212500000000006p -7.8262499999999998e-07 70.224999999999994p -7.6897699999999996e-07 70.237499999999997p -7.5475569999999998e-07 70.25p -7.3997090000000001e-07 70.262499999999989p -7.2463279999999999e-07 70.274999999999991p -7.0875220000000003e-07 70.287500000000009p -6.9234019999999995e-07 70.300000000000011p -6.7540859999999999e-07 70.3125p -6.5796939999999995e-07 70.325000000000003p -6.4003500000000003e-07 70.337500000000006p -6.2161849999999999e-07 70.349999999999994p -6.0273309999999997e-07 70.362499999999997p -5.833925e-07 70.375p -5.6361090000000004e-07 70.387500000000003p -5.4340279999999995e-07 70.399999999999991p -5.2278299999999995e-07 70.412499999999994p -5.0176670000000002e-07 70.425000000000011p -4.8036939999999995e-07
+ 70.4375p -4.5860710000000002e-07 70.450000000000003p -4.3649579999999998e-07 70.462500000000006p -4.1405220000000002e-07 70.474999999999994p -3.912928e-07 70.487499999999997p -3.682348e-07 70.5p -3.4489550000000001e-07 70.512500000000003p -3.2129230000000002e-07 70.524999999999991p -2.9744310000000002e-07 70.537499999999994p -2.7336590000000002e-07 70.550000000000011p -2.4907879999999999e-07 70.5625p -2.246001e-07 70.575000000000003p -1.999485e-07 70.587500000000006p -1.7514250000000001e-07 70.599999999999994p -1.5020100000000001e-07 70.612499999999997p -1.25143e-07 70.625p -9.9987449999999998e-08 70.637500000000003p -7.4753510000000005e-08 70.649999999999991p -4.9460389999999999e-08
+ 70.662499999999994p -2.4127330000000001e-08 70.674999999999997p 1.2263549999999999e-09 70.6875p 2.6581350000000001e-08 70.700000000000003p 5.1918330000000001e-08 70.712500000000006p 7.7217980000000004e-08 70.724999999999994p 1.0246099999999999e-07 70.737499999999997p 1.276281e-07 70.75p 1.527002e-07 70.762500000000003p 1.7765810000000001e-07 70.774999999999991p 2.0248279999999999e-07 70.787499999999994p 2.2715539999999999e-07 70.799999999999997p 2.5165699999999999e-07 70.8125p 2.7596910000000002e-07 70.825000000000003p 3.0007309999999998e-07 70.837500000000006p 3.2395079999999998e-07 70.850000000000009p 3.4758390000000001e-07 70.862499999999997p 3.7095449999999999e-07 70.875p 3.9404489999999999e-07
+ 70.887500000000003p 4.1683769999999999e-07 70.899999999999991p 4.3931549999999997e-07 70.912499999999994p 4.614614e-07 70.924999999999997p 4.8325859999999995e-07 70.9375p 5.0469079999999999e-07 70.950000000000003p 5.2574189999999995e-07 70.962500000000006p 5.4639599999999996e-07 70.975000000000009p 5.6663760000000003e-07 70.987499999999997p 5.8645159999999999e-07 71p 6.0582330000000001e-07 71.012500000000003p 6.247382e-07 71.024999999999991p 6.431823e-07 71.037499999999994p 6.6114200000000001e-07 71.049999999999997p 6.7860390000000001e-07 71.0625p 6.9555530000000001e-07 71.075000000000003p 7.1198369999999998e-07 71.087500000000006p 7.2787720000000004e-07 71.100000000000009p 7.4322420000000005e-07
+ 71.112499999999997p 7.5801359999999998e-07 71.125p 7.7223480000000002e-07 71.137500000000003p 7.8587760000000002e-07 71.149999999999991p 7.9893230000000005e-07 71.162499999999994p 8.1138969999999999e-07 71.174999999999997p 8.2324099999999998e-07 71.1875p 8.3447809999999998e-07 71.200000000000003p 8.4509310000000003e-07 71.212500000000006p 8.5507889999999998e-07 71.225000000000009p 8.6442869999999996e-07 71.237499999999997p 8.7313639999999996e-07 71.25p 8.8119620000000001e-07 71.262500000000003p 8.8860300000000003e-07 71.274999999999991p 8.9535219999999997e-07 71.287499999999994p 9.0143960000000004e-07 71.299999999999997p 9.0686170000000003e-07 71.3125p 9.1161540000000005e-07 71.325000000000003p 9.1569829999999995e-07
+ 71.337500000000006p 9.1910829999999995e-07 71.350000000000009p 9.2184399999999995e-07 71.362499999999997p 9.2390449999999997e-07 71.375p 9.2528949999999998e-07 71.387500000000003p 9.2599910000000002e-07 71.399999999999991p 9.2603399999999999e-07 71.412499999999994p 9.2539550000000005e-07 71.424999999999997p 9.2408519999999996e-07 71.4375p 9.2210549999999997e-07 71.450000000000003p 9.1945919999999996e-07 71.462500000000006p 9.1614960000000004e-07 71.475000000000009p 9.1218050000000002e-07 71.487499999999997p 9.0755629999999998e-07 71.5p 9.0228170000000003e-07 71.512500000000003p 8.963622e-07 71.525000000000006p 8.8980359999999997e-07 71.537499999999994p 8.8261209999999998e-07 71.549999999999997p 8.7479459999999997e-07
+ 71.5625p 8.6635830000000001e-07 71.575000000000003p 8.5731100000000002e-07 71.587500000000006p 8.4766089999999999e-07 71.600000000000009p 8.3741650000000005e-07 71.612499999999997p 8.2658689999999997e-07 71.625p 8.151816e-07 71.637500000000003p 8.0321060000000001e-07 71.650000000000006p 7.9068419999999997e-07 71.662499999999994p 7.7761300000000002e-07 71.674999999999997p 7.6400830000000005e-07 71.6875p 7.4988150000000003e-07 71.699999999999989p 7.3524439999999998e-07 71.712500000000006p 7.201094e-07 71.725000000000009p 7.0448889999999996e-07 71.737499999999997p 6.8839579999999995e-07 71.75p 6.718435e-07 71.762500000000003p 6.5484529999999996e-07 71.775000000000006p 6.374152e-07
+ 71.787499999999994p 6.1956730000000003e-07 71.799999999999997p 6.0131599999999998e-07 71.8125p 5.8267580000000004e-07 71.824999999999989p 5.6366180000000002e-07 71.837500000000006p 5.4428900000000004e-07 71.850000000000009p 5.2457280000000004e-07 71.862500000000011p 5.0452879999999997e-07 71.875p 4.8417270000000003e-07 71.887500000000003p 4.6352039999999998e-07 71.900000000000006p 4.4258809999999998e-07 71.912499999999994p 4.213919e-07 71.924999999999997p 3.999484e-07 71.9375p 3.7827390000000002e-07 71.949999999999989p 3.5638519999999998e-07 71.962499999999991p 3.3429899999999999e-07 71.975000000000009p 3.1203200000000002e-07 71.987500000000011p 2.8960120000000001e-07 72p 2.6702350000000001e-07
+ 72.012500000000003p 2.4431580000000002e-07 72.025000000000006p 2.214952e-07 72.037499999999994p 1.9857869999999999e-07 72.049999999999997p 1.755832e-07 72.0625p 1.5252590000000001e-07 72.074999999999989p 1.2942370000000001e-07 72.087499999999991p 1.062935e-07 72.100000000000009p 8.31522e-08 72.112500000000011p 6.0016659999999998e-08 72.125p 3.6903600000000002e-08 72.137500000000003p 1.3829679999999999e-08 72.150000000000006p -9.1885509999999996e-09 72.162499999999994p -3.2134669999999997e-08 72.174999999999997p -5.4992369999999999e-08 72.1875p -7.7745490000000003e-08 72.199999999999989p -1.00378e-07 72.212499999999991p -1.2287410000000001e-07 72.224999999999994p -1.4521809999999999e-07
+ 72.237500000000011p -1.673946e-07 72.25p -1.8938809999999999e-07 72.262500000000003p -2.1118380000000001e-07 72.275000000000006p -2.3276659999999999e-07 72.287499999999994p -2.54122e-07 72.299999999999997p -2.7523569999999999e-07 72.3125p -2.960934e-07 72.325000000000003p -3.166813e-07 72.337499999999991p -3.3698580000000001e-07 72.349999999999994p -3.5699360000000001e-07 72.362500000000011p -3.7669150000000001e-07 72.375p -3.96067e-07 72.387500000000003p -4.1510740000000001e-07 72.400000000000006p -4.3380069999999998e-07 72.412499999999994p -4.5213509999999998e-07 72.424999999999997p -4.7009899999999998e-07 72.4375p -4.8768130000000004e-07 72.450000000000003p -5.0487110000000001e-07
+ 72.462499999999991p -5.2165789999999998e-07 72.474999999999994p -5.3803169999999998e-07 72.487500000000011p -5.539826e-07 72.5p -5.6950109999999998e-07 72.512500000000003p -5.8457830000000004e-07 72.525000000000006p -5.9920540000000002e-07 72.537499999999994p -6.1337400000000005e-07 72.549999999999997p -6.270763e-07 72.5625p -6.4030470000000004e-07 72.575000000000003p -6.5305190000000005e-07 72.587499999999991p -6.6531119999999998e-07 72.599999999999994p -6.7707609999999996e-07 72.612499999999997p -6.8834060000000004e-07 72.625p -6.9909899999999998e-07 72.637500000000003p -7.0934620000000002e-07 72.650000000000006p -7.1907720000000001e-07 72.662500000000009p -7.2828759999999999e-07 72.674999999999997p -7.3697339999999996e-07
+ 72.6875p -7.4513069999999995e-07 72.700000000000003p -7.5275649999999998e-07 72.712499999999991p -7.5984770000000004e-07 72.724999999999994p -7.6640189999999999e-07 72.737499999999997p -7.7241699999999995e-07 72.75p -7.7789120000000005e-07 72.762500000000003p -7.8282329999999997e-07 72.775000000000006p -7.872123e-07 72.787500000000009p -7.9105759999999997e-07 72.799999999999997p -7.9435910000000004e-07 72.8125p -7.97117e-07 72.825000000000003p -7.9933190000000001e-07 72.837499999999991p -8.010046e-07 72.849999999999994p -8.0213669999999995e-07 72.862499999999997p -8.0272959999999997e-07 72.875p -8.0278549999999999e-07 72.887500000000003p -8.0230680000000003e-07 72.900000000000006p -8.0129620000000004e-07
+ 72.912500000000009p -7.9975689999999999e-07 72.924999999999997p -7.9769219999999998e-07 72.9375p -7.9510599999999997e-07 72.950000000000003p -7.9200240000000002e-07 72.962499999999991p -7.8838579999999999e-07 72.974999999999994p -7.8426089999999999e-07 72.987499999999997p -7.7963290000000004e-07 73p -7.7450709999999998e-07 73.012500000000003p -7.688893e-07 73.025000000000006p -7.6278529999999996e-07 73.037500000000009p -7.5620139999999995e-07 73.049999999999997p -7.4914430000000003e-07 73.0625p -7.416206e-07 73.075000000000003p -7.3363759999999997e-07 73.087499999999991p -7.2520250000000002e-07 73.099999999999994p -7.1632289999999998e-07 73.112499999999997p -7.0700679999999996e-07 73.125p -6.9726210000000003e-07
+ 73.137500000000003p -6.870973e-07 73.150000000000006p -6.7652079999999996e-07 73.162500000000009p -6.655415e-07 73.174999999999997p -6.5416819999999997e-07 73.1875p -6.4241020000000003e-07 73.200000000000003p -6.3027680000000004e-07 73.212499999999991p -6.1777749999999995e-07 73.224999999999994p -6.0492219999999998e-07 73.237499999999997p -5.9172059999999996e-07 73.25p -5.781828e-07 73.262500000000003p -5.6431900000000004e-07 73.275000000000006p -5.5013960000000001e-07 73.287500000000009p -5.3565509999999998e-07 73.299999999999997p -5.2087609999999998e-07 73.3125p -5.0581329999999995e-07 73.325000000000003p -4.9047750000000002e-07 73.337499999999991p -4.7487979999999999e-07 73.349999999999994p -4.5903120000000001e-07
+ 73.362499999999997p -4.4294270000000002e-07 73.375p -4.2662570000000002e-07 73.387500000000003p -4.1009149999999998e-07 73.400000000000006p -3.9335130000000002e-07 73.412500000000009p -3.7641659999999998e-07 73.424999999999997p -3.5929889999999997e-07 73.4375p -3.420097e-07 73.450000000000003p -3.245606e-07 73.462500000000006p -3.0696310000000001e-07 73.474999999999994p -2.8922879999999999e-07 73.487499999999997p -2.7136929999999998e-07 73.5p -2.533963e-07 73.512499999999989p -2.353213e-07 73.525000000000006p -2.1715599999999999e-07 73.537500000000009p -1.98912e-07 73.549999999999997p -1.8060080000000001e-07 73.5625p -1.62234e-07 73.575000000000003p -1.438231e-07
+ 73.587500000000006p -1.2537949999999999e-07 73.599999999999994p -1.0691460000000001e-07 73.612499999999997p -8.8439960000000004e-08 73.625p -6.9966710000000001e-08 73.637499999999989p -5.1506140000000003e-08 73.650000000000006p -3.3069410000000002e-08 73.662500000000009p -1.4667599999999999e-08 73.674999999999997p 3.6882729999999998e-09 73.6875p 2.19873e-08 73.700000000000003p 4.0218660000000002e-08 73.712500000000006p 5.8371630000000003e-08 73.724999999999994p 7.6435609999999998e-08 73.737499999999997p 9.4400070000000001e-08 73.75p 1.122546e-07 73.762499999999989p 1.2998910000000001e-07 73.774999999999991p 1.475932e-07 73.787500000000009p 1.650569e-07 73.800000000000011p 1.823705e-07
+ 73.8125p 1.995241e-07 73.825000000000003p 2.1650820000000001e-07 73.837500000000006p 2.333132e-07 73.849999999999994p 2.4992990000000002e-07 73.862499999999997p 2.6634920000000001e-07 73.875p 2.8256200000000001e-07 73.887499999999989p 2.9855949999999998e-07 73.899999999999991p 3.1433300000000001e-07 73.912500000000009p 3.2987399999999998e-07 73.925000000000011p 3.451742e-07 73.9375p 3.6022550000000003e-07 73.950000000000003p 3.7501979999999999e-07 73.962500000000006p 3.8954929999999999e-07 73.974999999999994p 4.0380650000000002e-07 73.987499999999997p 4.1778389999999999e-07 74p 4.3147419999999997e-07 74.012499999999989p 4.4487040000000001e-07 74.024999999999991p 4.5796559999999999e-07
+ 74.037500000000009p 4.7075310000000003e-07 74.050000000000011p 4.8322649999999998e-07 74.0625p 4.9537939999999997e-07 74.075000000000003p 5.072059e-07 74.087500000000006p 5.1870000000000001e-07 74.099999999999994p 5.2985599999999995e-07 74.112499999999997p 5.406684e-07 74.125p 5.5113209999999998e-07 74.137500000000003p 5.6124180000000003e-07 74.149999999999991p 5.7099289999999999e-07 74.162499999999994p 5.8038060000000002e-07 74.175000000000011p 5.8940050000000004e-07 74.1875p 5.9804830000000001e-07 74.200000000000003p 6.0632009999999998e-07 74.212500000000006p 6.1421210000000004e-07 74.224999999999994p 6.2172070000000004e-07 74.237499999999997p 6.2884239999999998e-07 74.25p 6.3557429999999995e-07
+ 74.262500000000003p 6.4191319999999997e-07 74.274999999999991p 6.4785650000000004e-07 74.287499999999994p 6.5340169999999999e-07 74.300000000000011p 6.5854650000000004e-07 74.3125p 6.6328879999999999e-07 74.325000000000003p 6.6762670000000005e-07 74.337500000000006p 6.7155860000000002e-07 74.349999999999994p 6.750831e-07 74.362499999999997p 6.7819889999999995e-07 74.375p 6.8090509999999999e-07 74.387500000000003p 6.8320080000000002e-07 74.399999999999991p 6.8508559999999998e-07 74.412499999999994p 6.8655890000000001e-07 74.424999999999997p 6.8762079999999995e-07 74.4375p 6.8827130000000001e-07 74.450000000000003p 6.8851070000000001e-07 74.462500000000006p 6.8833940000000003e-07 74.474999999999994p 6.8775819999999999e-07
+ 74.487499999999997p 6.86768e-07 74.5p 6.8536990000000001e-07 74.512500000000003p 6.8356530000000002e-07 74.524999999999991p 6.8135569999999997e-07 74.537499999999994p 6.7874290000000004e-07 74.549999999999997p 6.7572889999999996e-07 74.5625p 6.7231580000000004e-07 74.575000000000003p 6.6850590000000005e-07 74.587500000000006p 6.6430199999999999e-07 74.600000000000009p 6.5970660000000002e-07 74.612499999999997p 6.5472290000000001e-07 74.625p 6.4935399999999998e-07 74.637500000000003p 6.4360320000000003e-07 74.649999999999991p 6.3747420000000005e-07 74.662499999999994p 6.3097060000000005e-07 74.674999999999997p 6.2409649999999999e-07 74.6875p 6.1685600000000003e-07 74.700000000000003p 6.0925339999999998e-07
+ 74.712500000000006p 6.0129330000000001e-07 74.725000000000009p 5.9298029999999998e-07 74.737499999999997p 5.8431940000000003e-07 74.75p 5.7531559999999997e-07 74.762500000000003p 5.6597410000000003e-07 74.774999999999991p 5.5630040000000005e-07 74.787499999999994p 5.4630010000000001e-07 74.799999999999997p 5.3597899999999998e-07 74.8125p 5.2534299999999999e-07 74.825000000000003p 5.1439820000000004e-07 74.837500000000006p 5.0315080000000005e-07 74.850000000000009p 4.9160749999999998e-07 74.862499999999997p 4.7977460000000002e-07 74.875p 4.6765900000000002e-07 74.887500000000003p 4.5526769999999999e-07 74.899999999999991p 4.426075e-07 74.912499999999994p 4.2968589999999998e-07 74.924999999999997p 4.1651010000000001e-07
+ 74.9375p 4.0308760000000002e-07 74.950000000000003p 3.894261e-07 74.962500000000006p 3.7553329999999998e-07 74.975000000000009p 3.6141720000000002e-07 74.987499999999997p 3.4708569999999999e-07 75p 3.3254710000000001e-07 75.012500000000003p 3.1780969999999998e-07 75.024999999999991p 3.0288179999999999e-07 75.037499999999994p 2.8777199999999999e-07 75.049999999999997p 2.7248890000000001e-07 75.0625p 2.5704129999999998e-07 75.075000000000003p 2.4143789999999998e-07 75.087500000000006p 2.2568779999999999e-07 75.100000000000009p 2.0980000000000001e-07 75.112499999999997p 1.9378370000000001e-07 75.125p 1.77648e-07 75.137500000000003p 1.6140219999999999e-07 75.149999999999991p 1.4505579999999999e-07
+ 75.162499999999994p 1.286182e-07 75.174999999999997p 1.12099e-07 75.1875p 9.5507640000000002e-08 75.200000000000003p 7.8853929999999997e-08 75.212500000000006p 6.2147529999999997e-08 75.225000000000009p 4.5398210000000001e-08 75.237499999999997p 2.8615779999999999e-08 75.25p 1.181011e-08 75.262500000000003p -5.0089160000000001e-09 75.275000000000006p -2.1831380000000001e-08 75.287499999999994p -3.8647319999999998e-08 75.299999999999997p -5.544677e-08 75.3125p -7.2219740000000004e-08 75.325000000000003p -8.8956230000000006e-08 75.337500000000006p -1.056462e-07 75.350000000000009p -1.222798e-07 75.362499999999997p -1.3884679999999999e-07 75.375p -1.5533730000000001e-07
+ 75.387500000000003p -1.717414e-07 75.400000000000006p -1.8804910000000001e-07 75.412499999999994p -2.0425050000000001e-07 75.424999999999997p -2.203356e-07 75.4375p -2.3629470000000001e-07 75.449999999999989p -2.5211790000000002e-07 75.462500000000006p -2.6779549999999998e-07 75.475000000000009p -2.8331779999999999e-07 75.487499999999997p -2.9867509999999998e-07 75.5p -3.1385789999999999e-07 75.512500000000003p -3.2885669999999999e-07 75.525000000000006p -3.43662e-07 75.537499999999994p -3.5826459999999999e-07 75.549999999999997p -3.7265520000000001e-07 75.5625p -3.8682470000000002e-07 75.574999999999989p -4.00764e-07 75.587500000000006p -4.1446420000000001e-07 75.600000000000009p -4.2791649999999999e-07
+ 75.612500000000011p -4.4111229999999999e-07 75.625p -4.5404289999999999e-07 75.637500000000003p -4.6669990000000002e-07 75.650000000000006p -4.7907509999999999e-07 75.662499999999994p -4.9116030000000004e-07 75.674999999999997p -5.0294750000000002e-07 75.6875p -5.1442879999999997e-07 75.699999999999989p -5.2559669999999999e-07 75.712499999999991p -5.3644360000000004e-07 75.725000000000009p -5.4696209999999996e-07 75.737500000000011p -5.5714519999999999e-07 75.75p -5.6698579999999998e-07 75.762500000000003p -5.7647710000000005e-07 75.775000000000006p -5.8561260000000002e-07 75.787499999999994p -5.9438589999999997e-07 75.799999999999997p -6.0279079999999995e-07 75.8125p -6.1082130000000002e-07 75.824999999999989p -6.1847170000000003e-07
+ 75.837499999999991p -6.2573650000000005e-07 75.850000000000009p -6.3261020000000004e-07 75.862500000000011p -6.3908789999999999e-07 75.875p -6.4516470000000004e-07 75.887500000000003p -6.5083589999999997e-07 75.900000000000006p -6.5609719999999996e-07 75.912499999999994p -6.6094449999999995e-07 75.924999999999997p -6.6537400000000004e-07 75.9375p -6.6938180000000005e-07 75.949999999999989p -6.7296479999999995e-07 75.962499999999991p -6.7611980000000001e-07 75.974999999999994p -6.7884400000000001e-07 75.987500000000011p -6.8113479999999995e-07 76p -6.8298989999999996e-07 76.012500000000003p -6.8440729999999997e-07 76.025000000000006p -6.8538520000000003e-07 76.037499999999994p -6.8592209999999998e-07 76.049999999999997p -6.8601700000000002e-07
+ 76.0625p -6.8566879999999996e-07 76.075000000000003p -6.8487689999999995e-07 76.087499999999991p -6.8364110000000002e-07 76.099999999999994p -6.819613e-07 76.112500000000011p -6.798377e-07 76.125p -6.7727080000000002e-07 76.137500000000003p -6.7426159999999998e-07 76.150000000000006p -6.7081110000000003e-07 76.162499999999994p -6.6692079999999998e-07 76.174999999999997p -6.6259230000000004e-07 76.1875p -6.5782780000000002e-07 76.200000000000003p -6.5262940000000004e-07 76.212499999999991p -6.4699980000000003e-07 76.224999999999994p -6.4094199999999997e-07 76.237500000000011p -6.3445899999999995e-07 76.25p -6.2755450000000005e-07 76.262500000000003p -6.2023200000000004e-07 76.275000000000006p -6.1249590000000002e-07
+ 76.287499999999994p -6.0435030000000001e-07 76.299999999999997p -5.9579990000000004e-07 76.3125p -5.8684970000000001e-07 76.325000000000003p -5.7750489999999996e-07 76.337499999999991p -5.6777100000000004e-07 76.349999999999994p -5.5765379999999999e-07 76.362499999999997p -5.4715920000000005e-07 76.375p -5.3629369999999997e-07 76.387500000000003p -5.2506380000000004e-07 76.400000000000006p -5.1347639999999998e-07 76.412500000000009p -5.0153860000000003e-07 76.424999999999997p -4.8925780000000004e-07 76.4375p -4.7664159999999999e-07 76.450000000000003p -4.6369790000000001e-07 76.462499999999991p -4.5043489999999998e-07 76.474999999999994p -4.368608e-07 76.487499999999997p -4.2298429999999997e-07 76.5p -4.088143e-07
+ 76.512500000000003p -3.9435980000000001e-07 76.525000000000006p -3.7963000000000002e-07 76.537500000000009p -3.6463450000000002e-07 76.549999999999997p -3.49383e-07 76.5625p -3.3388529999999998e-07 76.575000000000003p -3.1815150000000001e-07 76.587499999999991p -3.0219199999999998e-07 76.599999999999994p -2.8601720000000002e-07 76.612499999999997p -2.6963779999999998e-07 76.625p -2.5306439999999999e-07 76.637500000000003p -2.3630820000000001e-07 76.650000000000006p -2.1938020000000001e-07 76.662500000000009p -2.022916e-07 76.674999999999997p -1.8505400000000001e-07 76.6875p -1.676787e-07 76.700000000000003p -1.5017759999999999e-07 76.712499999999991p -1.325622e-07 76.724999999999994p -1.148446e-07
+ 76.737499999999997p -9.7036640000000002e-08 76.75p -7.9150420000000006e-08 76.762500000000003p -6.1198080000000002e-08 76.775000000000006p -4.3191820000000003e-08 76.787500000000009p -2.5143910000000001e-08 76.799999999999997p -7.0666939999999998e-09 76.8125p 1.1027469999999999e-08 76.825000000000003p 2.912616e-08 76.837499999999991p 4.7216939999999999e-08 76.849999999999994p 6.528737e-08 76.862499999999997p 8.3324969999999997e-08 76.875p 1.013173e-07 76.887500000000003p 1.192518e-07 76.900000000000006p 1.3711620000000001e-07 76.912500000000009p 1.5489799999999999e-07 76.924999999999997p 1.725848e-07 76.9375p 1.9016430000000001e-07 76.950000000000003p 2.0762430000000001e-07
+ 76.962499999999991p 2.249525e-07 76.974999999999994p 2.4213670000000002e-07 76.987499999999997p 2.5916499999999998e-07 77p 2.7602540000000001e-07 77.012500000000003p 2.9270599999999997e-07 77.025000000000006p 3.091951e-07 77.037500000000009p 3.25481e-07 77.049999999999997p 3.4155220000000002e-07 77.0625p 3.573974e-07 77.075000000000003p 3.7300540000000002e-07 77.087499999999991p 3.8836509999999999e-07 77.099999999999994p 4.0346549999999998e-07 77.112499999999997p 4.1829599999999998e-07 77.125p 4.3284590000000002e-07 77.137500000000003p 4.4710500000000001e-07 77.150000000000006p 4.610631e-07 77.162500000000009p 4.7471019999999998e-07 77.174999999999997p 4.8803649999999998e-07
+ 77.1875p 5.0103239999999995e-07 77.200000000000003p 5.1368879999999998e-07 77.212500000000006p 5.2599650000000003e-07 77.224999999999994p 5.3794669999999996e-07 77.237499999999997p 5.4953080000000001e-07 77.25p 5.607404e-07 77.262499999999989p 5.7156750000000001e-07 77.275000000000006p 5.8200430000000003e-07 77.287500000000009p 5.9204329999999995e-07 77.299999999999997p 6.0167719999999998e-07 77.3125p 6.1089909999999996e-07 77.325000000000003p 6.1970220000000001e-07 77.337500000000006p 6.2808020000000003e-07 77.349999999999994p 6.3602709999999997e-07 77.362499999999997p 6.4353700000000003e-07 77.375p 6.5060460000000003e-07 77.387499999999989p 6.5722460000000002e-07 77.400000000000006p 6.6339229999999999e-07
+ 77.412500000000009p 6.6910320000000004e-07 77.424999999999997p 6.7435309999999997e-07 77.4375p 6.7913819999999996e-07 77.450000000000003p 6.8345500000000003e-07 77.462500000000006p 6.873003e-07 77.474999999999994p 6.9067129999999998e-07 77.487499999999997p 6.9356550000000002e-07 77.5p 6.9598080000000001e-07 77.512499999999989p 6.9791539999999998e-07 77.524999999999991p 6.9936789999999995e-07 77.537500000000009p 7.0033720000000004e-07 77.550000000000011p 7.0082250000000001e-07 77.5625p 7.0082350000000004e-07 77.575000000000003p 7.0034009999999998e-07 77.587500000000006p 6.993727e-07 77.599999999999994p 6.9792189999999995e-07 77.612499999999997p 6.9598869999999997e-07 77.625p 6.9357449999999995e-07
+ 77.637499999999989p 6.9068100000000002e-07 77.649999999999991p 6.8731029999999995e-07 77.662500000000009p 6.8346490000000005e-07 77.675000000000011p 6.7914739999999998e-07 77.6875p 6.7436100000000004e-07 77.700000000000003p 6.691092e-07 77.712500000000006p 6.6339570000000004e-07 77.724999999999994p 6.5722460000000002e-07 77.737499999999997p 6.5060049999999998e-07 77.75p 6.4352799999999999e-07 77.762499999999989p 6.3601229999999997e-07 77.774999999999991p 6.2805889999999995e-07 77.787500000000009p 6.1967340000000004e-07 77.800000000000011p 6.108621e-07 77.8125p 6.0163110000000004e-07 77.825000000000003p 5.9198719999999995e-07 77.837500000000006p 5.8193740000000003e-07 77.849999999999994p 5.7148899999999996e-07
+ 77.862499999999997p 5.6064949999999997e-07 77.875p 5.4942669999999996e-07 77.887500000000003p 5.3782869999999999e-07 77.899999999999991p 5.2586410000000002e-07 77.912499999999994p 5.1354130000000004e-07 77.925000000000011p 5.0086929999999996e-07 77.9375p 4.8785730000000003e-07 77.950000000000003p 4.7451459999999999e-07 77.962500000000006p 4.6085089999999998e-07 77.974999999999994p 4.4687609999999998e-07 77.987499999999997p 4.3260019999999998e-07 78p 4.1803359999999997e-07 78.012500000000003p 4.0318669999999999e-07 78.024999999999991p 3.8807019999999999e-07 78.037499999999994p 3.7269500000000002e-07 78.050000000000011p 3.5707229999999999e-07 78.0625p 3.4121309999999999e-07 78.075000000000003p 3.2512900000000003e-07
+ 78.087500000000006p 3.0883139999999999e-07 78.099999999999994p 2.9233220000000001e-07 78.112499999999997p 2.7564299999999998e-07 78.125p 2.5877599999999999e-07 78.137500000000003p 2.4174310000000001e-07 78.149999999999991p 2.245566e-07 78.162499999999994p 2.0722870000000001e-07 78.174999999999997p 1.8977189999999999e-07 78.1875p 1.721986e-07 78.200000000000003p 1.5452140000000001e-07 78.212500000000006p 1.367528e-07 78.225000000000009p 1.1890550000000001e-07 78.237499999999997p 1.0099220000000001e-07 78.25p 8.3025559999999997e-08 78.262500000000003p 6.5018449999999998e-08 78.274999999999991p 4.6983570000000001e-08 78.287499999999994p 2.893371e-08 78.299999999999997p 1.0881630000000001e-08
+ 78.3125p -7.1599230000000004e-09 78.325000000000003p -2.517821e-08 78.337500000000006p -4.3160550000000001e-08 78.350000000000009p -6.1094280000000001e-08 78.362499999999997p -7.8966809999999994e-08 78.375p -9.6765599999999999e-08 78.387500000000003p -1.144782e-07 78.399999999999991p -1.320922e-07 78.412499999999994p -1.4959519999999999e-07 78.424999999999997p -1.6697520000000001e-07 78.4375p -1.8421999999999999e-07 78.450000000000003p -2.013177e-07 78.462500000000006p -2.182563e-07 78.475000000000009p -2.350243e-07 78.487499999999997p -2.5160990000000002e-07 78.5p -2.6800179999999998e-07 78.512500000000003p -2.841887e-07 78.524999999999991p -3.001595e-07
+ 78.537499999999994p -3.1590319999999998e-07 78.549999999999997p -3.3140929999999998e-07 78.5625p -3.4666699999999999e-07 78.575000000000003p -3.6166599999999998e-07 78.587500000000006p -3.7639619999999999e-07 78.600000000000009p -3.9084760000000001e-07 78.612499999999997p -4.050106e-07 78.625p -4.1887549999999998e-07 78.637500000000003p -4.3243319999999998e-07 78.649999999999991p -4.456747e-07 78.662499999999994p -4.585911e-07 78.674999999999997p -4.7117380000000002e-07 78.6875p -4.8341480000000001e-07 78.700000000000003p -4.9530580000000002e-07 78.712500000000006p -5.0683919999999996e-07 78.725000000000009p -5.1800749999999995e-07 78.737499999999997p -5.2880350000000001e-07 78.75p -5.3922030000000001e-07
+ 78.762500000000003p -5.4925119999999998e-07 78.774999999999991p -5.5888989999999995e-07 78.787499999999994p -5.6813030000000002e-07 78.799999999999997p -5.7696669999999995e-07 78.8125p -5.8539369999999995e-07 78.825000000000003p -5.9340610000000001e-07 78.837500000000006p -6.0099900000000002e-07 78.850000000000009p -6.0816800000000002e-07 78.862499999999997p -6.1490870000000004e-07 78.875p -6.2121739999999999e-07 78.887500000000003p -6.2709029999999996e-07 78.899999999999991p -6.3252430000000004e-07 78.912499999999994p -6.3751640000000002e-07 78.924999999999997p -6.4206389999999998e-07 78.9375p -6.4616450000000003e-07 78.950000000000003p -6.498164e-07 78.962500000000006p -6.5301769999999998e-07 78.975000000000009p -6.5576719999999996e-07
+ 78.987499999999997p -6.5806379999999997e-07 79p -6.5990680000000002e-07 79.012500000000003p -6.6129600000000002e-07 79.025000000000006p -6.6223110000000004e-07 79.037499999999994p -6.6271259999999999e-07 79.049999999999997p -6.6274090000000005e-07 79.0625p -6.6231700000000004e-07 79.075000000000003p -6.6144220000000001e-07 79.087500000000006p -6.6011789999999996e-07 79.100000000000009p -6.5834600000000001e-07 79.112499999999997p -6.5612869999999998e-07 79.125p -6.5346840000000001e-07 79.137500000000003p -6.5036800000000002e-07 79.150000000000006p -6.4683040000000005e-07 79.162499999999994p -6.4285909999999999e-07 79.174999999999997p -6.3845780000000003e-07 79.1875p -6.3363029999999997e-07 79.199999999999989p -6.2838099999999999e-07
+ 79.212500000000006p -6.2271440000000002e-07 79.225000000000009p -6.1663529999999999e-07 79.237499999999997p -6.1014879999999998e-07 79.25p -6.0326019999999995e-07 79.262500000000003p -5.9597520000000003e-07 79.275000000000006p -5.8829959999999997e-07 79.287499999999994p -5.8023960000000004e-07 79.299999999999997p -5.7180159999999995e-07 79.3125p -5.6299220000000003e-07 79.324999999999989p -5.5381829999999999e-07 79.337500000000006p -5.4428699999999998e-07 79.350000000000009p -5.3440560000000001e-07 79.362500000000011p -5.241817e-07 79.375p -5.1362309999999999e-07 79.387500000000003p -5.0273770000000004e-07 79.400000000000006p -4.9153370000000004e-07 79.412499999999994p -4.8001949999999997e-07 79.424999999999997p -4.682037e-07
+ 79.4375p -4.5609499999999998e-07 79.449999999999989p -4.4370230000000001e-07 79.462499999999991p -4.3103480000000001e-07 79.475000000000009p -4.1810169999999999e-07 79.487500000000011p -4.0491240000000001e-07 79.5p -3.9147650000000002e-07 79.512500000000003p -3.7780369999999998e-07 79.525000000000006p -3.639037e-07 79.537499999999994p -3.497867e-07 79.549999999999997p -3.3546260000000002e-07 79.5625p -3.2094159999999999e-07 79.574999999999989p -3.0623400000000001e-07 79.587499999999991p -2.913503e-07 79.600000000000009p -2.7630089999999999e-07 79.612500000000011p -2.610963e-07 79.625p -2.4574719999999999e-07 79.637500000000003p -2.3026419999999999e-07 79.650000000000006p -2.146582e-07
+ 79.662499999999994p -1.9893989999999999e-07 79.674999999999997p -1.8312010000000001e-07 79.6875p -1.6720979999999999e-07 79.699999999999989p -1.5121990000000001e-07 79.712499999999991p -1.3516120000000001e-07 79.724999999999994p -1.190447e-07 79.737500000000011p -1.028813e-07 79.75p -8.6682069999999997e-08 79.762500000000003p -7.0457820000000004e-08 79.775000000000006p -5.4219479999999998e-08 79.787499999999994p -3.7977930000000002e-08 79.799999999999997p -2.1744039999999999e-08 79.8125p -5.5285980000000003e-09 79.825000000000003p 1.065762e-08 79.837499999999991p 2.6803920000000001e-08 79.849999999999994p 4.2899639999999998e-08 79.862500000000011p 5.8934209999999998e-08 79.875p 7.4897129999999994e-08
+ 79.887500000000003p 9.0777970000000004e-08 79.900000000000006p 1.065664e-07 79.912499999999994p 1.2225220000000001e-07 79.924999999999997p 1.3782519999999999e-07 79.9375p 1.532754e-07 79.950000000000003p 1.685928e-07 79.962499999999991p 1.837678e-07 79.974999999999994p 1.9879050000000001e-07 79.987499999999997p 2.136515e-07 80p 2.2834139999999999e-07 80.012500000000003p 2.4285100000000001e-07 80.025000000000006p 2.5717099999999999e-07 80.037499999999994p 2.712926e-07 80.049999999999997p 2.8520700000000002e-07 80.0625p 2.989055e-07 80.075000000000003p 3.1237980000000001e-07 80.087499999999991p 3.2562140000000002e-07 80.099999999999994p 3.3862240000000002e-07
+ 80.112499999999997p 3.5137470000000001e-07 80.125p 3.6387079999999998e-07 80.137500000000003p 3.7610290000000002e-07 80.150000000000006p 3.8806390000000001e-07 80.162500000000009p 3.9974650000000003e-07 80.174999999999997p 4.1114379999999998e-07 80.1875p 4.2224909999999998e-07 80.200000000000003p 4.3305589999999999e-07 80.212499999999991p 4.4355789999999999e-07 80.224999999999994p 4.5374889999999998e-07 80.237499999999997p 4.6362319999999998e-07 80.25p 4.7317510000000002e-07 80.262500000000003p 4.8239919999999999e-07 80.275000000000006p 4.9129030000000003e-07 80.287500000000009p 4.998435e-07 80.299999999999997p 5.0805399999999995e-07 80.3125p 5.1591729999999998e-07 80.325000000000003p 5.2342930000000002e-07
+ 80.337499999999991p 5.3058590000000004e-07 80.349999999999994p 5.3738330000000002e-07 80.362499999999997p 5.438181e-07 80.375p 5.4988699999999998e-07 80.387500000000003p 5.5558690000000004e-07 80.400000000000006p 5.6091499999999999e-07 80.412500000000009p 5.6586879999999996e-07 80.424999999999997p 5.7044599999999997e-07 80.4375p 5.7464459999999997e-07 80.450000000000003p 5.784628e-07 80.462499999999991p 5.8189899999999996e-07 80.474999999999994p 5.8495179999999997e-07 80.487499999999997p 5.8762039999999999e-07 80.5p 5.8990379999999998e-07 80.512500000000003p 5.9180150000000003e-07 80.525000000000006p 5.9331309999999998e-07 80.537500000000009p 5.9443860000000002e-07 80.549999999999997p 5.9517820000000005e-07
+ 80.5625p 5.9553230000000002e-07 80.575000000000003p 5.9550160000000004e-07 80.587499999999991p 5.9508690000000005e-07 80.599999999999994p 5.9428939999999995e-07 80.612499999999997p 5.9311040000000002e-07 80.625p 5.9155159999999995e-07 80.637500000000003p 5.8961480000000004e-07 80.650000000000006p 5.8730209999999997e-07 80.662500000000009p 5.8461580000000001e-07 80.674999999999997p 5.8155849999999999e-07 80.6875p 5.781328e-07 80.700000000000003p 5.7434179999999996e-07 80.712499999999991p 5.7018870000000005e-07 80.724999999999994p 5.656769e-07 80.737499999999997p 5.6080999999999995e-07 80.75p 5.5559189999999997e-07 80.762500000000003p 5.5002650000000002e-07 80.775000000000006p 5.4411830000000001e-07
+ 80.787500000000009p 5.3787159999999997e-07 80.799999999999997p 5.3129110000000001e-07 80.8125p 5.2438170000000001e-07 80.825000000000003p 5.1714829999999997e-07 80.837499999999991p 5.0959620000000004e-07 80.849999999999994p 5.0173089999999996e-07 80.862499999999997p 4.9355789999999999e-07 80.875p 4.8508290000000004e-07 80.887500000000003p 4.7631200000000001e-07 80.900000000000006p 4.6725130000000001e-07 80.912500000000009p 4.5790689999999998e-07 80.924999999999997p 4.4828539999999999e-07 80.9375p 4.383933e-07 80.950000000000003p 4.2823740000000002e-07 80.962500000000006p 4.1782449999999998e-07 80.974999999999994p 4.0716169999999997e-07 80.987499999999997p 3.9625610000000002e-07 81p 3.8511510000000001e-07
+ 81.012499999999989p 3.7374600000000002e-07 81.025000000000006p 3.6215640000000003e-07 81.037500000000009p 3.5035390000000002e-07 81.049999999999997p 3.3834629999999998e-07 81.0625p 3.2614160000000001e-07 81.075000000000003p 3.1374759999999999e-07 81.087500000000006p 3.011726e-07 81.099999999999994p 2.884245e-07 81.112499999999997p 2.7551179999999997e-07 81.125p 2.6244280000000001e-07 81.137499999999989p 2.4922590000000002e-07 81.150000000000006p 2.3586949999999999e-07 81.162500000000009p 2.2238229999999999e-07 81.174999999999997p 2.0877300000000001e-07 81.1875p 1.9505010000000001e-07 81.200000000000003p 1.812224e-07 81.212500000000006p 1.6729869999999999e-07 81.224999999999994p 1.532879e-07
+ 81.237499999999997p 1.3919879999999999e-07 81.25p 1.2504029999999999e-07 81.262499999999989p 1.108213e-07 81.274999999999991p 9.6550810000000001e-08 81.287500000000009p 8.2237729999999998e-08 81.300000000000011p 6.7891060000000002e-08 81.3125p 5.3519769999999998e-08 81.325000000000003p 3.9132830000000002e-08 81.337500000000006p 2.4739220000000001e-08 81.349999999999994p 1.0347890000000001e-08 81.362499999999997p -4.032202e-09 81.375p -1.8392139999999998e-08 81.387499999999989p -3.2723029999999998e-08 81.399999999999991p -4.7015989999999999e-08 81.412500000000009p -6.1262199999999994e-08 81.425000000000011p -7.5452860000000002e-08 81.4375p -8.9579239999999995e-08 81.450000000000003p -1.036326e-07
+ 81.462500000000006p -1.1760439999999999e-07 81.474999999999994p -1.3148599999999999e-07 81.487499999999997p -1.4526879999999999e-07 81.5p -1.5894450000000001e-07 81.512499999999989p -1.7250469999999999e-07 81.524999999999991p -1.8594100000000001e-07 81.537500000000009p -1.992454e-07 81.550000000000011p -2.1240960000000001e-07 81.5625p -2.2542569999999999e-07 81.575000000000003p -2.3828569999999999e-07 81.587500000000006p -2.509819e-07 81.599999999999994p -2.6350640000000003e-07 81.612499999999997p -2.7585179999999999e-07 81.625p -2.8801040000000002e-07 81.637500000000003p -2.9997499999999998e-07 81.649999999999991p -3.1173839999999998e-07 81.662499999999994p -3.2329329999999998e-07 81.675000000000011p -3.3463290000000001e-07
+ 81.6875p -3.4575020000000002e-07 81.700000000000003p -3.566386e-07 81.712500000000006p -3.6729149999999999e-07 81.724999999999994p -3.7770250000000002e-07 81.737499999999997p -3.8786529999999999e-07 81.75p -3.9777380000000001e-07 81.762500000000003p -4.0742210000000003e-07 81.774999999999991p -4.168044e-07 81.787499999999994p -4.2591500000000001e-07 81.800000000000011p -4.347486e-07 81.8125p -4.4329969999999998e-07 81.825000000000003p -4.5156330000000001e-07 81.837500000000006p -4.595345e-07 81.849999999999994p -4.6720850000000002e-07 81.862499999999997p -4.745807e-07 81.875p -4.8164680000000001e-07 81.887500000000003p -4.8840250000000002e-07 81.899999999999991p -4.9484379999999997e-07
+ 81.912499999999994p -5.0096690000000005e-07 81.924999999999997p -5.0676809999999997e-07 81.9375p -5.1224410000000004e-07 81.950000000000003p -5.1739169999999998e-07 81.962500000000006p -5.2220770000000004e-07 81.975000000000009p -5.2668930000000002e-07 81.987499999999997p -5.3083399999999995e-07 82p -5.3463920000000004e-07 82.012500000000003p -5.3810290000000002e-07 82.024999999999991p -5.4122289999999996e-07 82.037499999999994p -5.4399759999999998e-07 82.049999999999997p -5.4642520000000001e-07 82.0625p -5.4850450000000004e-07 82.075000000000003p -5.5023429999999995e-07 82.087500000000006p -5.5161349999999999e-07 82.100000000000009p -5.5264160000000004e-07 82.112499999999997p -5.5331789999999999e-07 82.125p -5.5364219999999996e-07
+ 82.137500000000003p -5.5361440000000002e-07 82.149999999999991p -5.532346e-07 82.162499999999994p -5.5250319999999997e-07 82.174999999999997p -5.514206e-07 82.1875p -5.4998769999999998e-07 82.200000000000003p -5.4820550000000004e-07 82.212500000000006p -5.4607519999999998e-07 82.225000000000009p -5.4359820000000001e-07 82.237499999999997p -5.4077600000000005e-07 82.25p -5.3761070000000001e-07 82.262500000000003p -5.3410410000000005e-07 82.274999999999991p -5.3025859999999999e-07 82.287499999999994p -5.260767e-07 82.299999999999997p -5.2156099999999999e-07 82.3125p -5.167144e-07 82.325000000000003p -5.1154000000000004e-07 82.337500000000006p -5.0604110000000002e-07 82.350000000000009p -5.0022129999999997e-07
+ 82.362499999999997p -4.9408409999999998e-07 82.375p -4.8763349999999997e-07 82.387500000000003p -4.8087370000000002e-07 82.399999999999991p -4.7380880000000002e-07 82.412499999999994p -4.6644329999999999e-07 82.424999999999997p -4.5878199999999999e-07 82.4375p -4.5082969999999999e-07 82.450000000000003p -4.425913e-07 82.462500000000006p -4.3407220000000001e-07 82.475000000000009p -4.2527759999999998e-07 82.487499999999997p -4.162133e-07 82.5p -4.068848e-07 82.512500000000003p -3.9729820000000003e-07 82.524999999999991p -3.874594e-07 82.537499999999994p -3.7737479999999999e-07 82.549999999999997p -3.6705069999999999e-07 82.5625p -3.5649360000000002e-07 82.575000000000003p -3.4571019999999997e-07
+ 82.587500000000006p -3.347074e-07 82.600000000000009p -3.2349219999999998e-07 82.612499999999997p -3.120716e-07 82.625p -3.004529e-07 82.637500000000003p -2.8864360000000001e-07 82.649999999999991p -2.7665100000000001e-07 82.662499999999994p -2.6448289999999998e-07 82.674999999999997p -2.5214690000000002e-07 82.6875p -2.3965099999999998e-07 82.700000000000003p -2.2700300000000001e-07 82.712500000000006p -2.1421100000000001e-07 82.725000000000009p -2.0128329999999999e-07 82.737499999999997p -1.8822800000000001e-07 82.75p -1.7505350000000001e-07 82.762500000000003p -1.6176809999999999e-07 82.775000000000006p -1.483805e-07 82.787499999999994p -1.3489909999999999e-07 82.799999999999997p -1.213326e-07
+ 82.8125p -1.076897e-07 82.825000000000003p -9.3979060000000003e-08 82.837500000000006p -8.0209570000000003e-08 82.850000000000009p -6.639004e-08 82.862499999999997p -5.2529349999999999e-08 82.875p -3.8636419999999998e-08 82.887500000000003p -2.472017e-08 82.900000000000006p -1.0789589999999999e-08 82.912499999999994p 3.1463620000000001e-09 82.924999999999997p 1.7078690000000001e-08 82.9375p 3.0998390000000003e-08 82.949999999999989p 4.4896489999999998e-08 82.962500000000006p 5.8763980000000003e-08 82.975000000000009p 7.25919e-08 82.987499999999997p 8.6371279999999996e-08 83p 1.0009320000000001e-07 83.012500000000003p 1.137488e-07 83.025000000000006p 1.2732910000000001e-07
+ 83.037499999999994p 1.4082539999999999e-07 83.049999999999997p 1.5422880000000001e-07 83.0625p 1.675306e-07 83.074999999999989p 1.807223e-07 83.087500000000006p 1.9379509999999999e-07 83.100000000000009p 2.067405e-07 83.112500000000011p 2.195501e-07 83.125p 2.3221550000000001e-07 83.137500000000003p 2.4472840000000001e-07 83.150000000000006p 2.5708070000000002e-07 83.162499999999994p 2.6926410000000001e-07 83.174999999999997p 2.8127080000000002e-07 83.1875p 2.9309279999999998e-07 83.199999999999989p 3.0472230000000002e-07 83.212499999999991p 3.161518e-07 83.225000000000009p 3.2737359999999998e-07 83.237500000000011p 3.3838040000000001e-07 83.25p 3.4916490000000002e-07
+ 83.262500000000003p 3.5971999999999999e-07 83.275000000000006p 3.7003869999999999e-07 83.287499999999994p 3.8011409999999998e-07 83.299999999999997p 3.8993969999999998e-07 83.3125p 3.995088e-07 83.324999999999989p 4.0881519999999998e-07 83.337499999999991p 4.1785260000000001e-07 83.350000000000009p 4.2661500000000001e-07 83.362500000000011p 4.3509660000000003e-07 83.375p 4.4329170000000002e-07 83.387500000000003p 4.5119489999999999e-07 83.400000000000006p 4.5880089999999999e-07 83.412499999999994p 4.6610449999999999e-07 83.424999999999997p 4.731009e-07 83.4375p 4.7978529999999998e-07 83.449999999999989p 4.8615340000000005e-07 83.462499999999991p 4.9220079999999996e-07 83.474999999999994p 4.979234e-07
+ 83.487500000000011p 5.0331729999999998e-07 83.5p 5.0837900000000003e-07 83.512500000000003p 5.131049e-07 83.525000000000006p 5.1749189999999997e-07 83.537499999999994p 5.2153699999999997e-07 83.549999999999997p 5.2523729999999996e-07 83.5625p 5.2859049999999996e-07 83.575000000000003p 5.3159420000000005e-07 83.587499999999991p 5.3424619999999999e-07 83.599999999999994p 5.3654479999999995e-07 83.612500000000011p 5.3848839999999997e-07 83.625p 5.4007549999999998e-07 83.637500000000003p 5.4130509999999998e-07 83.650000000000006p 5.4217629999999997e-07 83.662499999999994p 5.4268839999999996e-07 83.674999999999997p 5.4284090000000004e-07 83.6875p 5.426338e-07 83.700000000000003p 5.4206710000000005e-07
+ 83.712499999999991p 5.4114110000000001e-07 83.724999999999994p 5.3985629999999999e-07 83.737499999999997p 5.3821359999999998e-07 83.75p 5.3621389999999997e-07 83.762500000000003p 5.3385860000000005e-07 83.775000000000006p 5.3114920000000005e-07 83.787499999999994p 5.280874e-07 83.799999999999997p 5.2467510000000002e-07 83.8125p 5.2091479999999997e-07 83.825000000000003p 5.1680869999999998e-07 83.837499999999991p 5.1235960000000005e-07 83.849999999999994p 5.0757050000000005e-07 83.862499999999997p 5.0244439999999996e-07 83.875p 4.9698490000000003e-07 83.887500000000003p 4.9119539999999999e-07 83.900000000000006p 4.8507989999999995e-07 83.912500000000009p 4.7864249999999997e-07 83.924999999999997p 4.7188730000000003e-07
+ 83.9375p 4.6481899999999997e-07 83.950000000000003p 4.5744219999999999e-07 83.962499999999991p 4.4976179999999999e-07 83.974999999999994p 4.417831e-07 83.987499999999997p 4.3351130000000003e-07 84p 4.2495200000000001e-07 84.012500000000003p 4.1611100000000001e-07 84.025000000000006p 4.0699410000000002e-07 84.037500000000009p 3.9760750000000001e-07 84.049999999999997p 3.8795750000000002e-07 84.0625p 3.7805059999999998e-07 84.075000000000003p 3.6789339999999999e-07 84.087499999999991p 3.5749289999999999e-07 84.099999999999994p 3.4685589999999997e-07 84.112499999999997p 3.359898e-07 84.125p 3.2490180000000002e-07 84.137500000000003p 3.135993e-07 84.150000000000006p 3.0209010000000002e-07
+ 84.162500000000009p 2.9038189999999999e-07 84.174999999999997p 2.7848269999999999e-07 84.1875p 2.6640040000000002e-07 84.200000000000003p 2.5414319999999999e-07 84.212499999999991p 2.4171950000000001e-07 84.224999999999994p 2.291376e-07 84.237499999999997p 2.164061e-07 84.25p 2.0353360000000001e-07 84.262500000000003p 1.9052879999999999e-07 84.275000000000006p 1.774005e-07 84.287500000000009p 1.6415760000000001e-07 84.299999999999997p 1.508091e-07 84.3125p 1.373641e-07 84.325000000000003p 1.238316e-07 84.337499999999991p 1.102209e-07 84.349999999999994p 9.6541190000000005e-08 84.362499999999997p 8.2801720000000006e-08 84.375p 6.9011830000000002e-08
+ 84.387500000000003p 5.5180879999999998e-08 84.400000000000006p 4.1318260000000003e-08 84.412500000000009p 2.743338e-08 84.424999999999997p 1.353566e-08 84.4375p -3.6546809999999999e-10 84.450000000000003p -1.426057e-08 84.462499999999991p -2.814022e-08 84.474999999999994p -4.1994990000000003e-08 84.487499999999997p -5.5815489999999998e-08 84.5p -6.9592339999999995e-08 84.512500000000003p -8.3316200000000001e-08 84.525000000000006p -9.6977750000000003e-08 84.537500000000009p -1.105677e-07 84.549999999999997p -1.2407689999999999e-07 84.5625p -1.3749619999999999e-07 84.575000000000003p -1.5081639999999999e-07 84.587500000000006p -1.640286e-07 84.599999999999994p -1.7712380000000001e-07
+ 84.612499999999997p -1.9009319999999999e-07 84.625p -2.0292790000000001e-07 84.637500000000003p -2.156193e-07 84.650000000000006p -2.281587e-07 84.662500000000009p -2.4053790000000001e-07 84.674999999999997p -2.5274830000000001e-07 84.6875p -2.6478169999999999e-07 84.700000000000003p -2.7663000000000001e-07 84.712500000000006p -2.8828529999999999e-07 84.724999999999994p -2.9973969999999998e-07 84.737499999999997p -3.109854e-07 84.75p -3.2201499999999999e-07 84.762499999999989p -3.3282090000000002e-07 84.775000000000006p -3.4339600000000001e-07 84.787500000000009p -3.5373319999999999e-07 84.799999999999997p -3.6382549999999998e-07 84.8125p -3.7366620000000002e-07 84.825000000000003p -3.8324869999999999e-07
+ 84.837500000000006p -3.9256659999999998e-07 84.849999999999994p -4.0161379999999997e-07 84.862499999999997p -4.103841e-07 84.875p -4.188719e-07 84.887499999999989p -4.2707140000000002e-07 84.900000000000006p -4.349772e-07 84.912500000000009p -4.4258420000000003e-07 84.924999999999997p -4.4988730000000001e-07 84.9375p -4.5688170000000002e-07 84.950000000000003p -4.635628e-07 84.962500000000006p -4.699263e-07 84.974999999999994p -4.7596809999999998e-07 84.987499999999997p -4.8168429999999999e-07 85p -4.8707110000000005e-07 85.012499999999989p -4.9212510000000001e-07 85.024999999999991p -4.9684310000000002e-07 85.037500000000009p -5.0122209999999998e-07 85.050000000000011p -5.0525939999999995e-07
+ 85.0625p -5.0895249999999998e-07 85.075000000000003p -5.1229900000000003e-07 85.087500000000006p -5.1529699999999999e-07 85.099999999999994p -5.1794459999999995e-07 85.112499999999997p -5.2024040000000003e-07 85.125p -5.2218300000000001e-07 85.137499999999989p -5.2377139999999998e-07 85.149999999999991p -5.250048e-07 85.162500000000009p -5.258826e-07 85.175000000000011p -5.2640440000000003e-07 85.1875p -5.2657039999999995e-07 85.200000000000003p -5.2638050000000005e-07 85.212500000000006p -5.2583520000000001e-07 85.224999999999994p -5.2493529999999998e-07 85.237499999999997p -5.2368160000000002e-07 85.25p -5.2207530000000002e-07 85.262499999999989p -5.2011779999999999e-07 85.274999999999991p -5.178107e-07
+ 85.287500000000009p -5.1515589999999997e-07 85.300000000000011p -5.1215560000000003e-07 85.3125p -5.0881209999999996e-07 85.325000000000003p -5.0512790000000003e-07 85.337500000000006p -5.0110600000000001e-07 85.349999999999994p -4.9674939999999999e-07 85.362499999999997p -4.9206130000000003e-07 85.375p -4.8704529999999995e-07 85.387500000000003p -4.8170509999999995e-07 85.399999999999991p -4.7604470000000002e-07 85.412499999999994p -4.700683e-07 85.425000000000011p -4.6378009999999998e-07 85.4375p -4.5718490000000001e-07 85.450000000000003p -4.5028749999999997e-07 85.462500000000006p -4.4309269999999998e-07 85.474999999999994p -4.3560590000000002e-07 85.487499999999997p -4.278325e-07 85.5p -4.1977800000000002e-07
+ 85.512500000000003p -4.1144819999999998e-07 85.524999999999991p -4.028491e-07 85.537499999999994p -3.9398689999999997e-07 85.550000000000011p -3.8486779999999999e-07 85.5625p -3.7549830000000002e-07 85.575000000000003p -3.6588510000000002e-07 85.587500000000006p -3.5603510000000002e-07 85.599999999999994p -3.4595510000000002e-07 85.612499999999997p -3.356523e-07 85.625p -3.2513390000000001e-07 85.637500000000003p -3.1440740000000001e-07 85.649999999999991p -3.0348029999999999e-07 85.662499999999994p -2.9236019999999999e-07 85.674999999999997p -2.8105500000000002e-07 85.6875p -2.6957250000000001e-07 85.700000000000003p -2.5792070000000002e-07 85.712500000000006p -2.4610789999999998e-07 85.725000000000009p -2.341421e-07
+ 85.737499999999997p -2.2203170000000001e-07 85.75p -2.0978509999999999e-07 85.762500000000003p -1.974109e-07 85.774999999999991p -1.849175e-07 85.787499999999994p -1.723135e-07 85.799999999999997p -1.596078e-07 85.8125p -1.46809e-07 85.825000000000003p -1.3392590000000001e-07 85.837500000000006p -1.209674e-07 85.850000000000009p -1.079423e-07 85.862499999999997p -9.4859700000000001e-08 85.875p -8.1728390000000001e-08 85.887500000000003p -6.8557370000000002e-08 85.899999999999991p -5.5355640000000001e-08 85.912499999999994p -4.2132169999999998e-08 85.924999999999997p -2.889595e-08 85.9375p -1.5655969999999998e-08 85.950000000000003p -2.4212089999999998e-09
+ 85.962500000000006p 1.079939e-08 85.975000000000009p 2.3996890000000001e-08 85.987499999999997p 3.7162389999999997e-08 86p 5.0287030000000002e-08 86.012500000000003p 6.3361980000000002e-08 86.024999999999991p 7.6378469999999995e-08 86.037499999999994p 8.9327759999999994e-08 86.049999999999997p 1.022012e-07 86.0625p 1.149902e-07 86.075000000000003p 1.2768620000000001e-07 86.087500000000006p 1.4028089999999999e-07 86.100000000000009p 1.527657e-07 86.112499999999997p 1.6513250000000001e-07 86.125p 1.7737300000000001e-07 86.137500000000003p 1.8947920000000001e-07 86.149999999999991p 2.014431e-07 86.162499999999994p 2.132569e-07 86.174999999999997p 2.2491269999999999e-07
+ 86.1875p 2.36403e-07 86.200000000000003p 2.4772029999999997e-07 86.212500000000006p 2.5885709999999999e-07 86.225000000000009p 2.6980619999999999e-07 86.237499999999997p 2.8056060000000002e-07 86.25p 2.9111330000000002e-07 86.262500000000003p 3.0145739999999999e-07 86.274999999999991p 3.1158640000000002e-07 86.287499999999994p 3.2149369999999998e-07 86.299999999999997p 3.31173e-07 86.3125p 3.4061809999999998e-07 86.325000000000003p 3.4982310000000001e-07 86.337500000000006p 3.5878199999999999e-07 86.350000000000009p 3.6748930000000002e-07 86.362499999999997p 3.7593959999999999e-07 86.375p 3.8412739999999998e-07 86.387500000000003p 3.9204769999999999e-07 86.399999999999991p 3.9969569999999998e-07
+ 86.412499999999994p 4.0706650000000001e-07 86.424999999999997p 4.1415570000000002e-07 86.4375p 4.20959e-07 86.450000000000003p 4.2747219999999999e-07 86.462500000000006p 4.336915e-07 86.475000000000009p 4.3961299999999998e-07 86.487499999999997p 4.4523340000000002e-07 86.5p 4.5054930000000002e-07 86.512500000000003p 4.5555770000000001e-07 86.525000000000006p 4.6025559999999999e-07 86.537499999999994p 4.6464039999999998e-07 86.549999999999997p 4.6870969999999999e-07 86.5625p 4.7246129999999999e-07 86.574999999999989p 4.7589309999999998e-07 86.587500000000006p 4.7900329999999999e-07 86.600000000000009p 4.8179050000000004e-07 86.612499999999997p 4.8425320000000003e-07 86.625p 4.8639040000000002e-07
+ 86.637500000000003p 4.8820110000000001e-07 86.650000000000006p 4.8968450000000005e-07 86.662499999999994p 4.9084040000000004e-07 86.674999999999997p 4.9166840000000003e-07 86.6875p 4.921685e-07 86.699999999999989p 4.9234080000000002e-07 86.712500000000006p 4.9218590000000002e-07 86.725000000000009p 4.9170430000000002e-07 86.737499999999997p 4.9089690000000001e-07 86.75p 4.8976470000000002e-07 86.762500000000003p 4.8830899999999998e-07 86.775000000000006p 4.8653129999999995e-07 86.787499999999994p 4.844334e-07 86.799999999999997p 4.8201709999999999e-07 86.8125p 4.7928450000000001e-07 86.824999999999989p 4.7623799999999998e-07 86.837500000000006p 4.7288020000000002e-07 86.850000000000009p 4.6921359999999999e-07
+ 86.862500000000011p 4.652414e-07 86.875p 4.6096649999999999e-07 86.887500000000003p 4.563924e-07 86.900000000000006p 4.5152260000000002e-07 86.912499999999994p 4.4636069999999998e-07 86.924999999999997p 4.4091069999999999e-07 86.9375p 4.3517660000000001e-07 86.949999999999989p 4.2916270000000001e-07 86.962499999999991p 4.2287340000000003e-07 86.975000000000009p 4.163134e-07 86.987500000000011p 4.0948749999999998e-07 87p 4.0240040000000003e-07 87.012500000000003p 3.9505749999999998e-07 87.025000000000006p 3.8746390000000002e-07 87.037499999999994p 3.7962509999999998e-07 87.049999999999997p 3.7154660000000002e-07 87.0625p 3.6323419999999999e-07 87.074999999999989p 3.5469379999999998e-07
+ 87.087499999999991p 3.4593129999999998e-07 87.100000000000009p 3.369528e-07 87.112500000000011p 3.2776470000000002e-07 87.125p 3.1837340000000001e-07 87.137500000000003p 3.087853e-07 87.150000000000006p 2.9900709999999999e-07 87.162499999999994p 2.8904549999999999e-07 87.174999999999997p 2.7890749999999998e-07 87.1875p 2.6859990000000002e-07 87.199999999999989p 2.5812970000000002e-07 87.212499999999991p 2.4750429999999999e-07 87.224999999999994p 2.367307e-07 87.237500000000011p 2.2581629999999999e-07 87.25p 2.1476859999999999e-07 87.262500000000003p 2.035949e-07 87.275000000000006p 1.9230279999999999e-07 87.287499999999994p 1.8089989999999999e-07 87.299999999999997p 1.693939e-07
+ 87.3125p 1.577925e-07 87.325000000000003p 1.4610339999999999e-07 87.337499999999991p 1.343345e-07 87.349999999999994p 1.224935e-07 87.362500000000011p 1.1058840000000001e-07 87.375p 9.862704e-08 87.387500000000003p 8.6617359999999996e-08 87.400000000000006p 7.4567299999999998e-08 87.412499999999994p 6.2484799999999996e-08 87.424999999999997p 5.0377819999999998e-08 87.4375p 3.8254309999999999e-08 87.450000000000003p 2.6122230000000001e-08 87.462499999999991p 1.3989520000000001e-08 87.474999999999994p 1.8641039999999998e-09 87.487499999999997p -1.02461e-08 87.5p -2.233321e-08 87.512500000000003p -3.4389370000000003e-08 87.525000000000006p -4.640675e-08
+ 87.537499999999994p -5.8377589999999997e-08 87.549999999999997p -7.0294130000000002e-08 87.5625p -8.2148679999999994e-08 87.575000000000003p -9.3933629999999994e-08 87.587499999999991p -1.0564139999999999e-07 87.599999999999994p -1.1726440000000001e-07 87.612499999999997p -1.2879530000000001e-07 87.625p -1.402267e-07 87.637500000000003p -1.5155130000000001e-07 87.650000000000006p -1.627618e-07 87.662500000000009p -1.738512e-07 87.674999999999997p -1.848124e-07 87.6875p -1.9563850000000001e-07 87.700000000000003p -2.0632259999999999e-07 87.712499999999991p -2.16858e-07 87.724999999999994p -2.2723800000000001e-07 87.737499999999997p -2.3745619999999999e-07 87.75p -2.475062e-07
+ 87.762500000000003p -2.5738160000000003e-07 87.775000000000006p -2.670764e-07 87.787500000000009p -2.7658439999999998e-07 87.799999999999997p -2.8589970000000001e-07 87.8125p -2.950167e-07 87.825000000000003p -3.0392959999999997e-07 87.837499999999991p -3.1263299999999999e-07 87.849999999999994p -3.2112149999999999e-07 87.862499999999997p -3.2939000000000001e-07 87.875p -3.3743329999999998e-07 87.887500000000003p -3.452466e-07 87.900000000000006p -3.5282509999999998e-07 87.912500000000009p -3.601643e-07 87.924999999999997p -3.6725969999999999e-07 87.9375p -3.7410710000000002e-07 87.950000000000003p -3.8070239999999999e-07 87.962499999999991p -3.8704159999999998e-07 87.974999999999994p -3.9312099999999999e-07
+ 87.987499999999997p -3.9893700000000002e-07 88p -4.0448620000000002e-07 88.012500000000003p -4.0976539999999999e-07 88.025000000000006p -4.1477149999999999e-07 88.037500000000009p -4.1950169999999999e-07 88.049999999999997p -4.239532e-07 88.0625p -4.2812349999999999e-07 88.075000000000003p -4.3201029999999999e-07 88.087499999999991p -4.3561150000000001e-07 88.099999999999994p -4.3892519999999998e-07 88.112499999999997p -4.419494e-07 88.125p -4.4468269999999998e-07 88.137500000000003p -4.4712370000000002e-07 88.150000000000006p -4.4927110000000002e-07 88.162500000000009p -4.5112399999999998e-07 88.174999999999997p -4.5268149999999999e-07 88.1875p -4.5394289999999999e-07 88.200000000000003p -4.5490789999999999e-07
+ 88.212499999999991p -4.5557619999999999e-07 88.224999999999994p -4.5594770000000002e-07 88.237499999999997p -4.5602249999999999e-07 88.25p -4.5580089999999997e-07 88.262500000000003p -4.5528349999999998e-07 88.275000000000006p -4.544709e-07 88.287500000000009p -4.5336399999999998e-07 88.299999999999997p -4.5196389999999999e-07 88.3125p -4.5027179999999999e-07 88.325000000000003p -4.4828920000000001e-07 88.337500000000006p -4.460176e-07 88.349999999999994p -4.4345890000000001e-07 88.362499999999997p -4.4061500000000001e-07 88.375p -4.3748820000000002e-07 88.387500000000003p -4.3408059999999999e-07 88.400000000000006p -4.3039500000000001e-07 88.412500000000009p -4.2643380000000001e-07 88.424999999999997p -4.222001e-07
+ 88.4375p -4.1769679999999997e-07 88.450000000000003p -4.1292709999999999e-07 88.462500000000006p -4.0789440000000001e-07 88.474999999999994p -4.0260220000000001e-07 88.487499999999997p -3.9705430000000001e-07 88.5p -3.9125439999999999e-07 88.512499999999989p -3.852065e-07 88.525000000000006p -3.7891479999999999e-07 88.537500000000009p -3.7238369999999998e-07 88.549999999999997p -3.656175e-07 88.5625p -3.586209e-07 88.575000000000003p -3.5139859999999999e-07 88.587500000000006p -3.4395559999999999e-07 88.599999999999994p -3.3629670000000001e-07 88.612499999999997p -3.2842719999999999e-07 88.625p -3.2035230000000001e-07 88.637499999999989p -3.1207740000000002e-07 88.650000000000006p -3.0360819999999999e-07
+ 88.662500000000009p -2.9495010000000002e-07 88.674999999999997p -2.8610899999999998e-07 88.6875p -2.770907e-07 88.700000000000003p -2.6790130000000001e-07 88.712500000000006p -2.5854669999999999e-07 88.724999999999994p -2.4903320000000001e-07 88.737499999999997p -2.3936699999999998e-07 88.75p -2.2955450000000001e-07 88.762499999999989p -2.1960219999999999e-07 88.774999999999991p -2.095165e-07 88.787500000000009p -1.9930420000000001e-07 88.800000000000011p -1.8897189999999999e-07 88.8125p -1.785263e-07 88.825000000000003p -1.679743e-07 88.837500000000006p -1.573228e-07 88.849999999999994p -1.465787e-07 88.862499999999997p -1.3574900000000001e-07 88.875p -1.2484079999999999e-07
+ 88.887499999999989p -1.138611e-07 88.899999999999991p -1.0281710000000001e-07 88.912500000000009p -9.1716030000000002e-08 88.925000000000011p -8.0564970000000004e-08 88.9375p -6.9371200000000004e-08 88.950000000000003p -5.8141950000000003e-08 88.962500000000006p -4.6884499999999999e-08 88.974999999999994p -3.5606130000000003e-08 88.987499999999997p -2.4314110000000001e-08 89p -1.3015730000000001e-08 89.012499999999989p -1.718289e-09 89.024999999999991p 9.5709399999999992e-09 89.037500000000009p 2.084468e-08 89.050000000000011p 3.2095689999999999e-08 89.0625p 4.3316709999999997e-08 89.075000000000003p 5.4500539999999998e-08 89.087500000000006p 6.5639990000000001e-08 89.099999999999994p 7.6727919999999998e-08
+ 89.112499999999997p 8.7757199999999994e-08 89.125p 9.8720760000000004e-08 89.137500000000003p 1.0961159999999999e-07 89.149999999999991p 1.2042269999999999e-07 89.162499999999994p 1.311471e-07 89.175000000000011p 1.4177810000000001e-07 89.1875p 1.5230880000000001e-07 89.200000000000003p 1.627324e-07 89.212500000000006p 1.7304239999999999e-07 89.224999999999994p 1.832321e-07 89.237499999999997p 1.9329500000000001e-07 89.25p 2.0322480000000001e-07 89.262500000000003p 2.1301500000000001e-07 89.274999999999991p 2.226595e-07 89.287499999999994p 2.3215220000000001e-07 89.300000000000011p 2.414869e-07 89.3125p 2.5065780000000001e-07 89.325000000000003p 2.5965900000000001e-07
+ 89.337500000000006p 2.6848479999999997e-07 89.349999999999994p 2.7712970000000002e-07 89.362499999999997p 2.85588e-07 89.375p 2.9385460000000001e-07 89.387500000000003p 3.0192409999999999e-07 89.399999999999991p 3.0979140000000002e-07 89.412499999999994p 3.174517e-07 89.424999999999997p 3.2489990000000001e-07 89.4375p 3.3213149999999999e-07 89.450000000000003p 3.3914190000000001e-07 89.462500000000006p 3.4592670000000002e-07 89.475000000000009p 3.5248149999999998e-07 89.487499999999997p 3.5880239999999998e-07 89.5p 3.6488529999999998e-07 89.512500000000003p 3.7072630000000001e-07 89.524999999999991p 3.7632200000000003e-07 89.537499999999994p 3.816687e-07 89.549999999999997p 3.8676320000000002e-07
+ 89.5625p 3.9160220000000003e-07 89.575000000000003p 3.9618279999999998e-07 89.587500000000006p 4.0050210000000001e-07 89.600000000000009p 4.045575e-07 89.612499999999997p 4.0834639999999999e-07 89.625p 4.118666e-07 89.637500000000003p 4.1511589999999998e-07 89.649999999999991p 4.1809229999999999e-07 89.662499999999994p 4.2079409999999999e-07 89.674999999999997p 4.2321959999999998e-07 89.6875p 4.253673e-07 89.700000000000003p 4.2723609999999999e-07 89.712500000000006p 4.2882479999999999e-07 89.725000000000009p 4.3013250000000002e-07 89.737499999999997p 4.3115860000000001e-07 89.75p 4.3190250000000001e-07 89.762500000000003p 4.3236380000000001e-07 89.774999999999991p 4.3254230000000001e-07
+ 89.787499999999994p 4.3243820000000001e-07 89.799999999999997p 4.3205159999999999e-07 89.8125p 4.3138279999999998e-07 89.825000000000003p 4.3043249999999999e-07 89.837500000000006p 4.292014e-07 89.850000000000009p 4.2769040000000001e-07 89.862499999999997p 4.2590059999999997e-07 89.875p 4.2383330000000001e-07 89.887500000000003p 4.2149e-07 89.899999999999991p 4.1887240000000002e-07 89.912499999999994p 4.1598219999999998e-07 89.924999999999997p 4.128215e-07 89.9375p 4.0939240000000001e-07 89.950000000000003p 4.0569729999999999e-07 89.962500000000006p 4.0173879999999998e-07 89.975000000000009p 3.9751950000000001e-07 89.987499999999997p 3.9304230000000001e-07 90p 3.883102e-07
+ 90.012500000000003p 3.833264e-07 90.024999999999991p 3.780943e-07 90.037499999999994p 3.7261749999999999e-07 90.049999999999997p 3.6689950000000002e-07 90.0625p 3.6094419999999999e-07 90.075000000000003p 3.547557e-07 90.087500000000006p 3.4833800000000001e-07 90.100000000000009p 3.4169549999999998e-07 90.112499999999997p 3.348326e-07 90.125p 3.2775390000000002e-07 90.137500000000003p 3.204641e-07 90.149999999999991p 3.1296810000000002e-07 90.162499999999994p 3.0527080000000002e-07 90.174999999999997p 2.9737729999999998e-07 90.1875p 2.89293e-07 90.200000000000003p 2.8102330000000002e-07 90.212500000000006p 2.725735e-07 90.225000000000009p 2.6394929999999998e-07
+ 90.237499999999997p 2.5515650000000003e-07 90.25p 2.462009e-07 90.262500000000003p 2.3708840000000001e-07 90.275000000000006p 2.2782499999999999e-07 90.287499999999994p 2.1841699999999999e-07 90.299999999999997p 2.088705e-07 90.3125p 1.9919179999999999e-07 90.324999999999989p 1.893874e-07 90.337500000000006p 1.7946390000000001e-07 90.350000000000009p 1.694276e-07 90.362499999999997p 1.5928529999999999e-07 90.375p 1.4904380000000001e-07 90.387500000000003p 1.3870960000000001e-07 90.400000000000006p 1.2828980000000001e-07 90.412499999999994p 1.177912e-07 90.424999999999997p 1.0722079999999999e-07 90.4375p 9.6585420000000002e-08 90.449999999999989p 8.5892239999999996e-08
+ 90.462500000000006p 7.5148270000000006e-08 90.475000000000009p 6.4360620000000001e-08 90.487499999999997p 5.3536419999999999e-08 90.5p 4.2682820000000001e-08 90.512500000000003p 3.1806969999999999e-08 90.525000000000006p 2.0916069999999999e-08 90.537499999999994p 1.0017309999999999e-08 90.549999999999997p -8.821354e-10 90.5625p -1.177506e-08 90.574999999999989p -2.2654269999999999e-08 90.587500000000006p -3.3512600000000002e-08 90.600000000000009p -4.434289e-08 90.612500000000011p -5.5137989999999997e-08 90.625p -6.589078e-08 90.637500000000003p -7.6594179999999995e-08 90.650000000000006p -8.7241130000000002e-08 90.662499999999994p -9.7824620000000002e-08 90.674999999999997p -1.083377e-07
+ 90.6875p -1.187734e-07 90.699999999999989p -1.291248e-07 90.712499999999991p -1.393853e-07 90.725000000000009p -1.4954789999999999e-07 90.737500000000011p -1.5960600000000001e-07 90.75p -1.6955300000000001e-07 90.762500000000003p -1.7938240000000001e-07 90.775000000000006p -1.890877e-07 90.787499999999994p -1.986625e-07 90.799999999999997p -2.081005e-07 90.8125p -2.173956e-07 90.824999999999989p -2.265416e-07 90.837499999999991p -2.3553250000000001e-07 90.850000000000009p -2.4436250000000002e-07 90.862500000000011p -2.530257e-07 90.875p -2.6151649999999998e-07 90.887500000000003p -2.6982919999999998e-07 90.900000000000006p -2.7795859999999999e-07
+ 90.912499999999994p -2.858992e-07 90.924999999999997p -2.9364589999999999e-07 90.9375p -3.011935e-07 90.950000000000003p -3.0853729999999998e-07 90.962499999999991p -3.1567239999999999e-07 90.974999999999994p -3.2259399999999998e-07 90.987500000000011p -3.2929790000000002e-07 91p -3.3577949999999999e-07 91.012500000000003p -3.420347e-07 91.025000000000006p -3.480594e-07 91.037499999999994p -3.5384980000000002e-07 91.049999999999997p -3.59402e-07 91.0625p -3.647125e-07 91.075000000000003p -3.6977790000000003e-07 91.087499999999991p -3.7459490000000001e-07 91.099999999999994p -3.7916039999999998e-07 91.112500000000011p -3.8347150000000002e-07 91.125p -3.8752550000000001e-07
+ 91.137500000000003p -3.913198e-07 91.150000000000006p -3.9485200000000002e-07 91.162499999999994p -3.9811979999999998e-07 91.174999999999997p -4.0112119999999999e-07 91.1875p -4.0385439999999998e-07 91.200000000000003p -4.0631759999999998e-07 91.212499999999991p -4.0850939999999999e-07 91.224999999999994p -4.1042829999999998e-07 91.237499999999997p -4.1207340000000001e-07 91.25p -4.1344360000000001e-07 91.262500000000003p -4.1453809999999999e-07 91.275000000000006p -4.153564e-07 91.287499999999994p -4.158981e-07 91.299999999999997p -4.1616289999999997e-07 91.3125p -4.1615080000000002e-07 91.325000000000003p -4.1586200000000002e-07 91.337499999999991p -4.1529680000000001e-07 91.349999999999994p -4.1445569999999999e-07
+ 91.362499999999997p -4.1333950000000001e-07 91.375p -4.1194900000000001e-07 91.387500000000003p -4.102853e-07 91.400000000000006p -4.083497e-07 91.412500000000009p -4.0614359999999999e-07 91.424999999999997p -4.0366870000000001e-07 91.4375p -4.0092670000000002e-07 91.450000000000003p -3.9791969999999998e-07 91.462499999999991p -3.9464969999999997e-07 91.474999999999994p -3.9111919999999998e-07 91.487499999999997p -3.8733070000000001e-07 91.5p -3.8328680000000003e-07 91.512500000000003p -3.7899030000000001e-07 91.525000000000006p -3.7444439999999998e-07 91.537500000000009p -3.6965220000000002e-07 91.549999999999997p -3.6461700000000002e-07 91.5625p -3.5934240000000001e-07 91.575000000000003p -3.5383209999999998e-07
+ 91.587499999999991p -3.480898e-07 91.599999999999994p -3.4211959999999997e-07 91.612499999999997p -3.359255e-07 91.625p -3.2951199999999999e-07 91.637500000000003p -3.228833e-07 91.650000000000006p -3.1604420000000001e-07 91.662500000000009p -3.0899919999999998e-07 91.674999999999997p -3.0175330000000002e-07 91.6875p -2.9431139999999999e-07 91.700000000000003p -2.8667870000000002e-07 91.712499999999991p -2.7886030000000003e-07 91.724999999999994p -2.708617e-07 91.737499999999997p -2.6268830000000001e-07 91.75p -2.5434570000000002e-07 91.762500000000003p -2.4583960000000001e-07 91.775000000000006p -2.3717579999999999e-07 91.787500000000009p -2.2836029999999999e-07 91.799999999999997p -2.1939899999999999e-07
+ 91.8125p -2.1029809999999999e-07 91.825000000000003p -2.010637e-07 91.837499999999991p -1.917021e-07 91.849999999999994p -1.822197e-07 91.862499999999997p -1.72623e-07 91.875p -1.629184e-07 91.887500000000003p -1.5311249999999999e-07 91.900000000000006p -1.43212e-07 91.912500000000009p -1.3322360000000001e-07 91.924999999999997p -1.2315410000000001e-07 91.9375p -1.130102e-07 91.950000000000003p -1.027988e-07 91.962499999999991p -9.2526839999999994e-08 91.974999999999994p -8.2201229999999997e-08 91.987499999999997p -7.1828929999999998e-08 92p -6.1416929999999998e-08 92.012500000000003p -5.0972259999999998e-08 92.025000000000006p -4.0501929999999999e-08
+ 92.037500000000009p -3.0012999999999999e-08 92.049999999999997p -1.95125e-08 92.0625p -9.0075049999999997e-09 92.075000000000003p 1.494949e-09 92.087500000000006p 1.198782e-08 92.099999999999994p 2.2464060000000001e-08 92.112499999999997p 3.291668e-08 92.125p 4.3338659999999999e-08 92.137500000000003p 5.372305e-08 92.150000000000006p 6.4062919999999997e-08 92.162500000000009p 7.4351350000000001e-08 92.174999999999997p 8.4581489999999999e-08 92.1875p 9.4746520000000001e-08 92.200000000000003p 1.048397e-07 92.212500000000006p 1.1485429999999999e-07 92.224999999999994p 1.2478359999999999e-07 92.237499999999997p 1.3462109999999999e-07 92.25p 1.4436030000000001e-07
+ 92.262499999999989p 1.5399469999999999e-07 92.275000000000006p 1.635179e-07 92.287500000000009p 1.729236e-07 92.299999999999997p 1.8220570000000001e-07 92.3125p 1.9135800000000001e-07 92.325000000000003p 2.0037440000000001e-07 92.337500000000006p 2.0924920000000001e-07 92.349999999999994p 2.179763e-07 92.362499999999997p 2.2655009999999999e-07 92.375p 2.3496510000000001e-07 92.387499999999989p 2.432156e-07 92.400000000000006p 2.5129630000000001e-07 92.412500000000009p 2.5920199999999999e-07 92.424999999999997p 2.6692740000000001e-07 92.4375p 2.7446760000000002e-07 92.450000000000003p 2.8181769999999999e-07 92.462500000000006p 2.88973e-07 92.474999999999994p 2.9592870000000003e-07
+ 92.487499999999997p 3.0268050000000002e-07 92.5p 3.0922400000000002e-07 92.512499999999989p 3.1555500000000002e-07 92.524999999999991p 3.2166949999999998e-07 92.537500000000009p 3.2756349999999999e-07 92.550000000000011p 3.3323340000000003e-07 92.5625p 3.3867549999999999e-07 92.575000000000003p 3.4388640000000001e-07 92.587500000000006p 3.488629e-07 92.599999999999994p 3.5360180000000001e-07 92.612499999999997p 3.5810019999999999e-07 92.625p 3.6235540000000001e-07 92.637499999999989p 3.6636460000000002e-07 92.649999999999991p 3.7012549999999997e-07 92.662500000000009p 3.7363580000000001e-07 92.675000000000011p 3.7689329999999999e-07 92.6875p 3.7989619999999999e-07 92.700000000000003p 3.8264269999999999e-07
+ 92.712500000000006p 3.8513120000000002e-07 92.724999999999994p 3.8736040000000002e-07 92.737499999999997p 3.8932889999999999e-07 92.75p 3.9103570000000001e-07 92.762499999999989p 3.9247999999999998e-07 92.774999999999991p 3.9366100000000002e-07 92.787499999999994p 3.945783e-07 92.800000000000011p 3.9523150000000001e-07 92.8125p 3.9562040000000001e-07 92.825000000000003p 3.9574509999999999e-07 92.837500000000006p 3.956057e-07 92.849999999999994p 3.952026e-07 92.862499999999997p 3.945364e-07 92.875p 3.936078e-07 92.887500000000003p 3.9241769999999998e-07 92.899999999999991p 3.9096709999999998e-07 92.912499999999994p 3.8925729999999998e-07 92.925000000000011p 3.8728979999999998e-07
+ 92.9375p 3.8506609999999998e-07 92.950000000000003p 3.8258799999999998e-07 92.962500000000006p 3.798575e-07 92.974999999999994p 3.7687649999999998e-07 92.987499999999997p 3.736475e-07 93p 3.7017279999999998e-07 93.012500000000003p 3.6645499999999998e-07 93.024999999999991p 3.624969e-07 93.037499999999994p 3.5830140000000002e-07 93.050000000000011p 3.5387150000000002e-07 93.0625p 3.492105e-07 93.075000000000003p 3.4432180000000002e-07 93.087500000000006p 3.3920880000000002e-07 93.099999999999994p 3.3387530000000002e-07 93.112499999999997p 3.28325e-07 93.125p 3.22562e-07 93.137500000000003p 3.1659019999999999e-07 93.149999999999991p 3.1041399999999999e-07
+ 93.162499999999994p 3.0403759999999999e-07 93.174999999999997p 2.974656e-07 93.1875p 2.9070249999999999e-07 93.200000000000003p 2.837532e-07 93.212500000000006p 2.7662250000000001e-07 93.225000000000009p 2.6931519999999998e-07 93.237499999999997p 2.6183660000000002e-07 93.25p 2.5419179999999999e-07 93.262500000000003p 2.4638610000000001e-07 93.274999999999991p 2.3842479999999998e-07 93.287499999999994p 2.3031360000000001e-07 93.299999999999997p 2.220579e-07 93.3125p 2.1366339999999999e-07 93.325000000000003p 2.0513599999999999e-07 93.337500000000006p 1.9648139999999999e-07 93.350000000000009p 1.8770550000000001e-07 93.362499999999997p 1.7881449999999999e-07 93.375p 1.698142e-07
+ 93.387500000000003p 1.607109e-07 93.399999999999991p 1.5151070000000001e-07 93.412499999999994p 1.4221989999999999e-07 93.424999999999997p 1.3284480000000001e-07 93.4375p 1.2339169999999999e-07 93.450000000000003p 1.13867e-07 93.462500000000006p 1.042772e-07 93.475000000000009p 9.4628660000000004e-08 93.487499999999997p 8.4927930000000002e-08 93.5p 7.5181519999999997e-08 93.512500000000003p 6.5395980000000006e-08 93.524999999999991p 5.5577870000000001e-08 93.537499999999994p 4.5733749999999998e-08 93.549999999999997p 3.5870209999999997e-08 93.5625p 2.599383e-08 93.575000000000003p 1.6111209999999999e-08 93.587500000000006p 6.22892e-09 93.600000000000009p -3.6464679999999999e-09
+ 93.612499999999997p -1.350839e-08 93.625p -2.335032e-08 93.637500000000003p -3.3165719999999997e-08 93.649999999999991p -4.2948109999999997e-08 93.662499999999994p -5.2691030000000001e-08 93.674999999999997p -6.2388040000000002e-08 93.6875p -7.2032769999999993e-08 93.700000000000003p -8.1618870000000003e-08 93.712500000000006p -9.1140039999999994e-08 93.725000000000009p -1.0059e-07 93.737499999999997p -1.099627e-07 93.75p -1.192518e-07 93.762500000000003p -1.2845140000000001e-07 93.774999999999991p -1.375555e-07 93.787499999999994p -1.465581e-07 93.799999999999997p -1.5545330000000001e-07 93.8125p -1.642355e-07 93.825000000000003p -1.728989e-07
+ 93.837500000000006p -1.8143789999999999e-07 93.850000000000009p -1.8984699999999999e-07 93.862499999999997p -1.9812079999999999e-07 93.875p -2.0625399999999999e-07 93.887500000000003p -2.1424139999999999e-07 93.899999999999991p -2.2207770000000001e-07 93.912499999999994p -2.297582e-07 93.924999999999997p -2.3727770000000001e-07 93.9375p -2.4463160000000002e-07 93.950000000000003p -2.5181519999999999e-07 93.962500000000006p -2.588239e-07 93.975000000000009p -2.656534e-07 93.987499999999997p -2.7229919999999998e-07 94p -2.7875729999999999e-07 94.012500000000003p -2.8502359999999998e-07 94.025000000000006p -2.9109409999999999e-07 94.037499999999994p -2.969652e-07 94.049999999999997p -3.0263310000000003e-07
+ 94.0625p -3.0809439999999997e-07 94.074999999999989p -3.1334579999999999e-07 94.087500000000006p -3.1838389999999998e-07 94.100000000000009p -3.2320570000000001e-07 94.112499999999997p -3.2780839999999999e-07 94.125p -3.3218899999999998e-07 94.137500000000003p -3.3634509999999998e-07 94.150000000000006p -3.402742e-07 94.162499999999994p -3.439738e-07 94.174999999999997p -3.47442e-07 94.1875p -3.5067660000000002e-07 94.199999999999989p -3.5367579999999999e-07 94.212500000000006p -3.5643789999999999e-07 94.225000000000009p -3.5896139999999998e-07 94.237499999999997p -3.6124490000000001e-07 94.25p -3.6328719999999997e-07 94.262500000000003p -3.650872e-07 94.275000000000006p -3.6664419999999999e-07
+ 94.287499999999994p -3.6795719999999998e-07 94.299999999999997p -3.6902579999999997e-07 94.3125p -3.6984960000000002e-07 94.324999999999989p -3.7042829999999999e-07 94.337500000000006p -3.7076179999999998e-07 94.350000000000009p -3.708502e-07 94.362500000000011p -3.7069380000000001e-07 94.375p -3.702929e-07 94.387500000000003p -3.6964820000000001e-07 94.400000000000006p -3.6876020000000001e-07 94.412499999999994p -3.6763010000000001e-07 94.424999999999997p -3.662586e-07 94.4375p -3.6464719999999998e-07 94.449999999999989p -3.6279700000000002e-07 94.462499999999991p -3.6070969999999998e-07 94.475000000000009p -3.583869e-07 94.487500000000011p -3.5583030000000001e-07 94.5p -3.5304209999999998e-07
+ 94.512500000000003p -3.500242e-07 94.525000000000006p -3.4677900000000001e-07 94.537499999999994p -3.4330880000000001e-07 94.549999999999997p -3.396162e-07 94.5625p -3.3570400000000003e-07 94.574999999999989p -3.3157489999999998e-07 94.587499999999991p -3.2723190000000001e-07 94.600000000000009p -3.2267820000000001e-07 94.612500000000011p -3.17917e-07 94.625p -3.1295159999999999e-07 94.637500000000003p -3.077857e-07 94.650000000000006p -3.0242269999999998e-07 94.662499999999994p -2.9686649999999999e-07 94.674999999999997p -2.91121e-07 94.6875p -2.8519020000000001e-07 94.700000000000003p -2.7907810000000002e-07 94.712499999999991p -2.7278910000000001e-07 94.724999999999994p -2.6632740000000002e-07
+ 94.737500000000011p -2.5969750000000001e-07 94.75p -2.52904e-07 94.762500000000003p -2.4595149999999999e-07 94.775000000000006p -2.3884469999999999e-07 94.787499999999994p -2.315886e-07 94.799999999999997p -2.2418809999999999e-07 94.8125p -2.1664809999999999e-07 94.825000000000003p -2.0897379999999999e-07 94.837499999999991p -2.0117050000000001e-07 94.849999999999994p -1.9324330000000001e-07 94.862500000000011p -1.8519759999999999e-07 94.875p -1.7703890000000001e-07 94.887500000000003p -1.687726e-07 94.900000000000006p -1.6040429999999999e-07 94.912499999999994p -1.5193950000000001e-07 94.924999999999997p -1.4338400000000001e-07 94.9375p -1.347434e-07 94.950000000000003p -1.260236e-07
+ 94.962499999999991p -1.172303e-07 94.974999999999994p -1.083695e-07 94.987499999999997p -9.9446850000000002e-08 95p -9.0468450000000004e-08 95.012500000000003p 5.5013029999999999e-05 95.025000000000006p 3.4587639999999997e-05 95.037499999999994p 3.3639110000000002e-05 95.049999999999997p 3.3158480000000003e-05 95.0625p 3.3124689999999997e-05 95.075000000000003p 3.3513629999999999e-05 95.087499999999991p 3.430038e-05 95.099999999999994p 3.5460070000000001e-05 95.112499999999997p 3.6968239999999999e-05 95.125p 3.8800970000000001e-05 95.137500000000003p 4.0934969999999998e-05 95.150000000000006p 4.334772e-05 95.162500000000009p 4.601744e-05 95.174999999999997p 4.892321e-05
+ 95.1875p 5.2044959999999998e-05 95.200000000000003p 5.5363540000000002e-05 95.212499999999991p 5.8860760000000001e-05 95.224999999999994p 6.2519329999999998e-05 95.237499999999997p 6.6322970000000006e-05 95.25p 7.0256349999999997e-05 95.262500000000003p 7.4305129999999996e-05 95.275000000000006p 7.8455930000000004e-05 95.287500000000009p 8.2696320000000004e-05 95.299999999999997p 8.7014829999999994e-05 95.3125p 9.1400889999999994e-05 95.325000000000003p 9.5844850000000004e-05 95.337499999999991p 0.00010033789999999999 95.349999999999994p 0.0001048721 95.362499999999997p 0.0001094402 95.375p 0.000114036 95.387500000000003p 0.00011865360000000001 95.400000000000006p 0.0001232881
+ 95.412500000000009p 0.00012793510000000001 95.424999999999997p 0.00013259090000000001 95.4375p 0.00013725219999999999 95.450000000000003p 0.00014191630000000001 95.462499999999991p 0.0001465809 95.474999999999994p 0.00015124419999999999 95.487499999999997p 0.00015590450000000001 95.5p 0.0001605608 95.512500000000003p 0.000165212 95.525000000000006p 0.00016985749999999999 95.537500000000009p 0.0001744967 95.549999999999997p 0.00017912930000000001 95.5625p 0.00018375499999999999 95.575000000000003p 0.00018837359999999999 95.587499999999991p 0.00019298500000000001 95.599999999999994p 0.00019758889999999999 95.612499999999997p 0.00020218530000000001 95.625p 0.00020677400000000001
+ 95.637500000000003p 0.00021135460000000001 95.650000000000006p 0.00021592679999999999 95.662500000000009p 0.00022049010000000001 95.674999999999997p 0.0002250439 95.6875p 0.00022958740000000001 95.700000000000003p 0.0002341198 95.712499999999991p 0.00023864010000000001 95.724999999999994p 0.0002431469 95.737499999999997p 0.00024763900000000002 95.75p 0.00025211480000000001 95.762500000000003p 0.0002565725 95.775000000000006p 0.00026101040000000002 95.787500000000009p 0.00026542630000000002 95.799999999999997p 0.00026981809999999999 95.8125p 0.00027418339999999997 95.825000000000003p 0.0002785199 95.837500000000006p 0.000282825 95.849999999999994p 0.00028709599999999998
+ 95.862499999999997p 0.00029133000000000002 95.875p 0.0002955244 95.887500000000003p 0.00029967619999999998 95.900000000000006p 0.00030378250000000001 95.912500000000009p 0.00030784029999999997 95.924999999999997p 0.00031184669999999998 95.9375p 0.0003157988 95.950000000000003p 0.00031969369999999998 95.962500000000006p 0.00032352850000000002 95.974999999999994p 0.00032730040000000001 95.987499999999997p 0.00033100689999999999 96p 0.0003346453 96.012499999999989p 0.00028311889999999999 96.025000000000006p 0.00030704860000000002 96.037500000000009p 0.00031142650000000002 96.049999999999997p 0.00031525969999999999 96.0625p 0.00031856730000000001 96.075000000000003p 0.0003213717
+ 96.087500000000006p 0.00032369640000000003 96.099999999999994p 0.00032556490000000001 96.112499999999997p 0.00032700049999999999 96.125p 0.00032802629999999997 96.137499999999989p 0.00032866489999999998 96.150000000000006p 0.00032893819999999999 96.162500000000009p 0.0003288678 96.174999999999997p 0.00032847470000000001 96.1875p 0.00032777899999999999 96.200000000000003p 0.00032680030000000002 96.212500000000006p 0.0003255574 96.224999999999994p 0.00032406859999999999 96.237499999999997p 0.00032235119999999998 96.25p 0.00032042179999999999 96.262499999999989p 0.00031829630000000002 96.274999999999991p 0.00031598969999999999 96.287500000000009p 0.00031351650000000002 96.300000000000011p 0.00031089030000000002
+ 96.3125p 0.00030812379999999999 96.325000000000003p 0.00030522919999999997 96.337500000000006p 0.00030221799999999999 96.349999999999994p 0.00029910080000000001 96.362499999999997p 0.00029588770000000002 96.375p 0.0002925882 96.387499999999989p 0.00028921110000000003 96.399999999999991p 0.00028576460000000003 96.412500000000009p 0.00028225629999999998 96.425000000000011p 0.0002786935 96.4375p 0.00027508269999999997 96.450000000000003p 0.00027143030000000002 96.462500000000006p 0.00026774189999999998 96.474999999999994p 0.000264023 96.487499999999997p 0.00026027850000000003 96.5p 0.00025651310000000002 96.512499999999989p 0.00025273130000000001 96.524999999999991p 0.0002489371
+ 96.537499999999994p 0.00024513429999999998 96.550000000000011p 0.00024132670000000001 96.5625p 0.00023751769999999999 96.575000000000003p 0.00023371049999999999 96.587500000000006p 0.0002299084 96.599999999999994p 0.00022611429999999999 96.612499999999997p 0.0002223312 96.625p 0.00021856189999999999 96.637500000000003p 0.00021480929999999999 96.649999999999991p 0.00021107609999999999 96.662499999999994p 0.00020736499999999999 96.675000000000011p 0.00020367860000000001 96.6875p 0.00020001980000000001 96.700000000000003p 0.00019639120000000001 96.712500000000006p 0.00019279550000000001 96.724999999999994p 0.00018923550000000001 96.737499999999997p 0.00018571390000000001 96.75p 0.00018223339999999999
+ 96.762500000000003p 0.00017879699999999999 96.774999999999991p 0.00017540749999999999 96.787499999999994p 0.00017206780000000001 96.800000000000011p 0.0001687808 96.8125p 0.0001655494 96.825000000000003p 0.00016237669999999999 96.837500000000006p 0.00015926570000000001 96.849999999999994p 0.0001562194 96.862499999999997p 0.0001532409 96.875p 0.0001503334 96.887500000000003p 0.00014749979999999999 96.899999999999991p 0.00014474339999999999 96.912499999999994p 0.00014206719999999999 96.924999999999997p 0.0001394744 96.9375p 0.00013696800000000001 96.950000000000003p 0.00013455119999999999 96.962500000000006p 0.0001322269 96.975000000000009p 0.00012999830000000001
+ 96.987499999999997p 0.0001278683 97p 0.00012583979999999999 97.012500000000003p 0.0001239159 97.024999999999991p 0.00012209929999999999 97.037499999999994p 0.0001203929 97.049999999999997p 0.00011879930000000001 97.0625p 0.0001173214 97.075000000000003p 0.0001159615 97.087500000000006p 0.0001147224 97.100000000000009p 0.0001136064 97.112499999999997p 0.0001126159 97.125p 0.00011175310000000001 97.137500000000003p 0.0001110203 97.149999999999991p 0.0001104195 97.162499999999994p 0.0001099528 97.174999999999997p 0.000109622 97.1875p 0.00010942890000000001 97.200000000000003p 0.0001093753
+ 97.212500000000006p 0.00010946280000000001 97.225000000000009p 0.00010969279999999999 97.237499999999997p 0.00011006689999999999 97.25p 0.0001105862 97.262500000000003p 0.000111252 97.274999999999991p 0.0001120655 97.287499999999994p 0.0001130276 97.299999999999997p 0.0001141392 97.3125p 0.0001154012 97.325000000000003p 0.0001168142 97.337500000000006p 0.000118379 97.350000000000009p 0.000120096 97.362499999999997p 0.0001219656 97.375p 0.00012398810000000001 97.387500000000003p 0.0001261639 97.399999999999991p 0.0001284929 97.412499999999994p 0.00013097529999999999 97.424999999999997p 0.00013361100000000001
+ 97.4375p 0.00013639969999999999 97.450000000000003p 0.00013934129999999999 97.462500000000006p 0.00014243519999999999 97.475000000000009p 0.0001456811 97.487499999999997p 0.00014907820000000001 97.5p 0.00015262589999999999 97.512500000000003p 0.00015632330000000001 97.524999999999991p 0.0001601695 97.537499999999994p 0.00016416320000000001 97.549999999999997p 0.00016830330000000001 97.5625p 0.00017258829999999999 97.575000000000003p 0.0001770167 97.587500000000006p 0.00018158669999999999 97.600000000000009p 0.0001862965 97.612499999999997p 0.000191144 97.625p 0.0001961268 97.637500000000003p 0.0002012425 97.649999999999991p 0.00020648840000000001
+ 97.662499999999994p 0.0002118616 97.674999999999997p 0.00021735879999999999 97.6875p 0.0002229767 97.700000000000003p 0.00022871139999999999 97.712500000000006p 0.0002345591 97.725000000000009p 0.00024051549999999999 97.737499999999997p 0.00024657580000000002 97.75p 0.00025273519999999999 97.762500000000003p 0.00025898840000000001 97.775000000000006p 0.00026532969999999999 97.787499999999994p 0.00027175300000000001 97.799999999999997p 0.00027825210000000003 97.8125p 0.00028481989999999999 97.824999999999989p 0.00029144940000000002 97.837500000000006p 0.00029813270000000002 97.850000000000009p 0.0003048619 97.862499999999997p 0.00031162820000000001 97.875p 0.00031842280000000001
+ 97.887500000000003p 0.00032523609999999999 97.900000000000006p 0.0003320582 97.912499999999994p 0.00033887860000000002 97.924999999999997p 0.00034568640000000002 97.9375p 0.00035247030000000001 97.949999999999989p 0.00035921830000000001 97.962500000000006p 0.00036591830000000001 97.975000000000009p 0.00037255740000000001 97.987499999999997p 0.00037912260000000001 98p 0.00038560009999999997 98.012500000000003p 0.00039197590000000001 98.025000000000006p 0.00039823579999999999 98.037499999999994p 0.00040436489999999997 98.049999999999997p 0.00041034829999999999 98.0625p 0.0004161705 98.074999999999989p 0.00042181610000000002 98.087500000000006p 0.00042726910000000001 98.100000000000009p 0.00043251360000000003
+ 98.112500000000011p 0.00043753349999999999 98.125p 0.00044231259999999998 98.137500000000003p 0.00044683469999999998 98.150000000000006p 0.00045108350000000003 98.162499999999994p 0.00045504289999999999 98.174999999999997p 0.00045869679999999998 98.1875p 0.00046202930000000003 98.199999999999989p 0.00046502479999999997 98.212499999999991p 0.00046766800000000002 98.225000000000009p 0.00046994369999999998 98.237500000000011p 0.00047183730000000001 98.25p 0.00047333450000000001 98.262500000000003p 0.00047442170000000001 98.275000000000006p 0.00047508560000000002 98.287499999999994p 0.0004753135 98.299999999999997p 0.00047509359999999999 98.3125p 0.00047441429999999998 98.324999999999989p 0.00047326520000000002
+ 98.337499999999991p 0.00047163640000000002 98.350000000000009p 0.00046951890000000002 98.362500000000011p 0.00046690430000000002 98.375p 0.00046378530000000003 98.387500000000003p 0.00046015539999999999 98.400000000000006p 0.00045600909999999998 98.412499999999994p 0.00045134180000000002 98.424999999999997p 0.0004461496 98.4375p 0.00044043009999999999 98.450000000000003p 0.00043418139999999998 98.462499999999991p 0.00042740280000000001 98.474999999999994p 0.00042009479999999998 98.487500000000011p 0.00041225849999999999 98.5p 0.0004038965 98.512500000000003p 0.00039501210000000001 98.525000000000006p 0.00038560979999999998 98.537499999999994p 0.000375695 98.549999999999997p 0.00036527419999999997
+ 98.5625p 0.00035435499999999999 98.575000000000003p 0.00034294579999999999 98.587499999999991p 0.0003310562 98.599999999999994p 0.00031869659999999997 98.612500000000011p 0.0003058785 98.625p 0.00029261419999999997 98.637500000000003p 0.00027891709999999998 98.650000000000006p 0.0002648013 98.662499999999994p 0.00025028190000000002 98.674999999999997p 0.00023537469999999999 98.6875p 0.0002200963 98.700000000000003p 0.00020446430000000001 98.712499999999991p 0.00018849679999999999 98.724999999999994p 0.0001722126 98.737499999999997p 0.00015563130000000001 98.75p 0.00013877299999999999 98.762500000000003p 0.0001216583 98.775000000000006p 0.00010430860000000001
+ 98.787499999999994p 8.6745379999999997e-05 98.799999999999997p 6.8990950000000001e-05 98.8125p 5.1067820000000001e-05 98.825000000000003p 3.2998869999999998e-05 98.837499999999991p 1.480731e-05 98.849999999999994p -3.4834080000000002e-06 98.862499999999997p -2.1849609999999999e-05 98.875p -4.0267459999999997e-05 98.887500000000003p -5.8712979999999997e-05 98.900000000000006p -7.716214e-05 98.912500000000009p -9.5590860000000004e-05 98.924999999999997p -0.0001139751 98.9375p -0.00013229069999999999 98.950000000000003p -0.0001505139 98.962499999999991p -0.0001686208 98.974999999999994p -0.0001865878 98.987499999999997p -0.00020439150000000001 99p -0.00022200869999999999
+ 99.012500000000003p -0.0002394164 99.025000000000006p -0.0002565922 99.037500000000009p -0.00027351369999999999 99.049999999999997p -0.00029015909999999999 99.0625p -0.00030650689999999999 99.075000000000003p -0.00032253609999999998 99.087499999999991p -0.00033822609999999999 99.099999999999994p -0.000353557 99.112499999999997p -0.00036850899999999999 99.125p -0.0003830633 99.137500000000003p -0.00039720139999999999 99.150000000000006p -0.00041090529999999998 99.162500000000009p -0.00042415790000000002 99.174999999999997p -0.00043694259999999999 99.1875p -0.00044924329999999999 99.200000000000003p -0.00046104479999999997 99.212499999999991p -0.0004723323 99.224999999999994p -0.0004830921
+ 99.237499999999997p -0.00049331080000000001 99.25p -0.00050297609999999996 99.262500000000003p -0.00051207610000000001 99.275000000000006p -0.00052059990000000004 99.287500000000009p -0.00052853730000000003 99.299999999999997p -0.00053587890000000003 99.3125p -0.000542616 99.325000000000003p -0.00054874090000000002 99.337499999999991p -0.00055424649999999995 99.349999999999994p -0.00055912669999999998 99.362499999999997p -0.00056337620000000005 99.375p -0.00056699029999999996 99.387500000000003p -0.00056996550000000003 99.400000000000006p -0.00057229890000000004 99.412500000000009p -0.00057398859999999998 99.424999999999997p -0.0005750334 99.4375p -0.00057543299999999998 99.450000000000003p -0.00057518809999999995
+ 99.462499999999991p -0.00057429989999999999 99.474999999999994p -0.00057277079999999995 99.487499999999997p -0.00057060390000000002 99.5p -0.00056780299999999997 99.512500000000003p -0.00056437269999999996 99.525000000000006p -0.00056031869999999999 99.537500000000009p -0.0005556472 99.549999999999997p -0.00055036530000000003 99.5625p -0.00054448069999999999 99.575000000000003p -0.00053800199999999999 99.587500000000006p -0.00053093859999999999 99.599999999999994p -0.00052330029999999997 99.612499999999997p -0.00051509799999999997 99.625p -0.00050634289999999999 99.637500000000003p -0.00049704709999999995 99.650000000000006p -0.00048722320000000002 99.662500000000009p -0.00047688450000000002 99.674999999999997p -0.00046604490000000002
+ 99.6875p -0.00045471880000000001 99.700000000000003p -0.00044292129999999998 99.712500000000006p -0.00043066799999999999 99.724999999999994p -0.00041797489999999997 99.737499999999997p -0.00040485869999999999 99.75p -0.0003913365 99.762499999999989p -0.00037742599999999999 99.775000000000006p -0.00036314499999999999 99.787500000000009p -0.0003485122 99.799999999999997p -0.00033354640000000002 99.8125p -0.00031826689999999997 99.825000000000003p -0.00030269329999999998 99.837500000000006p -0.00028684560000000002 99.849999999999994p -0.00027074400000000001 99.862499999999997p -0.00025440910000000002 99.875p -0.00023786160000000001 99.887499999999989p -0.00022112259999999999 99.900000000000006p -0.00020421320000000001
+ 99.912500000000009p -0.0001871547 99.924999999999997p -0.0001699685 99.9375p -0.000152676 99.950000000000003p -0.0001352987 99.962500000000006p -0.0001178581 99.974999999999994p -0.0001003754 99.987499999999997p -8.2872010000000003e-05 100p -6.5368970000000002e-05 100.01249999999999p -4.7887180000000003e-05 100.02499999999999p -3.0447299999999999e-05 100.03750000000001p -1.30697e-05 100.05000000000001p 4.2255749999999998e-06 100.0625p 2.141886e-05 100.075p 3.8490910000000002e-05 100.08750000000001p 5.5422910000000002e-05 100.09999999999999p 7.2196579999999998e-05 100.1125p 8.879413e-05 100.125p 0.00010519840000000001
+ 100.13749999999999p 0.0001213927 100.14999999999999p 0.0001373612 100.16250000000001p 0.0001530886 100.17500000000001p 0.00016856029999999999 100.1875p 0.00018376239999999999 100.2p 0.00019868190000000001 100.21250000000001p 0.0002133065 100.22499999999999p 0.0002276247 100.2375p 0.00024162580000000001 100.25p 0.00025529989999999999 100.26249999999999p 0.00026863810000000001 100.27499999999999p 0.0002816324 100.28749999999999p 0.00029427540000000001 100.30000000000001p 0.00030656079999999999 100.3125p 0.00031848320000000001 100.325p 0.00033003809999999998 100.33750000000001p 0.00034122170000000003 100.34999999999999p 0.00035203140000000002
+ 100.3625p 0.00036246530000000001 100.375p 0.00037252249999999998 100.3875p 0.00038220289999999998 100.39999999999999p 0.00039150730000000003 100.41249999999999p 0.00040043730000000001 100.42500000000001p 0.0004089955 100.4375p 0.00041718529999999998 100.45p 0.00042501079999999997 100.46250000000001p 0.00043247700000000001 100.47499999999999p 0.00043958970000000002 100.4875p 0.0004463553 100.5p 0.00045278110000000001 100.5125p 0.00045887510000000001 100.52499999999999p 0.0004646459 100.53749999999999p 0.00047010269999999999 100.55000000000001p 0.00047525539999999998 100.5625p 0.00048011439999999999 100.575p 0.00048469080000000002
+ 100.58750000000001p 0.00048899610000000004 100.59999999999999p 0.00049304209999999999 100.6125p 0.00049684130000000003 100.625p 0.00050040640000000003 100.6375p 0.00050375050000000003 100.64999999999999p 0.00050688689999999999 100.66249999999999p 0.00050982930000000005 100.675p 0.00051259139999999999 100.6875p 0.00051518709999999999 100.7p 0.00051763039999999996 100.71250000000001p 0.00051993530000000001 100.72500000000001p 0.00052211569999999999 100.7375p 0.00052418549999999999 100.75p 0.00052615840000000001 100.7625p 0.00052804779999999997 100.77499999999999p 0.00052986709999999998 100.78749999999999p 0.00053162890000000001 100.8p 0.00053334590000000005
+ 100.8125p 0.0005350299 100.825p 0.00053669250000000003 100.83750000000001p 0.00053834460000000005 100.85000000000001p 0.00053999630000000005 100.8625p 0.00054165729999999996 100.875p 0.00054333620000000002 100.8875p 0.00054504100000000002 100.89999999999999p 0.00054677869999999996 100.91249999999999p 0.00054855560000000004 100.925p 0.00055037659999999998 100.9375p 0.00055224600000000005 100.95p 0.00055416679999999998 100.96250000000001p 0.00055614089999999998 100.97500000000001p 0.00055816920000000003 100.9875p 0.00056025119999999996 101p 0.00056238550000000005 101.0125p 0.00056456919999999997 101.02499999999999p 0.00056679850000000004
+ 101.03749999999999p 0.00056906800000000005 101.05p 0.00057137150000000005 101.0625p 0.00057370119999999999 101.075p 0.00057604840000000004 101.08750000000001p 0.00057840300000000001 101.10000000000001p 0.00058075409999999998 101.1125p 0.00058308929999999995 101.125p 0.00058539539999999998 101.1375p 0.00058765810000000005 101.14999999999999p 0.00058986230000000002 101.16249999999999p 0.00059199190000000003 101.175p 0.00059402999999999995 101.1875p 0.0005959591 101.2p 0.0005977609 101.21250000000001p 0.00059941659999999996 101.22500000000001p 0.00060090709999999995 101.2375p 0.00060221259999999996 101.25p 0.00060331350000000002
+ 101.2625p 0.00060418950000000005 101.27499999999999p 0.00060482050000000001 101.28749999999999p 0.00060518659999999995 101.3p 0.0006052675 101.3125p 0.00060504359999999997 101.325p 0.00060449539999999995 101.33750000000001p 0.00060360359999999996 101.35000000000001p 0.00060234980000000002 101.3625p 0.00060071579999999999 101.375p 0.00059868409999999997 101.3875p 0.00059623810000000005 101.39999999999999p 0.00059336179999999999 101.41249999999999p 0.00059004010000000004 101.425p 0.00058625889999999996 101.4375p 0.00058200500000000002 101.45p 0.00057726610000000003 101.46250000000001p 0.00057203129999999997 101.47500000000001p 0.00056629059999999999
+ 101.4875p 0.00056003520000000003 101.5p 0.00055325760000000002 101.5125p 0.00054595149999999999 101.52500000000001p 0.00053811189999999995 101.53749999999999p 0.00052973509999999996 101.55p 0.00052081869999999995 101.5625p 0.00051136179999999995 101.57499999999999p 0.00050136470000000004 101.58750000000001p 0.00049082930000000002 101.60000000000001p 0.00047975870000000002 101.6125p 0.00046815760000000001 101.625p 0.00045603199999999999 101.6375p 0.00044338940000000001 101.65000000000001p 0.00043023859999999998 101.66249999999999p 0.00041658990000000001 101.675p 0.0004024551 101.6875p 0.00038784710000000001 101.69999999999999p 0.00037278050000000003
+ 101.71250000000001p 0.00035727090000000001 101.72500000000001p 0.00034133550000000002 101.7375p 0.00032499269999999999 101.75p 0.00030826189999999998 101.7625p 0.00029116409999999999 101.77500000000001p 0.00027372110000000002 101.78749999999999p 0.00025595609999999998 101.8p 0.00023789309999999999 101.8125p 0.0002195574 101.82499999999999p 0.00020097490000000001 101.83750000000001p 0.00018217259999999999 101.85000000000001p 0.0001631785 101.86250000000001p 0.0001440209 101.875p 0.00012472920000000001 101.8875p 0.0001053332 101.90000000000001p 8.5863519999999997e-05 101.91249999999999p 6.6350949999999999e-05 101.925p 4.6826890000000003e-05
+ 101.9375p 2.7323039999999999e-05 101.94999999999999p 7.8713929999999997e-06 101.96249999999999p -1.149589e-05 101.97500000000001p -3.074649e-05 101.98750000000001p -4.9848049999999998e-05 102p -6.8768230000000005e-05 102.0125p -8.7474779999999997e-05 102.02500000000001p -0.0001059356 102.03749999999999p -0.00012411879999999999 102.05p -0.00014199279999999999 102.0625p -0.00015952650000000001 102.07499999999999p -0.00017668910000000001 102.08749999999999p -0.0001934502 102.10000000000001p -0.0002097802 102.11250000000001p -0.00022565009999999999 102.125p -0.0002410314 102.1375p -0.00025589640000000001 102.15000000000001p -0.00027021830000000001
+ 102.16249999999999p -0.00028397120000000001 102.175p -0.00029713 102.1875p -0.00030967039999999998 102.2p -0.00032156950000000002 102.21249999999999p -0.0003328052 102.22499999999999p -0.0003433566 102.23750000000001p -0.00035320380000000001 102.25p -0.00036232819999999999 102.2625p -0.00037071260000000003 102.27500000000001p -0.00037834069999999998 102.28749999999999p -0.00038519789999999997 102.3p -0.00039127049999999999 102.3125p -0.0003965466 102.325p -0.00040101520000000002 102.33749999999999p -0.00040466729999999999 102.34999999999999p -0.00040749470000000002 102.36250000000001p -0.000409491 102.375p -0.00041065129999999999
+ 102.3875p -0.00041097189999999997 102.40000000000001p -0.00041045079999999998 102.41249999999999p -0.00040908729999999998 102.425p -0.00040688230000000001 102.4375p -0.00040383800000000001 102.45p -0.0003999583 102.46249999999999p -0.00039524820000000002 102.47499999999999p -0.0003897145 102.4875p -0.00038336499999999999 102.5p -0.00037620919999999998 102.5125p -0.0003682577 102.52500000000001p -0.0003595227 102.53749999999999p -0.00035001729999999999 102.55p -0.00033975619999999999 102.5625p -0.00032875500000000002 102.575p -0.00031703070000000001 102.58749999999999p -0.00030460110000000003 102.59999999999999p -0.00029148530000000001
+ 102.6125p -0.00027770330000000001 102.625p -0.00026327590000000002 102.6375p -0.0002482249 102.65000000000001p -0.00023257280000000001 102.66250000000001p -0.000216343 102.675p -0.00019955940000000001 102.6875p -0.00018224650000000001 102.7p -0.0001644293 102.71249999999999p -0.00014613340000000001 102.72499999999999p -0.00012738459999999999 102.7375p -0.00010820919999999999 102.75p -8.8633519999999999e-05 102.7625p -6.8684199999999995e-05 102.77500000000001p -4.8387940000000001e-05 102.78750000000001p -2.7771489999999999e-05 102.8p -6.8615530000000003e-06 102.8125p 1.431523e-05 102.825p 3.5732380000000002e-05
+ 102.83749999999999p 5.7363600000000001e-05 102.84999999999999p 7.9182879999999996e-05 102.8625p 0.0001011645 102.875p 0.0001232831 102.8875p 0.0001455137 102.90000000000001p 0.00016783179999999999 102.91250000000001p 0.00019021350000000001 102.925p 0.00021263519999999999 102.9375p 0.0002350741 102.95p 0.00025750790000000001 102.96249999999999p 0.00027991510000000003 102.97499999999999p 0.0003022748 102.9875p 0.00032456690000000002 103p 0.0003467721 103.0125p 0.0003688718 103.02500000000001p 0.00039084839999999998 103.03750000000001p 0.00041268529999999998 103.05p 0.00043436659999999998
+ 103.0625p 0.00045587770000000001 103.075p 0.00047720469999999997 103.08749999999999p 0.00049833500000000003 103.09999999999999p 0.00051925690000000004 103.1125p 0.00053996009999999995 103.125p 0.00056043529999999996 103.1375p 0.00058067429999999998 103.15000000000001p 0.00060067029999999997 103.16250000000001p 0.00062041750000000001 103.175p 0.00063991169999999997 103.1875p 0.00065914969999999995 103.2p 0.00067812959999999996 103.21249999999999p 0.00069685090000000003 103.22499999999999p 0.00071531440000000002 103.2375p 0.00073352200000000002 103.25p 0.0007514771 103.2625p 0.00076918419999999997 103.27500000000001p 0.00078664930000000004
+ 103.28750000000001p 0.00080387929999999996 103.3p 0.00082088259999999998 103.3125p 0.00083766859999999995 103.325p 0.00085424790000000002 103.33750000000001p 0.00087063240000000001 103.34999999999999p 0.00088683469999999999 103.3625p 0.00090286860000000002 103.375p 0.00091874890000000003 103.3875p 0.00093449129999999996 103.40000000000001p 0.00095011209999999995 103.41250000000001p 0.00096562869999999997 103.425p 0.00098105890000000002 103.4375p 0.00099642130000000004 103.45p 0.0010117349999999999 103.46250000000001p 0.0010270189999999999 103.47499999999999p 0.001042294 103.4875p 0.0010575789999999999 103.5p 0.0010728949999999999
+ 103.51249999999999p 0.0010882610000000001 103.52500000000001p 0.001103698 103.53750000000001p 0.001119225 103.55p 0.001134861 103.5625p 0.0011506260000000001 103.575p 0.0011665359999999999 103.58750000000001p 0.00118261 103.59999999999999p 0.0011988630000000001 103.6125p 0.0012153089999999999 103.625p 0.001231963 103.63749999999999p 0.0012488359999999999 103.65000000000001p 0.001265937 103.66250000000001p 0.001283274 103.67500000000001p 0.001300853 103.6875p 0.001318678 103.7p 0.0013367469999999999 103.71250000000001p 0.001355059 103.72499999999999p 0.0013736079999999999
+ 103.7375p 0.001392384 103.75p 0.001411376 103.76249999999999p 0.0014305660000000001 103.77499999999999p 0.0014499350000000001 103.78750000000001p 0.001469457 103.80000000000001p 0.0014891049999999999 103.8125p 0.0015088460000000001 103.825p 0.001528642 103.83750000000001p 0.001548451 103.84999999999999p 0.0015682280000000001 103.8625p 0.0015879220000000001 103.875p 0.001607479 103.88749999999999p 0.0016268400000000001 103.89999999999999p 0.0016459420000000001 103.91250000000001p 0.0016647210000000001 103.92500000000001p 0.001683106 103.9375p 0.001701028 103.95p 0.0017184120000000001
+ 103.96250000000001p 0.001735183 103.97499999999999p 0.001751266 103.9875p 0.0017665840000000001 104p 0.001781063 104.01249999999999p 0.0017946279999999999 104.02499999999999p 0.0018072069999999999 104.03749999999999p 0.0018187310000000001 104.05000000000001p 0.0018291360000000001 104.0625p 0.0018383609999999999 104.075p 0.001846351 104.08750000000001p 0.001853057 104.09999999999999p 0.001858436 104.1125p 0.0018624539999999999 104.125p 0.0018650819999999999 104.1375p 0.0018663009999999999 104.14999999999999p 0.0018661000000000001 104.16249999999999p 0.0018644759999999999 104.17500000000001p 0.001861435
+ 104.1875p 0.0018569890000000001 104.2p 0.001851161 104.21250000000001p 0.001843981 104.22499999999999p 0.0018354840000000001 104.2375p 0.0018257150000000001 104.25p 0.001814724 104.2625p 0.001802566 104.27499999999999p 0.0017893010000000001 104.28749999999999p 0.001774996 104.30000000000001p 0.0017597190000000001 104.3125p 0.00174354 104.325p 0.0017265360000000001 104.33750000000001p 0.0017087809999999999 104.34999999999999p 0.001690352 104.3625p 0.001671327 104.375p 0.0016517840000000001 104.3875p 0.001631799 104.39999999999999p 0.001611449
+ 104.41249999999999p 0.001590808 104.425p 0.001569951 104.4375p 0.0015489480000000001 104.45p 0.0015278690000000001 104.46250000000001p 0.0015067800000000001 104.47500000000001p 0.001485746 104.4875p 0.0014648300000000001 104.5p 0.001444089 104.5125p 0.00142358 104.52499999999999p 0.0014033559999999999 104.53749999999999p 0.001383469 104.55p 0.001363965 104.5625p 0.0013448889999999999 104.575p 0.0013262829999999999 104.58750000000001p 0.001308186 104.60000000000001p 0.0012906339999999999 104.6125p 0.00127366 104.625p 0.0012572950000000001
+ 104.6375p 0.0012415659999999999 104.64999999999999p 0.001226499 104.66249999999999p 0.0012121149999999999 104.675p 0.0011984350000000001 104.6875p 0.0011854750000000001 104.7p 0.00117325 104.71250000000001p 0.0011617719999999999 104.72500000000001p 0.00115105 104.7375p 0.00114109 104.75p 0.0011318980000000001 104.7625p 0.001123474 104.77499999999999p 0.001115818 104.78749999999999p 0.0011089260000000001 104.8p 0.001102794 104.8125p 0.0010974120000000001 104.825p 0.0010927700000000001 104.83750000000001p 0.0010888549999999999 104.85000000000001p 0.0010856520000000001
+ 104.8625p 0.001083143 104.875p 0.0010813070000000001 104.8875p 0.001080124 104.89999999999999p 0.0010795679999999999 104.91249999999999p 0.001079614 104.925p 0.0010802330000000001 104.9375p 0.001081395 104.95p 0.001083068 104.96250000000001p 0.00108522 104.97500000000001p 0.001087815 104.9875p 0.0010908179999999999 105p 0.0010941919999999999 105.0125p 0.0010428049999999999 105.02499999999999p 0.001067244 105.03749999999999p 0.0010724619999999999 105.05p 0.001077431 105.0625p 0.0010821349999999999 105.075p 0.0010865580000000001
+ 105.08750000000001p 0.0010906900000000001 105.10000000000001p 0.0010945200000000001 105.1125p 0.0010980370000000001 105.125p 0.001101236 105.1375p 0.0011041079999999999 105.14999999999999p 0.001106648 105.16249999999999p 0.001108855 105.175p 0.0011107090000000001 105.1875p 0.001112125 105.2p 0.0011131050000000001 105.21250000000001p 0.0011136799999999999 105.22500000000001p 0.0011138859999999999 105.2375p 0.0011137580000000001 105.25p 0.0011133269999999999 105.2625p 0.0011126249999999999 105.27500000000001p 0.001111681 105.28749999999999p 0.001110523 105.3p 0.00110918
+ 105.3125p 0.0011076809999999999 105.32499999999999p 0.001106056 105.33750000000001p 0.001104334 105.35000000000001p 0.001102549 105.3625p 0.001100731 105.375p 0.001098913 105.3875p 0.0010971290000000001 105.40000000000001p 0.001095412 105.41249999999999p 0.0010937950000000001 105.425p 0.0010923040000000001 105.4375p 0.0010909540000000001 105.44999999999999p 0.0010897719999999999 105.46250000000001p 0.0010887889999999999 105.47500000000001p 0.0010880379999999999 105.4875p 0.0010875469999999999 105.5p 0.0010873460000000001 105.5125p 0.001087459 105.52500000000001p 0.0010879080000000001
+ 105.53749999999999p 0.0010887119999999999 105.55p 0.0010898870000000001 105.5625p 0.001091446 105.57499999999999p 0.0010933970000000001 105.58749999999999p 0.0010957460000000001 105.60000000000001p 0.0010984949999999999 105.61250000000001p 0.001101643 105.625p 0.001105183 105.6375p 0.0011091079999999999 105.65000000000001p 0.001113405 105.66249999999999p 0.001118059 105.675p 0.001123052 105.6875p 0.0011283619999999999 105.69999999999999p 0.0011339639999999999 105.71249999999999p 0.001139831 105.72500000000001p 0.001145933 105.73750000000001p 0.0011522380000000001 105.75p 0.0011587119999999999
+ 105.7625p 0.0011653169999999999 105.77500000000001p 0.001172017 105.78749999999999p 0.00117877 105.8p 0.001185537 105.8125p 0.0011922759999999999 105.82499999999999p 0.001198944 105.83749999999999p 0.0012054979999999999 105.85000000000001p 0.0012118960000000001 105.86250000000001p 0.0012180940000000001 105.875p 0.0012240249999999999 105.8875p 0.001229642 105.90000000000001p 0.0012349080000000001 105.91249999999999p 0.001239792 105.925p 0.0012442639999999999 105.9375p 0.001248295 105.95p 0.001251856 105.96249999999999p 0.001254919 105.97499999999999p 0.001257457
+ 105.98750000000001p 0.001259444 106p 0.001260859 106.0125p 0.0013167649999999999 106.02500000000001p 0.001296504 106.03749999999999p 0.0012950590000000001 106.05p 0.001293406 106.0625p 0.001291511 106.075p 0.0012893430000000001 106.08749999999999p 0.0012868739999999999 106.09999999999999p 0.0012840760000000001 106.11250000000001p 0.001280928 106.125p 0.001277411 106.1375p 0.0012735089999999999 106.15000000000001p 0.0012692109999999999 106.16249999999999p 0.0012645110000000001 106.175p 0.0012594030000000001 106.1875p 0.001253889 106.2p 0.0012479699999999999
+ 106.21249999999999p 0.0012416549999999999 106.22499999999999p 0.0012349539999999999 106.2375p 0.00122788 106.25p 0.001220451 106.2625p 0.0012126859999999999 106.27500000000001p 0.0012046089999999999 106.28749999999999p 0.001196246 106.3p 0.001187624 106.3125p 0.001178775 106.325p 0.0011697330000000001 106.33749999999999p 0.001160531 106.34999999999999p 0.001151209 106.3625p 0.001141804 106.375p 0.001132358 106.3875p 0.001122912 106.40000000000001p 0.0011135089999999999 106.41250000000001p 0.0011041930000000001 106.425p 0.0010950090000000001
+ 106.4375p 0.001086002 106.45p 0.0010772170000000001 106.46249999999999p 0.001068701 106.47499999999999p 0.0010604989999999999 106.4875p 0.001052657 106.5p 0.001045219 106.5125p 0.00103823 106.52500000000001p 0.0010317340000000001 106.53750000000001p 0.0010257739999999999 106.55p 0.001020391 106.5625p 0.0010156259999999999 106.575p 0.001011519 106.58749999999999p 0.0010081059999999999 106.59999999999999p 0.0010054230000000001 106.6125p 0.0010035070000000001 106.625p 0.001002387 106.6375p 0.0010020960000000001 106.65000000000001p 0.0010026600000000001
+ 106.66250000000001p 0.001004107 106.675p 0.00100646 106.6875p 0.0010097400000000001 106.7p 0.001013966 106.71249999999999p 0.0010191530000000001 106.72499999999999p 0.001025315 106.7375p 0.001032463 106.75p 0.001040603 106.7625p 0.00104974 106.77500000000001p 0.0010598750000000001 106.78750000000001p 0.001071006 106.8p 0.0010831269999999999 106.8125p 0.001096229 106.825p 0.0011102989999999999 106.83749999999999p 0.0011253210000000001 106.84999999999999p 0.0011412740000000001 106.8625p 0.0011581339999999999 106.875p 0.001175873
+ 106.8875p 0.001194458 106.90000000000001p 0.001213853 106.91250000000001p 0.0012340160000000001 106.925p 0.0012549029999999999 106.9375p 0.001276463 106.95p 0.0012986429999999999 106.96249999999999p 0.0013213840000000001 106.97499999999999p 0.0013446230000000001 106.9875p 0.001368293 107p 0.0013923220000000001 107.0125p 0.0014166350000000001 107.02500000000001p 0.0014411529999999999 107.03750000000001p 0.001465792 107.05p 0.001490466 107.0625p 0.001515085 107.075p 0.001539557 107.08750000000001p 0.001563788 107.09999999999999p 0.0015876810000000001
+ 107.1125p 0.0016111389999999999 107.125p 0.0016340650000000001 107.1375p 0.00165636 107.15000000000001p 0.001677928 107.16250000000001p 0.001698672 107.175p 0.0017185 107.1875p 0.001737321 107.2p 0.00175505 107.21250000000001p 0.001771604 107.22499999999999p 0.0017869069999999999 107.2375p 0.001800889 107.25p 0.001813486 107.26249999999999p 0.001824642 107.27500000000001p 0.00183431 107.28750000000001p 0.00184245 107.3p 0.001849032 107.3125p 0.0018540329999999999 107.325p 0.001857444
+ 107.33750000000001p 0.0018592599999999999 107.34999999999999p 0.001859491 107.3625p 0.001858153 107.375p 0.0018552729999999999 107.38749999999999p 0.001850885 107.40000000000001p 0.0018450350000000001 107.41250000000001p 0.0018377739999999999 107.42500000000001p 0.001829163 107.4375p 0.0018192690000000001 107.45p 0.0018081659999999999 107.46250000000001p 0.001795933 107.47499999999999p 0.001782655 107.4875p 0.0017684199999999999 107.5p 0.001753321 107.51249999999999p 0.0017374529999999999 107.52499999999999p 0.0017209129999999999 107.53750000000001p 0.0017038000000000001 107.55000000000001p 0.0016862120000000001
+ 107.5625p 0.0016682489999999999 107.575p 0.0016500099999999999 107.58750000000001p 0.0016315920000000001 107.59999999999999p 0.00161309 107.6125p 0.0015945989999999999 107.625p 0.0015762090000000001 107.63749999999999p 0.001558008 107.64999999999999p 0.0015400819999999999 107.66250000000001p 0.001522509 107.67500000000001p 0.0015053690000000001 107.6875p 0.0014887349999999999 107.7p 0.001472674 107.71250000000001p 0.0014572509999999999 107.72499999999999p 0.0014425270000000001 107.7375p 0.0014285579999999999 107.75p 0.0014153919999999999 107.76249999999999p 0.0014030780000000001 107.77499999999999p 0.001391656
+ 107.78749999999999p 0.001381164 107.80000000000001p 0.0013716329999999999 107.8125p 0.001363092 107.825p 0.001355562 107.83750000000001p 0.0013490640000000001 107.84999999999999p 0.0013436089999999999 107.8625p 0.0013392090000000001 107.875p 0.001335868 107.8875p 0.0013335879999999999 107.89999999999999p 0.001332363 107.91249999999999p 0.0013321870000000001 107.92500000000001p 0.001333047 107.9375p 0.0013349270000000001 107.95p 0.0013378070000000001 107.96250000000001p 0.001341662 107.97499999999999p 0.0013464639999999999 107.9875p 0.001352179 108p 0.0013587709999999999
+ 108.0125p 0.0013661999999999999 108.02499999999999p 0.001374421 108.03749999999999p 0.0013833859999999999 108.05000000000001p 0.0013930419999999999 108.0625p 0.001403334 108.075p 0.0014142009999999999 108.08750000000001p 0.001425581 108.09999999999999p 0.0014374069999999999 108.1125p 0.0014496089999999999 108.125p 0.001462114 108.1375p 0.001474845 108.14999999999999p 0.0014877239999999999 108.16249999999999p 0.00150067 108.175p 0.0015135979999999999 108.1875p 0.0015264230000000001 108.2p 0.001539059 108.21250000000001p 0.0015514159999999999 108.22500000000001p 0.0015634069999999999
+ 108.2375p 0.0015749410000000001 108.25p 0.0015859299999999999 108.2625p 0.001596285 108.27499999999999p 0.001605921 108.28749999999999p 0.001614753 108.3p 0.0016226979999999999 108.3125p 0.0016296780000000001 108.325p 0.0016356179999999999 108.33750000000001p 0.0016404480000000001 108.35000000000001p 0.001644104 108.3625p 0.001646525 108.375p 0.001647658 108.3875p 0.0016474580000000001 108.39999999999999p 0.0016458849999999999 108.41249999999999p 0.001642908 108.425p 0.001638504 108.4375p 0.001632657 108.45p 0.001625359
+ 108.46250000000001p 0.001616613 108.47500000000001p 0.0016064269999999999 108.4875p 0.00159482 108.5p 0.0015818150000000001 108.5125p 0.0015674479999999999 108.52499999999999p 0.0015517560000000001 108.53749999999999p 0.0015347869999999999 108.55p 0.001516594 108.5625p 0.001497235 108.575p 0.0014767739999999999 108.58750000000001p 0.0014552759999999999 108.60000000000001p 0.0014328139999999999 108.6125p 0.0014094610000000001 108.625p 0.0013852929999999999 108.6375p 0.0013603860000000001 108.64999999999999p 0.0013348189999999999 108.66249999999999p 0.0013086689999999999 108.675p 0.001282013
+ 108.6875p 0.0012549289999999999 108.7p 0.001227489 108.71250000000001p 0.001199767 108.72500000000001p 0.0011718329999999999 108.7375p 0.001143752 108.75p 0.0011155900000000001 108.7625p 0.0010874050000000001 108.77499999999999p 0.001059255 108.78749999999999p 0.001031192 108.8p 0.0010032649999999999 108.8125p 0.0009755187 108.825p 0.00094799360000000004 108.83750000000001p 0.00092072639999999999 108.85000000000001p 0.00089375010000000005 108.8625p 0.00086709350000000005 108.875p 0.00084078189999999995 108.8875p 0.00081483710000000004 108.89999999999999p 0.00078927740000000004
+ 108.91249999999999p 0.00076411790000000001 108.925p 0.00073937079999999999 108.9375p 0.00071504529999999998 108.95p 0.00069114830000000004 108.96250000000001p 0.00066768410000000002 108.97500000000001p 0.00064465499999999995 108.9875p 0.00062206139999999995 109p 0.0005999019 109.0125p 0.00057817380000000002 109.02500000000001p 0.00055687290000000001 109.03749999999999p 0.00053599419999999999 109.05p 0.00051553169999999998 109.0625p 0.00049547860000000003 109.07499999999999p 0.00047582789999999999 109.08750000000001p 0.00045657210000000001 109.10000000000001p 0.00043770339999999998 109.1125p 0.00041921409999999998 109.125p 0.00040109649999999999
+ 109.1375p 0.00038334330000000001 109.15000000000001p 0.0003659472 109.16249999999999p 0.00034890159999999997 109.175p 0.0003322 109.1875p 0.0003158368 109.19999999999999p 0.00029980669999999998 109.21250000000001p 0.00028410529999999999 109.22500000000001p 0.00026872860000000002 109.2375p 0.00025367340000000002 109.25p 0.00023893720000000001 109.2625p 0.00022451820000000001 109.27500000000001p 0.00021041540000000001 109.28749999999999p 0.0001966282 109.3p 0.0001831569 109.3125p 0.00017000239999999999 109.32499999999999p 0.00015716610000000001 109.33749999999999p 0.00014464999999999999 109.35000000000001p 0.00013245680000000001
+ 109.36250000000001p 0.00012058939999999999 109.375p 0.0001090512 109.3875p 9.7846230000000001e-05 109.40000000000001p 8.6978449999999997e-05 109.41249999999999p 7.6452320000000001e-05 109.425p 6.6272429999999995e-05 109.4375p 5.6443519999999997e-05 109.44999999999999p 4.69704e-05 109.46249999999999p 3.7857900000000002e-05 109.47500000000001p 2.9110780000000001e-05 109.48750000000001p 2.073369e-05 109.5p 1.273111e-05 109.5125p 5.107253e-06 109.52500000000001p -2.133962e-06 109.53749999999999p -8.9889910000000002e-06 109.55p -1.5454720000000001e-05 109.5625p -2.1528539999999998e-05 109.57499999999999p -2.7208359999999999e-05
+ 109.58749999999999p -3.2492710000000002e-05 109.60000000000001p -3.7380759999999997e-05 109.61250000000001p -4.1872380000000001e-05 109.625p -4.5968170000000003e-05 109.6375p -4.9669509999999997e-05 109.65000000000001p -5.297858e-05 109.66249999999999p -5.5898430000000002e-05 109.675p -5.8432930000000003e-05 109.6875p -6.0586849999999997e-05 109.7p -6.2365869999999997e-05 109.71249999999999p -6.3776540000000004e-05 109.72499999999999p -6.4826340000000002e-05 109.73750000000001p -6.5523669999999995e-05 109.75p -6.5877809999999995e-05 109.7625p -6.5898929999999996e-05 109.77500000000001p -6.5598089999999997e-05 109.78749999999999p -6.4987219999999995e-05 109.8p -6.4079059999999998e-05
+ 109.8125p -6.2887179999999995e-05 109.825p -6.142593e-05 109.83749999999999p -5.9710409999999997e-05 109.84999999999999p -5.7756420000000003e-05 109.86250000000001p -5.5580449999999997e-05 109.875p -5.3199609999999999e-05 109.8875p -5.063163e-05 109.90000000000001p -4.7894739999999997e-05 109.91249999999999p -4.5007699999999999e-05 109.925p -4.1989710000000003e-05 109.9375p -3.8860360000000002e-05 109.95p -3.5639570000000001e-05 109.96249999999999p -3.234758e-05 109.97499999999999p -2.900484e-05 109.9875p -2.563198e-05 110p -2.2249750000000002e-05 110.0125p -1.8878960000000001e-05 110.02500000000001p -1.554043e-05
+ 110.03749999999999p -1.2254909999999999e-05 110.05p -9.0430619999999992e-06 110.0625p -5.9253410000000003e-06 110.075p -2.921994e-06 110.08749999999999p -5.2972159999999998e-08 110.09999999999999p 2.6621159999999999e-06 110.1125p 5.2040620000000001e-06 110.125p 7.5541149999999996e-06 110.1375p 9.6940269999999995e-06 110.15000000000001p 1.160611e-05 110.16250000000001p 1.3273280000000001e-05 110.175p 1.467911e-05 110.1875p 1.5807869999999999e-05 110.2p 1.664455e-05 110.21249999999999p 1.7174950000000001e-05 110.22499999999999p 1.7385640000000001e-05 110.2375p 1.7264070000000001e-05 110.25p 1.6798530000000001e-05
+ 110.2625p 1.5978239999999998e-05 110.27500000000001p 1.4793299999999999e-05 110.28750000000001p 1.323477e-05 110.3p 1.129465e-05 110.3125p 8.9658970000000001e-06 110.325p 6.2424410000000002e-06 110.33749999999999p 3.119171e-06 110.34999999999999p -4.080555e-07 110.3625p -4.3424210000000001e-06 110.375p -8.6861559999999996e-06 110.3875p -1.344055e-05 110.40000000000001p -1.8605969999999999e-05 110.41250000000001p -2.4181880000000002e-05 110.425p -3.0166860000000001e-05 110.4375p -3.655861e-05 110.45p -4.335402e-05 110.46249999999999p -5.0549179999999999e-05 110.47499999999999p -5.813939e-05
+ 110.4875p -6.6119229999999997e-05 110.5p -7.4482549999999994e-05 110.5125p -8.3222549999999995e-05 110.52500000000001p -9.2331809999999996e-05 110.53750000000001p -0.00010180230000000001 110.55p -0.0001116255 110.5625p -0.0001217922 110.575p -0.00013229290000000001 110.58749999999999p -0.0001431177 110.59999999999999p -0.0001542561 110.6125p -0.0001656974 110.625p -0.0001774306 110.6375p -0.00018944440000000001 110.65000000000001p -0.0002017271 110.66250000000001p -0.00021426710000000001 110.675p -0.00022705229999999999 110.6875p -0.0002400708 110.7p -0.0002533104
+ 110.71249999999999p -0.0002667589 110.72499999999999p -0.00028040390000000001 110.7375p -0.00029423330000000002 110.75p -0.00030823480000000001 110.7625p -0.0003223961 110.77500000000001p -0.0003367051 110.78750000000001p -0.00035114979999999998 110.8p -0.00036571800000000001 110.8125p -0.00038039809999999998 110.825p -0.00039517810000000002 110.83750000000001p -0.0004100466 110.84999999999999p -0.00042499209999999999 110.8625p -0.0004400033 110.875p -0.000455069 110.8875p -0.00047017830000000002 110.90000000000001p -0.00048532030000000002 110.91250000000001p -0.00050048439999999996 110.925p -0.00051566000000000003
+ 110.9375p -0.00053083679999999997 110.95p -0.00054600440000000003 110.96250000000001p -0.00056115280000000004 110.97499999999999p -0.00057627169999999997 110.9875p -0.00059135139999999997 111p -0.00060638170000000004 111.01249999999999p -0.00062135290000000002 111.02500000000001p -0.00063625490000000003 111.03750000000001p -0.0006510779 111.05p -0.00066581189999999997 111.0625p -0.00068044679999999997 111.075p -0.00069497250000000003 111.08750000000001p -0.00070937870000000001 111.09999999999999p -0.00072365479999999995 111.1125p -0.00073779019999999996 111.125p -0.00075177399999999998 111.13749999999999p -0.00076559499999999999 111.15000000000001p -0.00077924169999999998
+ 111.16250000000001p -0.00079270230000000005 111.17500000000001p -0.0008059648 111.1875p -0.00081901659999999998 111.2p -0.00083184489999999997 111.21250000000001p -0.00084443639999999998 111.22499999999999p -0.0008567774 111.2375p -0.00086885369999999996 111.25p -0.00088065099999999998 111.26249999999999p -0.00089215409999999996 111.27499999999999p -0.0009033477 111.28750000000001p -0.0009142159 111.30000000000001p -0.00092474270000000001 111.3125p -0.00093491139999999999 111.325p -0.00094470489999999997 111.33750000000001p -0.00095410609999999996 111.34999999999999p -0.00096309740000000003 111.3625p -0.00097166080000000001 111.375p -0.00097977840000000008
+ 111.38749999999999p -0.00098743199999999989 111.39999999999999p -0.00099460309999999997 111.41250000000001p -0.001001273 111.42500000000001p -0.0010074249999999999 111.4375p -0.001013038 111.45p -0.001018096 111.46250000000001p -0.0010225810000000001 111.47499999999999p -0.0010264740000000001 111.4875p -0.001029758 111.5p -0.0010324170000000001 111.51249999999999p -0.0010344340000000001 111.52499999999999p -0.001035794 111.53749999999999p -0.00103648 111.55000000000001p -0.0010364790000000001 111.5625p -0.001035776 111.575p -0.00103436 111.58750000000001p -0.0010322179999999999 111.59999999999999p -0.0010293380000000001
+ 111.6125p -0.0010257129999999999 111.625p -0.0010213310000000001 111.6375p -0.001016187 111.64999999999999p -0.0010102729999999999 111.66249999999999p -0.0010035840000000001 111.67500000000001p -0.00099611620000000008 111.6875p -0.00098786740000000005 111.7p -0.00097883619999999992 111.71250000000001p -0.00096902260000000004 111.72499999999999p -0.00095842829999999999 111.7375p -0.00094705620000000001 111.75p -0.00093491080000000001 111.7625p -0.00092199790000000001 111.77499999999999p -0.00090832480000000001 111.78749999999999p -0.00089390019999999995 111.8p -0.00087873439999999997 111.8125p -0.00086283880000000005 111.825p -0.00084622639999999997
+ 111.83750000000001p -0.00082891140000000002 111.84999999999999p -0.00081090960000000005 111.8625p -0.00079223770000000002 111.875p -0.00077291380000000002 111.8875p -0.00075295729999999995 111.89999999999999p -0.00073238860000000004 111.91249999999999p -0.0007112291 111.925p -0.00068950130000000002 111.9375p -0.00066722850000000002 111.95p -0.00064443490000000003 111.96250000000001p -0.00062114560000000002 111.97500000000001p -0.00059738610000000002 111.9875p -0.00057318259999999998 112p -0.00054856190000000002 112.0125p -0.00052355119999999999 112.02499999999999p -0.00049817790000000002 112.03749999999999p -0.00047246959999999998 112.05p -0.00044645420000000001
+ 112.0625p -0.00042015960000000002 112.075p -0.0003936136 112.08750000000001p -0.00036684400000000001 112.10000000000001p -0.00033987809999999998 112.1125p -0.0003127432 112.125p -0.00028546609999999999 112.1375p -0.00025807320000000001 112.14999999999999p -0.00023059029999999999 112.16249999999999p -0.00020304270000000001 112.175p -0.00017545500000000001 112.1875p -0.00014785110000000001 112.2p -0.0001202541 112.21250000000001p -9.2686519999999996e-05 112.22500000000001p -6.516979e-05 112.2375p -3.772458e-05 112.25p -1.037069e-05 112.2625p 1.6873030000000001e-05 112.27499999999999p 4.3988639999999997e-05
+ 112.28749999999999p 7.0959130000000005e-05 112.3p 9.7768420000000005e-05 112.3125p 0.0001244014 112.325p 0.0001508437 112.33750000000001p 0.00017708209999999999 112.35000000000001p 0.00020310409999999999 112.3625p 0.000228898 112.375p 0.0002544531 112.3875p 0.00027975919999999999 112.39999999999999p 0.00030480710000000002 112.41249999999999p 0.00032958819999999998 112.425p 0.0003540943 112.4375p 0.00037831810000000003 112.45p 0.00040225249999999998 112.46250000000001p 0.00042589119999999998 112.47500000000001p 0.00044922810000000001 112.4875p 0.00047225730000000001 112.5p 0.0004949733
+ 112.5125p 0.00051737080000000002 112.52499999999999p 0.00053944460000000002 112.53749999999999p 0.00056118940000000005 112.55p 0.00058260020000000003 112.5625p 0.00060367159999999995 112.575p 0.0006243981 112.58750000000001p 0.00064477410000000001 112.60000000000001p 0.00066479379999999995 112.6125p 0.00068445069999999999 112.625p 0.0007037384 112.6375p 0.0007226496 112.64999999999999p 0.00074117689999999995 112.66249999999999p 0.00075931209999999998 112.675p 0.00077704670000000001 112.6875p 0.00079437140000000002 112.7p 0.00081127650000000005 112.71250000000001p 0.0008277515 112.72500000000001p 0.00084378559999999999
+ 112.7375p 0.00085936710000000002 112.75p 0.00087448389999999999 112.7625p 0.00088912330000000001 112.77500000000001p 0.00090327189999999996 112.78749999999999p 0.00091691609999999997 112.8p 0.00093004160000000004 112.8125p 0.00094263400000000003 112.82499999999999p 0.0009546782 112.83750000000001p 0.0009661591 112.85000000000001p 0.00097706130000000009 112.8625p 0.00098736940000000001 112.875p 0.00099706790000000001 112.8875p 0.0010061409999999999 112.90000000000001p 0.001014575 112.91249999999999p 0.0010223529999999999 112.925p 0.001029461 112.9375p 0.0010358850000000001 112.94999999999999p 0.001041611
+ 112.96250000000001p 0.0010466270000000001 112.97500000000001p 0.0010509199999999999 112.9875p 0.001054478 113p 0.001057292 113.0125p 0.0010593519999999999 113.02500000000001p 0.0010606490000000001 113.03749999999999p 0.001061176 113.05p 0.0010609269999999999 113.0625p 0.0010598980000000001 113.07499999999999p 0.0010580839999999999 113.08749999999999p 0.0010554850000000001 113.10000000000001p 0.001052098 113.11250000000001p 0.0010479249999999999 113.125p 0.001042968 113.1375p 0.0010372300000000001 113.15000000000001p 0.001030717 113.16249999999999p 0.0010234350000000001 113.175p 0.001015391
+ 113.1875p 0.001006596 113.19999999999999p 0.00099705980000000007 113.21249999999999p 0.0009867948000000001 113.22500000000001p 0.00097581429999999997 113.23750000000001p 0.00096413300000000005 113.25p 0.00095176720000000002 113.2625p 0.00093873380000000003 113.27500000000001p 0.00092505129999999997 113.28749999999999p 0.00091073909999999996 113.3p 0.00089581779999999998 113.3125p 0.00088030870000000002 113.32499999999999p 0.00086423420000000003 113.33749999999999p 0.00084761739999999997 113.35000000000001p 0.0008304823 113.36250000000001p 0.00081285340000000002 113.375p 0.00079475590000000005 113.3875p 0.00077621549999999997 113.40000000000001p 0.00075725830000000001
+ 113.41249999999999p 0.00073791069999999996 113.425p 0.00071819950000000005 113.4375p 0.0006981515 113.45p 0.00067779370000000002 113.46249999999999p 0.00065715320000000002 113.47499999999999p 0.00063625689999999996 113.48750000000001p 0.00061513159999999998 113.5p 0.00059380380000000001 113.5125p 0.00057229990000000005 113.52500000000001p 0.00055064559999999999 113.53749999999999p 0.00052886649999999997 113.55p 0.0005069874 113.5625p 0.00048503270000000001 113.575p 0.00046302600000000001 113.58749999999999p 0.00044099040000000002 113.59999999999999p 0.00041894799999999999 113.61250000000001p 0.00039692040000000002 113.625p 0.00037492789999999998
+ 113.6375p 0.00035299039999999999 113.65000000000001p 0.00033112650000000001 113.66249999999999p 0.00030935400000000002 113.675p 0.00028768959999999998 113.6875p 0.00026614919999999999 113.7p 0.00024474730000000001 113.71249999999999p 0.00022349779999999999 113.72499999999999p 0.00020241310000000001 113.7375p 0.00018150490000000001 113.75p 0.00016078349999999999 113.7625p 0.00014025849999999999 113.77500000000001p 0.0001199381 113.78750000000001p 9.9829759999999995e-05 113.8p 7.9939680000000002e-05 113.8125p 6.0273189999999997e-05 113.825p 4.0834580000000002e-05 113.83749999999999p 2.1627230000000001e-05 113.84999999999999p 2.653581e-06
+ 113.8625p -1.6084830000000001e-05 113.875p -3.45873e-05 113.8875p -5.2853960000000003e-05 113.90000000000001p -7.0885670000000003e-05 113.91250000000001p -8.8684079999999999e-05 113.925p -0.0001062515 113.9375p -0.0001235908 113.95p -0.00014070550000000001 113.96249999999999p -0.00015759979999999999 113.97499999999999p -0.00017427799999999999 113.9875p -0.0001907453 114p -0.00020700699999999999 114.0125p -0.00022306870000000001 114.02500000000001p -0.0002389364 114.03750000000001p -0.0002546162 114.05p -0.0002701146 114.0625p -0.00028543779999999999 114.075p -0.00030059249999999998
+ 114.08749999999999p -0.00031558500000000001 114.09999999999999p -0.00033042189999999999 114.1125p -0.00034510950000000003 114.125p -0.00035965390000000002 114.1375p -0.00037406119999999998 114.15000000000001p -0.00038833699999999999 114.16250000000001p -0.0004024869 114.175p -0.00041651589999999999 114.1875p -0.00043042869999999997 114.2p -0.0004442297 114.21249999999999p -0.00045792249999999999 114.22499999999999p -0.0004715106 114.2375p -0.00048499669999999998 114.25p -0.00049838300000000003 114.2625p -0.00051167110000000003 114.27500000000001p -0.00052486199999999996 114.28750000000001p -0.00053795589999999999 114.3p -0.00055095250000000001
+ 114.3125p -0.00056385069999999999 114.325p -0.00057664870000000005 114.33749999999999p -0.00058934389999999997 114.34999999999999p -0.00060193300000000003 114.3625p -0.00061441209999999998 114.375p -0.0006267763 114.3875p -0.00063901989999999998 114.40000000000001p -0.00065113680000000002 114.41250000000001p -0.00066311980000000005 114.425p -0.0006749611 114.4375p -0.00068665209999999998 114.45p -0.00069818349999999996 114.46249999999999p -0.0007095453 114.47499999999999p -0.000720727 114.4875p -0.00073171710000000004 114.5p -0.00074250379999999999 114.5125p -0.00075307460000000005 114.52500000000001p -0.00076341639999999997
+ 114.53750000000001p -0.00077351579999999996 114.55p -0.00078335869999999997 114.5625p -0.00079293090000000005 114.575p -0.00080221749999999999 114.58750000000001p -0.00081120369999999995 114.59999999999999p -0.00081987420000000002 114.6125p -0.00082821369999999997 114.625p -0.00083620660000000002 114.6375p -0.00084383760000000005 114.65000000000001p -0.00085109119999999996 114.66250000000001p -0.00085795209999999997 114.675p -0.00086440509999999998 114.6875p -0.00087043549999999998 114.7p -0.00087602860000000004 114.71250000000001p -0.00088117049999999998 114.72499999999999p -0.00088584739999999996 114.7375p -0.00089004640000000005 114.75p -0.00089375499999999998
+ 114.76249999999999p -0.00089696139999999997 114.77500000000001p -0.00089965469999999997 114.78750000000001p -0.00090182480000000002 114.8p -0.00090346230000000005 114.8125p -0.00090455889999999995 114.825p -0.00090510709999999997 114.83750000000001p -0.00090510069999999996 114.84999999999999p -0.00090453430000000002 114.8625p -0.00090340370000000002 114.875p -0.00090170569999999995 114.88749999999999p -0.00089943830000000001 114.90000000000001p -0.00089660070000000002 114.91250000000001p -0.00089319319999999998 114.92500000000001p -0.00088921710000000001 114.9375p -0.00088467509999999995 114.95p -0.00087957080000000004 114.96250000000001p -0.00087390890000000004 114.97499999999999p -0.00086769530000000003
+ 114.9875p -0.00086093680000000003 115p -0.00085364139999999995 115.01249999999999p -0.00084581789999999999 115.02499999999999p -0.00083747590000000005 115.03750000000001p -0.00082862620000000002 115.05000000000001p -0.00081928009999999996 115.0625p -0.00080944969999999998 115.075p -0.00079914790000000003 115.08750000000001p -0.00078838810000000004 115.09999999999999p -0.00077718440000000002 115.1125p -0.00076555130000000005 115.125p -0.00075350370000000001 115.13749999999999p -0.00074105690000000001 115.14999999999999p -0.00072822659999999999 115.16250000000001p -0.00071502849999999999 115.17500000000001p -0.00070147880000000001 115.1875p -0.0006875936 115.2p -0.00067338900000000004
+ 115.21250000000001p -0.00065888130000000004 115.22499999999999p -0.00064408670000000001 115.2375p -0.00062902119999999997 115.25p -0.00061370070000000003 115.26249999999999p -0.00059814090000000002 115.27499999999999p -0.00058235739999999995 115.28749999999999p -0.00056636540000000002 115.30000000000001p -0.00055017979999999998 115.3125p -0.00053381529999999998 115.325p -0.00051728620000000001 115.33750000000001p -0.0005006063 115.34999999999999p -0.00048378910000000002 115.3625p -0.0004668478 115.375p -0.00044979500000000001 115.3875p -0.00043264300000000002 115.39999999999999p -0.00041540359999999999 115.41249999999999p -0.00039808829999999999 115.42500000000001p -0.00038070790000000002
+ 115.4375p -0.00036327309999999998 115.45p -0.00034579389999999998 115.46250000000001p -0.00032827989999999999 115.47499999999999p -0.00031074059999999998 115.4875p -0.00029318459999999998 115.5p -0.00027562049999999997 115.5125p -0.00025805650000000001 115.52499999999999p -0.0002405001 115.53749999999999p -0.0002229589 115.55p -0.0002054399 115.5625p -0.0001879498 115.575p -0.00017049519999999999 115.58750000000001p -0.00015308220000000001 115.59999999999999p -0.00013571669999999999 115.6125p -0.0001184046 115.625p -0.0001011513 115.6375p -8.3962110000000001e-05 115.64999999999999p -6.6842239999999998e-05
+ 115.66249999999999p -4.9796709999999998e-05 115.675p -3.2830409999999997e-05 115.6875p -1.594814e-05 115.7p 8.4539330000000003e-07 115.71250000000001p 1.7545520000000001e-05 115.72500000000001p 3.414763e-05 115.7375p 5.064713e-05 115.75p 6.7039419999999995e-05 115.7625p 8.3319890000000001e-05 115.77499999999999p 9.9483900000000005e-05 115.78749999999999p 0.00011552680000000001 115.8p 0.00013144369999999999 115.8125p 0.0001472298 115.825p 0.00016288030000000001 115.83750000000001p 0.00017839 115.85000000000001p 0.00019375370000000001 115.8625p 0.0002089661 115.875p 0.00022402190000000001
+ 115.8875p 0.00023891529999999999 115.89999999999999p 0.00025364060000000001 115.91249999999999p 0.00026819190000000002 115.925p 0.000282563 115.9375p 0.0002967477 115.95p 0.00031073949999999999 115.96250000000001p 0.0003245317 115.97500000000001p 0.00033811760000000002 115.9875p 0.00035149010000000002 116p 0.00036464199999999998 116.0125p 0.0003775661 116.02499999999999p 0.00039025479999999998 116.03749999999999p 0.00040270060000000002 116.05p 0.00041489560000000002 116.0625p 0.0004268319 116.075p 0.00043850170000000002 116.08750000000001p 0.00044989679999999998 116.10000000000001p 0.00046100900000000002
+ 116.1125p 0.00047183009999999999 116.125p 0.00048235200000000002 116.1375p 0.00049256650000000001 116.14999999999999p 0.00050246519999999997 116.16249999999999p 0.00051204020000000002 116.175p 0.00052128319999999995 116.1875p 0.00053018640000000001 116.2p 0.00053874200000000004 116.21250000000001p 0.00054694230000000002 116.22500000000001p 0.00055477990000000002 116.2375p 0.00056224759999999997 116.25p 0.00056933859999999995 116.2625p 0.00057604610000000001 116.27499999999999p 0.00058236400000000004 116.28749999999999p 0.00058828649999999999 116.3p 0.00059380800000000003 116.3125p 0.0005989236 116.325p 0.00060362869999999996
+ 116.33750000000001p 0.00060791939999999998 116.35000000000001p 0.00061179219999999996 116.3625p 0.00061524409999999996 116.375p 0.00061827300000000002 116.3875p 0.00062087709999999996 116.39999999999999p 0.00062305529999999996 116.41249999999999p 0.00062480749999999996 116.42499999999998p 0.00062613369999999998 116.43749999999999p 0.00062703520000000003 116.45p 0.00062751340000000004 116.46250000000001p 0.00062757090000000002 116.47500000000001p 0.00062721079999999995 116.48750000000001p 0.00062643690000000005 116.50000000000001p 0.00062525359999999997 116.51249999999999p 0.00062366630000000004 116.52499999999999p 0.00062168080000000005 116.53749999999999p 0.0006193037 116.55p 0.00061654220000000005
+ 116.5625p 0.00061340410000000004 116.575p 0.00060989789999999996 116.58750000000001p 0.00060603250000000001 116.59999999999999p 0.0006018175 116.6125p 0.00059726289999999997 116.625p 0.00059237929999999997 116.6375p 0.00058717749999999999 116.65000000000001p 0.00058166890000000001 116.66250000000001p 0.00057586509999999998 116.67499999999998p 0.00056977799999999995 116.68749999999999p 0.00056342000000000002 116.69999999999999p 0.00055680330000000002 116.71250000000001p 0.00054994050000000002 116.72500000000001p 0.00054284440000000004 116.73750000000001p 0.00053552769999999997 116.75000000000001p 0.00052800310000000001 116.76249999999999p 0.00052028350000000003 116.77499999999999p 0.00051238140000000004
+ 116.78749999999999p 0.00050430959999999997 116.8p 0.00049608040000000001 116.8125p 0.00048770619999999998 116.825p 0.0004791989 116.83750000000001p 0.00047057030000000001 116.84999999999999p 0.0004618321 116.8625p 0.00045299540000000001 116.875p 0.00044407110000000002 116.8875p 0.00043506959999999999 116.90000000000001p 0.00042600130000000001 116.91250000000001p 0.0004168757 116.92500000000001p 0.00040770219999999998 116.93749999999999p 0.00039848979999999997 116.94999999999999p 0.00038924700000000001 116.96249999999999p 0.00037998159999999998 116.97500000000001p 0.00037070149999999998 116.98750000000001p 0.00036141359999999998 117.00000000000001p 0.00035212470000000001
+ 117.01249999999999p 0.00034284110000000001 117.02499999999999p 0.00033356850000000002 117.03749999999999p 0.00032431229999999999 117.05p 0.00031507749999999999 117.0625p 0.00030586859999999998 117.075p 0.00029668970000000001 117.08750000000001p 0.00028754460000000003 117.09999999999999p 0.00027843650000000002 117.1125p 0.00026936849999999998 117.125p 0.00026034309999999999 117.1375p 0.00025136279999999998 117.15000000000001p 0.0002424293 117.16250000000001p 0.00023354450000000001 117.17500000000001p 0.00022470969999999999 117.18749999999999p 0.00021592590000000001 117.19999999999999p 0.0002071942 117.21249999999999p 0.0001985151 117.22499999999999p 0.0001898891
+ 117.23750000000001p 0.0001813165 117.25000000000001p 0.0001727973 117.26250000000002p 0.00016433149999999999 117.27499999999999p 0.00015591880000000001 117.28749999999999p 0.00014755909999999999 117.3p 0.00013925170000000001 117.3125p 0.0001309963 117.325p 0.00012279230000000001 117.33750000000001p 0.0001146389 117.34999999999999p 0.0001065357 117.3625p 9.8481819999999998e-05 117.375p 9.0476580000000006e-05 117.3875p 8.2519260000000005e-05 117.40000000000001p 7.460914e-05 117.41250000000001p 6.6745519999999994e-05 117.42500000000001p 5.8927690000000001e-05 117.43749999999999p 5.1155010000000001e-05 117.44999999999999p 4.3426849999999999e-05
+ 117.46249999999999p 3.574261e-05 117.47499999999999p 2.810176e-05 117.4875p 2.0503799999999998e-05 117.50000000000001p 1.2948270000000001e-05 117.51250000000002p 5.4348e-06 117.52499999999999p -2.0369669999999999e-06 117.53749999999999p -9.4673160000000004e-06 117.55p -1.6856479999999999e-05 117.5625p -2.4204640000000001e-05 117.575p -3.1511930000000001e-05 117.58750000000001p -3.8778430000000003e-05 117.60000000000001p -4.600417e-05 117.6125p -5.3189139999999998e-05 117.625p -6.0333300000000001e-05 117.6375p -6.7436540000000007e-05 117.65000000000001p -7.4498760000000003e-05 117.66250000000001p -8.1519780000000004e-05 117.67500000000001p -8.8499439999999998e-05
+ 117.68749999999999p -9.5437529999999998e-05 117.69999999999999p -0.0001023338 117.71249999999999p -0.00010918810000000001 117.72499999999999p -0.00011600009999999999 117.7375p -0.00012276959999999999 117.75p -0.00012949629999999999 117.76250000000002p -0.00013617999999999999 117.77499999999999p -0.0001428205 117.78749999999999p -0.0001494174 117.8p -0.0001559706 117.8125p -0.00016247979999999999 117.825p -0.0001689448 117.83750000000001p -0.00017536559999999999 117.85000000000001p -0.0001817418 117.86249999999998p -0.00018807329999999999 117.875p -0.00019436010000000001 117.8875p -0.000200602 117.90000000000001p -0.00020679889999999999
+ 117.91250000000001p -0.00021295069999999999 117.92500000000001p -0.00021905739999999999 117.93750000000001p -0.00022511889999999999 117.94999999999999p -0.0002311352 117.96249999999999p -0.0002371063 117.97499999999999p -0.00024303209999999999 117.9875p -0.00024891250000000001 118p -0.00025474770000000001 118.0125p -0.0002605374 118.02499999999999p -0.00026628170000000002 118.03749999999999p -0.00027198039999999998 118.05p -0.00027763339999999998 118.0625p -0.0002832407 118.075p -0.00028880190000000002 118.08750000000001p -0.00029431679999999998 118.10000000000001p -0.00029978520000000002 118.11249999999998p -0.00030520660000000002 118.12499999999999p -0.00031058069999999999
+ 118.1375p -0.00031590680000000002 118.15000000000001p -0.00032118439999999999 118.16250000000001p -0.00032641270000000001 118.17500000000001p -0.00033159090000000002 118.18750000000001p -0.00033671800000000001 118.19999999999999p -0.00034179309999999999 118.21249999999999p -0.00034681490000000001 118.22499999999999p -0.00035178199999999997 118.2375p -0.00035669299999999999 118.25p -0.00036154619999999998 118.2625p -0.00036633979999999998 118.27500000000002p -0.00037107189999999998 118.28749999999999p -0.00037574020000000002 118.3p -0.00038034249999999999 118.3125p -0.00038487619999999999 118.325p -0.00038933860000000002 118.33750000000001p -0.00039372689999999999 118.35000000000001p -0.00039803780000000001
+ 118.36249999999998p -0.000402268 118.37499999999999p -0.0004064141 118.38749999999999p -0.00041047229999999999 118.40000000000001p -0.00041443870000000001 118.41250000000001p -0.00041830909999999999 118.42500000000001p -0.00042207909999999999 118.43750000000001p -0.00042574429999999998 118.44999999999999p -0.00042929969999999998 118.46249999999999p -0.00043274049999999999 118.47499999999999p -0.00043606150000000002 118.4875p -0.00043925730000000002 118.5p -0.00044232240000000001 118.5125p -0.00044525119999999998 118.52500000000001p -0.0004480377 118.53749999999999p -0.00045067579999999999 118.55p -0.0004531596 118.5625p -0.00045548259999999999 118.575p -0.00045763850000000002
+ 118.58750000000001p -0.00045962070000000002 118.60000000000001p -0.0004614226 118.61249999999998p -0.00046303760000000001 118.62499999999999p -0.00046445900000000002 118.63749999999999p -0.00046568 118.65000000000001p -0.00046669389999999999 118.66250000000001p -0.00046749379999999998 118.67500000000001p -0.00046807309999999998 118.68750000000001p -0.0004684251 118.69999999999999p -0.00046854310000000001 118.71249999999999p -0.00046842059999999998 118.72499999999999p -0.0004680512 118.7375p -0.00046742860000000003 118.75p -0.00046654660000000002 118.7625p -0.00046539930000000001 118.77500000000001p -0.00046398099999999997 118.78749999999999p -0.00046228600000000001 118.8p -0.00046030909999999998
+ 118.8125p -0.00045804519999999998 118.825p -0.00045548959999999999 118.83750000000001p -0.00045263779999999998 118.85000000000001p -0.0004494856 118.86250000000001p -0.00044602930000000002 118.87499999999999p -0.00044226539999999998 118.88749999999999p -0.00043819090000000001 118.89999999999999p -0.00043380300000000002 118.91250000000001p -0.00042909950000000001 118.92500000000001p -0.00042407840000000002 118.93750000000001p -0.00041873840000000002 118.94999999999999p -0.00041307829999999999 118.96249999999999p -0.00040709779999999998 118.97499999999999p -0.00040079649999999998 118.9875p -0.00039417500000000003 119p -0.00038723389999999999 119.0125p -0.00037997459999999998 119.02500000000001p -0.00037239880000000002
+ 119.03749999999999p -0.00036450870000000001 119.05p -0.00035630699999999999 119.0625p -0.00034779690000000002 119.075p -0.00033898210000000002 119.08750000000001p -0.00032986650000000001 119.10000000000001p -0.00032045480000000002 119.11250000000001p -0.00031075189999999999 119.12499999999999p -0.00030076320000000002 119.13749999999999p -0.0002904947 119.14999999999999p -0.00027995249999999999 119.16249999999999p -0.00026914339999999998 119.17500000000001p -0.00025807450000000002 119.18750000000001p -0.00024675309999999998 119.20000000000002p -0.0002351872 119.21249999999999p -0.00022338490000000001 119.22499999999999p -0.00021135460000000001 119.2375p -0.0001991052 119.25p -0.00018664589999999999
+ 119.2625p -0.00017398589999999999 119.27500000000001p -0.00016113499999999999 119.28749999999999p -0.00014810290000000001 119.3p -0.0001349 119.3125p -0.0001215364 119.325p -0.0001080226 119.33750000000001p -9.436933e-05 119.35000000000001p -8.0587390000000006e-05 119.36250000000001p -6.668768e-05 119.37499999999999p -5.2681259999999997e-05 119.38749999999999p -3.8579250000000002e-05 119.39999999999999p -2.4392840000000001e-05 119.41249999999999p -1.013328e-05 119.425p 4.18814e-06 119.43750000000001p 1.8560109999999999e-05 119.45000000000002p 3.2971320000000002e-05 119.46249999999999p 4.7410480000000001e-05 119.47499999999999p 6.1866300000000001e-05
+ 119.4875p 7.632754e-05 119.5p 9.0783020000000003e-05 119.5125p 0.0001052216 119.52500000000001p 0.0001196323 119.53750000000001p 0.00013400400000000001 119.55p 0.0001483259 119.5625p 0.0001625873 119.575p 0.00017677740000000001 119.58750000000001p 0.00019088570000000001 119.60000000000001p 0.00020490180000000001 119.61250000000001p 0.00021881529999999999 119.62499999999999p 0.000232616 119.63749999999999p 0.00024629399999999998 119.64999999999999p 0.00025983929999999998 119.66249999999999p 0.00027324210000000002 119.675p 0.00028649269999999998 119.6875p 0.00029958179999999999 119.70000000000002p 0.00031249990000000003
+ 119.71249999999999p 0.00032523779999999998 119.72499999999999p 0.00033778649999999998 119.7375p 0.00035013710000000002 119.75p 0.0003622807 119.7625p 0.00037420880000000001 119.77500000000001p 0.00038591290000000001 119.78750000000001p 0.0003973847 119.79999999999998p 0.00040861579999999998 119.8125p 0.0004195984 119.825p 0.00043032459999999998 119.83750000000001p 0.00044078649999999999 119.85000000000001p 0.00045097650000000002 119.86250000000001p 0.00046088740000000002 119.87500000000001p 0.00047051169999999998 119.88749999999999p 0.00047984239999999999 119.89999999999999p 0.00048887240000000003 119.91249999999999p 0.00049759510000000002 119.925p 0.00050600380000000004
+ 119.9375p 0.00051409199999999996 119.95p 0.00052185339999999999 119.96249999999999p 0.00052928209999999999 119.97499999999999p 0.00053637219999999998 119.9875p 0.00054311799999999999 120p 0.00054951399999999997 120.0125p 0.000555555 120.02500000000001p 0.00056123610000000004 120.03750000000001p 0.00056655249999999996 120.04999999999998p 0.00057149960000000004 120.06249999999999p 0.00057607329999999997 120.075p 0.0005802696 120.08750000000001p 0.0005840849 120.10000000000001p 0.00058751560000000003 120.11250000000001p 0.00059055879999999998 120.12500000000001p 0.00059321160000000005 120.13749999999999p 0.0005954717 120.14999999999999p 0.00059733690000000005
+ 120.16249999999999p 0.00059880549999999995 120.175p 0.00059987590000000002 120.1875p 0.00060054719999999995 120.2p 0.00060081869999999995 120.21250000000001p 0.0006006901 120.22499999999999p 0.00060016140000000002 120.2375p 0.00059923300000000001 120.25p 0.00059790590000000001 120.2625p 0.00059618119999999995 120.27500000000001p 0.00059406059999999998 120.28750000000001p 0.00059154620000000005 120.29999999999998p 0.00058864029999999997 120.31249999999999p 0.00058534579999999998 120.32499999999999p 0.000581666 120.33750000000001p 0.00057760440000000004 120.35000000000001p 0.00057316500000000005 120.36250000000001p 0.00056835239999999997 120.37500000000001p 0.00056317119999999997
+ 120.38749999999999p 0.0005576267 120.39999999999999p 0.00055172429999999996 120.41249999999999p 0.00054547000000000005 120.425p 0.00053886980000000004 120.4375p 0.00053193049999999996 120.45p 0.00052465889999999999 120.46250000000001p 0.00051706219999999995 120.47499999999999p 0.0005091478 120.4875p 0.00050092340000000004 120.5p 0.00049239719999999996 120.5125p 0.00048357739999999998 120.52500000000001p 0.00047447240000000001 120.53750000000001p 0.000465091 120.55000000000001p 0.00045544200000000002 120.56249999999999p 0.00044553449999999999 120.57499999999999p 0.0004353777 120.58749999999999p 0.00042498090000000002 120.60000000000001p 0.00041435369999999998
+ 120.61250000000001p 0.00040350549999999997 120.62500000000001p 0.00039244600000000002 120.63749999999999p 0.0003811849 120.64999999999999p 0.00036973190000000002 120.66249999999999p 0.00035809669999999999 120.675p 0.00034628909999999998 120.6875p 0.00033431869999999997 120.7p 0.00032219520000000001 120.71250000000001p 0.00030992820000000002 120.72499999999999p 0.00029752730000000001 120.7375p 0.00028500189999999999 120.75p 0.0002723612 120.7625p 0.00025961460000000001 120.77500000000001p 0.00024677109999999999 120.78750000000001p 0.0002338397 120.80000000000001p 0.00022082889999999999 120.81249999999999p 0.0002077475 120.82499999999999p 0.00019460389999999999
+ 120.83749999999999p 0.00018140619999999999 120.85000000000001p 0.0001681625 120.86250000000001p 0.00015488040000000001 120.87500000000001p 0.00014156769999999999 120.88749999999999p 0.00012823169999999999 120.89999999999999p 0.0001148795 120.91249999999999p 0.000101518 120.925p 8.8153839999999999e-05 120.9375p 7.479357e-05 120.95p 6.144337e-05 120.96250000000001p 4.810924e-05 120.97499999999999p 3.4796979999999998e-05 120.9875p 2.151214e-05 121p 8.2600700000000004e-06 121.0125p -4.954073e-06 121.02500000000001p -1.8125350000000001e-05 121.03750000000001p -3.1248989999999998e-05 121.05000000000001p -4.4320429999999999e-05
+ 121.06249999999999p -5.7335259999999997e-05 121.07499999999999p -7.0289239999999994e-05 121.08749999999999p -8.3178270000000001e-05 121.09999999999999p -9.599841e-05 121.11250000000001p -0.0001087458 121.12500000000001p -0.00012141680000000001 121.13750000000002p -0.0001340077 121.14999999999999p -0.00014651510000000001 121.16249999999999p -0.0001589354 121.175p -0.00017126540000000001 121.1875p -0.00018350150000000001 121.2p -0.00019564060000000001 121.21250000000001p -0.00020767919999999999 121.22499999999999p -0.00021961419999999999 121.2375p -0.00023144220000000001 121.25p -0.00024315989999999999 121.2625p -0.00025476379999999997 121.27500000000001p -0.00026625059999999998
+ 121.28750000000001p -0.00027761680000000001 121.30000000000001p -0.00028885880000000002 121.31249999999999p -0.0002999729 121.32499999999999p -0.00031095539999999999 121.33749999999999p -0.00032180240000000002 121.34999999999999p -0.00033250990000000002 121.3625p -0.00034307389999999998 121.37500000000001p -0.00035348999999999998 121.38750000000002p -0.00036375390000000001 121.39999999999999p -0.00037386100000000002 121.41249999999999p -0.00038380670000000001 121.425p -0.0003935861 121.4375p -0.00040319420000000002 121.45p -0.00041262580000000002 121.46250000000001p -0.00042187570000000002 121.47500000000001p -0.00043093830000000001 121.4875p -0.00043980799999999997 121.5p -0.00044847920000000001
+ 121.5125p -0.00045694570000000002 121.52500000000001p -0.00046520170000000002 121.53750000000001p -0.00047324079999999999 121.55000000000001p -0.0004810568 121.56249999999999p -0.00048864329999999997 121.57499999999999p -0.00049599379999999997 121.58749999999999p -0.00050310160000000004 121.59999999999999p -0.00050995999999999995 121.6125p -0.00051656249999999999 121.625p -0.00052290210000000004 121.63750000000002p -0.00052897199999999995 121.64999999999999p -0.00053476559999999997 121.66249999999999p -0.00054027600000000002 121.675p -0.00054549630000000002 121.6875p -0.00055042009999999996 121.7p -0.00055504049999999998 121.71250000000001p -0.00055935109999999996 121.72500000000001p -0.00056334539999999995
+ 121.73749999999998p -0.00056701729999999995 121.75p -0.00057036040000000004 121.7625p -0.00057336900000000001 121.77500000000001p -0.00057603730000000005 121.78750000000001p -0.00057835969999999999 121.80000000000001p -0.00058033110000000005 121.81250000000001p -0.00058194639999999999 121.82499999999999p -0.00058320080000000003 121.83749999999999p -0.00058409010000000003 121.84999999999999p -0.00058461009999999998 121.8625p -0.00058475710000000002 121.875p -0.00058452769999999996 121.8875p -0.00058391900000000002 121.89999999999999p -0.00058292830000000002 121.91249999999999p -0.00058155339999999998 121.925p -0.00057979259999999997 121.9375p -0.00057764450000000005 121.95p -0.00057510809999999999
+ 121.96250000000001p -0.00057218310000000001 121.97500000000001p -0.00056886930000000005 121.98749999999998p -0.00056516729999999999 121.99999999999999p -0.00056107789999999998 122.0125p -0.00055660249999999996 122.02500000000001p -0.00055174279999999998 122.03750000000001p -0.00054650119999999998 122.05000000000001p -0.00054088050000000005 122.06250000000001p -0.00053488370000000002 122.07499999999999p -0.00052851459999999999 122.08749999999999p -0.00052177729999999996 122.09999999999999p -0.0005146762 122.1125p -0.0005072163 122.125p -0.00049940300000000004 122.1375p -0.00049124200000000002 122.15000000000001p -0.00048273949999999999 122.16249999999999p -0.000473902 122.175p -0.0004647365
+ 122.1875p -0.00045525019999999999 122.2p -0.0004454506 122.21250000000001p -0.00043534569999999998 122.22500000000001p -0.00042494370000000002 122.23749999999998p -0.00041425300000000001 122.24999999999999p -0.00040328249999999999 122.26249999999999p -0.00039204099999999998 122.27500000000001p -0.0003805379 122.28750000000001p -0.0003687826 122.30000000000001p -0.00035678469999999999 122.31250000000001p -0.00034455400000000001 122.32499999999999p -0.0003321005 122.33749999999999p -0.0003194343 122.34999999999999p -0.00030656569999999998 122.3625p -0.00029350490000000002 122.375p -0.00028026249999999999 122.3875p -0.00026684890000000001 122.40000000000001p -0.00025327470000000002
+ 122.41249999999999p -0.0002395505 122.425p -0.000225687 122.4375p -0.00021169480000000001 122.45p -0.00019758450000000001 122.46250000000001p -0.0001833669 122.47500000000001p -0.0001690525 122.48750000000001p -0.00015465189999999999 122.49999999999999p -0.00014017580000000001 122.51249999999999p -0.00012563449999999999 122.52499999999999p -0.0001110386 122.53750000000001p -9.6398449999999999e-05 122.55000000000001p -8.1724340000000002e-05 122.56250000000001p -6.7026489999999999e-05 122.57499999999999p -5.2315060000000001e-05 122.58749999999999p -3.7600099999999999e-05 122.59999999999999p -2.289156e-05 122.6125p -8.1993189999999999e-06 122.625p 6.466865e-06
+ 122.6375p 2.1097330000000001e-05 122.65000000000001p 3.5682500000000003e-05 122.66249999999999p 5.0212929999999997e-05 122.675p 6.4679249999999999e-05 122.6875p 7.9072210000000006e-05 122.7p 9.3382649999999999e-05 122.71250000000001p 0.0001076015 122.72500000000001p 0.0001217199 122.73750000000001p 0.00013572890000000001 122.74999999999999p 0.0001496197 122.76249999999999p 0.00016338370000000001 122.77499999999999p 0.00017701239999999999 122.78749999999999p 0.00019049719999999999 122.80000000000001p 0.00020382979999999999 122.81250000000001p 0.00021700189999999999 122.82500000000002p 0.00023000510000000001 122.83749999999999p 0.0002428315 122.84999999999999p 0.00025547299999999998
+ 122.8625p 0.0002679216 122.875p 0.00028016940000000001 122.8875p 0.00029220869999999999 122.90000000000001p 0.00030403169999999998 122.91249999999999p 0.00031563080000000001 122.925p 0.00032699859999999999 122.9375p 0.00033812760000000001 122.95p 0.00034901039999999999 122.96250000000001p 0.00035963990000000001 122.97500000000001p 0.00037000889999999999 122.98750000000001p 0.00038011039999999999 122.99999999999999p 0.00038993760000000002 123.01249999999999p 0.00039948369999999998 123.02499999999999p 0.00040874219999999998 123.03749999999999p 0.00041770639999999998 123.05p 0.00042637019999999999 123.06250000000001p 0.00043472740000000001 123.07500000000002p 0.00044277200000000002
+ 123.08749999999999p 0.00045049819999999998 123.09999999999999p 0.0004579006 123.1125p 0.0004649737 123.125p 0.00047171239999999997 123.1375p 0.00047811190000000001 123.15000000000001p 0.00048416749999999998 123.16250000000001p 0.00048987480000000001 123.175p 0.00049522970000000005 123.1875p 0.00050022860000000001 123.2p 0.00050486789999999997 123.21250000000001p 0.00050914440000000003 123.22500000000001p 0.00051305540000000003 123.23750000000001p 0.00051659839999999998 123.24999999999999p 0.00051977130000000003 123.26249999999999p 0.00052257240000000004 123.27499999999999p 0.00052500020000000004 123.28749999999999p 0.00052705389999999996 123.3p 0.00052873299999999998
+ 123.31250000000001p 0.00053003709999999995 123.32500000000002p 0.00053096670000000003 123.33749999999999p 0.00053152240000000001 123.34999999999999p 0.00053170539999999997 123.3625p 0.00053151710000000005 123.375p 0.00053095949999999996 123.3875p 0.00053003519999999995 123.40000000000001p 0.00052874669999999999 123.41250000000001p 0.00052709760000000001 123.42499999999998p 0.00052509129999999998 123.4375p 0.00052273200000000004 123.45p 0.00052002410000000004 123.46250000000001p 0.0005169727 123.47500000000001p 0.00051358280000000001 123.48750000000001p 0.00050986029999999999 123.49999999999999p 0.000505811 123.51249999999999p 0.00050144139999999996 123.52499999999999p 0.00049675809999999996
+ 123.53749999999999p 0.00049176809999999999 123.55p 0.00048647870000000001 123.5625p 0.00048089749999999999 123.57500000000002p 0.00047503219999999997 123.58749999999999p 0.00046889099999999998 123.59999999999999p 0.00046248209999999999 123.6125p 0.00045581389999999999 123.625p 0.00044889510000000002 123.6375p 0.00044173429999999999 123.65000000000001p 0.00043434060000000001 123.66250000000001p 0.00042672290000000002 123.67499999999998p 0.00041889020000000001 123.6875p 0.00041085170000000002 123.7p 0.00040261639999999998 123.71250000000001p 0.00039419360000000003 123.72500000000001p 0.00038559230000000002 123.73750000000001p 0.00037682170000000002 123.75000000000001p 0.00036789070000000002
+ 123.76249999999999p 0.00035880850000000002 123.77499999999999p 0.00034958370000000001 123.78749999999999p 0.00034022510000000002 123.8p 0.00033074150000000002 123.8125p 0.00032114120000000001 123.825p 0.00031143259999999998 123.83749999999999p 0.0003016238 123.84999999999999p 0.00029172280000000001 123.8625p 0.00028173739999999998 123.875p 0.00027167499999999998 123.8875p 0.00026154310000000002 123.90000000000001p 0.0002513487 123.91250000000001p 0.0002410988 123.92499999999998p 0.0002308 123.93749999999999p 0.00022045880000000001 123.95p 0.0002100812 123.96250000000001p 0.00019967340000000001 123.97500000000001p 0.00018924090000000001
+ 123.98750000000001p 0.00017878929999999999 124.00000000000001p 0.00016832380000000001 124.01249999999999p 0.0001578494 124.02499999999999p 0.0001473709 124.03749999999999p 0.00013689290000000001 124.05p 0.0001264196 124.0625p 0.0001159553 124.075p 0.0001055039 124.08750000000001p 9.5069110000000002e-05 124.09999999999999p 8.4654520000000002e-05 124.1125p 7.426353e-05 124.125p 6.3899360000000004e-05 124.1375p 5.3565089999999999e-05 124.15000000000001p 4.3263670000000002e-05 124.16250000000001p 3.2997889999999997e-05 124.17499999999998p 2.2770459999999999e-05 124.18749999999999p 1.2583939999999999e-05 124.19999999999999p 2.4408399999999998e-06
+ 124.21250000000001p -7.6564520000000007e-06 124.22500000000001p -1.7705599999999999e-05 124.23750000000001p -2.7704340000000001e-05 124.25000000000001p -3.7650439999999997e-05 124.26249999999999p -4.7541730000000001e-05 124.27499999999999p -5.7376049999999998e-05 124.28749999999999p -6.7151259999999999e-05 124.3p -7.6865230000000006e-05 124.3125p -8.6515829999999998e-05 124.325p -9.6100910000000001e-05 124.33750000000001p -0.0001056183 124.34999999999999p -0.0001150658 124.3625p -0.00012444109999999999 124.375p -0.00013374209999999999 124.3875p -0.00014296630000000001 124.40000000000001p -0.00015211129999999999 124.41250000000001p -0.00016117470000000001 124.42500000000001p -0.000170154
+ 124.43749999999999p -0.00017904649999999999 124.44999999999999p -0.0001878495 124.46249999999999p -0.0001965604 124.47500000000001p -0.00020517619999999999 124.48750000000001p -0.000213694 124.50000000000001p -0.0002221108 124.51249999999999p -0.00023042350000000001 124.52499999999999p -0.00023862880000000001 124.53749999999999p -0.0002467236 124.55p -0.00025470430000000001 124.5625p -0.00026256769999999998 124.575p -0.00027031020000000002 124.58750000000001p -0.00027792810000000002 124.59999999999999p -0.0002854178 124.6125p -0.00029277559999999999 124.625p -0.00029999760000000002 124.6375p -0.00030708009999999997 124.65000000000001p -0.0003140191
+ 124.66250000000001p -0.00032081059999999997 124.67500000000001p -0.00032745080000000002 124.68749999999999p -0.0003339355 124.69999999999999p -0.0003402608 124.71249999999999p -0.00034642270000000001 124.72499999999999p -0.000352417 124.73750000000001p -0.00035823970000000002 124.75000000000001p -0.00036388689999999999 124.76250000000002p -0.00036935450000000002 124.77499999999999p -0.00037463859999999999 124.78749999999999p -0.00037973519999999998 124.8p -0.00038464050000000001 124.8125p -0.00038935059999999999 124.825p -0.00039386180000000002 124.83750000000001p -0.00039817040000000002 124.84999999999999p -0.0004022729 124.8625p -0.00040616570000000002 124.875p -0.00040984540000000002
+ 124.8875p -0.00041330879999999998 124.90000000000001p -0.00041655259999999998 124.91250000000001p -0.00041957399999999998 124.92500000000001p -0.00042236980000000002 124.93749999999999p -0.00042493750000000002 124.94999999999999p -0.0004272743 124.96249999999999p -0.00042937779999999999 124.97499999999999p -0.00043124569999999999 124.9875p -0.00043287570000000001 125.00000000000001p -0.00043426599999999999 125.01250000000002p -0.0004354146 125.02499999999999p -0.00043632000000000002 125.03749999999999p -0.00043698069999999997 125.05p -0.00043739529999999998 125.0625p -0.00043756269999999998 125.075p -0.000437482 125.08750000000001p -0.00043715250000000001 125.10000000000001p -0.0004365735
+ 125.1125p -0.0004357446 125.125p -0.00043466570000000001 125.1375p -0.00043333670000000001 125.15000000000001p -0.00043175780000000001 125.16250000000001p -0.00042992920000000002 125.17500000000001p -0.00042785149999999999 125.18749999999999p -0.00042552539999999998 125.19999999999999p -0.00042295169999999999 125.21249999999999p -0.00042013149999999997 125.22499999999999p -0.00041706579999999999 125.2375p -0.0004137562 125.25p -0.000410204 125.26250000000002p -0.00040641100000000002 125.27499999999999p -0.00040237900000000002 125.28749999999999p -0.00039811000000000002 125.3p -0.00039360600000000001 125.3125p -0.00038886949999999997 125.325p -0.00038390279999999999
+ 125.33750000000001p -0.00037870850000000001 125.35000000000001p -0.00037328920000000002 125.36249999999998p -0.00036764790000000001 125.375p -0.0003617874 125.3875p -0.00035571080000000002 125.40000000000001p -0.0003494215 125.41250000000001p -0.0003429226 125.42500000000001p -0.00033621760000000002 125.43750000000001p -0.00032931019999999999 125.44999999999999p -0.00032220399999999998 125.46249999999999p -0.00031490279999999999 125.47499999999999p -0.00030741040000000001 125.4875p -0.00029973100000000002 125.5p -0.0002918687 125.5125p -0.00028382759999999999 125.52499999999999p -0.00027561209999999998 125.53749999999999p -0.00026722660000000001 125.55p -0.00025867559999999997
+ 125.5625p -0.0002499639 125.575p -0.000241096 125.58750000000001p -0.00023207689999999999 125.60000000000001p -0.00022291149999999999 125.61249999999998p -0.00021360469999999999 125.62499999999999p -0.00020416170000000001 125.6375p -0.00019458759999999999 125.65000000000001p -0.00018488780000000001 125.66250000000001p -0.00017506760000000001 125.67500000000001p -0.0001651325 125.68750000000001p -0.00015508810000000001 125.69999999999999p -0.00014494 125.71249999999999p -0.0001346939 125.72499999999999p -0.00012435570000000001 125.7375p -0.0001139312 125.75p -0.0001034264 125.7625p -9.2847319999999996e-05 125.77500000000002p -8.2200180000000005e-05
+ 125.78749999999999p -7.1491139999999993e-05 125.8p -6.0726480000000001e-05 125.8125p -4.9912579999999999e-05 125.825p -3.9055840000000002e-05 125.83750000000001p -2.8162769999999999e-05 125.85000000000001p -1.7239929999999999e-05 125.86249999999998p -6.2939209999999999e-06 125.87499999999999p 4.668559e-06 125.88749999999999p 1.564078e-05 125.90000000000001p 2.6615950000000001e-05 125.91250000000001p 3.758722e-05 125.92500000000001p 4.8547719999999997e-05 125.93750000000001p 5.9490500000000002e-05 125.94999999999999p 7.0408599999999995e-05 125.96249999999999p 8.1295020000000001e-05 125.97499999999999p 9.2142719999999996e-05 125.9875p 0.0001029446 126p 0.00011369370000000001
+ 126.0125p 0.0001243828 126.02500000000001p 0.00013500480000000001 126.03749999999999p 0.00014555260000000001 126.05p 0.00015601910000000001 126.0625p 0.00016639709999999999 126.075p 0.00017667959999999999 126.08750000000001p 0.0001868595 126.10000000000001p 0.00019692970000000001 126.11249999999998p 0.0002068832 126.12499999999999p 0.000216713 126.13749999999999p 0.000226412 126.15000000000001p 0.00023597350000000001 126.16250000000001p 0.00024539050000000001 126.17500000000001p 0.00025465619999999998 126.18750000000001p 0.00026376399999999999 126.19999999999999p 0.00027270730000000001 126.21249999999999p 0.0002814793 126.22499999999999p 0.00029007380000000001
+ 126.2375p 0.0002984843 126.25p 0.00030670460000000002 126.2625p 0.0003147286 126.27500000000001p 0.0003225503 126.28749999999999p 0.00033016380000000002 126.3p 0.00033756349999999999 126.3125p 0.00034474359999999999 126.325p 0.00035169889999999999 126.33750000000001p 0.0003584242 126.35000000000001p 0.00036491429999999998 126.36250000000001p 0.00037116429999999999 126.37499999999999p 0.00037716969999999997 126.38749999999999p 0.00038292589999999998 126.39999999999999p 0.0003884286 126.41250000000001p 0.00039367390000000002 126.42500000000001p 0.00039865780000000002 126.43750000000001p 0.00040337670000000002 126.44999999999999p 0.00040782740000000001
+ 126.46249999999999p 0.00041200660000000001 126.47499999999999p 0.00041591140000000001 126.4875p 0.00041953930000000002 126.5p 0.00042288779999999999 126.5125p 0.00042595490000000002 126.52500000000001p 0.0004287386 126.53749999999999p 0.00043123750000000001 126.55p 0.00043345010000000003 126.5625p 0.00043537540000000003 126.575p 0.00043701260000000001 126.58750000000001p 0.00043836119999999997 126.60000000000001p 0.00043942109999999999 126.61250000000001p 0.00044019220000000002 126.62499999999999p 0.0004406748 126.63749999999999p 0.00044086949999999999 126.64999999999999p 0.00044077720000000001 126.66249999999999p 0.00044039889999999998 126.67500000000001p 0.00043973610000000001
+ 126.68750000000001p 0.00043879029999999999 126.70000000000002p 0.00043756349999999998 126.71249999999999p 0.00043605770000000002 126.72499999999999p 0.00043427530000000002 126.7375p 0.00043221900000000002 126.75p 0.00042989139999999998 126.7625p 0.00042729569999999998 126.77500000000001p 0.0004244351 126.78749999999999p 0.00042131310000000002 126.8p 0.00041793329999999999 126.8125p 0.00041429949999999998 126.825p 0.00041041580000000002 126.83750000000001p 0.00040628620000000002 126.85000000000001p 0.00040191530000000002 126.86250000000001p 0.0003973073 126.87499999999999p 0.00039246700000000002 126.88749999999999p 0.0003873991 126.89999999999999p 0.00038210849999999999
+ 126.91249999999999p 0.00037660010000000003 126.925p 0.00037087900000000001 126.93750000000001p 0.0003649503 126.95000000000002p 0.0003588194 126.96249999999999p 0.00035249149999999998 126.97499999999999p 0.000345972 126.9875p 0.00033926619999999997 127p 0.0003323798 127.0125p 0.00032531809999999998 127.02500000000001p 0.00031808660000000002 127.03750000000001p 0.00031069099999999998 127.05p 0.00030313680000000002 127.0625p 0.0002954295 127.075p 0.00028757460000000001 127.08750000000001p 0.00027957779999999998 127.10000000000001p 0.00027144449999999998 127.11250000000001p 0.00026318020000000003 127.12499999999999p 0.00025479039999999999
+ 127.13749999999999p 0.00024628049999999999 127.14999999999999p 0.00023765599999999999 127.16249999999999p 0.00022892219999999999 127.175p 0.0002200844 127.1875p 0.00021114779999999999 127.20000000000002p 0.0002021178 127.21249999999999p 0.00019299939999999999 127.22499999999999p 0.00018379790000000001 127.2375p 0.00017451810000000001 127.25p 0.00016516529999999999 127.2625p 0.00015574419999999999 127.27500000000001p 0.00014625980000000001 127.28750000000001p 0.00013671700000000001 127.29999999999998p 0.0001271205 127.3125p 0.000117475 127.325p 0.0001077852 127.33750000000001p 9.8055779999999996e-05 127.35000000000001p 8.8291240000000002e-05
+ 127.36250000000001p 7.8496119999999997e-05 127.37500000000001p 6.8674909999999996e-05 127.38749999999999p 5.8832020000000003e-05 127.39999999999999p 4.8971860000000002e-05 127.41249999999999p 3.9098769999999997e-05 127.425p 2.921708e-05 127.4375p 1.9331059999999999e-05 127.45p 9.4449849999999992e-06 127.46249999999999p -4.3692020000000001e-07 127.47499999999999p -1.031044e-05 127.4875p -2.0171390000000001e-05 127.5p -3.001558e-05 127.5125p -3.9838849999999999e-05 127.52500000000001p -4.9637040000000002e-05 127.53750000000001p -5.9405989999999999e-05 127.54999999999998p -6.9141540000000005e-05 127.56249999999999p -7.8839540000000006e-05 127.575p -8.8495820000000002e-05
+ 127.58750000000001p -9.8106199999999999e-05 127.60000000000001p -0.0001076665 127.61250000000001p -0.0001171725 127.62500000000001p -0.00012662 127.63749999999999p -0.00013600480000000001 127.64999999999999p -0.00014532250000000001 127.66249999999999p -0.00015456890000000001 127.675p -0.00016373970000000001 127.6875p -0.0001728306 127.7p -0.00018183709999999999 127.71250000000001p -0.00019075480000000001 127.72499999999999p -0.0001995794 127.7375p -0.0002083063 127.75p -0.00021693099999999999 127.7625p -0.00022544899999999999 127.77500000000001p -0.00023385579999999999 127.78750000000001p -0.00024214669999999999 127.79999999999998p -0.00025031720000000002
+ 127.81249999999999p -0.0002583625 127.82499999999999p -0.000266278 127.83750000000001p -0.000274059 127.85000000000001p -0.00028170080000000002 127.86250000000001p -0.00028919859999999999 127.87500000000001p -0.0002965477 127.88749999999999p -0.00030374340000000001 127.89999999999999p -0.00031078079999999998 127.91249999999999p -0.00031765530000000001 127.925p -0.00032436200000000002 127.9375p -0.00033089620000000003 127.95p -0.00033725330000000003 127.96250000000001p -0.0003434283 127.97499999999999p -0.00034941680000000002 127.9875p -0.0003552141 128p -0.00036081539999999998 128.01249999999999p -0.00036621640000000002 128.02500000000001p -0.00037141250000000001
+ 128.03750000000002p -0.00037639919999999999 128.05000000000001p -0.0003811722 128.0625p -0.0003857272 128.07499999999999p -0.00039006000000000002 128.08750000000001p -0.0003941665 128.09999999999999p -0.0003980427 128.11250000000001p -0.00040168469999999999 128.125p -0.0004050886 128.13749999999999p -0.00040825090000000001 128.15000000000001p -0.00041116809999999998 128.16249999999999p -0.00041383670000000002 128.17500000000001p -0.00041625359999999999 128.1875p -0.00041841559999999999 128.20000000000002p -0.0004203198 128.21250000000001p -0.00042196360000000001 128.22499999999999p -0.00042334430000000003 128.23749999999998p -0.00042445949999999998 128.25p -0.0004253072
+ 128.26249999999999p -0.00042588519999999999 128.27500000000001p -0.00042619190000000001 128.28749999999999p -0.00042622560000000001 128.30000000000001p -0.0004259849 128.3125p -0.00042546879999999997 128.32499999999999p -0.00042467630000000002 128.33750000000001p -0.00042360660000000002 128.34999999999999p -0.0004222594 128.36250000000001p -0.00042063430000000002 128.375p -0.00041873140000000001 128.38750000000002p -0.00041655080000000002 128.39999999999998p -0.00041409319999999999 128.41249999999999p -0.00041135899999999998 128.42500000000001p -0.00040834939999999999 128.4375p -0.00040506549999999998 128.45000000000002p -0.00040150860000000001 128.46250000000001p -0.00039768049999999998 128.47499999999999p -0.00039358310000000001
+ 128.48749999999998p -0.00038921849999999999 128.5p -0.00038458900000000001 128.51249999999999p -0.00037969730000000001 128.52500000000001p -0.00037454619999999997 128.53749999999999p -0.00036913879999999998 128.55000000000001p -0.00036347830000000003 128.5625p -0.0003575683 128.57499999999999p -0.00035141250000000001 128.58750000000001p -0.00034501470000000001 128.59999999999999p -0.00033837919999999999 128.61250000000001p -0.00033151030000000002 128.625p -0.0003244125 128.63750000000002p -0.0003170906 128.64999999999998p -0.00030954950000000001 128.66249999999999p -0.00030179430000000003 128.67500000000001p -0.00029383030000000002 128.6875p -0.00028566289999999999 128.70000000000002p -0.00027729780000000003
+ 128.71250000000001p -0.00026874069999999997 128.72499999999999p -0.00025999760000000003 128.73749999999998p -0.00025107459999999999 128.75p -0.0002419779 128.76249999999999p -0.00023271380000000001 128.77500000000001p -0.00022328880000000001 128.78749999999999p -0.00021370960000000001 128.80000000000001p -0.00020398279999999999 128.8125p -0.00019411539999999999 128.82499999999999p -0.00018411419999999999 128.83750000000001p -0.00017398629999999999 128.84999999999999p -0.0001637388 128.86250000000001p -0.00015337900000000001 128.875p -0.00014291409999999999 128.88750000000002p -0.00013235149999999999 128.89999999999998p -0.0001216986 128.91249999999999p -0.000110963 128.92499999999998p -0.00010015230000000001
+ 128.9375p -8.9273929999999995e-05 128.95000000000002p -7.8335679999999995e-05 128.96250000000001p -6.7345210000000001e-05 128.97500000000002p -5.631027e-05 128.98749999999998p -4.5238609999999998e-05 129p -3.4138029999999999e-05 129.01249999999999p -2.3016340000000001e-05 129.02500000000001p -1.1881370000000001e-05 129.03749999999999p -7.4093969999999999e-07 129.05000000000001p 1.039709e-05 129.0625p 2.1524890000000001e-05 129.07499999999999p 3.2634610000000002e-05 129.08750000000001p 4.371843e-05 129.09999999999999p 5.4768519999999997e-05 129.11250000000001p 6.5777089999999997e-05 129.125p 7.6736350000000003e-05 129.13750000000002p 8.7638560000000002e-05 129.14999999999998p 9.8475989999999996e-05
+ 129.16249999999999p 0.00010924100000000001 129.17499999999998p 0.0001199258 129.1875p 0.00013052300000000001 129.20000000000002p 0.00014102480000000001 129.21250000000001p 0.00015142399999999999 129.22500000000002p 0.00016171290000000001 129.23749999999998p 0.00017188429999999999 129.25p 0.00018193079999999999 129.26249999999999p 0.00019184510000000001 129.27500000000001p 0.0002016203 129.28749999999999p 0.0002112491 129.30000000000001p 0.00022072460000000001 129.3125p 0.00023003990000000001 129.32499999999999p 0.0002391882 129.33750000000001p 0.00024816299999999998 129.34999999999999p 0.00025695749999999999 129.36250000000001p 0.00026556540000000002 129.375p 0.00027398039999999998
+ 129.38750000000002p 0.00028219619999999998 129.39999999999998p 0.00029020689999999997 129.41249999999999p 0.00029800660000000001 129.42499999999998p 0.00030558940000000002 129.4375p 0.00031294990000000001 129.44999999999999p 0.0003200826 129.46250000000001p 0.00032698230000000002 129.47500000000002p 0.00033364389999999999 129.48749999999998p 0.00034006260000000001 129.5p 0.00034623370000000001 129.51249999999999p 0.00035215259999999999 129.52500000000001p 0.0003578152 129.53749999999999p 0.0003632175 129.55000000000001p 0.00036835550000000001 129.5625p 0.0003732257 129.57499999999999p 0.00037782469999999999 129.58750000000001p 0.00038214949999999998 129.59999999999999p 0.0003861971
+ 129.61250000000001p 0.0003899649 129.625p 0.00039345070000000002 129.63750000000002p 0.00039665220000000001 129.65000000000001p 0.0003995677 129.66249999999999p 0.00040219570000000002 129.67499999999998p 0.00040453480000000002 129.6875p 0.00040658399999999998 129.69999999999999p 0.00040834269999999998 129.71250000000001p 0.00040981049999999999 129.72500000000002p 0.00041098699999999997 129.73749999999998p 0.00041187260000000002 129.75p 0.00041246760000000001 129.76249999999999p 0.00041277270000000002 129.77500000000001p 0.00041278899999999999 129.78749999999999p 0.00041251759999999998 129.80000000000001p 0.00041196020000000002 129.8125p 0.00041111849999999998 129.82499999999999p 0.00040999470000000003
+ 129.83750000000001p 0.00040859110000000001 129.84999999999999p 0.00040691030000000001 129.86250000000001p 0.00040495530000000002 129.875p 0.00040272909999999998 129.88750000000002p 0.00040023510000000001 129.90000000000001p 0.00039747699999999998 129.91249999999999p 0.00039445849999999999 129.92499999999998p 0.00039118379999999997 129.9375p 0.00038765700000000002 129.94999999999999p 0.00038388270000000002 129.96250000000001p 0.00037986550000000002 129.97500000000002p 0.00037561030000000001 129.98750000000001p 0.00037112190000000001 130p 0.00036640570000000001 130.01249999999999p 0.00036146680000000001 130.02500000000001p 0.00035631079999999998 130.03749999999999p 0.0003509432 130.05000000000001p 0.00034536959999999998
+ 130.0625p 0.00033959600000000001 130.07499999999999p 0.00033362799999999998 130.08750000000001p 0.00032747180000000002 130.09999999999999p 0.00032113319999999999 130.11250000000001p 0.00031461850000000002 130.125p 0.00030793360000000002 130.13750000000002p 0.00030108480000000002 130.15000000000001p 0.00029407819999999999 130.16249999999999p 0.00028692000000000002 130.17499999999998p 0.00027961639999999997 130.1875p 0.00027217369999999998 130.19999999999999p 0.00026459790000000002 130.21250000000001p 0.0002568952 130.22499999999999p 0.0002490719 130.23750000000001p 0.00024113380000000001 130.25p 0.00023308709999999999 130.26249999999999p 0.00022493780000000001 130.27500000000001p 0.0002166918
+ 130.28749999999999p 0.00020835499999999999 130.30000000000001p 0.00019993309999999999 130.3125p 0.0001914319 130.32500000000002p 0.000182857 130.33749999999998p 0.0001742139 130.34999999999999p 0.0001655083 130.36250000000001p 0.00015674530000000001 130.375p 0.00014793050000000001 130.38750000000002p 0.00013906890000000001 130.40000000000001p 0.00013016570000000001 130.41249999999999p 0.00012122599999999999 130.42499999999998p 0.0001122546 130.4375p 0.0001032565 130.44999999999999p 9.4236330000000006e-05 130.46250000000001p 8.5198890000000001e-05 130.47499999999999p 7.614872e-05 130.48750000000001p 6.7090349999999994e-05 130.5p 5.8028200000000001e-05
+ 130.51249999999999p 4.8966630000000002e-05 130.52500000000001p 3.9909910000000003e-05 130.53749999999999p 3.0862250000000001e-05 130.55000000000001p 2.1827790000000001e-05 130.5625p 1.281061e-05 130.57500000000002p 3.8147110000000002e-06 130.58749999999998p -5.1559440000000004e-06 130.59999999999999p -1.409745e-05 130.61250000000001p -2.300596e-05 130.625p -3.1877649999999998e-05 130.63750000000002p -4.0708769999999997e-05 130.65000000000001p -4.9495559999999998e-05 130.66250000000002p -5.8234340000000002e-05 130.67499999999998p -6.6921429999999995e-05 130.6875p -7.5553169999999998e-05 130.69999999999999p -8.4125949999999997e-05 130.71250000000001p -9.2636149999999996e-05 130.72499999999999p -0.0001010802
+ 130.73750000000001p -0.0001094544 130.75p -0.00011775529999999999 130.76249999999999p -0.00012597929999999999 130.77500000000001p -0.0001341228 130.78749999999999p -0.00014218219999999999 130.80000000000001p -0.000150154 130.8125p -0.0001580346 130.82500000000002p -0.0001658203 130.83749999999998p -0.00017350770000000001 130.84999999999999p -0.00018109300000000001 130.86249999999998p -0.0001885728 130.875p -0.00019594330000000001 130.88750000000002p -0.0002032011 130.90000000000001p -0.00021034229999999999 130.91250000000002p -0.00021736349999999999 130.92499999999998p -0.00022426090000000001 130.9375p -0.00023103110000000001 130.94999999999999p -0.00023767020000000001
+ 130.96250000000001p -0.00024417470000000002 130.97499999999999p -0.00025054100000000001 130.98750000000001p -0.00025676540000000003 131p -0.00026284429999999997 131.01249999999999p -0.00026877429999999999 131.02500000000001p -0.00027455159999999998 131.03749999999999p -0.0002801727 131.05000000000001p -0.00028563420000000001 131.0625p -0.00029093259999999997 131.07500000000002p -0.00029606430000000001 131.08749999999998p -0.00030102610000000001 131.09999999999999p -0.0003058146 131.11249999999998p -0.00031042640000000001 131.125p -0.00031485839999999997 131.13750000000002p -0.00031910739999999998 131.15000000000001p -0.0003231703 131.16250000000002p -0.00032704400000000002 131.17499999999998p -0.0003307257
+ 131.1875p -0.00033421250000000003 131.19999999999999p -0.0003375017 131.21250000000001p -0.00034059059999999998 131.22499999999999p -0.00034347659999999999 131.23750000000001p -0.00034615740000000001 131.25p -0.00034863070000000002 131.26249999999999p -0.00035089419999999999 131.27500000000001p -0.00035294580000000002 131.28749999999999p -0.00035478380000000001 131.30000000000001p -0.00035640630000000002 131.3125p -0.00035781149999999999 131.32500000000002p -0.00035899819999999998 131.33749999999998p -0.0003599648 131.34999999999999p -0.00036071019999999999 131.36249999999998p -0.00036123330000000002 131.375p -0.00036153340000000001 131.38749999999999p -0.00036160959999999997 131.40000000000001p -0.00036146140000000002
+ 131.41250000000002p -0.0003610884 131.42499999999998p -0.00036049049999999999 131.4375p -0.00035966749999999999 131.44999999999999p -0.0003586196 131.46250000000001p -0.00035734710000000003 131.47499999999999p -0.00035585039999999998 131.48750000000001p -0.00035413030000000002 131.5p -0.00035218750000000002 131.51249999999999p -0.0003500229 131.52500000000001p -0.00034763790000000001 131.53749999999999p -0.0003450336 131.55000000000001p -0.00034221149999999999 131.5625p -0.00033917339999999999 131.57500000000002p -0.00033592110000000002 131.58750000000001p -0.00033245650000000002 131.59999999999999p -0.00032878170000000002 131.61249999999998p -0.00032489919999999998 131.625p -0.00032081120000000002
+ 131.63749999999999p -0.00031652049999999999 131.65000000000001p -0.00031202980000000002 131.66250000000002p -0.000307342 131.67499999999998p -0.00030246 131.6875p -0.00029738719999999999 131.69999999999999p -0.0002921267 131.71250000000001p -0.0002866821 131.72499999999999p -0.0002810569 131.73750000000001p -0.00027525470000000003 131.75p -0.00026927940000000001 131.76249999999999p -0.00026313500000000001 131.77500000000001p -0.00025682530000000002 131.78749999999999p -0.00025035470000000002 131.80000000000001p -0.00024372719999999999 131.8125p -0.00023694729999999999 131.82500000000002p -0.00023001940000000001 131.83750000000001p -0.00022294789999999999 131.84999999999999p -0.00021573760000000001
+ 131.86249999999998p -0.0002083931 131.875p -0.0002009193 131.88749999999999p -0.0001933208 131.90000000000001p -0.00018560279999999999 131.91249999999999p -0.00017777019999999999 131.92500000000001p -0.00016982799999999999 131.9375p -0.0001617814 131.94999999999999p -0.00015363559999999999 131.96250000000001p -0.00014539589999999999 131.97499999999999p -0.0001370675 131.98750000000001p -0.00012865580000000001 132p -0.00012016629999999999 132.01249999999999p -0.0001116043 132.02499999999998p -0.0001029754 132.03749999999999p -9.4285120000000004e-05 132.05000000000001p -8.5538999999999995e-05 132.0625p -7.6742679999999998e-05 132.07500000000002p -6.790179e-05
+ 132.08750000000001p -5.9021999999999998e-05 132.09999999999999p -5.0109019999999999e-05 132.11249999999998p -4.1168570000000002e-05 132.125p -3.2206380000000002e-05 132.13749999999999p -2.3228230000000001e-05 132.15000000000001p -1.423989e-05 132.16249999999999p -5.2471479999999998e-06 132.17500000000001p 3.7441869999999999e-06 132.1875p 1.27283e-05 132.19999999999999p 2.169939e-05 132.21250000000001p 3.0651629999999998e-05 132.22499999999999p 3.9579190000000001e-05 132.23750000000001p 4.8476280000000001e-05 132.25p 5.7337080000000002e-05 132.26250000000002p 6.6155789999999994e-05 132.27499999999998p 7.4926639999999998e-05 132.28749999999999p 8.3643850000000004e-05 132.30000000000001p 9.2301670000000002e-05
+ 132.3125p 0.0001008944 132.32500000000002p 0.0001094163 132.33750000000001p 0.0001178617 132.34999999999999p 0.0001262251 132.36249999999998p 0.00013450070000000001 132.375p 0.00014268310000000001 132.38749999999999p 0.00015076679999999999 132.40000000000001p 0.00015874619999999999 132.41249999999999p 0.0001666161 132.42500000000001p 0.00017437099999999999 132.4375p 0.0001820057 132.44999999999999p 0.00018951499999999999 132.46250000000001p 0.00019689370000000001 132.47499999999999p 0.00020413690000000001 132.48750000000001p 0.00021123950000000001 132.5p 0.0002181966 132.51250000000002p 0.00022500349999999999 132.52499999999998p 0.0002316555
+ 132.53749999999999p 0.00023814809999999999 132.55000000000001p 0.00024447660000000002 132.5625p 0.00025063679999999999 132.57500000000002p 0.00025662450000000001 132.58750000000001p 0.0002624355 132.60000000000002p 0.0002680658 132.61249999999998p 0.00027351170000000001 132.625p 0.00027876929999999999 132.63749999999999p 0.0002838351 132.65000000000001p 0.0002887058 132.66249999999999p 0.00029337800000000001 132.67500000000001p 0.00029784869999999999 132.6875p 0.00030211490000000001 132.69999999999999p 0.00030617380000000003 132.71250000000001p 0.0003100229 132.72499999999999p 0.00031365979999999999 132.73750000000001p 0.00031708209999999998 132.75p 0.00032028789999999997
+ 132.76250000000002p 0.00032327529999999998 132.77499999999998p 0.00032604249999999997 132.78749999999999p 0.00032858820000000001 132.79999999999998p 0.0003309109 132.8125p 0.00033300959999999998 132.82500000000002p 0.00033488339999999999 132.83750000000001p 0.00033653159999999998 132.85000000000002p 0.00033795359999999998 132.86249999999998p 0.00033914919999999997 132.875p 0.00034011810000000002 132.88749999999999p 0.0003408606 132.90000000000001p 0.00034137680000000001 132.91249999999999p 0.00034166719999999999 132.92500000000001p 0.00034173260000000002 132.9375p 0.00034157360000000001 132.94999999999999p 0.00034119149999999997 132.96250000000001p 0.00034058740000000002 132.97499999999999p 0.00033976269999999999
+ 132.98750000000001p 0.00033871900000000002 133p 0.00033745809999999999 133.01250000000002p 0.00033598200000000002 133.02499999999998p 0.00033429260000000002 133.03749999999999p 0.00033239229999999998 133.04999999999998p 0.0003302836 133.0625p 0.00032796890000000002 133.07500000000002p 0.00032545099999999998 133.08750000000001p 0.0003227328 133.10000000000002p 0.00031981719999999998 133.11249999999998p 0.0003167073 133.125p 0.00031340650000000002 133.13749999999999p 0.00030991800000000001 133.15000000000001p 0.00030624539999999999 133.16249999999999p 0.00030239209999999999 133.17500000000001p 0.00029836179999999997 133.1875p 0.00029415840000000001 133.19999999999999p 0.00028978549999999999
+ 133.21250000000001p 0.00028524719999999999 133.22499999999999p 0.00028054730000000002 133.23750000000001p 0.00027568999999999998 133.25p 0.00027067930000000001 133.26250000000002p 0.00026551930000000002 133.27500000000001p 0.00026021429999999998 133.28749999999999p 0.00025476840000000003 133.29999999999998p 0.0002491859 133.3125p 0.00024347109999999999 133.32499999999999p 0.0002376282 133.33750000000001p 0.00023166159999999999 133.35000000000002p 0.00022557569999999999 133.36249999999998p 0.00021937460000000001 133.375p 0.00021306290000000001 133.38749999999999p 0.00020664469999999999 133.40000000000001p 0.00020012440000000001 133.41249999999999p 0.00019350629999999999 133.42500000000001p 0.0001867948
+ 133.4375p 0.00017999410000000001 133.44999999999999p 0.0001731084 133.46250000000001p 0.00016614200000000001 133.47499999999999p 0.00015909919999999999 133.48750000000001p 0.00015198410000000001 133.5p 0.0001448009 133.51250000000002p 0.0001375537 133.52500000000001p 0.00013024670000000001 133.53749999999999p 0.00012288380000000001 133.54999999999998p 0.0001154693 133.5625p 0.0001080071 133.57499999999999p 0.0001005011 133.58750000000001p 9.2955409999999995e-05 133.60000000000002p 8.5373880000000005e-05 133.61249999999998p 7.7760430000000004e-05 133.625p 7.0118940000000007e-05 133.63749999999999p 6.2453239999999996e-05 133.65000000000001p 5.4767150000000003e-05
+ 133.66249999999999p 4.7064470000000001e-05 133.67500000000001p 3.9348960000000003e-05 133.6875p 3.162437e-05 133.69999999999999p 2.389441e-05 133.71250000000001p 1.61628e-05 133.72499999999999p 8.4332150000000002e-06 133.73750000000001p 7.0931839999999997e-07 133.75p -7.0052359999999996e-06 133.76250000000002p -1.470681e-05 133.77500000000001p -2.239178e-05 133.78749999999999p -3.0056530000000001e-05 133.79999999999998p -3.7697449999999999e-05 133.8125p -4.5310949999999997e-05 133.82499999999999p -5.289343e-05 133.83750000000001p -6.0441310000000001e-05 133.84999999999999p -6.7951e-05 133.86250000000001p -7.5418909999999998e-05 133.875p -8.2841469999999994e-05
+ 133.88749999999999p -9.0215099999999996e-05 133.90000000000001p -9.7536209999999997e-05 133.91249999999999p -0.0001048012 133.92500000000001p -0.00011200650000000001 133.9375p -0.00011914860000000001 133.94999999999999p -0.00012622379999999999 133.96249999999998p -0.0001332285 133.97499999999999p -0.00014015920000000001 133.98750000000001p -0.00014701220000000001 134p -0.00015378399999999999 134.01250000000002p -0.0001604709 134.02500000000001p -0.0001670694 134.03749999999999p -0.00017357580000000001 134.04999999999998p -0.0001799866 134.0625p -0.00018629820000000001 134.07499999999999p -0.00019250690000000001 134.08750000000001p -0.0001986092 134.09999999999999p -0.00020460159999999999
+ 134.11250000000001p -0.00021048050000000001 134.125p -0.00021624219999999999 134.13749999999999p -0.0002218834 134.15000000000001p -0.00022740060000000001 134.16249999999999p -0.00023279010000000001 134.17500000000001p -0.0002380486 134.1875p -0.00024317269999999999 134.20000000000002p -0.00024815889999999999 134.21249999999998p -0.00025300399999999998 134.22499999999999p -0.00025770449999999999 134.23750000000001p -0.0002622573 134.25p -0.00026665910000000002 134.26250000000002p -0.00027090669999999998 134.27500000000001p -0.0002749971 134.28749999999999p -0.00027892709999999997 134.29999999999998p -0.00028269390000000002 134.3125p -0.00028629440000000001 134.32499999999999p -0.00028972589999999999
+ 134.33750000000001p -0.00029298559999999999 134.34999999999999p -0.0002960708 134.36250000000001p -0.00029897890000000002 134.375p -0.00030170739999999999 134.38749999999999p -0.00030425390000000002 134.40000000000001p -0.00030661620000000002 134.41249999999999p -0.00030879189999999997 134.42500000000001p -0.00031077900000000001 134.4375p -0.00031257559999999998 134.45000000000002p -0.00031417970000000001 134.46249999999998p -0.0003155896 134.47499999999999p -0.00031680370000000002 134.48749999999998p -0.00031782039999999999 134.5p -0.0003186385 134.51250000000002p -0.00031925660000000001 134.52500000000001p -0.0003196737 134.53750000000002p -0.0003198888 134.54999999999998p -0.00031990110000000002
+ 134.5625p -0.00031970989999999998 134.57499999999999p -0.0003193146 134.58750000000001p -0.00031871489999999998 134.59999999999999p -0.00031791049999999998 134.61250000000001p -0.00031690139999999999 134.625p -0.00031568759999999998 134.63749999999999p -0.00031426920000000001 134.65000000000001p -0.00031264679999999998 134.66249999999999p -0.00031082069999999998 134.67500000000001p -0.00030879170000000001 134.6875p -0.00030656059999999998 134.70000000000002p -0.0003041284 134.71249999999998p -0.00030149620000000002 134.72499999999999p -0.00029866529999999998 134.73749999999998p -0.00029563719999999998 134.75p -0.0002924135 134.76250000000002p -0.00028899589999999999 134.77500000000001p -0.00028538629999999999
+ 134.78750000000002p -0.00028158669999999998 134.79999999999998p -0.00027759950000000002 134.8125p -0.00027342680000000001 134.82499999999999p -0.00026907130000000001 134.83750000000001p -0.0002645355 134.84999999999999p -0.00025982220000000001 134.86250000000001p -0.0002549343 134.875p -0.00024987490000000001 134.88749999999999p -0.00024464719999999998 134.90000000000001p -0.0002392544 134.91249999999999p -0.00023369999999999999 134.92500000000001p -0.00022798750000000001 134.9375p -0.0002221208 134.95000000000002p -0.00021610339999999999 134.96249999999998p -0.0002099395 134.97499999999999p -0.00020363290000000001 134.98749999999998p -0.00019718789999999999 135p -0.00019060870000000001
+ 135.01250000000002p -0.0001838996 135.02500000000001p -0.0001770652 135.03750000000002p -0.0001701099 135.04999999999998p -0.00016303840000000001 135.0625p -0.0001558555 135.07499999999999p -0.00014856590000000001 135.08750000000001p -0.00014117449999999999 135.09999999999999p -0.00013368639999999999 135.11250000000001p -0.0001261066 135.125p -0.0001184402 135.13749999999999p -0.0001106924 135.15000000000001p -0.0001028685 135.16249999999999p -9.497377e-05 135.17500000000001p -8.7013640000000006e-05 135.1875p -7.8993530000000004e-05 135.20000000000002p -7.0918919999999998e-05 135.21250000000001p -6.2795329999999994e-05 135.22499999999999p -5.4628340000000003e-05
+ 135.23749999999998p -4.6423559999999998e-05 135.25p -3.8186640000000001e-05 135.26249999999999p -2.9923249999999998e-05 135.27500000000001p -2.1639110000000002e-05 135.28750000000002p -1.333994e-05 135.29999999999998p -5.0314889999999999e-06 135.3125p 3.2804739999999999e-06 135.32499999999999p 1.1590169999999999e-05 135.33750000000001p 1.9891809999999999e-05 135.34999999999999p 2.8179610000000001e-05 135.36250000000001p 3.6447769999999998e-05 135.375p 4.4690510000000003e-05 135.38749999999999p 5.2902029999999998e-05 135.40000000000001p 6.1076569999999995e-05 135.41249999999999p 6.9208380000000005e-05 135.42500000000001p 7.7291709999999998e-05 135.4375p 8.5320849999999995e-05 135.45000000000002p 9.3290120000000005e-05
+ 135.46250000000001p 0.0001011939 135.47499999999999p 0.0001090265 135.48749999999998p 0.0001167824 135.5p 0.000124456 135.51249999999999p 0.00013204189999999999 135.52500000000001p 0.00013953460000000001 135.53750000000002p 0.0001469288 135.55000000000001p 0.00015421909999999999 135.5625p 0.00016140039999999999 135.57499999999999p 0.0001684674 135.58750000000001p 0.00017541510000000001 135.59999999999999p 0.00018223840000000001 135.61250000000001p 0.0001889324 135.625p 0.00019549230000000001 135.63749999999999p 0.00020191330000000001 135.65000000000001p 0.0002081908 135.66249999999999p 0.0002143204 135.67500000000001p 0.0002202974
+ 135.6875p 0.00022611770000000001 135.70000000000002p 0.00023177699999999999 135.71250000000001p 0.00023727129999999999 135.72499999999999p 0.00024259659999999999 135.73749999999998p 0.00024774919999999998 135.75p 0.00025272530000000002 135.76249999999999p 0.0002575214 135.77500000000001p 0.00026213419999999998 135.78749999999999p 0.00026656040000000002 135.80000000000001p 0.00027079699999999998 135.8125p 0.00027484090000000003 135.82499999999999p 0.0002786895 135.83750000000001p 0.00028234020000000002 135.84999999999999p 0.00028579050000000002 135.86250000000001p 0.00028903810000000001 135.875p 0.0002920811 135.88750000000002p 0.00029491750000000002 135.89999999999998p 0.00029754549999999998
+ 135.91249999999999p 0.00029996370000000001 135.92500000000001p 0.00030217070000000001 135.9375p 0.00030416520000000003 135.95000000000002p 0.0003059464 135.96250000000001p 0.00030751340000000001 135.97499999999999p 0.00030886550000000003 135.98749999999998p 0.00031000249999999999 136p 0.00031092400000000002 136.01249999999999p 0.0003116301 136.02500000000001p 0.00031212070000000001 136.03749999999999p 0.00031239640000000002 136.05000000000001p 0.00031245760000000002 136.0625p 0.00031230489999999999 136.07499999999999p 0.00031193939999999998 136.08750000000001p 0.00031136199999999998 136.09999999999999p 0.00031057399999999998 136.11250000000001p 0.00030957679999999999 136.125p 0.00030837209999999999
+ 136.13750000000002p 0.00030696150000000003 136.14999999999998p 0.00030534699999999998 136.16249999999999p 0.00030353059999999998 136.17500000000001p 0.00030151469999999998 136.1875p 0.00029930149999999998 136.20000000000002p 0.00029689380000000001 136.21250000000001p 0.00029429400000000001 136.22499999999999p 0.00029150509999999999 136.23749999999998p 0.00028853 136.25p 0.0002853717 136.26249999999999p 0.00028203359999999999 136.27500000000001p 0.00027851880000000001 136.28749999999999p 0.0002748308 136.30000000000001p 0.00027097310000000002 136.3125p 0.00026694940000000002 136.32499999999999p 0.00026276339999999998 136.33750000000001p 0.00025841880000000001 136.34999999999999p 0.00025391949999999997
+ 136.36250000000001p 0.00024926959999999998 136.375p 0.00024447290000000001 136.38750000000002p 0.00023953360000000001 136.39999999999998p 0.00023445580000000001 136.41249999999999p 0.00022924370000000001 136.42499999999998p 0.0002239016 136.4375p 0.00021843359999999999 136.45000000000002p 0.00021284409999999999 136.46250000000001p 0.0002071373 136.47500000000002p 0.00020131780000000001 136.48749999999998p 0.00019538969999999999 136.5p 0.00018935760000000001 136.51249999999999p 0.00018322569999999999 136.52500000000001p 0.0001769985 136.53749999999999p 0.00017068040000000001 136.55000000000001p 0.0001642758 136.5625p 0.000157789 136.57499999999999p 0.00015122439999999999
+ 136.58750000000001p 0.00014458639999999999 136.59999999999999p 0.00013787940000000001 136.61250000000001p 0.0001311076 136.625p 0.0001242754 136.63750000000002p 0.0001173871 136.64999999999998p 0.0001104469 136.66249999999999p 0.000103459 136.67499999999998p 9.6427800000000005e-05 136.6875p 8.9357330000000001e-05 136.70000000000002p 8.2251789999999997e-05 136.71250000000001p 7.5115289999999995e-05 136.72500000000002p 6.7951939999999998e-05 136.73749999999998p 6.07658e-05 136.75p 5.3560899999999997e-05 136.76249999999999p 4.634125e-05 136.77500000000001p 3.911082e-05 136.78749999999999p 3.1873550000000002e-05 136.80000000000001p 2.463335e-05
+ 136.8125p 1.7394120000000001e-05 136.82499999999999p 1.015969e-05 136.83750000000001p 2.9339040000000001e-06 136.84999999999999p -4.2794489999999999e-06 136.86250000000001p -1.14766e-05 136.875p -1.865379e-05 136.88750000000002p -2.580731e-05 136.89999999999998p -3.2933469999999997e-05 136.91249999999999p -4.0028579999999997e-05 136.92499999999998p -4.7089000000000003e-05 136.9375p -5.4111099999999998e-05 136.94999999999999p -6.1091269999999994e-05 136.96250000000001p -6.8025919999999997e-05 136.97500000000002p -7.4911489999999995e-05 136.98749999999998p -8.1744409999999997e-05 137p -8.852117e-05 137.01249999999999p -9.5238240000000002e-05 137.02500000000001p -0.0001018921
+ 137.03749999999999p -0.0001084794 137.05000000000001p -0.0001149965 137.0625p -0.00012144 137.07499999999999p -0.00012780650000000001 137.08750000000001p -0.00013409270000000001 137.09999999999999p -0.000140295 137.11250000000001p -0.00014641010000000001 137.125p -0.00015243470000000001 137.13750000000002p -0.0001583655 137.15000000000001p -0.0001641991 137.16249999999999p -0.00016993220000000001 137.17499999999998p -0.00017556160000000001 137.1875p -0.000181084 137.19999999999999p -0.00018649620000000001 137.21250000000001p -0.00019179510000000001 137.22500000000002p -0.00019697740000000001 137.23749999999998p -0.00020204009999999999 137.25p -0.00020698010000000001
+ 137.26249999999999p -0.00021179440000000001 137.27500000000001p -0.00021647990000000001 137.28749999999999p -0.0002210337 137.30000000000001p -0.00022545289999999999 137.3125p -0.00022973469999999999 137.32499999999999p -0.0002338761 137.33750000000001p -0.00023787459999999999 137.34999999999999p -0.00024172730000000001 137.36250000000001p -0.00024543170000000002 137.375p -0.00024898530000000001 137.38750000000002p -0.00025238540000000002 137.40000000000001p -0.0002556298 137.41249999999999p -0.00025871599999999998 137.42499999999998p -0.00026164189999999999 137.4375p -0.00026440520000000001 137.44999999999999p -0.00026700390000000001 137.46250000000001p -0.00026943589999999998 137.47500000000002p -0.00027169949999999998
+ 137.48750000000001p -0.00027379269999999999 137.5p -0.0002757139 137.51249999999999p -0.00027746139999999998 137.52500000000001p -0.00027903390000000002 137.53749999999999p -0.00028042989999999999 137.55000000000001p -0.00028164809999999999 137.5625p -0.00028268740000000003 137.57499999999999p -0.00028354679999999997 137.58749999999998p -0.00028422540000000001 137.59999999999999p -0.0002847223 137.61250000000001p -0.00028503699999999997 137.625p -0.00028516879999999998 137.63750000000002p -0.00028511740000000002 137.65000000000001p -0.00028488249999999998 137.66249999999999p -0.00028446400000000001 137.67499999999998p -0.0002838618 137.6875p -0.00028307609999999998 137.69999999999999p -0.00028210710000000001
+ 137.71250000000001p -0.00028095529999999999 137.72499999999999p -0.00027962110000000001 137.73750000000001p -0.00027810520000000002 137.75p -0.00027640850000000002 137.76249999999999p -0.00027453180000000001 137.77500000000001p -0.00027247620000000003 137.78749999999999p -0.00027024299999999998 137.80000000000001p -0.00026783349999999999 137.8125p -0.00026524909999999999 137.82500000000002p -0.00026249150000000001 137.83749999999998p -0.00025956239999999999 137.84999999999999p -0.0002564636 137.86250000000001p -0.00025319729999999998 137.875p -0.00024976540000000002 137.88750000000002p -0.0002461702 137.90000000000001p -0.00024241409999999999 137.91249999999999p -0.0002384996 137.92499999999998p -0.00023442919999999999
+ 137.9375p -0.00023020580000000001 137.94999999999999p -0.00022583210000000001 137.96250000000001p -0.000221311 137.97499999999999p -0.0002166456 137.98750000000001p -0.0002118391 138p -0.0002068947 138.01249999999999p -0.00020181570000000001 138.02500000000001p -0.0001966057 138.03749999999999p -0.000191268 138.05000000000001p -0.00018580650000000001 138.0625p -0.00018022470000000001 138.07500000000002p -0.0001745265 138.08749999999998p -0.00016871569999999999 138.09999999999999p -0.00016279630000000001 138.11250000000001p -0.00015677240000000001 138.125p -0.000150648 138.13750000000002p -0.00014442740000000001 138.15000000000001p -0.00013811459999999999
+ 138.16250000000002p -0.00013171410000000001 138.17499999999998p -0.00012523020000000001 138.1875p -0.00011866719999999999 138.19999999999999p -0.0001120297 138.21250000000001p -0.00010532220000000001 138.22499999999999p -9.8549150000000005e-05 138.23750000000001p -9.171521e-05 138.25p -8.4825010000000003e-05 138.26249999999999p -7.7883220000000001e-05 138.27500000000001p -7.089455e-05 138.28749999999999p -6.3863720000000005e-05 138.30000000000001p -5.6795510000000003e-05 138.3125p -4.9694699999999997e-05 138.32500000000002p -4.2566089999999998e-05 138.33749999999998p -3.5414519999999999e-05 138.34999999999999p -2.824483e-05 138.36249999999998p -2.106187e-05 138.375p -1.38705e-05
+ 138.38750000000002p -6.6756019999999997e-06 138.40000000000001p 5.1796039999999998e-07 138.41250000000002p 7.7053110000000007e-06 138.42499999999998p 1.488158e-05 138.4375p 2.20419e-05 138.44999999999999p 2.918142e-05 138.46250000000001p 3.6295280000000003e-05 138.47499999999999p 4.3378679999999997e-05 138.48750000000001p 5.0426780000000002e-05 138.5p 5.7434810000000002e-05 138.51249999999999p 6.4397990000000002e-05 138.52500000000001p 7.1311589999999996e-05 138.53749999999999p 7.8170900000000001e-05 138.55000000000001p 8.4971260000000001e-05 138.5625p 9.1708019999999998e-05 138.57500000000002p 9.8376579999999995e-05 138.58749999999998p 0.0001049724 138.59999999999999p 0.00011149099999999999
+ 138.61249999999998p 0.00011792790000000001 138.625p 0.00012427870000000001 138.63750000000002p 0.00013053899999999999 138.65000000000001p 0.00013670469999999999 138.66250000000002p 0.00014277140000000001 138.67499999999998p 0.00014873499999999999 138.6875p 0.00015459149999999999 138.69999999999999p 0.0001603369 138.71250000000001p 0.00016596720000000001 138.72499999999999p 0.00017147850000000001 138.73750000000001p 0.00017686730000000001 138.75p 0.0001821297 138.76249999999999p 0.00018726220000000001 138.77500000000001p 0.0001922614 138.78749999999999p 0.0001971238 138.80000000000001p 0.00020184620000000001 138.8125p 0.0002064255 138.82500000000002p 0.00021085860000000001
+ 138.83749999999998p 0.00021514249999999999 138.84999999999999p 0.0002192745 138.86249999999998p 0.0002232518 138.875p 0.0002270718 138.88749999999999p 0.0002307322 138.90000000000001p 0.00023423049999999999 138.91250000000002p 0.00023756459999999999 138.92499999999998p 0.00024073240000000001 138.9375p 0.000243732 138.94999999999999p 0.00024656150000000002 138.96250000000001p 0.00024921950000000002 138.97499999999999p 0.00025170429999999999 138.98750000000001p 0.00025401450000000001 139p 0.00025614909999999998 139.01249999999999p 0.00025810679999999997 139.02500000000001p 0.00025988669999999999 139.03749999999999p 0.0002614882 139.05000000000001p 0.0002629105
+ 139.0625p 0.00026415310000000002 139.07500000000002p 0.00026521569999999998 139.08750000000001p 0.0002660982 139.09999999999999p 0.00026680049999999999 139.11249999999998p 0.00026732269999999998 139.125p 0.00026766510000000003 139.13749999999999p 0.00026782789999999998 139.15000000000001p 0.0002678119 139.16250000000002p 0.00026761770000000002 139.17499999999998p 0.00026724609999999999 139.1875p 0.000266698 139.19999999999999p 0.00026597470000000001 139.21250000000001p 0.00026507720000000002 139.22499999999999p 0.00026400700000000002 139.23750000000001p 0.00026276560000000002 139.25p 0.00026135459999999998 139.26249999999999p 0.00025977569999999998 139.27500000000001p 0.00025803080000000002
+ 139.28749999999999p 0.00025612189999999998 139.30000000000001p 0.00025405099999999998 139.3125p 0.00025182040000000001 139.32500000000002p 0.00024943239999999998 139.33750000000001p 0.00024688930000000002 139.34999999999999p 0.00024419369999999999 139.36249999999998p 0.00024134809999999999 139.375p 0.00023835530000000001 139.38749999999999p 0.0002352179 139.40000000000001p 0.00023193890000000001 139.41249999999999p 0.000228521 139.42500000000001p 0.00022496739999999999 139.4375p 0.00022128109999999999 139.44999999999999p 0.0002174651 139.46250000000001p 0.0002135227 139.47499999999999p 0.000209457 139.48750000000001p 0.0002052713 139.5p 0.00020096900000000001
+ 139.51249999999999p 0.00019655329999999999 139.52499999999998p 0.00019202769999999999 139.53749999999999p 0.00018739559999999999 139.55000000000001p 0.00018266039999999999 139.5625p 0.00017782569999999999 139.57500000000002p 0.0001728949 139.58750000000001p 0.0001678715 139.59999999999999p 0.000162759 139.61249999999998p 0.0001575611 139.625p 0.0001522812 139.63749999999999p 0.0001469229 139.65000000000001p 0.00014148970000000001 139.66249999999999p 0.0001359853 139.67500000000001p 0.0001304132 139.6875p 0.00012477699999999999 139.69999999999999p 0.0001190801 139.71250000000001p 0.0001133263 139.72499999999999p 0.0001075189
+ 139.73750000000001p 0.0001016615 139.75p 9.5757690000000006e-05 139.76250000000002p 8.9810930000000006e-05 139.77499999999998p 8.3824709999999998e-05 139.78749999999999p 7.7802519999999994e-05 139.80000000000001p 7.1747820000000006e-05 139.8125p 6.5664060000000004e-05 139.82500000000002p 5.9554679999999999e-05 139.83750000000001p 5.3423089999999999e-05 139.84999999999999p 4.7272699999999999e-05 139.86249999999998p 4.1106889999999997e-05 139.875p 3.4929019999999999e-05 139.88749999999999p 2.8742450000000001e-05 139.90000000000001p 2.2550519999999998e-05 139.91249999999999p 1.635653e-05 139.92500000000001p 1.016379e-05 139.9375p 3.9755889999999996e-06 139.94999999999999p -2.2048130000000002e-06
+ 139.96250000000001p -8.3741589999999997e-06 139.97499999999999p -1.452921e-05 139.98750000000001p -2.0666760000000001e-05 140p -2.6783580000000001e-05 140.01250000000002p -3.2876490000000002e-05 140.02499999999998p -3.8942320000000003e-05 140.03749999999999p -4.4977890000000001e-05 140.05000000000001p -5.0980060000000001e-05 140.0625p -5.6945699999999999e-05 140.07500000000002p -6.2871689999999996e-05 140.08750000000001p -6.8754909999999995e-05 140.10000000000002p -7.4592279999999999e-05 140.11249999999998p -8.0380709999999995e-05 140.125p -8.6117149999999999e-05 140.13749999999999p -9.1798540000000001e-05 140.15000000000001p -9.7421850000000006e-05 140.16249999999999p -0.000102984 140.17500000000001p -0.0001084821
+ 140.1875p -0.0001139131 140.19999999999999p -0.0001192741 140.21250000000001p -0.00012456199999999999 140.22499999999999p -0.00012977400000000001 140.23750000000001p -0.00013490710000000001 140.25p -0.0001399584 140.26250000000002p -0.0001449252 140.27499999999998p -0.00014980439999999999 140.28749999999999p -0.00015459339999999999 140.29999999999998p -0.00015928930000000001 140.3125p -0.00016388930000000001 140.32500000000002p -0.00016839080000000001 140.33750000000001p -0.00017279099999999999 140.35000000000002p -0.00017708719999999999 140.36249999999998p -0.0001812769 140.375p -0.00018535740000000001 140.38749999999999p -0.0001893261 140.40000000000001p -0.00019318070000000001
+ 140.41249999999999p -0.00019691850000000001 140.42500000000001p -0.00020053719999999999 140.4375p -0.0002040345 140.44999999999999p -0.00020740790000000001 140.46250000000001p -0.0002106554 140.47499999999999p -0.0002137745 140.48750000000001p -0.00021676329999999999 140.5p -0.00021961959999999999 140.51250000000002p -0.00022234140000000001 140.52499999999998p -0.0002249268 140.53749999999999p -0.00022737389999999999 140.54999999999998p -0.00022968080000000001 140.5625p -0.00023184599999999999 140.57500000000002p -0.00023386770000000001 140.58750000000001p -0.00023574429999999999 140.60000000000002p -0.0002374744 140.61249999999998p -0.00023905660000000001 140.625p -0.00024048949999999999
+ 140.63749999999999p -0.00024177199999999999 140.65000000000001p -0.00024290290000000001 140.66249999999999p -0.0002438811 140.67500000000001p -0.00024470580000000001 140.6875p -0.00024537609999999998 140.69999999999999p -0.00024589119999999999 140.71250000000001p -0.0002462505 140.72499999999999p -0.0002464535 140.73750000000001p -0.00024649969999999998 140.75p -0.0002463888 140.76250000000002p -0.00024612050000000002 140.77500000000001p -0.00024569480000000002 140.78749999999999p -0.00024511170000000003 140.79999999999998p -0.00024437109999999999 140.8125p -0.00024347339999999999 140.82499999999999p -0.0002424189 140.83750000000001p -0.000241208 140.85000000000002p -0.00023984120000000001
+ 140.86249999999998p -0.00023831920000000001 140.875p -0.00023664270000000001 140.88749999999999p -0.00023481270000000001 140.90000000000001p -0.00023283000000000001 140.91249999999999p -0.00023069590000000001 140.92500000000001p -0.00022841140000000001 140.9375p -0.000225978 140.94999999999999p -0.00022339699999999999 140.96250000000001p -0.00022067000000000001 140.97499999999999p -0.00021779850000000001 140.98750000000001p -0.00021478440000000001 141p -0.0002116295 141.01250000000002p -0.0002083357 141.02500000000001p -0.00020490499999999999 141.03749999999999p -0.0002013397 141.04999999999998p -0.00019764199999999999 141.0625p -0.00019381420000000001 141.07499999999999p -0.00018985869999999999
+ 141.08750000000001p -0.0001857781 141.10000000000002p -0.00018157500000000001 141.11250000000001p -0.00017725210000000001 141.125p -0.00017281220000000001 141.13749999999999p -0.0001682582 141.15000000000001p -0.0001635931 141.16249999999999p -0.00015882 141.17500000000001p -0.0001539418 141.1875p -0.00014896199999999999 141.19999999999999p -0.00014388359999999999 141.21250000000001p -0.00013871019999999999 141.22499999999999p -0.0001334451 141.23750000000001p -0.00012809179999999999 141.25p -0.00012265379999999999 141.26250000000002p -0.0001171348 141.27500000000001p -0.0001115385 141.28749999999999p -0.0001058685 141.29999999999998p -0.0001001287
+ 141.3125p -9.4322930000000007e-05 141.32499999999999p -8.8455059999999997e-05 141.33750000000001p -8.2529039999999998e-05 141.34999999999999p -7.6548840000000004e-05 141.36250000000001p -7.0518489999999998e-05 141.375p -6.4442049999999994e-05 141.38749999999999p -5.832362e-05 141.40000000000001p -5.2167350000000001e-05 141.41249999999999p -4.5977370000000003e-05 141.42500000000001p -3.9757910000000002e-05 141.4375p -3.351316e-05 141.44999999999999p -2.7247370000000001e-05 141.46249999999998p -2.0964789999999999e-05 141.47499999999999p -1.4669719999999999e-05 141.48750000000001p -8.3664270000000006e-06 141.5p -2.0592239999999999e-06 141.51250000000002p 4.2475800000000001e-06 141.52500000000001p 1.054967e-05
+ 141.53749999999999p 1.6842729999999999e-05 141.54999999999998p 2.312244e-05 141.5625p 2.9384489999999999e-05 141.57499999999999p 3.5624570000000002e-05 141.58750000000001p 4.1838380000000001e-05 141.59999999999999p 4.8021639999999997e-05 141.61250000000001p 5.4170079999999997e-05 141.625p 6.0279450000000001e-05 141.63749999999999p 6.6345519999999998e-05 141.65000000000001p 7.2364099999999994e-05 141.66249999999999p 7.8330990000000005e-05 141.67500000000001p 8.4242080000000003e-05 141.6875p 9.0093229999999995e-05 141.70000000000002p 9.5880389999999997e-05 141.71249999999998p 0.0001015995 141.72499999999999p 0.0001072467 141.73750000000001p 0.0001128178 141.75p 0.0001183092
+ 141.76250000000002p 0.00012371689999999999 141.77500000000001p 0.00012903710000000001 141.78749999999999p 0.00013426630000000001 141.79999999999998p 0.00013940059999999999 141.8125p 0.00014443649999999999 141.82499999999999p 0.0001493706 141.83750000000001p 0.00015419930000000001 141.84999999999999p 0.00015891930000000001 141.86250000000001p 0.00016352740000000001 141.875p 0.0001680203 141.88749999999999p 0.00017239490000000001 141.90000000000001p 0.0001766483 141.91249999999999p 0.00018077739999999999 141.92500000000001p 0.00018477949999999999 141.9375p 0.00018865169999999999 141.95000000000002p 0.0001923916 141.96249999999998p 0.00019599649999999999 141.97499999999999p 0.000199464
+ 141.98749999999998p 0.00020279179999999999 142p 0.0002059776 142.01250000000002p 0.00020901949999999999 142.02500000000001p 0.00021191539999999999 142.03750000000002p 0.00021466350000000001 142.04999999999998p 0.00021726189999999999 142.0625p 0.00021970919999999999 142.07499999999999p 0.00022200369999999999 142.08750000000001p 0.0002241442 142.09999999999999p 0.00022612939999999999 142.11250000000001p 0.000227958 142.125p 0.00022962929999999999 142.13749999999999p 0.0002311422 142.15000000000001p 0.000232496 142.16249999999999p 0.00023369020000000001 142.17500000000001p 0.0002347242 142.1875p 0.00023559770000000001 142.20000000000002p 0.00023631039999999999
+ 142.21249999999998p 0.0002368623 142.22499999999999p 0.00023725349999999999 142.23749999999998p 0.00023748399999999999 142.25p 0.00023755409999999999 142.26250000000002p 0.0002374644 142.27500000000001p 0.0002372152 142.28750000000002p 0.00023680730000000001 142.29999999999998p 0.0002362415 142.3125p 0.00023551860000000001 142.32499999999999p 0.0002346397 142.33750000000001p 0.000233606 142.34999999999999p 0.00023241860000000001 142.36250000000001p 0.00023107889999999999 142.375p 0.00022958850000000001 142.38749999999999p 0.00022794880000000001 142.40000000000001p 0.0002261617 142.41249999999999p 0.0002242287 142.42500000000001p 0.00022215200000000001
+ 142.4375p 0.0002199333 142.45000000000002p 0.00021757490000000001 142.46249999999998p 0.0002150788 142.47499999999999p 0.00021244729999999999 142.48749999999998p 0.00020968270000000001 142.5p 0.0002067874 142.51250000000002p 0.00020376389999999999 142.52500000000001p 0.0002006148 142.53750000000002p 0.0001973427 142.54999999999998p 0.00019395020000000001 142.5625p 0.00019044020000000001 142.57499999999999p 0.0001868153 142.58750000000001p 0.00018307849999999999 142.59999999999999p 0.0001792327 142.61250000000001p 0.0001752809 142.625p 0.00017122590000000001 142.63749999999999p 0.000167071 142.65000000000001p 0.00016281910000000001
+ 142.66249999999999p 0.00015847349999999999 142.67500000000001p 0.0001540371 142.6875p 0.00014951330000000001 142.70000000000002p 0.00014490520000000001 142.71250000000001p 0.00014021610000000001 142.72499999999999p 0.0001354491 142.73749999999998p 0.0001306077 142.75p 0.00012569489999999999 142.76249999999999p 0.0001207143 142.77500000000001p 0.00011566900000000001 142.78750000000002p 0.0001105624 142.79999999999998p 0.0001053977 142.8125p 0.0001001785 142.82499999999999p 9.4907849999999996e-05 142.83750000000001p 8.9589240000000002e-05 142.84999999999999p 8.4225970000000001e-05 142.86250000000001p 7.8821379999999996e-05 142.875p 7.3378790000000002e-05
+ 142.88749999999999p 6.7901539999999996e-05 142.90000000000001p 6.2392930000000006e-05 142.91249999999999p 5.68563e-05 142.92500000000001p 5.1294949999999999e-05 142.9375p 4.5712169999999997e-05 142.95000000000002p 4.0111260000000001e-05 142.96250000000001p 3.4495500000000002e-05 142.97499999999999p 2.886816e-05 142.98749999999998p 2.3232500000000002e-05 143p 1.7591770000000001e-05 143.01249999999999p 1.194919e-05 143.02500000000001p 6.3079929999999996e-06 143.03750000000002p 6.7138719999999999e-07 143.05000000000001p -4.9574339999999998e-06 143.0625p -1.057529e-05 143.07499999999999p -1.617902e-05 143.08750000000001p -2.1765460000000001e-05 143.09999999999999p -2.7331479999999999e-05
+ 143.11250000000001p -3.2873970000000002e-05 143.125p -3.8389809999999997e-05 143.13749999999999p -4.3875919999999999e-05 143.15000000000001p -4.9329220000000003e-05 143.16249999999999p -5.474667e-05 143.17500000000001p -6.012522e-05 143.1875p -6.5461859999999995e-05 143.20000000000002p -7.0753590000000006e-05 143.21250000000001p -7.599742e-05 143.22499999999999p -8.119039e-05 143.23749999999998p -8.6329560000000005e-05 143.25p -9.141202e-05 143.26249999999999p -9.6434859999999998e-05 143.27500000000001p -0.0001013952 143.28749999999999p -0.0001062902 143.30000000000001p -0.000111117 143.3125p -0.0001158729 143.32499999999999p -0.000120555
+ 143.33750000000001p -0.00012516059999999999 143.34999999999999p -0.00012968699999999999 143.36250000000001p -0.00013413149999999999 143.375p -0.00013849150000000001 143.38750000000002p -0.0001427643 143.39999999999998p -0.00014694729999999999 143.41249999999999p -0.00015103800000000001 143.42500000000001p -0.00015503390000000001 143.4375p -0.00015893250000000001 143.45000000000002p -0.00016273129999999999 143.46250000000001p -0.00016642800000000001 143.47499999999999p -0.0001700203 143.48749999999998p -0.0001735059 143.5p -0.00017688240000000001 143.51249999999999p -0.0001801478 143.52500000000001p -0.0001832998 143.53749999999999p -0.0001863364 143.55000000000001p -0.0001892556
+ 143.5625p -0.0001920554 143.57499999999999p -0.0001947339 143.58750000000001p -0.00019728930000000001 143.59999999999999p -0.0001997197 143.61250000000001p -0.00020202349999999999 143.625p -0.00020419899999999999 143.63750000000002p -0.00020624479999999999 143.64999999999998p -0.00020815920000000001 143.66249999999999p -0.00020994089999999999 143.67500000000001p -0.0002115885 143.6875p -0.00021310090000000001 143.70000000000002p -0.00021447670000000001 143.71250000000001p -0.000215715 143.72500000000002p -0.00021681479999999999 143.73749999999998p -0.00021777499999999999 143.75p -0.000218595 143.76249999999999p -0.00021927399999999999 143.77500000000001p -0.00021981130000000001
+ 143.78749999999999p -0.00022020629999999999 143.80000000000001p -0.00022045880000000001 143.8125p -0.00022056819999999999 143.82499999999999p -0.00022053430000000001 143.83750000000001p -0.0002203571 143.84999999999999p -0.0002200363 143.86250000000001p -0.0002195721 143.875p -0.0002189646 143.88750000000002p -0.00021821399999999999 143.89999999999998p -0.00021732070000000001 143.91249999999999p -0.00021628509999999999 143.92499999999998p -0.0002151078 143.9375p -0.00021378940000000001 143.95000000000002p -0.00021233060000000001 143.96250000000001p -0.00021073239999999999 143.97500000000002p -0.0002089956 143.98749999999998p -0.0002071214 144p -0.00020511079999999999
+ 144.01249999999999p -0.00020296520000000001 144.02500000000001p -0.00020068580000000001 144.03749999999999p -0.0001982741 144.05000000000001p -0.00019573170000000001 144.0625p -0.00019306029999999999 144.07499999999999p -0.0001902614 144.08750000000001p -0.00018733700000000001 144.09999999999999p -0.0001842891 144.11250000000001p -0.00018111949999999999 144.125p -0.0001778304 144.13750000000002p -0.00017442409999999999 144.14999999999998p -0.00017090270000000001 144.16249999999999p -0.0001672686 144.17499999999998p -0.00016352430000000001 144.1875p -0.00015967229999999999 144.20000000000002p -0.0001557152 144.21250000000001p -0.00015165560000000001 144.22500000000002p -0.0001474964
+ 144.23749999999998p -0.00014324030000000001 144.25p -0.00013889020000000001 144.26249999999999p -0.00013444910000000001 144.27500000000001p -0.00012992 144.28749999999999p -0.000125306 144.30000000000001p -0.00012061030000000001 144.3125p -0.00011583599999999999 144.32499999999999p -0.00011098650000000001 144.33750000000001p -0.0001060649 144.34999999999999p -0.0001010748 144.36250000000001p -9.6019489999999997e-05 144.375p -9.0902469999999997e-05 144.38750000000002p -8.5727230000000004e-05 144.39999999999998p -8.0497339999999995e-05 144.41249999999999p -7.5216380000000006e-05 144.42499999999998p -6.9887960000000003e-05 144.4375p -6.451575e-05 144.44999999999999p -5.9103439999999997e-05
+ 144.46250000000001p -5.3654740000000003e-05 144.47500000000002p -4.8173390000000001e-05 144.48749999999998p -4.2663159999999999e-05 144.5p -3.7127840000000003e-05 144.51249999999999p -3.1571230000000002e-05 144.52500000000001p -2.5997149999999999e-05 144.53749999999999p -2.040943e-05 144.55000000000001p -1.4811919999999999e-05 144.5625p -9.208461e-06 144.57499999999999p -3.6029170000000001e-06 144.58750000000001p 2.0008579999999999e-06 144.59999999999999p 7.5990079999999998e-06 144.61250000000001p 1.3187679999999999e-05 144.625p 1.8763020000000001e-05 144.63750000000002p 2.43212e-05 144.65000000000001p 2.9858380000000001e-05 144.66249999999999p 3.5370760000000001e-05 144.67499999999998p 4.0854530000000002e-05
+ 144.6875p 4.6305910000000001e-05 144.69999999999999p 5.1721159999999999e-05 144.71250000000001p 5.7096540000000001e-05 144.72500000000002p 6.2428340000000003e-05 144.73749999999998p 6.77129e-05 144.75p 7.2946580000000003e-05 144.76249999999999p 7.8125760000000001e-05 144.77500000000001p 8.3246890000000004e-05 144.78749999999999p 8.8306439999999995e-05 144.80000000000001p 9.3300940000000003e-05 144.8125p 9.8226940000000002e-05 144.82499999999999p 0.0001030811 144.83750000000001p 0.00010786 144.84999999999999p 0.00011256039999999999 144.86250000000001p 0.0001171792 144.875p 0.0001217131 144.88750000000002p 0.00012615900000000001 144.90000000000001p 0.000130514
+ 144.91249999999999p 0.00013477500000000001 144.92499999999998p 0.00013893910000000001 144.9375p 0.00014300369999999999 144.94999999999999p 0.00014696579999999999 144.96250000000001p 0.00015082290000000001 144.97500000000002p 0.0001545723 144.98750000000001p 0.00015821159999999999 145p 0.0001617384 145.01249999999999p 0.00016515019999999999 145.02500000000001p 0.000168445 145.03749999999999p 0.00017162049999999999 145.05000000000001p 0.00017467470000000001 145.0625p 0.00017760559999999999 145.07499999999999p 0.00018041140000000001 145.08749999999998p 0.0001830903 145.09999999999999p 0.00018564060000000001 145.11250000000001p 0.00018806079999999999 145.125p 0.00019034950000000001
+ 145.13750000000002p 0.0001925052 145.15000000000001p 0.00019452679999999999 145.16249999999999p 0.0001964131 145.17499999999998p 0.00019816309999999999 145.1875p 0.00019977579999999999 145.19999999999999p 0.00020125039999999999 145.21250000000001p 0.00020258630000000001 145.22499999999999p 0.00020378280000000001 145.23750000000001p 0.00020483949999999999 145.25p 0.000205756 145.26249999999999p 0.00020653199999999999 145.27500000000001p 0.00020716739999999999 145.28749999999999p 0.00020766210000000001 145.30000000000001p 0.00020801620000000001 145.3125p 0.0002082299 145.32500000000002p 0.0002083035 145.33749999999998p 0.0002082373 145.34999999999999p 0.00020803179999999999
+ 145.36250000000001p 0.00020768769999999999 145.375p 0.00020720560000000001 145.38750000000002p 0.0002065864 145.40000000000001p 0.00020583090000000001 145.41249999999999p 0.00020494010000000001 145.42499999999998p 0.00020391530000000001 145.4375p 0.0002027575 145.44999999999999p 0.000201468 145.46250000000001p 0.00020004819999999999 145.47499999999999p 0.0001984996 145.48750000000001p 0.00019682369999999999 145.5p 0.0001950222 145.51249999999999p 0.00019309669999999999 145.52500000000001p 0.00019104920000000001 145.53749999999999p 0.0001888813 145.55000000000001p 0.0001865952 145.5625p 0.00018419270000000001 145.57500000000002p 0.000181676
+ 145.58749999999998p 0.00017904720000000001 145.59999999999999p 0.00017630860000000001 145.61250000000001p 0.00017346230000000001 145.625p 0.00017051069999999999 145.63750000000002p 0.0001674562 145.65000000000001p 0.00016430129999999999 145.66250000000002p 0.0001610483 145.67499999999998p 0.0001576998 145.6875p 0.0001542584 145.69999999999999p 0.0001507267 145.71250000000001p 0.00014710729999999999 145.72499999999999p 0.0001434029 145.73750000000001p 0.0001396162 145.75p 0.00013574990000000001 145.76249999999999p 0.00013180679999999999 145.77500000000001p 0.00012778959999999999 145.78749999999999p 0.00012370130000000001 145.80000000000001p 0.00011954459999999999
+ 145.8125p 0.00011532240000000001 145.82500000000002p 0.0001110374 145.83749999999998p 0.0001066927 145.84999999999999p 0.00010229109999999999 145.86249999999998p 9.7835549999999999e-05 145.875p 9.3328860000000004e-05 145.88750000000002p 8.877399e-05 145.90000000000001p 8.4173860000000001e-05 145.91250000000002p 7.9531399999999995e-05 145.92499999999998p 7.4849529999999998e-05 145.9375p 7.0131179999999996e-05 145.94999999999999p 6.5379280000000005e-05 145.96250000000001p 6.0596739999999998e-05 145.97499999999999p 5.5786479999999997e-05 145.98750000000001p 5.0951439999999997e-05 146p 4.6094499999999997e-05 146.01249999999999p 4.1218589999999998e-05 146.02500000000001p 3.6326599999999999e-05
+ 146.03749999999999p 3.1421429999999999e-05 146.05000000000001p 2.6505939999999999e-05 146.0625p 2.1583029999999999e-05 146.07500000000002p 1.665555e-05 146.08749999999998p 1.172635e-05 146.09999999999999p 6.7982819999999997e-06 146.11249999999998p 1.874171e-06 146.125p -3.043165e-06 146.13750000000002p -7.9509179999999996e-06 146.15000000000001p -1.2846299999999999e-05 146.16250000000002p -1.7726529999999999e-05 146.17499999999998p -2.2588839999999999e-05 146.1875p -2.743049e-05 146.19999999999999p -3.2248729999999997e-05 146.21250000000001p -3.7040869999999998e-05 146.22499999999999p -4.1804180000000001e-05 146.23750000000001p -4.6535990000000002e-05 146.25p -5.1233629999999999e-05
+ 146.26249999999999p -5.5894450000000002e-05 146.27500000000001p -6.0515830000000003e-05 146.28749999999999p -6.5095139999999996e-05 146.30000000000001p -6.9629789999999995e-05 146.3125p -7.4117229999999998e-05 146.32500000000002p -7.8554890000000002e-05 146.33749999999998p -8.2940250000000006e-05 146.34999999999999p -8.7270799999999998e-05 146.36249999999998p -9.1544069999999994e-05 146.375p -9.5757589999999999e-05 146.38749999999999p -9.9908950000000005e-05 146.40000000000001p -0.0001039957 146.41250000000002p -0.0001080156 146.42499999999998p -0.0001119661 146.4375p -0.000115845 146.44999999999999p -0.00011964999999999999 146.46250000000001p -0.00012337890000000001 146.47499999999999p -0.00012702929999999999
+ 146.48750000000001p -0.0001305992 146.5p -0.00013408650000000001 146.51249999999999p -0.00013748880000000001 146.52500000000001p -0.00014080430000000001 146.53749999999999p -0.0001440309 146.55000000000001p -0.00014716649999999999 146.5625p -0.00015020929999999999 146.57500000000002p -0.0001531573 146.58750000000001p -0.00015600870000000001 146.59999999999999p -0.00015876169999999999 146.61249999999998p -0.0001614145 146.625p -0.00016396529999999999 146.63749999999999p -0.0001664127 146.65000000000001p -0.0001687549 146.66250000000002p -0.0001709905 146.67499999999998p -0.0001731178 146.6875p -0.0001751356 146.69999999999999p -0.00017704250000000001
+ 146.71250000000001p -0.0001788371 146.72499999999999p -0.0001805182 146.73750000000001p -0.00018208459999999999 146.75p -0.00018353529999999999 146.76249999999999p -0.00018486920000000001 146.77500000000001p -0.00018608540000000001 146.78749999999999p -0.00018718280000000001 146.80000000000001p -0.0001881609 146.8125p -0.00018901860000000001 146.82500000000002p -0.00018975550000000001 146.83750000000001p -0.00019037089999999999 146.84999999999999p -0.0001908643 146.86249999999998p -0.00019123529999999999 146.875p -0.0001914834 146.88749999999999p -0.00019160839999999999 146.90000000000001p -0.0001916101 146.91249999999999p -0.0001914885 146.92500000000001p -0.00019124330000000001
+ 146.9375p -0.0001908747 146.94999999999999p -0.00019038289999999999 146.96250000000001p -0.00018976799999999999 146.97499999999999p -0.00018903029999999999 146.98750000000001p -0.0001881702 147p -0.0001871881 147.01249999999999p -0.00018608470000000001 147.02499999999998p -0.00018486039999999999 147.03749999999999p -0.00018351620000000001 147.05000000000001p -0.0001820526 147.0625p -0.00018047070000000001 147.07500000000002p -0.00017877139999999999 147.08750000000001p -0.00017695570000000001 147.09999999999999p -0.0001750248 147.11249999999998p -0.0001729798 147.125p -0.000170822 147.13749999999999p -0.00016855289999999999 147.15000000000001p -0.00016617389999999999
+ 147.16249999999999p -0.00016368639999999999 147.17500000000001p -0.0001610921 147.1875p -0.00015839270000000001 147.19999999999999p -0.00015558990000000001 147.21250000000001p -0.00015268559999999999 147.22499999999999p -0.00014968150000000001 147.23750000000001p -0.00014657980000000001 147.25p -0.0001433824 147.26250000000002p -0.00014009149999999999 147.27499999999998p -0.00013670920000000001 147.28749999999999p -0.00013323769999999999 147.30000000000001p -0.0001296794 147.3125p -0.00012603660000000001 147.32500000000002p -0.0001223117 147.33750000000001p -0.0001185073 147.34999999999999p -0.0001146258 147.36249999999998p -0.0001106698 147.375p -0.000106642
+ 147.38749999999999p -0.0001025451 147.40000000000001p -9.8381780000000006e-05 147.41249999999999p -9.4154890000000001e-05 147.42500000000001p -8.9867260000000003e-05 147.4375p -8.5521749999999995e-05 147.44999999999999p -8.1121290000000005e-05 147.46250000000001p -7.6668839999999996e-05 147.47499999999999p -7.2167400000000003e-05 147.48750000000001p -6.7620000000000006e-05 147.5p -6.3029710000000005e-05 147.51250000000002p -5.8399629999999998e-05 147.52499999999998p -5.373288e-05 147.53749999999999p -4.9032610000000003e-05 147.54999999999998p -4.4302019999999998e-05 147.5625p -3.9544279999999999e-05 147.57500000000002p -3.4762640000000001e-05 147.58750000000001p -2.9960330000000001e-05 147.60000000000002p -2.514059e-05
+ 147.61249999999998p -2.0306710000000001e-05 147.625p -1.546197e-05 147.63749999999999p -1.060964e-05 147.65000000000001p -5.7530400000000001e-06 147.66249999999999p -8.9545849999999996e-07 147.67500000000001p 3.9597969999999999e-06 147.6875p 8.8094230000000003e-06 147.69999999999999p 1.365012e-05 147.71250000000001p 1.8478580000000002e-05 147.72499999999999p 2.329152e-05 147.73750000000001p 2.8085659999999998e-05 147.75p 3.2857729999999998e-05 147.76250000000002p 3.760447e-05 147.77499999999998p 4.2322640000000003e-05 147.78749999999999p 4.7009019999999998e-05 147.79999999999998p 5.1660409999999998e-05 147.8125p 5.6273629999999998e-05 147.82500000000002p 6.0845540000000002e-05
+ 147.83750000000001p 6.5372999999999999e-05 147.85000000000002p 6.9852930000000005e-05 147.86249999999998p 7.4282259999999996e-05 147.875p 7.8657980000000003e-05 147.88749999999999p 8.2977089999999995e-05 147.90000000000001p 8.7236639999999994e-05 147.91249999999999p 9.143373e-05 147.92500000000001p 9.5565510000000006e-05 147.9375p 9.9629150000000001e-05 147.94999999999999p 0.0001036219 147.96250000000001p 0.00010754100000000001 147.97499999999999p 0.0001113839 147.98750000000001p 0.0001151479 148p 0.0001188304 148.01250000000002p 0.0001224291 148.02499999999998p 0.00012594139999999999 148.03749999999999p 0.0001293651 148.04999999999998p 0.0001326977
+ 148.0625p 0.0001359372 148.07500000000002p 0.00013908130000000001 148.08750000000001p 0.00014212790000000001 148.10000000000002p 0.0001450751 148.11249999999998p 0.00014792089999999999 148.125p 0.0001506635 148.13749999999999p 0.00015330110000000001 148.15000000000001p 0.00015583200000000001 148.16249999999999p 0.00015825449999999999 148.17500000000001p 0.00016056720000000001 148.1875p 0.0001627686 148.19999999999999p 0.00016485729999999999 148.21250000000001p 0.00016683219999999999 148.22499999999999p 0.00016869190000000001 148.23750000000001p 0.0001704354 148.25p 0.00017206160000000001 148.26250000000002p 0.00017356979999999999 148.27500000000001p 0.000174959
+ 148.28749999999999p 0.00017622849999999999 148.29999999999998p 0.00017737769999999999 148.3125p 0.00017840600000000001 148.32499999999999p 0.00017931300000000001 148.33750000000001p 0.0001800983 148.35000000000002p 0.0001807616 148.36249999999998p 0.00018130279999999999 148.375p 0.00018172180000000001 148.38749999999999p 0.0001820185 148.40000000000001p 0.0001821932 148.41249999999999p 0.00018224579999999999 148.42500000000001p 0.00018217689999999999 148.4375p 0.00018198659999999999 148.44999999999999p 0.00018167549999999999 148.46250000000001p 0.00018124410000000001 148.47499999999999p 0.00018069310000000001 148.48750000000001p 0.0001800231 148.5p 0.000179235
+ 148.51250000000002p 0.00017832960000000001 148.52500000000001p 0.00017730790000000001 148.53749999999999p 0.000176171 148.54999999999998p 0.00017491990000000001 148.5625p 0.0001735559 148.57499999999999p 0.00017208020000000001 148.58750000000001p 0.0001704942 148.60000000000002p 0.00016879920000000001 148.61250000000001p 0.00016699689999999999 148.625p 0.0001650887 148.63749999999999p 0.0001630762 148.65000000000001p 0.0001609611 148.66249999999999p 0.0001587452 148.67500000000001p 0.00015643030000000001 148.6875p 0.0001540181 148.69999999999999p 0.00015151070000000001 148.71250000000001p 0.00014891000000000001 148.72499999999999p 0.00014621790000000001
+ 148.73750000000001p 0.00014343670000000001 148.75p 0.0001405682 148.76250000000002p 0.00013761479999999999 148.77500000000001p 0.00013457860000000001 148.78749999999999p 0.00013146180000000001 148.79999999999998p 0.0001282667 148.8125p 0.0001249957 148.82499999999999p 0.0001216509 148.83750000000001p 0.0001182349 148.84999999999999p 0.0001147499 148.86250000000001p 0.0001111985 148.875p 0.000107583 148.88749999999999p 0.000103906 148.90000000000001p 0.0001001699 148.91249999999999p 9.6377299999999996e-05 148.92500000000001p 9.2530650000000002e-05 148.9375p 8.8632539999999998e-05 148.94999999999999p 8.4685520000000002e-05
+ 148.96249999999998p 8.0692170000000004e-05 148.97499999999999p 7.6655079999999996e-05 148.98750000000001p 7.2576839999999995e-05 149p 6.8460079999999997e-05 149.01250000000002p 6.4307390000000006e-05 149.02500000000001p 6.0121399999999997e-05 149.03749999999999p 5.5904749999999997e-05 149.04999999999998p 5.166005e-05 149.0625p 4.7389940000000001e-05 149.07499999999999p 4.3097060000000002e-05 149.08750000000001p 3.8784040000000003e-05 149.09999999999999p 3.4453519999999999e-05 149.11250000000001p 3.0108119999999999e-05 149.125p 2.5750479999999999e-05 149.13749999999999p 2.138322e-05 149.15000000000001p 1.7008970000000001e-05 149.16249999999999p 1.2630339999999999e-05 149.17500000000001p 8.249937e-06
+ 149.1875p 3.8703729999999997e-06 149.20000000000002p -5.0576020000000003e-07 149.21249999999998p -4.8758760000000004e-06 149.22499999999999p -9.2373959999999997e-06 149.23750000000001p -1.358775e-05 149.25p -1.792439e-05 149.26250000000002p -2.2244760000000001e-05 149.27500000000001p -2.654634e-05 149.28749999999999p -3.0826600000000001e-05 149.29999999999998p -3.5083039999999999e-05 149.3125p -3.9313159999999999e-05 149.32499999999999p -4.3514499999999998e-05 149.33750000000001p -4.7684579999999999e-05 149.34999999999999p -5.1820980000000003e-05 149.36250000000001p -5.592126e-05 149.375p -5.998302e-05 149.38749999999999p -6.4003869999999997e-05 149.40000000000001p -6.7981440000000002e-05
+ 149.41249999999999p -7.1913400000000002e-05 149.42500000000001p -7.5797409999999994e-05 149.4375p -7.9631179999999996e-05 149.45000000000002p -8.3412429999999997e-05 149.46249999999998p -8.7138910000000001e-05 149.47499999999999p -9.0808400000000003e-05 149.48749999999998p -9.4418699999999998e-05 149.5p -9.7967629999999996e-05 149.51250000000002p -0.0001014531 149.52500000000001p -0.0001048729 149.53750000000002p -0.000108225 149.54999999999998p -0.0001115074 149.5625p -0.0001147181 149.57499999999999p -0.000117855 149.58750000000001p -0.00012091620000000001 149.59999999999999p -0.0001238999 149.61250000000001p -0.00012680419999999999 149.625p -0.00012962720000000001
+ 149.63749999999999p -0.0001323672 149.65000000000001p -0.0001350224 149.66249999999999p -0.00013759119999999999 149.67500000000001p -0.0001400718 149.6875p -0.00014246269999999999 149.70000000000002p -0.00014476239999999999 149.71249999999998p -0.00014696929999999999 149.72499999999999p -0.00014908200000000001 149.73749999999998p -0.0001510991 149.75p -0.00015301919999999999 149.76250000000002p -0.00015484099999999999 149.77500000000001p -0.0001565634 149.78750000000002p -0.00015818519999999999 149.79999999999998p -0.00015970510000000001 149.8125p -0.00016112219999999999 149.82499999999999p -0.00016243559999999999 149.83750000000001p -0.00016364409999999999 149.84999999999999p -0.00016474710000000001
+ 149.86250000000001p -0.0001657436 149.875p -0.00016663299999999999 149.88749999999999p -0.00016741459999999999 149.90000000000001p -0.00016808780000000001 149.91249999999999p -0.00016865200000000001 149.92500000000001p -0.00016910680000000001 149.9375p -0.00016945179999999999 149.95000000000002p -0.0001696867 149.96249999999998p -0.0001698112 149.97499999999999p -0.00016982520000000001 149.98749999999998p -0.0001697286 150p -0.0001695213 150.01249999999999p -0.00016920339999999999 150.02500000000001p -0.000168775 150.03750000000002p -0.00016823629999999999 150.04999999999998p -0.00016758769999999999 150.0625p -0.00016682930000000001 150.07499999999999p -0.0001659617
+ 150.08750000000001p -0.00016498540000000001 150.09999999999999p -0.00016390090000000001 150.11250000000001p -0.0001627089 150.125p -0.00016141009999999999 150.13749999999999p -0.00016000540000000001 150.15000000000001p -0.00015849549999999999 150.16249999999999p -0.0001568815 150.17500000000001p -0.0001551643 150.1875p -0.0001533451 150.20000000000002p -0.00015142509999999999 150.21250000000001p -0.0001494054 150.22499999999999p -0.00014728739999999999 150.23749999999998p -0.0001450724 150.25p -0.000142762 150.26249999999999p -0.00014035769999999999 150.27500000000001p -0.00013786089999999999 150.28750000000002p -0.00013527339999999999 150.29999999999998p -0.000132597
+ 150.3125p -0.00012983330000000001 150.32499999999999p -0.0001269842 150.33750000000001p -0.00012405169999999999 150.34999999999999p -0.0001210376 150.36250000000001p -0.00011794399999999999 150.375p -0.0001147731 150.38749999999999p -0.0001115269 150.40000000000001p -0.0001082076 150.41249999999999p -0.0001048175 150.42500000000001p -0.0001013588 150.4375p -9.7833920000000007e-05 150.45000000000002p -9.4245249999999994e-05 150.46250000000001p -9.0595199999999996e-05 150.47499999999999p -8.6886259999999999e-05 150.48749999999998p -8.3120960000000003e-05 150.5p -7.9301859999999998e-05 150.51249999999999p -7.5431550000000001e-05 150.52500000000001p -7.1512689999999996e-05
+ 150.53750000000002p -6.7547930000000006e-05 150.55000000000001p -6.3540000000000005e-05 150.5625p -5.949163e-05 150.57499999999999p -5.5405580000000002e-05 150.58750000000001p -5.1284649999999997e-05 150.59999999999999p -4.7131669999999999e-05 150.61250000000001p -4.2949469999999997e-05 150.625p -3.8740920000000002e-05 150.63749999999999p -3.4508899999999998e-05 150.65000000000001p -3.0256319999999998e-05 150.66249999999999p -2.5986090000000001e-05 150.67500000000001p -2.1701140000000001e-05 150.6875p -1.740442e-05 150.70000000000002p -1.309886e-05 150.71250000000001p -8.7874309999999997e-06 150.72499999999999p -4.4730890000000003e-06 150.73749999999998p -1.5879780000000001e-07 150.75p 4.1524789999999997e-06
+ 150.76249999999999p 8.4577789999999998e-06 150.77500000000001p 1.275414e-05 150.78749999999999p 1.7038620000000001e-05 150.80000000000001p 2.1308269999999999e-05 150.8125p 2.5560139999999999e-05 150.82499999999999p 2.979134e-05 150.83750000000001p 3.3998929999999999e-05 150.84999999999999p 3.818004e-05 150.86250000000001p 4.23318e-05 150.875p 4.6451340000000003e-05 150.88750000000002p 5.0535850000000002e-05 150.89999999999998p 5.4582529999999997e-05 150.91249999999999p 5.8588590000000003e-05 150.92500000000001p 6.2551289999999998e-05 150.9375p 6.6467919999999996e-05 150.95000000000002p 7.0335789999999998e-05 150.96250000000001p 7.4152269999999996e-05 150.97499999999999p 7.7914739999999997e-05
+ 150.98749999999998p 8.1620639999999999e-05 151p 8.526745e-05 151.01249999999999p 8.8852670000000002e-05 151.02500000000001p 9.2373889999999999e-05 151.03749999999999p 9.58287e-05 151.05000000000001p 9.9214770000000002e-05 151.0625p 0.0001025298 151.07499999999999p 0.0001057716 151.08750000000001p 0.00010893800000000001 151.09999999999999p 0.0001120267 151.11250000000001p 0.00011503589999999999 151.125p 0.0001179635 151.13750000000002p 0.00012080750000000001 151.14999999999998p 0.000123566 151.16249999999999p 0.00012623730000000001 151.17500000000001p 0.00012881970000000001 151.1875p 0.0001313113 151.20000000000002p 0.00013371069999999999
+ 151.21250000000001p 0.0001360163 151.22500000000002p 0.00013822659999999999 151.23749999999998p 0.0001403403 151.25p 0.000142356 151.26249999999999p 0.0001442724 151.27500000000001p 0.00014608850000000001 151.28749999999999p 0.00014780319999999999 151.30000000000001p 0.00014941530000000001 151.3125p 0.00015092409999999999 151.32499999999999p 0.00015232860000000001 151.33750000000001p 0.00015362810000000001 151.34999999999999p 0.00015482190000000001 151.36250000000001p 0.00015590929999999999 151.375p 0.00015689 151.38750000000002p 0.00015776329999999999 151.39999999999998p 0.00015852889999999999 151.41249999999999p 0.00015918670000000001 151.42499999999998p 0.00015973619999999999
+ 151.4375p 0.00016017749999999999 151.45000000000002p 0.0001605105 151.46250000000001p 0.0001607352 151.47500000000002p 0.0001608518 151.48749999999998p 0.0001608603 151.5p 0.00016076130000000001 151.51249999999999p 0.00016055480000000001 151.52500000000001p 0.00016024149999999999 151.53749999999999p 0.00015982179999999999 151.55000000000001p 0.00015929630000000001 151.5625p 0.00015866569999999999 151.57499999999999p 0.0001579307 151.58750000000001p 0.00015709200000000001 151.59999999999999p 0.00015615059999999999 151.61250000000001p 0.00015510740000000001 151.625p 0.0001539635 151.63750000000002p 0.0001527198 151.64999999999998p 0.0001513776
+ 151.66249999999999p 0.00014993809999999999 151.67499999999998p 0.00014840249999999999 151.6875p 0.00014677209999999999 151.70000000000002p 0.0001450484 151.71250000000001p 0.0001432328 151.72500000000002p 0.0001413268 151.73749999999998p 0.00013933199999999999 151.75p 0.0001372499 151.76249999999999p 0.00013508230000000001 151.77500000000001p 0.00013283079999999999 151.78749999999999p 0.00013049709999999999 151.80000000000001p 0.00012808319999999999 151.8125p 0.0001255908 151.82499999999999p 0.0001230219 151.83750000000001p 0.00012037820000000001 151.84999999999999p 0.00011766190000000001 151.86250000000001p 0.0001148748 151.875p 0.00011201910000000001
+ 151.88750000000002p 0.0001090967 151.89999999999998p 0.0001061098 151.91249999999999p 0.0001030605 151.92499999999998p 9.9950990000000005e-05 151.9375p 9.6783339999999995e-05 151.94999999999999p 9.3559790000000004e-05 151.96250000000001p 9.0282559999999999e-05 151.97500000000002p 8.695388e-05 151.98749999999998p 8.3576010000000001e-05 152p 8.0151220000000001e-05 152.01249999999999p 7.6681799999999995e-05 152.02500000000001p 7.3170049999999996e-05 152.03749999999999p 6.9618280000000003e-05 152.05000000000001p 6.6028810000000001e-05 152.0625p 6.2403989999999993e-05 152.07499999999999p 5.874615e-05 152.08750000000001p 5.5057650000000003e-05 152.09999999999999p 5.1340839999999998e-05
+ 152.11250000000001p 4.7598079999999999e-05 152.125p 4.3831739999999999e-05 152.13750000000002p 4.0044189999999998e-05 152.15000000000001p 3.623779e-05 152.16249999999999p 3.2414920000000002e-05 152.17499999999998p 2.8577939999999999e-05 152.1875p 2.4729219999999998e-05 152.19999999999999p 2.0871119999999999e-05 152.21250000000001p 1.700601e-05 152.22500000000002p 1.3136240000000001e-05 152.23749999999998p 9.2641660000000005e-06 152.25p 5.3921259999999999e-06 152.26249999999999p 1.52246e-06 152.27500000000001p -2.3425040000000001e-06 152.28749999999999p -6.2004449999999997e-06 152.30000000000001p -1.004905e-05 152.3125p -1.388602e-05 152.32499999999999p -1.7709070000000001e-05
+ 152.33750000000001p -2.1515930000000001e-05 152.34999999999999p -2.5304310000000002e-05 152.36250000000001p -2.9071990000000001e-05 152.375p -3.2816720000000002e-05 152.38750000000002p -3.6536270000000002e-05 152.40000000000001p -4.022846e-05 152.41249999999999p -4.3891080000000003e-05 152.42499999999998p -4.7521980000000002e-05 152.4375p -5.1118990000000002e-05 152.44999999999999p -5.4679989999999998e-05 152.46250000000001p -5.8202860000000002e-05 152.47500000000002p -6.1685519999999999e-05 152.48750000000001p -6.5125900000000006e-05 152.5p -6.8521940000000001e-05 152.51249999999999p -7.1871639999999994e-05 152.52500000000001p -7.5172980000000005e-05 152.53749999999999p -7.8424000000000007e-05 152.55000000000001p -8.1622749999999997e-05
+ 152.5625p -8.4767320000000005e-05 152.57499999999999p -8.7855799999999993e-05 152.58749999999998p -9.0886349999999994e-05 152.59999999999999p -9.3857130000000002e-05 152.61250000000001p -9.6766349999999999e-05 152.625p -9.9612219999999996e-05 152.63750000000002p -0.00010239299999999999 152.65000000000001p -0.0001051071 152.66249999999999p -0.0001077527 152.67499999999998p -0.00011032820000000001 152.6875p -0.0001128321 152.69999999999999p -0.0001152628 152.71250000000001p -0.0001176188 152.72499999999999p -0.0001198986 152.73750000000001p -0.0001221009 152.75p -0.00012422409999999999 152.76249999999999p -0.0001262669 152.77500000000001p -0.00012822819999999999
+ 152.78749999999999p -0.00013010659999999999 152.80000000000001p -0.00013190089999999999 152.8125p -0.00013360990000000001 152.82500000000002p -0.00013523269999999999 152.83749999999998p -0.000136768 152.84999999999999p -0.00013821490000000001 152.86250000000001p -0.00013957250000000001 152.875p -0.00014083990000000001 152.88750000000002p -0.0001420162 152.90000000000001p -0.0001431006 152.91249999999999p -0.0001440925 152.92499999999998p -0.00014499099999999999 152.9375p -0.00014579569999999999 152.94999999999999p -0.000146506 152.96250000000001p -0.0001471213 152.97499999999999p -0.00014764119999999999 152.98750000000001p -0.00014806539999999999 153p -0.00014839359999999999
+ 153.01249999999999p -0.00014862539999999999 153.02500000000001p -0.0001487607 153.03749999999999p -0.0001487994 153.05000000000001p -0.00014874140000000001 153.0625p -0.0001485867 153.07500000000002p -0.0001483353 153.08749999999998p -0.00014798740000000001 153.09999999999999p -0.0001475433 153.11250000000001p -0.00014700299999999999 153.125p -0.000146367 153.13750000000002p -0.00014563569999999999 153.15000000000001p -0.0001448094 153.16250000000002p -0.0001438888 153.17499999999998p -0.0001428743 153.1875p -0.00014176670000000001 153.19999999999999p -0.0001405666 153.21250000000001p -0.0001392748 153.22499999999999p -0.00013789210000000001
+ 153.23750000000001p -0.00013641940000000001 153.25p -0.00013485769999999999 153.26249999999999p -0.000133208 153.27500000000001p -0.0001314714 153.28749999999999p -0.00012964899999999999 153.30000000000001p -0.000127742 153.3125p -0.0001257517 153.32500000000002p -0.00012367939999999999 153.33749999999998p -0.0001215264 153.34999999999999p -0.00011929429999999999 153.36249999999998p -0.0001169844 153.375p -0.0001145983 153.38750000000002p -0.0001121376 153.40000000000001p -0.000109604 153.41250000000002p -0.0001069991 153.42499999999998p -0.00010432469999999999 153.4375p -0.00010158260000000001 153.44999999999999p -9.8774650000000005e-05
+ 153.46250000000001p -9.5902679999999998e-05 153.47499999999999p -9.296866e-05 153.48750000000001p -8.9974550000000001e-05 153.5p -8.6922390000000006e-05 153.51249999999999p -8.3814209999999995e-05 153.52500000000001p -8.0652139999999996e-05 153.53749999999999p -7.7438290000000006e-05 153.55000000000001p -7.4174840000000003e-05 153.5625p -7.0864010000000005e-05 153.57500000000002p -6.7508020000000006e-05 153.58749999999998p -6.4109150000000003e-05 153.59999999999999p -6.06697e-05 153.61249999999998p -5.7191999999999997e-05 153.625p -5.3678399999999998e-05 153.63750000000002p -5.0131299999999999e-05 153.65000000000001p -4.65531e-05 153.66250000000002p -4.294622e-05 153.67499999999998p -3.9313110000000002e-05
+ 153.6875p -3.5656240000000002e-05 153.69999999999999p -3.1978089999999997e-05 153.71250000000001p -2.828116e-05 153.72499999999999p -2.456796e-05 153.73750000000001p -2.0841020000000001e-05 153.75p -1.7102859999999999e-05 153.76249999999999p -1.3356029999999999e-05 153.77500000000001p -9.6030719999999997e-06 153.78749999999999p -5.8465419999999997e-06 153.80000000000001p -2.0889910000000002e-06 153.8125p 1.6670249999999999e-06 153.82500000000002p 5.4189529999999999e-06 153.83750000000001p 9.1642419999999993e-06 153.84999999999999p 1.2900349999999999e-05 153.86249999999998p 1.6624720000000002e-05 153.875p 2.0334850000000001e-05 153.88749999999999p 2.4028190000000001e-05 153.90000000000001p 2.7702250000000001e-05
+ 153.91250000000002p 3.1354520000000001e-05 153.92499999999998p 3.4982530000000001e-05 153.9375p 3.8583820000000003e-05 153.94999999999999p 4.2155930000000003e-05 153.96250000000001p 4.5696460000000003e-05 153.97499999999999p 4.9202990000000002e-05 153.98750000000001p 5.267316e-05 154p 5.610462e-05 154.01249999999999p 5.9495030000000001e-05 154.02500000000001p 6.2842130000000001e-05 154.03749999999999p 6.6143639999999997e-05 154.05000000000001p 6.9397339999999996e-05 154.0625p 7.2601029999999994e-05 154.07500000000002p 7.5752580000000002e-05 154.08750000000001p 7.8849849999999995e-05 154.09999999999999p 8.1890780000000004e-05 154.11249999999998p 8.4873329999999995e-05 154.125p 8.7795510000000004e-05
+ 154.13749999999999p 9.0655380000000005e-05 154.15000000000001p 9.3451029999999999e-05 154.16250000000002p 9.6180610000000006e-05 154.17499999999998p 9.8842329999999996e-05 154.1875p 0.00010143440000000001 154.19999999999999p 0.0001039552 154.21250000000001p 0.000106403 154.22499999999999p 0.0001087763 154.23750000000001p 0.0001110734 154.25p 0.000113293 154.26249999999999p 0.00011543360000000001 154.27500000000001p 0.0001174938 154.28749999999999p 0.0001194724 154.30000000000001p 0.0001213681 154.3125p 0.00012317980000000001 154.32500000000002p 0.0001249062 154.33750000000001p 0.00012654640000000001 154.34999999999999p 0.00012809940000000001
+ 154.36249999999998p 0.0001295642 154.375p 0.0001309401 154.38749999999999p 0.0001322262 154.40000000000001p 0.0001334218 154.41249999999999p 0.00013452620000000001 154.42500000000001p 0.0001355389 154.4375p 0.00013645930000000001 154.44999999999999p 0.0001372871 154.46250000000001p 0.0001380218 154.47499999999999p 0.000138663 154.48750000000001p 0.00013921070000000001 154.5p 0.00013966449999999999 154.51249999999999p 0.00014002439999999999 154.52499999999998p 0.0001402904 154.53749999999999p 0.00014046250000000001 154.55000000000001p 0.0001405407 154.5625p 0.00014052530000000001 154.57500000000002p 0.00014041650000000001
+ 154.58750000000001p 0.0001402145 154.59999999999999p 0.00013991979999999999 154.61249999999998p 0.00013953270000000001 154.625p 0.00013905379999999999 154.63749999999999p 0.00013848349999999999 154.65000000000001p 0.0001378227 154.66249999999999p 0.0001370718 154.67500000000001p 0.00013623159999999999 154.6875p 0.000135303 154.69999999999999p 0.00013428680000000001 154.71250000000001p 0.0001331839 154.72499999999999p 0.00013199530000000001 154.73750000000001p 0.000130722 154.75p 0.0001293651 154.76250000000002p 0.0001279257 154.77499999999998p 0.0001264049 154.78749999999999p 0.00012480410000000001 154.80000000000001p 0.00012312449999999999
+ 154.8125p 0.0001213675 154.82500000000002p 0.00011953430000000001 154.83750000000001p 0.0001176264 154.84999999999999p 0.0001156454 154.86249999999998p 0.00011359259999999999 154.875p 0.0001114696 154.88749999999999p 0.00010927800000000001 154.90000000000001p 0.0001070194 154.91249999999999p 0.00010469549999999999 154.92500000000001p 0.0001023079 154.9375p 9.9858390000000005e-05 154.94999999999999p 9.7348679999999997e-05 154.96250000000001p 9.4780559999999996e-05 154.97499999999999p 9.2155830000000005e-05 154.98750000000001p 8.9476320000000004e-05 155p 8.6743890000000001e-05 155.01250000000002p 8.3960430000000005e-05 155.02499999999998p 8.1127830000000001e-05
+ 155.03749999999999p 7.8248020000000002e-05 155.04999999999998p 7.5322949999999993e-05 155.0625p 7.2354570000000005e-05 155.07500000000002p 6.9344879999999999e-05 155.08750000000001p 6.6295859999999994e-05 155.10000000000002p 6.3209529999999994e-05 155.11249999999998p 6.0087909999999998e-05 155.125p 5.6933030000000001e-05 155.13749999999999p 5.3746950000000002e-05 155.15000000000001p 5.0531719999999997e-05 155.16249999999999p 4.7289410000000002e-05 155.17500000000001p 4.4022089999999999e-05 155.1875p 4.0731839999999998e-05 155.19999999999999p 3.7420750000000003e-05 155.21250000000001p 3.4090900000000003e-05 155.22499999999999p 3.0744400000000003e-05 155.23750000000001p 2.7383320000000001e-05 155.25p 2.400978e-05
+ 155.26250000000002p 2.0625859999999999e-05 155.27499999999998p 1.7233669999999999e-05 155.28749999999999p 1.383529e-05 155.29999999999998p 1.043283e-05 155.3125p 7.0283670000000001e-06 155.32500000000002p 3.6239889999999999e-06 155.33750000000001p 2.2177589999999999e-07 155.35000000000002p -3.1761989999999999e-06 155.36249999999998p -6.5678689999999996e-06 155.375p -9.9511739999999994e-06 155.38749999999999p -1.3324060000000001e-05 155.40000000000001p -1.6684499999999999e-05 155.41249999999999p -2.003044e-05 155.42500000000001p -2.3359879999999998e-05 155.4375p -2.6670799999999999e-05 155.44999999999999p -2.99612e-05 155.46250000000001p -3.3229119999999998e-05 155.47499999999999p -3.6472559999999998e-05
+ 155.48750000000001p -3.96896e-05 155.5p -4.2878269999999997e-05 155.51250000000002p -4.6036679999999998e-05 155.52499999999998p -4.9162909999999997e-05 155.53749999999999p -5.2255069999999998e-05 155.54999999999998p -5.5311310000000001e-05 155.5625p -5.8329779999999997e-05 155.57500000000002p -6.1308649999999994e-05 155.58750000000001p -6.4246130000000004e-05 155.60000000000002p -6.7140430000000001e-05 155.61249999999998p -6.9989799999999999e-05 155.625p -7.2792499999999998e-05 155.63749999999999p -7.5546840000000003e-05 155.65000000000001p -7.8251120000000002e-05 155.66249999999999p -8.0903710000000003e-05 155.67500000000001p -8.3502970000000001e-05 155.6875p -8.6047310000000006e-05 155.69999999999999p -8.8535170000000004e-05
+ 155.71250000000001p -9.0965009999999995e-05 155.72499999999999p -9.3335319999999995e-05 155.73750000000001p -9.5644649999999999e-05 155.75p -9.789155e-05 155.76250000000002p -0.00010007460000000001 155.77500000000001p -0.00010219249999999999 155.78749999999999p -0.00010424390000000001 155.79999999999998p -0.0001062274 155.8125p -0.0001081419 155.82499999999999p -0.0001099862 155.83750000000001p -0.0001117589 155.85000000000002p -0.00011345910000000001 155.86249999999998p -0.00011508569999999999 155.875p -0.0001166375 155.88749999999999p -0.0001181136 155.90000000000001p -0.0001195131 155.91249999999999p -0.0001208349 155.92500000000001p -0.00012207830000000001
+ 155.9375p -0.0001232425 155.94999999999999p -0.0001243266 155.96250000000001p -0.00012532999999999999 155.97499999999999p -0.0001262519 155.98750000000001p -0.0001270918 156p -0.00012784910000000001 156.01250000000002p -0.00012852330000000001 156.02500000000001p -0.00012911389999999999 156.03749999999999p -0.0001296205 156.04999999999998p -0.00013004269999999999 156.0625p -0.0001303802 156.07499999999999p -0.00013063279999999999 156.08750000000001p -0.00013080040000000001 156.10000000000002p -0.00013088260000000001 156.11250000000001p -0.00013087950000000001 156.125p -0.00013079110000000001 156.13749999999999p -0.00013061729999999999 156.15000000000001p -0.0001303582
+ 156.16249999999999p -0.0001300141 156.17500000000001p -0.00012958499999999999 156.1875p -0.00012907120000000001 156.19999999999999p -0.00012847309999999999 156.21250000000001p -0.00012779100000000001 156.22499999999999p -0.00012702540000000001 156.23750000000001p -0.00012617659999999999 156.25p -0.00012524530000000001 156.26250000000002p -0.00012423210000000001 156.27500000000001p -0.0001231375 156.28749999999999p -0.0001219623 156.29999999999998p -0.0001207073 156.3125p -0.0001193733 156.32499999999999p -0.0001179611 156.33750000000001p -0.0001164717 156.34999999999999p -0.000114906 156.36250000000001p -0.0001132651 156.375p -0.00011155009999999999
+ 156.38749999999999p -0.000109762 156.40000000000001p -0.0001079021 156.41249999999999p -0.0001059717 156.42500000000001p -0.00010397190000000001 156.4375p -0.0001019041 156.45000000000002p -9.9769739999999997e-05 156.46249999999998p -9.7570210000000004e-05 156.47499999999999p -9.5306979999999999e-05 156.48750000000001p -9.2981569999999995e-05 156.5p -9.0595540000000006e-05 156.51250000000002p -8.8150489999999995e-05 156.52500000000001p -8.5648079999999996e-05 156.53749999999999p -8.3089970000000004e-05 156.54999999999998p -8.0477910000000005e-05 156.5625p -7.7813639999999999e-05 156.57499999999999p -7.5098980000000006e-05 156.58750000000001p -7.2335750000000003e-05 156.59999999999999p -6.9525819999999999e-05
+ 156.61250000000001p -6.6671109999999993e-05 156.625p -6.3773529999999997e-05 156.63749999999999p -6.083506e-05 156.65000000000001p -5.7857689999999999e-05 156.66249999999999p -5.484344e-05 156.67500000000001p -5.1794359999999997e-05 156.6875p -4.871252e-05 156.70000000000002p -4.5600009999999998e-05 156.71249999999998p -4.2458949999999998e-05 156.72499999999999p -3.929148e-05 156.73750000000001p -3.6099749999999999e-05 156.75p -3.288595e-05 156.76250000000002p -2.9652250000000001e-05 156.77500000000001p -2.6400860000000001e-05 156.78749999999999p -2.3133989999999998e-05 156.79999999999998p -1.9853879999999998e-05 156.8125p -1.6562760000000001e-05 156.82499999999999p -1.3262869999999999e-05
+ 156.83750000000001p -9.9564619999999997e-06 156.84999999999999p -6.6457959999999999e-06 156.86250000000001p -3.333127e-06 156.875p -2.0715820000000001e-08 156.88749999999999p 3.2891789999999998e-06 156.90000000000001p 6.5942990000000003e-06 156.91249999999999p 9.8923899999999997e-06 156.92500000000001p 1.31812e-05 156.9375p 1.6458490000000001e-05 156.95000000000002p 1.9722030000000001e-05 156.96249999999998p 2.296959e-05 156.97499999999999p 2.6198950000000001e-05 156.98749999999998p 2.9407929999999999e-05 157p 3.2594320000000002e-05 157.01250000000002p 3.575598e-05 157.02500000000001p 3.889074e-05 157.03750000000002p 4.1996470000000001e-05 157.04999999999998p 4.5071070000000001e-05
+ 157.0625p 4.811245e-05 157.07499999999999p 5.1118539999999998e-05 157.08750000000001p 5.4087320000000001e-05 157.09999999999999p 5.7016769999999997e-05 157.11250000000001p 5.9904909999999997e-05 157.125p 6.2749790000000006e-05 157.13749999999999p 6.55495e-05 157.15000000000001p 6.8302159999999995e-05 157.16249999999999p 7.1005899999999997e-05 157.17500000000001p 7.3658930000000003e-05 157.1875p 7.6259469999999995e-05 157.20000000000002p 7.8805780000000002e-05 157.21249999999998p 8.129616e-05 157.22499999999999p 8.3728959999999995e-05 157.23749999999998p 8.6102579999999996e-05 157.25p 8.8415440000000003e-05 157.26250000000002p 9.0666020000000004e-05 157.27500000000001p 9.2852850000000003e-05
+ 157.28750000000002p 9.4974509999999997e-05 157.29999999999998p 9.7029609999999997e-05 157.3125p 9.9016820000000005e-05 157.32499999999999p 0.0001009349 157.33750000000001p 0.0001027825 157.34999999999999p 0.0001045586 157.36250000000001p 0.0001062621 157.375p 0.0001078918 157.38749999999999p 0.0001094467 157.40000000000001p 0.00011092589999999999 157.41249999999999p 0.00011232849999999999 157.42500000000001p 0.0001136537 157.4375p 0.0001149006 157.45000000000002p 0.0001160686 157.46249999999998p 0.000117157 157.47499999999999p 0.0001181651 157.48749999999998p 0.0001190925 157.5p 0.0001199386
+ 157.51249999999999p 0.00012070310000000001 157.52500000000001p 0.00012138540000000001 157.53750000000002p 0.00012198540000000001 157.54999999999998p 0.0001225028 157.5625p 0.00012293739999999999 157.57499999999999p 0.00012328910000000001 157.58750000000001p 0.0001235578 157.59999999999999p 0.0001237434 157.61250000000001p 0.00012384620000000001 157.625p 0.00012386600000000001 157.63749999999999p 0.00012380320000000001 157.65000000000001p 0.00012365799999999999 157.66249999999999p 0.00012343059999999999 157.67500000000001p 0.00012312130000000001 157.6875p 0.00012273070000000001 157.70000000000002p 0.0001222591 157.71250000000001p 0.00012170700000000001 157.72499999999999p 0.000121075
+ 157.73749999999998p 0.0001203638 157.75p 0.0001195739 157.76249999999999p 0.0001187062 157.77500000000001p 0.0001177614 157.78750000000002p 0.0001167402 157.79999999999998p 0.0001156437 157.8125p 0.00011447270000000001 157.82499999999999p 0.00011322819999999999 157.83750000000001p 0.00011191119999999999 157.84999999999999p 0.0001105227 157.86250000000001p 0.0001090639 157.875p 0.0001075359 157.88749999999999p 0.00010594000000000001 157.90000000000001p 0.00010427720000000001 157.91249999999999p 0.000102549 157.92500000000001p 0.0001007566 157.9375p 9.8901290000000001e-05 157.95000000000002p 9.6984560000000004e-05
+ 157.96250000000001p 9.5007770000000007e-05 157.97499999999999p 9.2972370000000002e-05 157.98749999999998p 9.087985e-05 158p 8.8731709999999997e-05 158.01249999999999p 8.6529490000000005e-05 158.02500000000001p 8.4274749999999998e-05 158.03750000000002p 8.1969099999999994e-05 158.05000000000001p 7.9614129999999996e-05 158.0625p 7.7211509999999998e-05 158.07499999999999p 7.4762899999999995e-05 158.08750000000001p 7.2269969999999995e-05 158.09999999999999p 6.9734449999999998e-05 158.11250000000001p 6.715805e-05 158.125p 6.4542530000000003e-05 158.13749999999999p 6.1889639999999994e-05 158.15000000000001p 5.9201170000000003e-05 158.16249999999999p 5.6478899999999999e-05 158.17500000000001p 5.3724650000000001e-05
+ 158.1875p 5.0940219999999999e-05 158.20000000000002p 4.812746e-05 158.21250000000001p 4.5288189999999997e-05 158.22499999999999p 4.2424279999999998e-05 158.23749999999998p 3.9537569999999997e-05 158.25p 3.6629940000000003e-05 158.26249999999999p 3.3703240000000002e-05 158.27500000000001p 3.075936e-05 158.28749999999999p 2.7800180000000001e-05 158.30000000000001p 2.4827570000000001e-05 158.3125p 2.184342e-05 158.32499999999999p 1.8849620000000001e-05 158.33750000000001p 1.5848050000000002e-05 158.34999999999999p 1.284059e-05 158.36250000000001p 9.8291330000000007e-06 158.375p 6.8155509999999997e-06 158.38750000000002p 3.801723e-06 158.39999999999998p 7.8952020000000003e-07
+ 158.41249999999999p -2.21919e-06 158.42500000000001p -5.2225460000000004e-06 158.4375p -8.2186949999999994e-06 158.45000000000002p -1.120579e-05 158.46250000000001p -1.4182000000000001e-05 158.47499999999999p -1.7145479999999999e-05 158.48749999999998p -2.0094430000000001e-05 158.5p -2.3027040000000001e-05 158.51249999999999p -2.594151e-05 158.52500000000001p -2.8836060000000001e-05 158.53749999999999p -3.1708919999999999e-05 158.55000000000001p -3.455834e-05 158.5625p -3.7382570000000001e-05 158.57499999999999p -4.0179899999999998e-05 158.58750000000001p -4.2948619999999999e-05 158.59999999999999p -4.5687040000000001e-05 158.61250000000001p -4.8393490000000003e-05 158.625p -5.1066310000000003e-05
+ 158.63750000000002p -5.3703889999999999e-05 158.64999999999998p -5.6304590000000002e-05 158.66249999999999p -5.886685e-05 158.67500000000001p -6.1389079999999997e-05 158.6875p -6.3869759999999993e-05 158.70000000000002p -6.6307349999999998e-05 158.71250000000001p -6.8700360000000001e-05 158.72500000000002p -7.1047329999999995e-05 158.73749999999998p -7.3346810000000001e-05 158.75p -7.5597390000000002e-05 158.76249999999999p -7.7797679999999994e-05 158.77500000000001p -7.9946320000000005e-05 158.78749999999999p -8.2041989999999997e-05 158.80000000000001p -8.4083390000000001e-05 158.8125p -8.6069249999999996e-05 158.82499999999999p -8.7998340000000004e-05 158.83750000000001p -8.9869459999999995e-05 158.84999999999999p -9.1681439999999995e-05
+ 158.86250000000001p -9.3433149999999995e-05 158.875p -9.5123499999999998e-05 158.88750000000002p -9.6751419999999998e-05 158.89999999999998p -9.8315900000000005e-05 158.91249999999999p -9.9815940000000004e-05 158.92499999999998p -0.0001012506 158.9375p -0.000102619 158.95000000000002p -0.00010392019999999999 158.96250000000001p -0.0001051534 158.97500000000002p -0.0001063179 158.98749999999998p -0.0001074128 159p -0.00010843759999999999 159.01249999999999p -0.0001093915 159.02500000000001p -0.00011027379999999999 159.03749999999999p -0.0001110842 159.05000000000001p -0.00011182189999999999 159.0625p -0.00011248659999999999 159.07499999999999p -0.0001130779
+ 159.08750000000001p -0.0001135952 159.09999999999999p -0.0001140383 159.11250000000001p -0.000114407 159.125p -0.0001147008 159.13750000000002p -0.0001149198 159.14999999999998p -0.00011506359999999999 159.16249999999999p -0.0001151323 159.17499999999998p -0.0001151257 159.1875p -0.0001150439 159.20000000000002p -0.00011488690000000001 159.21250000000001p -0.00011465480000000001 159.22500000000002p -0.0001143477 159.23749999999998p -0.00011396590000000001 159.25p -0.0001135097 159.26249999999999p -0.0001129792 159.27500000000001p -0.00011237479999999999 159.28749999999999p -0.000111697 159.30000000000001p -0.00011094620000000001
+ 159.3125p -0.0001101229 159.32499999999999p -0.0001092276 159.33750000000001p -0.00010826090000000001 159.34999999999999p -0.0001072234 159.36250000000001p -0.0001061159 159.375p -0.0001049391 159.38750000000002p -0.0001036938 159.39999999999998p -0.0001023807 159.41249999999999p -0.0001010008 159.42499999999998p -9.9555039999999994e-05 159.4375p -9.8044310000000007e-05 159.44999999999999p -9.6469650000000006e-05 159.46250000000001p -9.4832119999999998e-05 159.47500000000002p -9.3132820000000005e-05 159.48749999999998p -9.137289e-05 159.5p -8.9553509999999996e-05 159.51249999999999p -8.7675899999999999e-05 159.52500000000001p -8.5741340000000001e-05
+ 159.53749999999999p -8.375112e-05 159.55000000000001p -8.1706580000000007e-05 159.5625p -7.9609119999999998e-05 159.57499999999999p -7.7460130000000003e-05 159.58750000000001p -7.5261090000000003e-05 159.59999999999999p -7.3013460000000006e-05 159.61250000000001p -7.0718779999999996e-05 159.625p -6.8378600000000003e-05 159.63750000000002p -6.59945e-05 159.65000000000001p -6.3568090000000005e-05 159.66249999999999p -6.1101019999999998e-05 159.67499999999998p -5.8594970000000002e-05 159.6875p -5.6051619999999999e-05 159.69999999999999p -5.3472720000000002e-05 159.71250000000001p -5.0859999999999998e-05 159.72500000000002p -4.8215250000000002e-05 159.73749999999998p -4.5540249999999998e-05 159.75p -4.2836819999999998e-05
+ 159.76249999999999p -4.0106810000000001e-05 159.77500000000001p -3.7352050000000001e-05 159.78749999999999p -3.4574430000000001e-05 159.80000000000001p -3.1775839999999998e-05 159.8125p -2.8958170000000001e-05 159.82499999999999p -2.612333e-05 159.83750000000001p -2.3273270000000001e-05 159.84999999999999p -2.0409899999999999e-05 159.86250000000001p -1.753518e-05 159.875p -1.465106e-05 159.88750000000002p -1.17595e-05 159.90000000000001p -8.8624699999999999e-06 159.91249999999999p -5.96193e-06 159.92499999999998p -3.0598520000000001e-06 159.9375p -1.5820800000000001e-07 159.94999999999999p 2.741033e-06 159.96250000000001p 5.6359039999999998e-06 159.97499999999999p 8.5244400000000003e-06
+ 159.98750000000001p 1.140468e-05 160p 1.4274679999999999e-05 160.01249999999999p 1.7132480000000001e-05 160.02500000000001p 1.9976160000000001e-05 160.03749999999999p 2.2803789999999999e-05 160.05000000000001p 2.5613450000000001e-05 160.0625p 2.8403249999999999e-05 160.07499999999999p 3.1171299999999997e-05 160.08749999999998p 3.391573e-05 160.09999999999999p 3.6634690000000003e-05 160.11250000000001p 3.932635e-05 160.125p 4.19889e-05 160.13750000000002p 4.462054e-05 160.15000000000001p 4.7219519999999999e-05 160.16249999999999p 4.9784080000000002e-05 160.17499999999998p 5.2312509999999998e-05 160.1875p 5.4803119999999999e-05 160.19999999999999p 5.7254240000000001e-05
+ 160.21250000000001p 5.966424e-05 160.22499999999999p 6.2031519999999999e-05 160.23750000000001p 6.4354509999999996e-05 160.25p 6.6631659999999998e-05 160.26249999999999p 6.8861479999999997e-05 160.27500000000001p 7.1042489999999995e-05 160.28749999999999p 7.3173260000000004e-05 160.30000000000001p 7.5252390000000004e-05 160.3125p 7.7278529999999998e-05 160.32500000000002p 7.9250349999999999e-05 160.33749999999998p 8.1166590000000002e-05 160.34999999999999p 8.302599e-05 160.36250000000001p 8.4827380000000006e-05 160.375p 8.6569580000000004e-05 160.38750000000002p 8.8251510000000001e-05 160.40000000000001p 8.9872080000000002e-05 160.41249999999999p 9.1430290000000004e-05 160.42499999999998p 9.2925169999999994e-05
+ 160.4375p 9.4355780000000001e-05 160.44999999999999p 9.5721250000000004e-05 160.46250000000001p 9.7020760000000002e-05 160.47499999999999p 9.8253510000000005e-05 160.48750000000001p 9.9418770000000002e-05 160.5p 0.0001005159 160.51249999999999p 0.0001015442 160.52500000000001p 0.0001025031 160.53749999999999p 0.0001033921 160.55000000000001p 0.0001042107 160.5625p 0.0001049585 160.57500000000002p 0.00010563509999999999 160.58749999999998p 0.00010624010000000001 160.59999999999999p 0.0001067734 160.61250000000001p 0.0001072346 160.625p 0.0001076236 160.63750000000002p 0.0001079402 160.65000000000001p 0.0001081845
+ 160.66250000000002p 0.0001083564 160.67499999999998p 0.0001084559 160.6875p 0.0001084831 160.69999999999999p 0.0001084381 160.71250000000001p 0.0001083211 160.72499999999999p 0.0001081324 160.73750000000001p 0.0001078722 160.75p 0.0001075409 160.76249999999999p 0.0001071388 160.77500000000001p 0.00010666630000000001 160.78749999999999p 0.0001061241 160.80000000000001p 0.0001055124 160.8125p 0.0001048321 160.82500000000002p 0.00010408349999999999 160.83749999999998p 0.00010326749999999999 160.84999999999999p 0.0001023846 160.86249999999998p 0.0001014357 160.875p 0.0001004215
+ 160.88750000000002p 9.9342899999999994e-05 160.90000000000001p 9.8200699999999996e-05 160.91250000000002p 9.6995810000000005e-05 160.92499999999998p 9.5729200000000005e-05 160.9375p 9.4401839999999997e-05 160.94999999999999p 9.3014749999999999e-05 160.96250000000001p 9.1568990000000003e-05 160.97499999999999p 9.0065650000000004e-05 160.98750000000001p 8.8505839999999998e-05 161p 8.6890740000000001e-05 161.01249999999999p 8.5221509999999998e-05 161.02500000000001p 8.3499399999999995e-05 161.03749999999999p 8.1725629999999998e-05 161.05000000000001p 7.990149e-05 161.0625p 7.8028279999999998e-05 161.07500000000002p 7.6107330000000004e-05 161.08749999999998p 7.4140000000000005e-05 161.09999999999999p 7.2127680000000003e-05
+ 161.11249999999998p 7.0071749999999999e-05 161.125p 6.7973649999999999e-05 161.13750000000002p 6.5834839999999998e-05 161.15000000000001p 6.3656760000000001e-05 161.16250000000002p 6.1440920000000005e-05 161.17499999999998p 5.9188809999999999e-05 161.1875p 5.6901950000000002e-05 161.19999999999999p 5.45819e-05 161.21250000000001p 5.2230179999999999e-05 161.22499999999999p 4.9848390000000001e-05 161.23750000000001p 4.7438080000000001e-05 161.25p 4.5000860000000002e-05 161.26249999999999p 4.2538330000000001e-05 161.27500000000001p 4.0052100000000002e-05 161.28749999999999p 3.7543789999999997e-05 161.30000000000001p 3.5015029999999998e-05 161.3125p 3.2467459999999998e-05 161.32500000000002p 2.9902719999999999e-05
+ 161.33750000000001p 2.7322459999999999e-05 161.34999999999999p 2.4728340000000001e-05 161.36249999999998p 2.212201e-05 161.375p 1.9505129999999999e-05 161.38749999999999p 1.687936e-05 161.40000000000001p 1.424636e-05 161.41250000000002p 1.1607799999999999e-05 161.42499999999998p 8.9653379999999993e-06 161.4375p 6.3206330000000004e-06 161.44999999999999p 3.6753429999999999e-06 161.46250000000001p 1.0311219999999999e-06 161.47499999999999p -1.610381e-06 161.48750000000001p -4.2475189999999999e-06 161.5p -6.8786529999999996e-06 161.51249999999999p -9.5021500000000002e-06 161.52500000000001p -1.211638e-05 161.53749999999999p -1.471974e-05 161.55000000000001p -1.73106e-05
+ 161.5625p -1.9887380000000001e-05 161.57500000000002p -2.2448479999999999e-05 161.58750000000001p -2.4992319999999999e-05 161.59999999999999p -2.7517340000000001e-05 161.61249999999998p -3.002198e-05 161.625p -3.2504710000000001e-05 161.63749999999999p -3.4963999999999999e-05 161.65000000000001p -3.739834e-05 161.66250000000002p -3.9806230000000001e-05 161.67499999999998p -4.2186189999999999e-05 161.6875p -4.4536770000000002e-05 161.69999999999999p -4.6856510000000002e-05 161.71250000000001p -4.9144000000000002e-05 161.72499999999999p -5.139783e-05 161.73750000000001p -5.3616609999999998e-05 161.75p -5.5798979999999997e-05 161.76249999999999p -5.7943599999999999e-05 161.77500000000001p -6.0049139999999997e-05
+ 161.78749999999999p -6.2114300000000003e-05 161.80000000000001p -6.4137820000000003e-05 161.8125p -6.6118449999999997e-05 161.82500000000002p -6.8054959999999995e-05 161.83750000000001p -6.9946149999999994e-05 161.84999999999999p -7.1790849999999994e-05 161.86249999999998p -7.3587919999999995e-05 161.875p -7.5336240000000002e-05 161.88749999999999p -7.7034730000000005e-05 161.90000000000001p -7.868234e-05 161.91249999999999p -8.0278019999999994e-05 161.92500000000001p -8.1820800000000001e-05 161.9375p -8.3309700000000006e-05 161.94999999999999p -8.4743789999999999e-05 161.96250000000001p -8.6122169999999998e-05 161.97499999999999p -8.7443989999999998e-05 161.98750000000001p -8.8708400000000006e-05 162p -8.9914609999999995e-05
+ 162.01249999999999p -9.1061869999999994e-05 162.02499999999998p -9.2149440000000005e-05 162.03749999999999p -9.3176639999999994e-05 162.05000000000001p -9.4142819999999997e-05 162.0625p -9.5047369999999999e-05 162.07500000000002p -9.5889699999999998e-05 162.08750000000001p -9.6669289999999999e-05 162.09999999999999p -9.7385639999999994e-05 162.11249999999998p -9.8038280000000005e-05 162.125p -9.8626810000000003e-05 162.13749999999999p -9.9150840000000002e-05 162.15000000000001p -9.9610049999999993e-05 162.16249999999999p -0.00010000409999999999 162.17500000000001p -0.0001003328 162.1875p -0.0001005959 162.19999999999999p -0.0001007933 162.21250000000001p -0.00010092470000000001 162.22499999999999p -0.00010099019999999999
+ 162.23750000000001p -0.0001009897 162.25p -0.0001009232 162.26250000000002p -0.0001007907 162.27499999999998p -0.0001005923 162.28749999999999p -0.00010032820000000001 162.30000000000001p -9.9998499999999995e-05 162.3125p -9.9603450000000006e-05 162.32500000000002p -9.9143310000000004e-05 162.33750000000001p -9.8618379999999996e-05 162.34999999999999p -9.8029009999999993e-05 162.36249999999998p -9.7375579999999995e-05 162.375p -9.6658530000000005e-05 162.38749999999999p -9.5878340000000003e-05 162.40000000000001p -9.5035529999999997e-05 162.41249999999999p -9.4130639999999999e-05 162.42500000000001p -9.3164299999999998e-05 162.4375p -9.2137129999999998e-05 162.44999999999999p -9.1049830000000006e-05
+ 162.46250000000001p -8.9903110000000004e-05 162.47499999999999p -8.8697750000000006e-05 162.48750000000001p -8.7434550000000001e-05 162.5p -8.6114359999999994e-05 162.51250000000002p -8.4738050000000004e-05 162.52499999999998p -8.3306560000000004e-05 162.53749999999999p -8.1820830000000003e-05 162.54999999999998p -8.0281880000000007e-05 162.5625p -7.8690720000000003e-05 162.57500000000002p -7.7048440000000002e-05 162.58750000000001p -7.5356129999999997e-05 162.60000000000002p -7.3614930000000001e-05 162.61249999999998p -7.1826020000000001e-05 162.625p -6.99906e-05 162.63749999999999p -6.8109900000000003e-05 162.65000000000001p -6.6185200000000005e-05 162.66249999999999p -6.42178e-05 162.67500000000001p -6.2209020000000002e-05
+ 162.6875p -6.0160210000000001e-05 162.69999999999999p -5.8072770000000002e-05 162.71250000000001p -5.5948110000000001e-05 162.72499999999999p -5.3787650000000003e-05 162.73750000000001p -5.1592870000000003e-05 162.75p -4.9365240000000002e-05 162.76250000000002p -4.7106289999999999e-05 162.77499999999998p -4.4817519999999997e-05 162.78749999999999p -4.2500499999999997e-05 162.79999999999998p -4.0156800000000001e-05 162.8125p -3.7787999999999998e-05 162.82500000000002p -3.5395709999999998e-05 162.83750000000001p -3.2981549999999999e-05 162.85000000000002p -3.0547150000000001e-05 162.86249999999998p -2.8094170000000001e-05 162.875p -2.562428e-05 162.88749999999999p -2.313914e-05 162.90000000000001p -2.0640439999999999e-05
+ 162.91249999999999p -1.8129879999999999e-05 162.92500000000001p -1.560916e-05 162.9375p -1.307998e-05 162.94999999999999p -1.0544070000000001e-05 162.96250000000001p -8.0031499999999998e-06 162.97499999999999p -5.4589310000000002e-06 162.98750000000001p -2.9131440000000001e-06 163p -3.6751409999999998e-07 163.01250000000002p 2.1762340000000001e-06 163.02499999999998p 4.7163759999999996e-06 163.03749999999999p 7.2511909999999997e-06 163.04999999999998p 9.778965e-06 163.0625p 1.2297990000000001e-05 163.07500000000002p 1.480655e-05 163.08750000000001p 1.7302960000000001e-05 163.10000000000002p 1.9785530000000001e-05 163.11249999999998p 2.225258e-05 163.125p 2.4702449999999999e-05
+ 163.13749999999999p 2.7133479999999999e-05 163.15000000000001p 2.954404e-05 163.16249999999999p 3.19325e-05 163.17500000000001p 3.4297259999999998e-05 163.1875p 3.6636730000000003e-05 163.19999999999999p 3.8949319999999998e-05 163.21250000000001p 4.1233509999999998e-05 163.22499999999999p 4.3487740000000003e-05 163.23750000000001p 4.5710529999999998e-05 163.25p 4.7900369999999998e-05 163.26250000000002p 5.0055819999999997e-05 163.27500000000001p 5.2175429999999997e-05 163.28749999999999p 5.425779e-05 163.29999999999998p 5.6301539999999999e-05 163.3125p 5.8305299999999999e-05 163.32499999999999p 6.0267769999999997e-05 163.33750000000001p 6.2187639999999997e-05 163.35000000000002p 6.4063650000000005e-05
+ 163.36249999999998p 6.5894590000000004e-05 163.375p 6.7679240000000004e-05 163.38749999999999p 6.9416450000000005e-05 163.40000000000001p 7.1105079999999997e-05 163.41249999999999p 7.2744059999999998e-05 163.42500000000001p 7.4332330000000002e-05 163.4375p 7.5868860000000005e-05 163.44999999999999p 7.7352679999999994e-05 163.46250000000001p 7.8782839999999997e-05 163.47499999999999p 8.0158450000000005e-05 163.48750000000001p 8.1478639999999999e-05 163.5p 8.2742600000000003e-05 163.51250000000002p 8.3949540000000003e-05 163.52500000000001p 8.5098730000000001e-05 163.53749999999999p 8.6189460000000003e-05 163.54999999999998p 8.7221090000000004e-05 163.5625p 8.8193000000000001e-05 163.57499999999999p 8.9104629999999996e-05
+ 163.58750000000001p 8.9955459999999993e-05 163.60000000000002p 9.0744999999999999e-05 163.61250000000001p 9.1472809999999997e-05 163.625p 9.213852e-05 163.63749999999999p 9.2741759999999998e-05 163.65000000000001p 9.3282249999999996e-05 163.66249999999999p 9.3759710000000004e-05 163.67500000000001p 9.4173950000000007e-05 163.6875p 9.4524790000000006e-05 163.69999999999999p 9.4812100000000007e-05 163.71250000000001p 9.5035820000000004e-05 163.72499999999999p 9.5195909999999995e-05 163.73750000000001p 9.5292379999999994e-05 163.75p 9.5325290000000006e-05 163.76250000000002p 9.5294729999999996e-05 163.77500000000001p 9.5200850000000002e-05 163.78749999999999p 9.5043829999999995e-05 163.79999999999998p 9.4823910000000006e-05
+ 163.8125p 9.454137e-05 163.82499999999999p 9.4196499999999998e-05 163.83750000000001p 9.378968e-05 163.84999999999999p 9.3321300000000004e-05 163.86250000000001p 9.2791810000000002e-05 163.875p 9.220167e-05 163.88749999999999p 9.1551419999999994e-05 163.90000000000001p 9.0841619999999996e-05 163.91249999999999p 9.0072850000000006e-05 163.92500000000001p 8.9245760000000003e-05 163.9375p 8.8361020000000005e-05 163.95000000000002p 8.7419349999999995e-05 163.96249999999998p 8.6421489999999998e-05 163.97499999999999p 8.5368220000000002e-05 163.98750000000001p 8.4260359999999994e-05 164p 8.3098749999999994e-05 164.01250000000002p 8.1884289999999997e-05 164.02500000000001p 8.0617889999999999e-05
+ 164.03749999999999p 7.9300489999999997e-05 164.04999999999998p 7.7933070000000006e-05 164.0625p 7.6516640000000001e-05 164.07499999999999p 7.5052230000000002e-05 164.08750000000001p 7.354091e-05 164.09999999999999p 7.1983770000000005e-05 164.11250000000001p 7.0381919999999999e-05 164.125p 6.8736499999999995e-05 164.13749999999999p 6.7048690000000007e-05 164.15000000000001p 6.5319659999999995e-05 164.16249999999999p 6.3550640000000004e-05 164.17500000000001p 6.1742859999999999e-05 164.1875p 5.9897559999999998e-05 164.20000000000002p 5.8016029999999997e-05 164.21249999999998p 5.6099549999999997e-05 164.22499999999999p 5.4149430000000002e-05 164.23750000000001p 5.2167019999999998e-05 164.25p 5.0153630000000002e-05
+ 164.26250000000002p 4.8110640000000003e-05 164.27500000000001p 4.603942e-05 164.28749999999999p 4.3941360000000003e-05 164.29999999999998p 4.1817840000000001e-05 164.3125p 3.9670289999999998e-05 164.32499999999999p 3.7500119999999998e-05 164.33750000000001p 3.530876e-05 164.34999999999999p 3.3097659999999997e-05 164.36250000000001p 3.0868260000000001e-05 164.375p 2.8622009999999999e-05 164.38749999999999p 2.6360380000000001e-05 164.40000000000001p 2.4084829999999999e-05 164.41249999999999p 2.1796840000000001e-05 164.42500000000001p 1.949788e-05 164.4375p 1.718942e-05 164.45000000000002p 1.4872940000000001e-05 164.46249999999998p 1.2549939999999999e-05 164.47499999999999p 1.022188e-05
+ 164.48749999999998p 7.8902609999999996e-06 164.5p 5.5565500000000002e-06 164.51250000000002p 3.2222299999999998e-06 164.52500000000001p 8.8877649999999995e-07 164.53750000000002p -1.4423369999999999e-06 164.54999999999998p -3.7696409999999999e-06 164.5625p -6.0916729999999999e-06 164.57499999999999p -8.4069749999999992e-06 164.58750000000001p -1.07141e-05 164.59999999999999p -1.301159e-05 164.61250000000001p -1.529802e-05 164.625p -1.7571960000000001e-05 164.63749999999999p -1.9831989999999998e-05 164.65000000000001p -2.2076700000000002e-05 164.66249999999999p -2.4304700000000001e-05 164.67500000000001p -2.6514590000000001e-05 164.6875p -2.8705010000000001e-05 164.70000000000002p -3.0874589999999997e-05
+ 164.71249999999998p -3.3021990000000003e-05 164.72499999999999p -3.5145870000000003e-05 164.73749999999998p -3.7244920000000001e-05 164.75p -3.931783e-05 164.76250000000002p -4.136333e-05 164.77500000000001p -4.3380129999999997e-05 164.78750000000002p -4.536699e-05 164.79999999999998p -4.7322679999999999e-05 164.8125p -4.9245980000000001e-05 164.82499999999999p -5.113571e-05 164.83750000000001p -5.2990679999999999e-05 164.84999999999999p -5.4809760000000002e-05 164.86250000000001p -5.6591810000000003e-05 164.875p -5.8335719999999999e-05 164.88749999999999p -6.0040410000000003e-05 164.90000000000001p -6.1704819999999994e-05 164.91249999999999p -6.3327919999999995e-05 164.92500000000001p -6.4908690000000003e-05
+ 164.9375p -6.6446160000000005e-05 164.95000000000002p -6.7939359999999999e-05 164.96249999999998p -6.9387370000000004e-05 164.97499999999999p -7.0789269999999995e-05 164.98749999999998p -7.2144200000000006e-05 165p -7.3451319999999994e-05 165.01249999999999p -7.4709789999999993e-05 165.02500000000001p -7.5918840000000005e-05 165.03750000000002p -7.7077710000000003e-05 165.04999999999998p -7.8185680000000005e-05 165.0625p -7.9242040000000001e-05 165.07499999999999p -8.024614e-05 165.08750000000001p -8.1197349999999999e-05 165.09999999999999p -8.2095069999999997e-05 165.11250000000001p -8.2938739999999995e-05 165.125p -8.3727829999999997e-05 165.13749999999999p -8.4461839999999994e-05 165.15000000000001p -8.5140319999999997e-05
+ 165.16249999999999p -8.576283e-05 165.17500000000001p -8.6328990000000006e-05 165.1875p -8.6838440000000001e-05 165.20000000000002p -8.7290879999999993e-05 165.21250000000001p -8.7686e-05 165.22499999999999p -8.8023579999999994e-05 165.23749999999998p -8.8303399999999999e-05 165.25p -8.8525290000000004e-05 165.26249999999999p -8.8689109999999998e-05 165.27500000000001p -8.8794780000000004e-05 165.28750000000002p -8.8842240000000004e-05 165.29999999999998p -8.8831459999999995e-05 165.3125p -8.8762460000000007e-05 165.32499999999999p -8.8635300000000002e-05 165.33750000000001p -8.845007e-05 165.34999999999999p -8.8206909999999998e-05 165.36250000000001p -8.7905979999999993e-05 165.375p -8.7547500000000002e-05
+ 165.38749999999999p -8.7131709999999999e-05 165.40000000000001p -8.6658890000000004e-05 165.41249999999999p -8.612937e-05 165.42500000000001p -8.5543509999999999e-05 165.4375p -8.4901710000000001e-05 165.45000000000002p -8.4204399999999996e-05 165.46250000000001p -8.3452050000000003e-05 165.47499999999999p -8.2645170000000004e-05 165.48749999999998p -8.1784319999999997e-05 165.5p -8.0870059999999994e-05 165.51249999999999p -7.9903019999999999e-05 165.52500000000001p -7.8883860000000003e-05 165.53750000000002p -7.781326e-05 165.55000000000001p -7.6691939999999999e-05 165.5625p -7.5520670000000001e-05 165.57499999999999p -7.4300230000000006e-05 165.58750000000001p -7.3031460000000004e-05 165.59999999999999p -7.1715200000000001e-05
+ 165.61250000000001p -7.0352350000000004e-05 165.625p -6.8943829999999998e-05 165.63749999999999p -6.7490599999999994e-05 165.65000000000001p -6.5993639999999994e-05 165.66249999999999p -6.445395e-05 165.67500000000001p -6.2872590000000004e-05 165.6875p -6.1250630000000001e-05 165.70000000000002p -5.9589159999999999e-05 165.71250000000001p -5.7889300000000002e-05 165.72499999999999p -5.6152220000000002e-05 165.73749999999998p -5.4379090000000002e-05 165.75p -5.2571110000000003e-05 165.76249999999999p -5.0729500000000003e-05 165.77500000000001p -4.8855520000000001e-05 165.78749999999999p -4.6950429999999999e-05 165.80000000000001p -4.5015529999999998e-05 165.8125p -4.3052130000000003e-05 165.82499999999999p -4.1061569999999998e-05
+ 165.83750000000001p -3.9045180000000002e-05 165.84999999999999p -3.7004349999999997e-05 165.86250000000001p -3.4940449999999998e-05 165.875p -3.2854890000000002e-05 165.88750000000002p -3.0749079999999999e-05 165.89999999999998p -2.862445e-05 165.91249999999999p -2.6482430000000001e-05 165.92500000000001p -2.4324500000000001e-05 165.9375p -2.2152100000000001e-05 165.95000000000002p -1.996671e-05 165.96250000000001p -1.7769810000000001e-05 165.97499999999999p -1.5562889999999999e-05 165.98749999999998p -1.3347459999999999e-05 166p -1.1124999999999999e-05 166.01249999999999p -8.897033e-06 166.02500000000001p -6.6650599999999997e-06 166.03749999999999p -4.4305929999999996e-06 166.05000000000001p -2.195146e-06
+ 166.0625p 3.9767670000000003e-08 166.07499999999999p 2.272637e-06 166.08750000000001p 4.5019519999999998e-06 166.09999999999999p 6.7262049999999996e-06 166.11250000000001p 8.9438950000000005e-06 166.125p 1.1153520000000001e-05 166.13750000000002p 1.33536e-05 166.14999999999998p 1.5542639999999999e-05 166.16249999999999p 1.7719169999999999e-05 166.17500000000001p 1.9881729999999998e-05 166.1875p 2.2028849999999998e-05 166.20000000000002p 2.41591e-05 166.21250000000001p 2.6271039999999999e-05 166.22500000000002p 2.8363270000000001e-05 166.23749999999998p 3.0434369999999999e-05 166.25p 3.2482949999999997e-05 166.26249999999999p 3.4507659999999999e-05 166.27500000000001p 3.6507139999999998e-05
+ 166.28749999999999p 3.8480050000000001e-05 166.30000000000001p 4.042509e-05 166.3125p 4.2340950000000003e-05 166.32499999999999p 4.4226369999999999e-05 166.33750000000001p 4.6080099999999999e-05 166.34999999999999p 4.7900910000000001e-05 166.36250000000001p 4.9687600000000002e-05 166.375p 5.1439e-05 166.38750000000002p 5.3153959999999997e-05 166.39999999999998p 5.4831350000000001e-05 166.41249999999999p 5.6470079999999999e-05 166.42499999999998p 5.8069080000000001e-05 166.4375p 5.9627309999999998e-05 166.45000000000002p 6.1143760000000006e-05 166.46250000000001p 6.2617470000000006e-05 166.47500000000002p 6.4047469999999998e-05 166.48749999999998p 6.5432859999999999e-05 166.5p 6.6772760000000003e-05
+ 166.51249999999999p 6.8066310000000003e-05 166.52500000000001p 6.9312709999999999e-05 166.53749999999999p 7.0511170000000001e-05 166.55000000000001p 7.166094e-05 166.5625p 7.2761319999999999e-05 166.57499999999999p 7.3811640000000006e-05 166.58750000000001p 7.4811240000000002e-05 166.59999999999999p 7.5759550000000002e-05 166.61250000000001p 7.6655980000000005e-05 166.625p 7.7500010000000001e-05 166.63750000000002p 7.8291159999999997e-05 166.64999999999998p 7.9028970000000003e-05 166.66249999999999p 7.9713030000000003e-05 166.67499999999998p 8.0342959999999997e-05 166.6875p 8.0918430000000003e-05 166.70000000000002p 8.143914e-05 166.71250000000001p 8.1904829999999998e-05 166.72500000000002p 8.2315280000000007e-05
+ 166.73749999999998p 8.2670320000000002e-05 166.75p 8.2969789999999999e-05 166.76249999999999p 8.3213600000000006e-05 166.77500000000001p 8.3401680000000003e-05 166.78749999999999p 8.3534000000000004e-05 166.80000000000001p 8.3610589999999995e-05 166.8125p 8.3631480000000006e-05 166.82499999999999p 8.3596780000000004e-05 166.83750000000001p 8.3506599999999998e-05 166.84999999999999p 8.3361119999999999e-05 166.86250000000001p 8.3160539999999994e-05 166.875p 8.2905089999999999e-05 166.88750000000002p 8.2595059999999995e-05 166.89999999999998p 8.2230760000000003e-05 166.91249999999999p 8.1812540000000006e-05 166.92499999999998p 8.1340780000000004e-05 166.9375p 8.0815910000000001e-05 166.94999999999999p 8.0238379999999999e-05
+ 166.96250000000001p 7.9608679999999994e-05 166.97500000000002p 7.8927339999999995e-05 166.98749999999998p 7.819491e-05 167p 7.7411989999999996e-05 167.01249999999999p 7.657919e-05 167.02500000000001p 7.5697160000000002e-05 167.03749999999999p 7.4766599999999997e-05 167.05000000000001p 7.3788219999999994e-05 167.0625p 7.2762760000000005e-05 167.07499999999999p 7.1691000000000002e-05 167.08750000000001p 7.057373e-05 167.09999999999999p 6.9411780000000004e-05 167.11250000000001p 6.8206020000000005e-05 167.125p 6.6957319999999998e-05 167.13750000000002p 6.5666590000000005e-05 167.15000000000001p 6.4334759999999997e-05 167.16249999999999p 6.2962789999999999e-05 167.17499999999998p 6.1551649999999999e-05
+ 167.1875p 6.010236e-05 167.19999999999999p 5.8615919999999997e-05 167.21250000000001p 5.7093389999999997e-05 167.22500000000002p 5.5535819999999999e-05 167.23749999999998p 5.3944309999999999e-05 167.25p 5.2319940000000003e-05 167.26249999999999p 5.0663849999999998e-05 167.27500000000001p 4.897716e-05 167.28749999999999p 4.7261030000000002e-05 167.30000000000001p 4.5516619999999999e-05 167.3125p 4.3745119999999997e-05 167.32499999999999p 4.194773e-05 167.33750000000001p 4.0125639999999997e-05 167.34999999999999p 3.8280079999999998e-05 167.36250000000001p 3.6412280000000002e-05 167.375p 3.4523480000000001e-05 167.38750000000002p 3.261493e-05 167.40000000000001p 3.0687900000000001e-05
+ 167.41249999999999p 2.874365e-05 167.42499999999998p 2.6783449999999998e-05 167.4375p 2.4808600000000002e-05 167.44999999999999p 2.2820380000000001e-05 167.46250000000001p 2.0820069999999999e-05 167.47499999999999p 1.8808990000000002e-05 167.48750000000001p 1.6788420000000001e-05 167.5p 1.4759680000000001e-05 167.51249999999999p 1.272407e-05 167.52500000000001p 1.068289e-05 167.53749999999999p 8.6374609999999999e-06 167.55000000000001p 6.5890830000000003e-06 167.5625p 4.5390629999999999e-06 167.57499999999999p 2.4887080000000002e-06 167.58749999999998p 4.3931970000000002e-07 167.59999999999999p -1.6078009999999999e-06 167.61250000000001p -3.6513589999999998e-06 167.625p -5.6900609999999999e-06
+ 167.63750000000002p -7.7226219999999997e-06 167.65000000000001p -9.7477600000000007e-06 167.66249999999999p -1.17642e-05 167.67499999999998p -1.377068e-05 167.6875p -1.576593e-05 167.69999999999999p -1.7748700000000002e-05 167.71250000000001p -1.971776e-05 167.72499999999999p -2.167187e-05 167.73750000000001p -2.360981e-05 167.75p -2.553037e-05 167.76249999999999p -2.7432349999999998e-05 167.77500000000001p -2.9314559999999999e-05 167.78749999999999p -3.1175840000000003e-05 167.80000000000001p -3.3015010000000002e-05 167.8125p -3.4830940000000002e-05 167.82500000000002p -3.6622499999999997e-05 167.83749999999998p -3.8388569999999998e-05 167.84999999999999p -4.0128050000000003e-05
+ 167.86250000000001p -4.1839860000000003e-05 167.875p -4.3522939999999999e-05 167.88750000000002p -4.5176239999999999e-05 167.90000000000001p -4.6798729999999998e-05 167.91249999999999p -4.8389410000000002e-05 167.92499999999998p -4.9947280000000001e-05 167.9375p -5.1471380000000002e-05 167.94999999999999p -5.296076e-05 167.96250000000001p -5.4414499999999999e-05 167.97499999999999p -5.5831690000000002e-05 167.98750000000001p -5.7211440000000002e-05 168p -5.855291e-05 168.01249999999999p -5.985526e-05 168.02500000000001p -6.1117669999999997e-05 168.03749999999999p -6.2339359999999999e-05 168.05000000000001p -6.3519579999999999e-05 168.0625p -6.4657590000000002e-05 168.07500000000002p -6.5752669999999996e-05
+ 168.08749999999998p -6.6804150000000003e-05 168.09999999999999p -6.7811380000000005e-05 168.11250000000001p -6.8773719999999997e-05 168.125p -6.9690580000000005e-05 168.13750000000002p -7.0561390000000004e-05 168.15000000000001p -7.1385609999999997e-05 168.16250000000002p -7.2162720000000001e-05 168.17499999999998p -7.2892239999999996e-05 168.1875p -7.3573720000000005e-05 168.19999999999999p -7.4206739999999998e-05 168.21250000000001p -7.4790900000000002e-05 168.22499999999999p -7.5325850000000007e-05 168.23750000000001p -7.5811260000000001e-05 168.25p -7.6246830000000005e-05 168.26249999999999p -7.663228e-05 168.27500000000001p -7.6967399999999998e-05 168.28749999999999p -7.7251979999999997e-05 168.30000000000001p -7.7485839999999999e-05
+ 168.3125p -7.7668859999999995e-05 168.32500000000002p -7.7800930000000005e-05 168.33749999999998p -7.7881969999999995e-05 168.34999999999999p -7.7911960000000006e-05 168.36249999999998p -7.7890879999999995e-05 168.375p -7.7818770000000006e-05 168.38750000000002p -7.7695690000000001e-05 168.40000000000001p -7.7521730000000002e-05 168.41250000000002p -7.7297030000000004e-05 168.42499999999998p -7.7021740000000004e-05 168.4375p -7.6696060000000003e-05 168.44999999999999p -7.6320220000000003e-05 168.46250000000001p -7.5894479999999995e-05 168.47499999999999p -7.541913e-05 168.48750000000001p -7.489451e-05 168.5p -7.4320969999999993e-05 168.51249999999999p -7.3698909999999994e-05 168.52500000000001p -7.3028750000000004e-05
+ 168.53749999999999p -7.2310940000000002e-05 168.55000000000001p -7.1545979999999994e-05 168.5625p -7.0734390000000004e-05 168.57500000000002p -6.9876710000000002e-05 168.58749999999998p -6.8973540000000002e-05 168.59999999999999p -6.8025470000000006e-05 168.61249999999998p -6.7033170000000005e-05 168.625p -6.5997290000000005e-05 168.63750000000002p -6.4918540000000001e-05 168.65000000000001p -6.3797650000000004e-05 168.66250000000002p -6.2635379999999999e-05 168.67499999999998p -6.143252e-05 168.6875p -6.0189880000000003e-05 168.69999999999999p -5.89083e-05 168.71250000000001p -5.7588650000000003e-05 168.72499999999999p -5.6231820000000001e-05 168.73750000000001p -5.4838739999999997e-05 168.75p -5.3410340000000002e-05
+ 168.76249999999999p -5.1947599999999997e-05 168.77500000000001p -5.0451490000000002e-05 168.78749999999999p -4.8923040000000002e-05 168.80000000000001p -4.736328e-05 168.8125p -4.5773260000000002e-05 168.82500000000002p -4.4154070000000003e-05 168.83750000000001p -4.2506789999999997e-05 168.84999999999999p -4.0832550000000003e-05 168.86249999999998p -3.9132470000000003e-05 168.875p -3.7407709999999998e-05 168.88749999999999p -3.5659430000000002e-05 168.90000000000001p -3.3888820000000001e-05 168.91250000000002p -3.209708e-05 168.92499999999998p -3.0285420000000001e-05 168.9375p -2.8455059999999999e-05 168.94999999999999p -2.6607249999999998e-05 168.96250000000001p -2.4743229999999999e-05 168.97499999999999p -2.2864269999999999e-05
+ 168.98750000000001p -2.097163e-05 169p -1.9066600000000001e-05 169.01249999999999p -1.7150469999999999e-05 169.02500000000001p -1.522453e-05 169.03749999999999p -1.329008e-05 169.05000000000001p -1.134843e-05 169.0625p -9.4008940000000003e-06 169.07500000000002p -7.4487850000000004e-06 169.08750000000001p -5.493422e-06 169.09999999999999p -3.5361260000000002e-06 169.11249999999998p -1.578216e-06 169.125p 3.78987e-07 169.13749999999999p 2.3341630000000001e-06 169.15000000000001p 4.2859940000000004e-06 169.16250000000002p 6.2331660000000002e-06 169.17500000000001p 8.174368e-06 169.1875p 1.010829e-05 169.19999999999999p 1.2033640000000001e-05
+ 169.21250000000001p 1.394912e-05 169.22499999999999p 1.585345e-05 169.23750000000001p 1.774534e-05 169.25p 1.9623530000000001e-05 169.26249999999999p 2.148676e-05 169.27500000000001p 2.3333779999999999e-05 169.28749999999999p 2.5163360000000001e-05 169.30000000000001p 2.6974279999999999e-05 169.3125p 2.8765329999999999e-05 169.32500000000002p 3.053532e-05 169.33750000000001p 3.228306e-05 169.34999999999999p 3.4007400000000002e-05 169.36249999999998p 3.5707200000000003e-05 169.375p 3.7381330000000003e-05 169.38749999999999p 3.902868e-05 169.40000000000001p 4.0648159999999999e-05 169.41249999999999p 4.223871e-05 169.42500000000001p 4.3799279999999998e-05
+ 169.4375p 4.5328860000000003e-05 169.44999999999999p 4.6826419999999997e-05 169.46250000000001p 4.8291010000000003e-05 169.47499999999999p 4.972167e-05 169.48750000000001p 5.1117459999999997e-05 169.5p 5.2477479999999999e-05 169.51249999999999p 5.3800859999999999e-05 169.52499999999998p 5.5086749999999999e-05 169.53749999999999p 5.6334320000000002e-05 169.55000000000001p 5.7542779999999999e-05 169.5625p 5.8711349999999998e-05 169.57500000000002p 5.9839300000000002e-05 169.58750000000001p 6.092592e-05 169.59999999999999p 6.1970540000000002e-05 169.61249999999998p 6.2972500000000001e-05 169.625p 6.3931169999999993e-05 169.63749999999999p 6.4845989999999995e-05 169.65000000000001p 6.5716380000000005e-05
+ 169.66249999999999p 6.6541830000000003e-05 169.67500000000001p 6.7321840000000006e-05 169.6875p 6.8055959999999997e-05 169.69999999999999p 6.8743750000000001e-05 169.71250000000001p 6.9384830000000002e-05 169.72499999999999p 6.9978820000000003e-05 169.73750000000001p 7.0525409999999995e-05 169.75p 7.1024299999999997e-05 169.76250000000002p 7.1475220000000004e-05 169.77499999999998p 7.1877960000000003e-05 169.78749999999999p 7.2232320000000004e-05 169.80000000000001p 7.2538129999999998e-05 169.8125p 7.2795280000000003e-05 169.82500000000002p 7.3003669999999998e-05 169.83750000000001p 7.3163239999999994e-05 169.84999999999999p 7.3273970000000001e-05 169.86249999999998p 7.3335859999999994e-05 169.875p 7.3348970000000003e-05
+ 169.88749999999999p 7.3313360000000006e-05 169.90000000000001p 7.3229149999999997e-05 169.91249999999999p 7.3096479999999999e-05 169.92500000000001p 7.2915509999999997e-05 169.9375p 7.2686469999999994e-05 169.94999999999999p 7.2409580000000004e-05 169.96250000000001p 7.2085119999999993e-05 169.97499999999999p 7.1713399999999997e-05 169.98750000000001p 7.1294739999999996e-05)
R_LOAD OUT 0 10
I_IBIAS 0 IBIAS pwl(0p 0 1p 35u 2p 35u 170p 35u)
.tran 0.0125p 170p
.print P(BJs|XBQ) V(BJs|XBQ) I(BJs|XBQ)
.print P(BJL1|XBQ) V(BJL1|XBQ) I(BJL1|XBQ)
.print P(BJL2|XBQ) V(BJL2|XBQ) I(BJL2|XBQ)
.print I(Lin|XBQ) I(L0|XBQ) I(L1|XBQ) I(L2|XBQ) I(RB|XBQ) I(RJ1|XBQ) I(RJ2|XBQ)
.print V(IN) I(V_REPLAY) V(OUT) I(R_LOAD)
.end
