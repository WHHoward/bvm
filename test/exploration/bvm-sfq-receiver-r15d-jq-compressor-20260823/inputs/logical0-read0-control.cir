* R15-D logical0 + READ=0 control.
.include jjmit.cir
.include bvm_cell.cir
.include r15d_jq_compressor.cir

XBVM1 WL1 BL1 SE1 SL1 BVM
XR15D SL1 R15D

I_WL1 0 WL1 pwl(0p 0 10p 0 11p +100U 20p +100U 21p 0 170p 0)
I_BL1 0 BL1 pwl(0p 0 10p 0 11p +100U 20p +100U 21p 0 170p 0)
I_SE1 0 SE1 pwl(0p 0 170p 0)

.tran 0.0125p 170p
.print P(B_DET|XR15D) V(B_DET|XR15D) I(B_DET|XR15D)
.print P(B_SET|XR15D) V(B_SET|XR15D) I(B_SET|XR15D)
.print P(B_Q|XR15D) V(B_Q|XR15D) I(B_Q|XR15D)
.print V(N_QJ|XR15D) V(N_QB|XR15D)
.print I(L_TX|XR15D) I(L_RET|XR15D) I(L_S|XR15D) I(L_Q|XR15D)
.print I(I_SET|XR15D) I(R_BIAS|XR15D) I(R_IN|XR15D) I(I_DET|XR15D)
.print I(R_Q|XR15D) I(I_Q|XR15D)
.print V(SL1) V(N6|XBVM1) I(L_SL|XBVM1)
.print P(B_JM1|XBVM1) V(B_JM1|XBVM1) P(B_JM2|XBVM1) V(B_JM2|XBVM1)
.print P(B_JS1|XBVM1) V(B_JS1|XBVM1) P(B_JS2|XBVM1) V(B_JS2|XBVM1)
.print I(L_S1|XBVM1) I(L_S2|XBVM1) I(L_S3|XBVM1) I(L_M3|XBVM1)
.print I(I_WL1) I(I_BL1) I(I_SE1)
.end
