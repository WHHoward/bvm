* QB-Q2C logical1-read, scale=0.70, IBIAS=24.5u; frozen canonical replay=C-canonical-logical1-vsl.csv
.include ../jjmit.cir
.include bq_cell.cir
XBQ IN OUT IBIAS BQ
V_REPLAY IN 0 pwl(0p 0 0.012500000000000001p 0 0.025000000000000001p 0 0.037499999999999999p 0 0.050000000000000003p 0 0.0625p 0 0.074999999999999997p 0 0.087500000000000008p 0 0.10000000000000001p 0 0.1125p 0 0.125p 0 0.13749999999999998p 0 0.14999999999999999p 0 0.16249999999999998p 0 0.17500000000000002p 0 0.1875p 0 0.20000000000000001p 0 0.21249999999999999p 0
+ 0.22500000000000001p 0 0.23749999999999999p 0 0.25p 0 0.26250000000000001p 0 0.27499999999999997p 0 0.28749999999999998p 0 0.29999999999999999p 0 0.3125p 0 0.32499999999999996p 0 0.33749999999999997p 0 0.35000000000000003p 0 0.36250000000000004p 0 0.375p 0 0.38750000000000001p 0 0.40000000000000002p 0 0.41250000000000003p 0 0.42499999999999999p 0 0.4375p 0
+ 0.45000000000000001p 0 0.46250000000000002p 0 0.47499999999999998p 0 0.48749999999999999p 0 0.5p 0 0.51249999999999996p 0 0.52500000000000002p 0 0.53749999999999998p 0 0.54999999999999993p 0 0.5625p 0 0.57499999999999996p 0 0.58750000000000002p 0 0.59999999999999998p 0 0.61249999999999993p 0 0.625p 0 0.63749999999999996p 0 0.64999999999999991p 0 0.66249999999999998p 0
+ 0.67499999999999993p 0 0.6875p 0 0.70000000000000007p 0 0.71250000000000002p 0 0.72500000000000009p 0 0.73750000000000004p 0 0.75p 0 0.76250000000000007p 0 0.77500000000000002p 0 0.78749999999999998p 0 0.80000000000000004p 0 0.8125p 0 0.82500000000000007p 0 0.83750000000000002p 0 0.84999999999999998p 0 0.86250000000000004p 0 0.875p 0 0.88749999999999996p 0
+ 0.90000000000000002p 0 0.91249999999999998p 0 0.92500000000000004p 0 0.9375p 0 0.94999999999999996p 0 0.96250000000000002p 0 0.97499999999999998p 0 0.98749999999999993p 0 1p 0 1.0125p 0 1.0249999999999999p 0 1.0374999999999999p 0 1.05p 0 1.0625p 0 1.075p 0 1.0874999999999999p 0 1.0999999999999999p 0 1.1125p 0
+ 1.125p 0 1.1375p 0 1.1499999999999999p 0 1.1624999999999999p 0 1.175p 0 1.1875p 0 1.2p 0 1.2124999999999999p 0 1.2249999999999999p 0 1.2374999999999998p 0 1.25p 0 1.2625p 0 1.2749999999999999p 0 1.2874999999999999p 0 1.2999999999999998p 0 1.3125p 0 1.325p 0 1.3374999999999999p 0
+ 1.3499999999999999p 0 1.3624999999999998p 0 1.375p 0 1.3875000000000002p 0 1.4000000000000001p 0 1.4125000000000001p 0 1.425p 0 1.4375p 0 1.4500000000000002p 0 1.4625000000000001p 0 1.4750000000000001p 0 1.4875p 0 1.5p 0 1.5125000000000002p 0 1.5250000000000001p 0 1.5375000000000001p 0 1.55p 0 1.5625p 0
+ 1.575p 0 1.5875000000000001p 0 1.6000000000000001p 0 1.6125p 0 1.625p 0 1.6375p 0 1.6500000000000001p 0 1.6625000000000001p 0 1.675p 0 1.6875p 0 1.7p 0 1.7125000000000001p 0 1.7250000000000001p 0 1.7375p 0 1.75p 0 1.7625p 0 1.7749999999999999p 0 1.7875000000000001p 0
+ 1.8p 0 1.8125p 0 1.825p 0 1.8375000000000001p 0 1.8625000000000003p 0 1.875p 0 1.8875000000000002p 0 1.8999999999999999p 0 1.9125000000000001p 0 1.925p 0 1.9375000000000002p 0 1.95p 0 1.9625000000000001p 0 1.9749999999999999p 0 1.9875000000000003p 0 2p 0 2.0125000000000002p 0 2.0249999999999999p 0
+ 2.0375000000000001p 0 2.0499999999999998p 0 2.0625p 0 2.0749999999999997p 0 2.0875000000000004p 0 2.1000000000000001p 0 2.1125000000000003p 0 2.125p 0 2.1375000000000002p 0 2.1499999999999999p 0 2.1625000000000001p 0 2.1749999999999998p 0 2.1875p 0 2.1999999999999997p 0 2.2124999999999999p 0 2.2250000000000001p 0 2.2375000000000003p 0 2.25p 0
+ 2.2625000000000002p 0 2.2749999999999999p 0 2.2875000000000001p 0 2.2999999999999998p 0 2.3125p 0 2.3249999999999997p 0 2.3374999999999999p 0 2.3500000000000001p 0 2.3625000000000003p 0 2.375p 0 2.3875000000000002p 0 2.3999999999999999p 0 2.4125000000000001p 0 2.4249999999999998p 0 2.4375p 0 2.4499999999999997p 0 2.4624999999999999p 0 2.4749999999999996p 0
+ 2.4875000000000003p 0 2.5p 0 2.5125000000000002p 0 2.5249999999999999p 0 2.5375000000000001p 0 2.5499999999999998p 0 2.5625p 0 2.5749999999999997p 0 2.5874999999999999p 0 2.5999999999999996p 0 2.6124999999999998p 0 2.625p 0 2.6375000000000002p 0 2.6499999999999999p 0 2.6625000000000001p 0 2.6749999999999998p 0 2.6875p 0 2.6999999999999997p 0
+ 2.7124999999999999p 0 2.7249999999999996p 0 2.7374999999999998p 0 2.75p 0 2.7625000000000002p 0 2.7750000000000004p 0 2.7875000000000001p 0 2.8000000000000003p 0 2.8125p 0 2.8250000000000002p 0 2.8374999999999999p 0 2.8500000000000001p 0 2.8624999999999998p 0 2.875p 0 2.8875000000000002p 0 2.9000000000000004p 0 2.9125000000000001p 0 2.9250000000000003p 0
+ 2.9375p 0 2.9500000000000002p 0 2.9624999999999999p 0 2.9750000000000001p 0 2.9874999999999998p 0 3p 0 3.0124999999999997p 0 3.0250000000000004p 0 3.0375000000000001p 0 3.0500000000000003p 0 3.0625p 0 3.0750000000000002p 0 3.0874999999999999p 0 3.1000000000000001p 0 3.1124999999999998p 0 3.125p 0 3.1374999999999997p 0 3.1499999999999999p 0
+ 3.1625000000000001p 0 3.1750000000000003p 0 3.1875p 0 3.2000000000000002p 0 3.2124999999999999p 0 3.2250000000000001p 0 3.2374999999999998p 0 3.25p 0 3.2624999999999997p 0 3.2749999999999999p 0 3.2875000000000001p 0 3.3000000000000003p 0 3.3125p 0 3.3250000000000002p 0 3.3374999999999999p 0 3.3500000000000001p 0 3.3624999999999998p 0 3.375p 0
+ 3.3874999999999997p 0 3.3999999999999999p 0 3.4124999999999996p 0 3.4250000000000003p 0 3.4375p 0 3.4500000000000002p 0 3.4624999999999999p 0 3.4750000000000001p 0 3.4874999999999998p 0 3.5p 0 3.5124999999999997p 0 3.5249999999999999p 0 3.5374999999999996p 0 3.5499999999999998p 0 3.5625p 0 3.5750000000000002p 0 3.5874999999999999p 0 3.6000000000000001p 0
+ 3.6124999999999998p 0 3.625p 0 3.6374999999999997p 0 3.6499999999999999p 0 3.6624999999999996p 0 3.6750000000000003p 0 3.6875p 0 3.7000000000000002p 0 3.7124999999999999p 0 3.7250000000000005p 0 3.7375000000000003p 0 3.75p 0 3.7624999999999997p 0 3.7750000000000004p 0 3.7875000000000001p 0 3.7999999999999998p 0 3.8124999999999996p 0 3.8250000000000002p 0
+ 3.8375000000000004p 0 3.8500000000000001p 0 3.8624999999999998p 0 3.8750000000000004p 0 3.8875000000000002p 0 3.8999999999999999p 0 3.9124999999999996p 0 3.9250000000000003p 0 3.9375p 0 3.9499999999999997p 0 3.9624999999999999p 0 3.9750000000000005p 0 3.9875000000000003p 0 4p 0 4.0124999999999993p 0 4.0250000000000004p 0 4.0375000000000005p 0 4.0499999999999998p 0
+ 4.0625p 0 4.0750000000000002p 0 4.0875000000000004p 0 4.0999999999999996p 0 4.1124999999999998p 0 4.125p 0 4.1375000000000002p 0 4.1499999999999995p 0 4.1624999999999996p 0 4.1750000000000007p 0 4.1875p 0 4.2000000000000002p 0 4.2124999999999995p 0 4.2250000000000005p 0 4.2374999999999998p 0 4.25p 0 4.2624999999999993p 0 4.2750000000000004p 0
+ 4.2874999999999996p 0 4.2999999999999998p 0 4.3125p 0 4.3250000000000002p 0 4.3375000000000004p 0 4.3499999999999996p 0 4.3624999999999998p 0 4.375p 0 4.3875000000000002p 0 4.3999999999999995p 0 4.4124999999999996p 0 4.4249999999999998p 0 4.4375p 0 4.4500000000000002p 0 4.4624999999999995p 0 4.4750000000000005p 0 4.4874999999999998p 0 4.5p 0
+ 4.5124999999999993p 0 4.5250000000000004p 0 4.5374999999999996p 0 4.5499999999999998p 0 4.5625p 0 4.5750000000000002p 0 4.5875000000000004p 0 4.5999999999999996p 0 4.6125000000000007p 0 4.625p 0 4.6375000000000002p 0 4.6499999999999995p 0 4.6625000000000005p 0 4.6749999999999998p 0 4.6875p 0 4.7000000000000002p 0 4.7125000000000004p 0 4.7250000000000005p 0
+ 4.7374999999999998p 0 4.75p 0 4.7625000000000002p 0 4.7750000000000004p 0 4.7874999999999996p 0 4.7999999999999998p 0 4.8125p 0 4.8250000000000002p 0 4.8375000000000004p 0 4.8499999999999996p 0 4.8625000000000007p 0 4.875p 0 4.8875000000000002p 0 4.8999999999999995p 0 4.9125000000000005p 0 4.9249999999999998p 0 4.9375p 0 4.9499999999999993p 0
+ 4.9625000000000004p 0 4.9750000000000005p 0 4.9874999999999998p 0 5p 0 5.0125000000000002p 0 5.0250000000000004p 0 5.0374999999999996p 0 5.0499999999999998p 0 5.0625p 0 5.0750000000000002p 0 5.0874999999999995p 0 5.0999999999999996p 0 5.1125000000000007p 0 5.125p 0 5.1375000000000002p 0 5.1499999999999995p 0 5.1625000000000005p 0 5.1749999999999998p 0
+ 5.1875p 0 5.1999999999999993p 0 5.2125000000000004p 0 5.2249999999999996p 0 5.2374999999999998p 0 5.25p 0 5.2625000000000002p 0 5.2750000000000004p 0 5.2874999999999996p 0 5.2999999999999998p 0 5.3125p 0 5.3250000000000002p 0 5.3374999999999995p 0 5.3499999999999996p 0 5.3624999999999998p 0 5.375p 0 5.3875000000000002p 0 5.3999999999999995p 0
+ 5.4125000000000005p 0 5.4249999999999998p 0 5.4375p 0 5.4499999999999993p 0 5.4625000000000004p 0 5.4749999999999996p 0 5.4874999999999998p 0 5.5p 0 5.5125000000000002p 0 5.5250000000000004p 0 5.5374999999999996p 0 5.5500000000000007p 0 5.5625p 0 5.5750000000000002p 0 5.5874999999999995p 0 5.6000000000000005p 0 5.6124999999999998p 0 5.625p 0
+ 5.6375000000000002p 0 5.6500000000000004p 0 5.6625000000000005p 0 5.6749999999999998p 0 5.6875p 0 5.7000000000000002p 0 5.7125000000000004p 0 5.7249999999999996p 0 5.7374999999999998p 0 5.75p 0 5.7625000000000002p 0 5.7750000000000004p 0 5.7874999999999996p 0 5.8000000000000007p 0 5.8125p 0 5.8250000000000002p 0 5.8374999999999995p 0 5.8500000000000005p 0
+ 5.8624999999999998p 0 5.875p 0 5.8874999999999993p 0 5.9000000000000004p 0 5.9125000000000005p 0 5.9249999999999998p 0 5.9375p 0 5.9500000000000002p 0 5.9625000000000004p 0 5.9749999999999996p 0 5.9874999999999998p 0 6p 0 6.0125000000000002p 0 6.0249999999999995p 0 6.0374999999999996p 0 6.0500000000000007p 0 6.0625p 0 6.0750000000000002p 0
+ 6.0874999999999995p 0 6.1000000000000005p 0 6.1124999999999998p 0 6.125p 0 6.1374999999999993p 0 6.1500000000000004p 0 6.1624999999999996p 0 6.1749999999999998p 0 6.1875p 0 6.2000000000000002p 0 6.2125000000000004p 0 6.2249999999999996p 0 6.2374999999999998p 0 6.25p 0 6.2625000000000002p 0 6.2749999999999995p 0 6.2874999999999996p 0 6.2999999999999998p 0
+ 6.3125p 0 6.3250000000000002p 0 6.3374999999999995p 0 6.3500000000000005p 0 6.3624999999999998p 0 6.375p 0 6.3875000000000002p 0 6.4000000000000004p 0 6.4124999999999996p 0 6.4249999999999998p 0 6.4375p 0 6.4500000000000002p 0 6.4625000000000004p 0 6.4749999999999996p 0 6.4875000000000007p 0 6.5p 0 6.5125000000000002p 0 6.5249999999999995p 0
+ 6.5375000000000005p 0 6.5499999999999998p 0 6.5625p 0 6.5750000000000002p 0 6.5875000000000004p 0 6.6000000000000005p 0 6.6124999999999998p 0 6.625p 0 6.6375000000000002p 0 6.6500000000000004p 0 6.6624999999999996p 0 6.6749999999999998p 0 6.6875p 0 6.7000000000000002p 0 6.7125000000000004p 0 6.7249999999999996p 0 6.7375000000000007p 0 6.75p 0
+ 6.7625000000000002p 0 6.7749999999999995p 0 6.7875000000000005p 0 6.7999999999999998p 0 6.8125p 0 6.8249999999999993p 0 6.8375000000000004p 0 6.8500000000000005p 0 6.8624999999999998p 0 6.875p 0 6.8875000000000002p 0 6.9000000000000004p 0 6.9124999999999996p 0 6.9249999999999998p 0 6.9375p 0 6.9500000000000002p 0 6.9624999999999995p 0 6.9749999999999996p 0
+ 6.9874999999999998p 0 7p 0 7.0125000000000002p 0 7.0249999999999995p 0 7.0375000000000005p 0 7.0499999999999998p 0 7.0625p 0 7.0749999999999993p 0 7.0875000000000004p 0 7.0999999999999996p 0 7.1124999999999998p 0 7.125p 0 7.1375000000000002p 0 7.1500000000000004p 0 7.1624999999999996p 0 7.1749999999999998p 0 7.1875p 0 7.2000000000000002p 0
+ 7.2124999999999995p 0 7.2249999999999996p 0 7.2374999999999998p 0 7.25p 0 7.2625000000000002p 0 7.2749999999999995p 0 7.2874999999999996p 0 7.2999999999999998p 0 7.3125000000000009p 0 7.3249999999999993p 0 7.3375000000000004p 0 7.3500000000000005p 0 7.3624999999999998p 0 7.375p 0 7.3874999999999993p 0 7.4000000000000004p 0 7.4125000000000005p 0 7.4249999999999998p 0
+ 7.4375p 0 7.4500000000000011p 0 7.4624999999999995p 0 7.4750000000000005p 0 7.4874999999999989p 0 7.5p 0 7.5125000000000002p 0 7.5249999999999995p 0 7.5375000000000005p 0 7.5500000000000007p 0 7.5625p 0 7.5750000000000002p 0 7.5874999999999995p 0 7.5999999999999996p 0 7.6125000000000007p 0 7.6249999999999991p 0 7.6375000000000002p 0 7.6500000000000004p 0
+ 7.6624999999999996p 0 7.6750000000000007p 0 7.6874999999999991p 0 7.7000000000000002p 0 7.7125000000000004p 0 7.7249999999999996p 0 7.7374999999999998p 0 7.7500000000000009p 0 7.7624999999999993p 0 7.7750000000000004p 0 7.7874999999999996p 0 7.7999999999999998p 0 7.8125000000000009p 0 7.8249999999999993p 0 7.8375000000000004p 0 7.8500000000000005p 0 7.8624999999999998p 0 7.875p 0
+ 7.8874999999999993p 0 7.8999999999999995p 0 7.9125000000000005p 0 7.9249999999999998p 0 7.9375p 0 7.9500000000000011p 0 7.9624999999999995p 0 7.9750000000000005p 0 7.9874999999999989p 0 8p 0 8.0125000000000011p 0 8.0249999999999986p 0 8.0374999999999996p 0 8.0500000000000007p 0 8.0625p 0 8.0750000000000011p 0 8.0874999999999986p 0 8.0999999999999996p 0
+ 8.1125000000000007p 0 8.125p 0 8.1374999999999993p 0 8.1500000000000004p 0 8.1624999999999996p 0 8.1750000000000007p 0 8.1875p 0 8.1999999999999993p 0 8.2125000000000004p 0 8.2249999999999996p 0 8.2375000000000007p 0 8.25p 0 8.2624999999999993p 0 8.2750000000000004p 0 8.2875000000000014p 0 8.2999999999999989p 0 8.3125p 0 8.3249999999999993p 0
+ 8.3375000000000004p 0 8.3500000000000014p 0 8.3624999999999989p 0 8.375p 0 8.3875000000000011p 0 8.4000000000000004p 0 8.4124999999999996p 0 8.4249999999999989p 0 8.4375p 0 8.4500000000000011p 0 8.4625000000000004p 0 8.4749999999999996p 0 8.4875000000000007p 0 8.5p 0 8.5125000000000011p 0 8.5249999999999986p 0 8.5374999999999996p 0 8.5500000000000007p 0
+ 8.5625p 0 8.5749999999999993p 0 8.5875000000000004p 0 8.5999999999999996p 0 8.6125000000000007p 0 8.625p 0 8.6374999999999993p 0 8.6500000000000004p 0 8.6624999999999996p 0 8.6750000000000007p 0 8.6875p 0 8.6999999999999993p 0 8.7125000000000004p 0 8.7249999999999996p 0 8.7375000000000007p 0 8.75p 0 8.7624999999999993p 0 8.7750000000000004p 0
+ 8.7875000000000014p 0 8.7999999999999989p 0 8.8125p 0 8.8249999999999993p 0 8.8375000000000004p 0 8.8499999999999996p 0 8.8624999999999989p 0 8.875p 0 8.8875000000000011p 0 8.9000000000000004p 0 8.9124999999999996p 0 8.9249999999999989p 0 8.9375p 0 8.9500000000000011p 0 8.9624999999999986p 0 8.9749999999999996p 0 8.9875000000000007p 0 9p 0
+ 9.0125000000000011p 0 9.0249999999999986p 0 9.0374999999999996p 0 9.0500000000000007p 0 9.0625p 0 9.0749999999999993p 0 9.0875000000000004p 0 9.0999999999999996p 0 9.1125000000000007p 0 9.125p 0 9.1374999999999993p 0 9.1500000000000004p 0 9.1624999999999996p 0 9.1750000000000007p 0 9.1875p 0 9.1999999999999993p 0 9.2125000000000004p 0 9.2250000000000014p 0
+ 9.2374999999999989p 0 9.25p 0 9.2624999999999993p 0 9.2750000000000004p 0 9.2875000000000014p 0 9.2999999999999989p 0 9.3125p 0 9.3250000000000011p 0 9.3375000000000004p 0 9.3499999999999996p 0 9.3624999999999989p 0 9.375p 0 9.3875000000000011p 0 9.4000000000000004p 0 9.4124999999999996p 0 9.4250000000000007p 0 9.4375p 0 9.4500000000000011p 0
+ 9.4624999999999986p 0 9.4749999999999996p 0 9.4875000000000007p 0 9.5p 0 9.5124999999999993p 0 9.5250000000000004p 0 9.5374999999999996p 0 9.5500000000000007p 0 9.5625p 0 9.5749999999999993p 0 9.5875000000000004p 0 9.5999999999999996p 0 9.6125000000000007p 0 9.625p 0 9.6374999999999993p 0 9.6500000000000004p 0 9.6624999999999996p 0 9.6750000000000007p 0
+ 9.6875p 0 9.6999999999999993p 0 9.7125000000000004p 0 9.7250000000000014p 0 9.7374999999999989p 0 9.75p 0 9.7624999999999993p 0 9.7750000000000004p 0 9.7874999999999996p 0 9.7999999999999989p 0 9.8125p 0 9.8250000000000011p 0 9.8375000000000004p 0 9.8499999999999996p 0 9.8624999999999989p 0 9.875p 0 9.8875000000000011p 0 9.8999999999999986p 0
+ 9.9124999999999996p 0 9.9250000000000007p 0 9.9375p 0 9.9500000000000011p 0 9.9624999999999986p 0 9.9749999999999996p 0 9.9875000000000007p 0 10p 5.8258119999999998e-19 10.012499999999999p 4.5075039999999997e-06 10.025p 8.4256019999999999e-06 10.0375p 1.17876e-05 10.050000000000001p 1.4662939999999999e-05 10.0625p 1.7125450000000001e-05 10.074999999999999p 1.9243289999999999e-05 10.0875p 2.107645e-05 10.1p 2.2676699999999999e-05 10.112500000000001p 2.4088359999999999e-05 10.125p 2.5349209999999998e-05
+ 10.137499999999999p 2.6491349999999998e-05 10.15p 2.7542040000000001e-05 10.162500000000001p 2.8524310000000001e-05 10.174999999999999p 2.9457629999999999e-05 10.1875p 3.0358369999999998e-05 10.199999999999999p 3.1240230000000002e-05 10.2125p 3.2114650000000003e-05 10.225000000000001p 3.2991119999999998e-05 10.237499999999999p 3.3877429999999997e-05 10.25p 3.4779929999999998e-05 10.262500000000001p 3.5703729999999997e-05 10.275p 3.665286e-05 10.2875p 3.7630440000000001e-05 10.299999999999999p 3.86388e-05 10.3125p 3.9679560000000003e-05 10.325000000000001p 4.0753780000000001e-05 10.3375p 4.1861989999999999e-05 10.35p 4.3004289999999997e-05
+ 10.362500000000001p 4.4180420000000003e-05 10.375p 4.5389760000000001e-05 10.387500000000001p 4.6631439999999998e-05 10.399999999999999p 4.7904339999999997e-05 10.4125p 4.9207130000000001e-05 10.425000000000001p 5.0538290000000003e-05 10.4375p 5.1896169999999997e-05 10.449999999999999p 5.3279000000000003e-05 10.4625p 5.4684859999999999e-05 10.475p 5.6111769999999998e-05 10.487500000000001p 5.7557679999999998e-05 10.5p 5.9020439999999998e-05 10.512499999999999p 6.0497890000000002e-05 10.525p 6.1987810000000004e-05 10.5375p 6.3487949999999996e-05 10.550000000000001p 6.4996050000000003e-05 10.5625p 6.6509819999999999e-05 10.574999999999999p 6.8026980000000003e-05
+ 10.5875p 6.9545240000000002e-05 10.6p 7.106232e-05 10.612500000000001p 7.2575960000000002e-05 10.625p 7.4083909999999998e-05 10.637499999999999p 7.5583949999999997e-05 10.65p 7.7073870000000005e-05 10.662500000000001p 7.8551519999999996e-05 10.674999999999999p 8.0014759999999996e-05 10.6875p 8.1461510000000007e-05 10.699999999999999p 8.2889709999999994e-05 10.7125p 8.4297369999999995e-05 10.725p 8.5682539999999994e-05 10.737499999999999p 8.7043319999999995e-05 10.75p 8.8377860000000004e-05 10.762500000000001p 8.9684390000000004e-05 10.775p 9.0961179999999998e-05 10.7875p 9.2206570000000004e-05 10.799999999999999p 9.3418970000000006e-05
+ 10.8125p 9.4596850000000006e-05 10.825000000000001p 9.5738759999999996e-05 10.837499999999999p 9.6843310000000002e-05 10.85p 9.790919e-05 10.862500000000001p 9.8935149999999998e-05 10.875p 9.9920049999999996e-05 10.887500000000001p 0.0001008628 10.899999999999999p 0.00010176240000000001 10.9125p 0.0001026178 10.925000000000001p 0.0001034284 10.9375p 0.0001041932 10.949999999999999p 0.00010491169999999999 10.9625p 0.0001055831 10.975p 0.0001062071 10.987500000000001p 0.0001067831 11p 0.0001073107 11.012499999999999p 0.0001032823 11.025p 9.9794499999999995e-05
+ 11.0375p 9.6813880000000004e-05 11.050000000000001p 9.4270990000000005e-05 11.0625p 9.2092040000000001e-05 11.074999999999999p 9.0208990000000002e-05 11.0875p 8.856205e-05 11.100000000000001p 8.7099729999999998e-05 11.112499999999999p 8.5778049999999994e-05 11.125p 8.4559669999999994e-05 11.137499999999999p 8.3412960000000006e-05 11.15p 8.2311229999999994e-05 11.162500000000001p 8.1232080000000003e-05 11.174999999999999p 8.0156730000000007e-05 11.1875p 7.9069579999999998e-05 11.200000000000001p 7.7957729999999996e-05 11.2125p 7.6810619999999994e-05 11.225p 7.5619700000000004e-05 11.237499999999999p 7.4378149999999995e-05 11.25p 7.3080670000000004e-05
+ 11.262500000000001p 7.1723229999999993e-05 11.275p 7.0302910000000001e-05 11.2875p 6.8817800000000004e-05 11.300000000000001p 6.7266770000000002e-05 11.3125p 6.5649449999999999e-05 11.325000000000001p 6.3966079999999996e-05 11.337499999999999p 6.2217439999999994e-05 11.35p 6.0404800000000001e-05 11.362500000000001p 5.8529809999999997e-05 11.375p 5.6594490000000001e-05 11.387499999999999p 5.4601149999999998e-05 11.4p 5.255238e-05 11.4125p 5.0450980000000001e-05 11.425000000000001p 4.8299949999999998e-05 11.4375p 4.610248e-05 11.449999999999999p 4.3861859999999998e-05 11.4625p 4.1581520000000003e-05 11.475p 3.9265019999999999e-05
+ 11.487500000000001p 3.6915960000000001e-05 11.5p 3.4538020000000002e-05 11.512499999999999p 3.213496e-05 11.525p 2.971056e-05 11.5375p 2.726862e-05 11.550000000000001p 2.4813000000000001e-05 11.5625p 2.234752e-05 11.574999999999999p 1.987604e-05 11.5875p 1.7402400000000001e-05 11.600000000000001p 1.4930430000000001e-05 11.612499999999999p 1.246394e-05 11.625p 1.0006709999999999e-05 11.637499999999999p 7.5624730000000003e-06 11.65p 5.1349499999999999e-06 11.6625p 2.7277979999999999e-06 11.674999999999999p 3.4462939999999998e-07 11.6875p -2.0109990000000001e-06 11.700000000000001p -4.335591e-06
+ 11.7125p -6.6257150000000001e-06 11.725p -8.8780080000000006e-06 11.737499999999999p -1.1089180000000001e-05 11.75p -1.325602e-05 11.762500000000001p -1.5375409999999999e-05 11.774999999999999p -1.744428e-05 11.7875p -1.9459699999999999e-05 11.800000000000001p -2.1418780000000001e-05 11.8125p -2.331878e-05 11.825000000000001p -2.5157020000000001e-05 11.8375p -2.6930920000000001e-05 11.85p -2.8638039999999999e-05 11.862500000000001p -3.0276020000000001e-05 11.875p -3.184261e-05 11.887499999999999p -3.3335689999999999e-05 11.9p -3.4753250000000001e-05 11.9125p -3.6093390000000002e-05 11.925000000000001p -3.7354329999999998e-05
+ 11.9375p -3.8534429999999997e-05 11.949999999999999p -3.963216e-05 11.9625p -4.0646119999999998e-05 11.975p -4.1575039999999997e-05 11.987500000000001p -4.2417769999999997e-05 12p -4.3173300000000002e-05 12.012499999999999p -4.3840759999999999e-05 12.025p -4.4419390000000003e-05 12.037500000000001p -4.4908569999999997e-05 12.049999999999999p -4.5307840000000003e-05 12.0625p -4.5616840000000003e-05 12.074999999999999p -4.5835360000000002e-05 12.0875p -4.5963330000000003e-05 12.100000000000001p -4.6000800000000002e-05 12.112499999999999p -4.594798e-05 12.125p -4.5805169999999998e-05 12.137500000000001p -4.5572860000000003e-05 12.15p -4.525162e-05
+ 12.1625p -4.4842190000000002e-05 12.174999999999999p -4.4345409999999998e-05 12.1875p -4.3762269999999997e-05 12.200000000000001p -4.3093870000000002e-05 12.2125p -4.2341459999999998e-05 12.225p -4.1506379999999998e-05 12.237500000000001p -4.0590109999999997e-05 12.25p -3.9594249999999998e-05 12.262500000000001p -3.8520509999999999e-05 12.274999999999999p -3.7370709999999998e-05 12.2875p -3.6146780000000003e-05 12.300000000000001p -3.4850759999999999e-05 12.3125p -3.3484790000000001e-05 12.324999999999999p -3.2051129999999998e-05 12.3375p -3.0552100000000002e-05 12.35p -2.8990130000000001e-05 12.362500000000001p -2.7367749999999999e-05 12.375p -2.5687559999999998e-05
+ 12.387499999999999p -2.3952250000000001e-05 12.4p -2.216458e-05 12.4125p -2.032738e-05 12.425000000000001p -1.8443550000000001e-05 12.4375p -1.6516049999999999e-05 12.449999999999999p -1.4547910000000001e-05 12.4625p -1.2542210000000001e-05 12.475p -1.050206e-05 12.487500000000001p -8.430645e-06 12.5p -6.3311609999999996e-06 12.512499999999999p -4.2068530000000001e-06 12.525p -2.060992e-06 12.537500000000001p 1.0312649999999999e-07 12.549999999999999p 2.2821889999999998e-06 12.5625p 4.4728669999999997e-06 12.574999999999999p 6.6718229999999998e-06 12.5875p 8.8757170000000003e-06 12.6p 1.1081210000000001e-05
+ 12.612499999999999p 1.328496e-05 12.625p 1.5483659999999999e-05 12.637500000000001p 1.767399e-05 12.65p 1.9852669999999998e-05 12.6625p 2.2016440000000001e-05 12.674999999999999p 2.4162070000000002e-05 12.6875p 2.6286370000000001e-05 12.700000000000001p 2.8386180000000001e-05 12.712499999999999p 3.04584e-05 12.725p 3.2499970000000002e-05 12.737500000000001p 3.4507880000000001e-05 12.75p 3.6479190000000001e-05 12.762500000000001p 3.8411010000000003e-05 12.775p 4.030052e-05 12.7875p 4.2144980000000003e-05 12.800000000000001p 4.394171e-05 12.8125p 4.5688110000000001e-05 12.824999999999999p 4.7381679999999999e-05
+ 12.8375p 4.901998e-05 12.85p 5.0600670000000003e-05 12.862500000000001p 5.2121499999999999e-05 12.875p 5.3580320000000001e-05 12.887499999999999p 5.4975059999999999e-05 12.9p 5.6303769999999999e-05 12.9125p 5.756458e-05 12.925000000000001p 5.8755760000000001e-05 12.9375p 5.9875640000000003e-05 12.949999999999999p 6.0922699999999999e-05 12.9625p 6.1895499999999997e-05 12.975000000000001p 6.2792720000000001e-05 12.987499999999999p 6.361316e-05 13p 6.435573e-05 13.012499999999999p 6.501946e-05 13.025p 6.5603479999999995e-05 13.037500000000001p 6.6107039999999999e-05 13.049999999999999p 6.6529519999999995e-05
+ 13.0625p 6.6870400000000003e-05 13.075000000000001p 6.7129289999999994e-05 13.0875p 6.7305910000000003e-05 13.1p 6.7400100000000005e-05 13.112499999999999p 6.7411789999999997e-05 13.125p 6.7341059999999995e-05 13.137500000000001p 6.7188090000000001e-05 13.15p 6.6953160000000005e-05 13.1625p 6.6636679999999997e-05 13.175000000000001p 6.6239159999999998e-05 13.1875p 6.5761209999999997e-05 13.200000000000001p 6.5203550000000004e-05 13.212499999999999p 6.4567029999999996e-05 13.225p 6.3852559999999996e-05 13.237500000000001p 6.3061179999999997e-05 13.25p 6.2194019999999996e-05 13.262499999999999p 6.1252299999999996e-05 13.275p 6.0237340000000003e-05
+ 13.2875p 5.9150549999999999e-05 13.300000000000001p 5.7993420000000001e-05 13.3125p 5.6767549999999998e-05 13.324999999999999p 5.5474579999999998e-05 13.3375p 5.4116259999999999e-05 13.35p 5.2694420000000003e-05 13.362500000000001p 5.1210949999999998e-05 13.375p 4.966781e-05 13.387499999999999p 4.8067040000000002e-05 13.4p 4.6410730000000001e-05 13.4125p 4.4701040000000001e-05 13.425000000000001p 4.2940199999999999e-05 13.4375p 4.1130459999999999e-05 13.449999999999999p 3.9274150000000001e-05 13.4625p 3.7373660000000002e-05 13.475000000000001p 3.543138e-05 13.487499999999999p 3.3449799999999999e-05 13.5p 3.1431399999999999e-05
+ 13.512499999999999p 2.9378719999999998e-05 13.525p 2.7294329999999999e-05 13.5375p 2.518083e-05 13.549999999999999p 2.3040850000000001e-05 13.5625p 2.0877029999999999e-05 13.575000000000001p 1.8692039999999999e-05 13.5875p 1.6488560000000001e-05 13.6p 1.4269300000000001e-05 13.612499999999999p 1.203697e-05 13.625p 9.7942910000000008e-06 13.637500000000001p 7.5439769999999997e-06 13.649999999999999p 5.2887580000000002e-06 13.6625p 3.0313609999999999e-06 13.675000000000001p 7.7450429999999999e-07 13.6875p -1.4790970000000001e-06 13.700000000000001p -3.7267389999999998e-06 13.7125p -5.9657310000000001e-06 13.725p -8.1933970000000003e-06
+ 13.737500000000001p -1.0407079999999999e-05 13.75p -1.260414e-05 13.762499999999999p -1.478197e-05 13.775p -1.6937980000000001e-05 13.7875p -1.9069619999999999e-05 13.800000000000001p -2.117437e-05 13.8125p -2.324972e-05 13.824999999999999p -2.529324e-05 13.8375p -2.7302509999999999e-05 13.85p -2.9275169999999998e-05 13.862500000000001p -3.1208889999999998e-05 13.875p -3.3101390000000001e-05 13.887499999999999p -3.4950460000000001e-05 13.9p -3.6753920000000002e-05 13.912500000000001p -3.8509649999999998e-05 13.924999999999999p -4.0215610000000002e-05 13.9375p -4.1869780000000002e-05 13.949999999999999p -4.3470239999999999e-05
+ 13.9625p -4.5015119999999997e-05 13.975p -4.6502609999999998e-05 13.987499999999999p -4.7930979999999998e-05 14p -4.929856e-05 14.012500000000001p -5.0603779999999997e-05 14.025p -5.1845100000000003e-05 14.0375p -5.302111e-05 14.049999999999999p -5.4130440000000002e-05 14.0625p -5.5171820000000001e-05 14.075000000000001p -5.6144039999999999e-05 14.0875p -5.7046019999999997e-05 14.1p -5.7876710000000002e-05 14.112500000000001p -5.8635180000000003e-05 14.125p -5.9320600000000003e-05 14.137500000000001p -5.9932190000000001e-05 14.149999999999999p -6.046929e-05 14.1625p -6.093134e-05 14.175000000000001p -6.131783e-05
+ 14.1875p -6.162839e-05 14.199999999999999p -6.1862719999999994e-05 14.2125p -6.2020619999999995e-05 14.225p -6.2101979999999995e-05 14.237500000000001p -6.2106790000000006e-05 14.25p -6.2035139999999994e-05 14.262499999999999p -6.188721e-05 14.275p -6.166326e-05 14.2875p -6.1363689999999996e-05 14.300000000000001p -6.0988929999999997e-05 14.3125p -6.0539569999999997e-05 14.324999999999999p -6.0016239999999999e-05 14.3375p -5.9419690000000002e-05 14.35p -5.8750750000000003e-05 14.362500000000001p -5.8010349999999999e-05 14.375p -5.71995e-05 14.387499999999999p -5.6319310000000002e-05 14.4p -5.537096e-05
+ 14.412500000000001p -5.435572e-05 14.424999999999999p -5.3274949999999997e-05 14.4375p -5.2130080000000003e-05 14.449999999999999p -5.092261e-05 14.4625p -4.965415e-05 14.475p -4.8326350000000002e-05 14.487499999999999p -4.694095e-05 14.5p -4.5499749999999997e-05 14.512500000000001p -4.4004619999999997e-05 14.525p -4.2457499999999998e-05 14.5375p -4.0860369999999997e-05 14.549999999999999p -3.9215290000000003e-05 14.562500000000002p -3.7524370000000001e-05 14.574999999999999p -3.5789769999999999e-05 14.587499999999999p -3.4013700000000003e-05 14.6p -3.21984e-05 14.612500000000001p -3.034618e-05 14.625000000000002p -2.8459369999999999e-05
+ 14.637499999999999p -2.654034e-05 14.649999999999999p -2.45915e-05 14.6625p -2.2615279999999999e-05 14.675000000000001p -2.0614139999999999e-05 14.687500000000002p -1.8590559999999998e-05 14.700000000000001p -1.6547030000000001e-05 14.712499999999999p -1.448607e-05 14.725p -1.24102e-05 14.737500000000001p -1.0321959999999999e-05 14.75p -8.2238889999999992e-06 14.762500000000001p -6.1185160000000004e-06 14.774999999999999p -4.0083810000000001e-06 14.7875p -1.896011e-06 14.800000000000001p 2.160744e-07 14.8125p 2.325369e-06 14.825000000000001p 4.4293839999999999e-06 14.837499999999999p 6.5256489999999997e-06 14.85p 8.6117200000000006e-06
+ 14.862499999999999p 1.0685179999999999e-05 14.875p 1.274363e-05 14.887500000000001p 1.4784720000000001e-05 14.900000000000002p 1.680613e-05 14.9125p 1.880557e-05 14.924999999999999p 2.078081e-05 14.9375p 2.2729660000000001e-05 14.950000000000001p 2.464996e-05 14.962500000000002p 2.6539630000000001e-05 14.974999999999998p 2.8396609999999999e-05 14.987499999999999p 3.0218920000000001e-05 15p 3.2004639999999998e-05 15.012500000000001p 3.3751880000000003e-05 15.025p 3.5458859999999997e-05 15.037499999999998p 3.712382e-05 15.049999999999999p 3.8745100000000003e-05 15.0625p 4.0321080000000001e-05 15.075000000000001p 4.1850230000000003e-05
+ 15.0875p 4.3331100000000003e-05 15.100000000000001p 4.4762299999999997e-05 15.112499999999999p 4.6142500000000001e-05 15.125p 4.7470479999999998e-05 15.137499999999999p 4.8745080000000001e-05 15.15p 4.9965220000000002e-05 15.162500000000001p 5.11299e-05 15.174999999999999p 5.2238209999999998e-05 15.1875p 5.3289299999999998e-05 15.199999999999999p 5.4282430000000003e-05 15.2125p 5.5216919999999998e-05 15.225000000000001p 5.6092189999999997e-05 15.237499999999999p 5.6907719999999999e-05 15.249999999999998p 5.76631e-05 15.262499999999999p 5.8357989999999999e-05 15.275p 5.8992140000000003e-05 15.287500000000001p 5.9565360000000001e-05 15.300000000000001p 6.007757e-05
+ 15.312499999999998p 6.0528759999999999e-05 15.324999999999999p 6.0919009999999998e-05 15.3375p 6.1248449999999998e-05 15.350000000000001p 6.1517329999999997e-05 15.362500000000001p 6.1725959999999995e-05 15.374999999999998p 6.1874719999999994e-05 15.387499999999999p 6.1964069999999996e-05 15.4p 6.1994560000000002e-05 15.4125p 6.1966789999999997e-05 15.425000000000001p 6.1881460000000004e-05 15.437499999999998p 6.1739299999999993e-05 15.449999999999999p 6.1541149999999996e-05 15.4625p 6.1287890000000006e-05 15.475p 6.0980480000000002e-05 15.487500000000001p 6.0619930000000001e-05 15.500000000000002p 6.0207329999999997e-05 15.512499999999999p 5.9743810000000003e-05 15.524999999999999p 5.9230559999999999e-05
+ 15.5375p 5.866885e-05 15.550000000000001p 5.8059970000000001e-05 15.562500000000002p 5.7405260000000001e-05 15.574999999999999p 5.6706149999999999e-05 15.587499999999999p 5.596407e-05 15.6p 5.5180519999999999e-05 15.612500000000001p 5.4357020000000003e-05 15.625000000000002p 5.349516e-05 15.637500000000001p 5.259654e-05 15.649999999999999p 5.1662800000000003e-05 15.6625p 5.0695609999999997e-05 15.675000000000001p 4.9696690000000001e-05 15.6875p 4.8667759999999999e-05 15.700000000000001p 4.7610569999999999e-05 15.712499999999999p 4.6526909999999997e-05 15.725p 4.5418560000000003e-05 15.737500000000001p 4.4287350000000002e-05 15.75p 4.3135089999999999e-05
+ 15.762500000000001p 4.1963620000000001e-05 15.774999999999999p 4.0774800000000001e-05 15.7875p 3.9570480000000002e-05 15.799999999999999p 3.8352519999999997e-05 15.8125p 3.7122770000000001e-05 15.825000000000001p 3.5883110000000003e-05 15.837500000000002p 3.4635390000000003e-05 15.85p 3.3381460000000003e-05 15.862499999999999p 3.2123170000000002e-05 15.875p 3.0862360000000002e-05 15.887500000000001p 2.960086e-05 15.900000000000002p 2.8340460000000001e-05 15.912499999999998p 2.7082969999999999e-05 15.924999999999999p 2.583017e-05 15.9375p 2.45838e-05 15.950000000000001p 2.3345599999999999e-05 15.9625p 2.211727e-05 15.974999999999998p 2.090049e-05
+ 15.987499999999999p 1.9696919999999999e-05 16p 1.8508170000000001e-05 16.012499999999999p 1.7335819999999999e-05 16.025000000000002p 1.6181419999999999e-05 16.037500000000001p 1.504649e-05 16.049999999999997p 1.3932499999999999e-05 16.0625p 1.2840870000000001e-05 16.074999999999999p 1.177301e-05 16.087500000000002p 1.073024e-05 16.100000000000001p 9.7138789999999995e-06 16.112499999999997p 8.7251659999999994e-06 16.125p 7.7653039999999993e-06 16.137499999999999p 6.8354410000000003e-06 16.150000000000002p 5.9366769999999998e-06 16.162500000000001p 5.0700529999999997e-06 16.174999999999997p 4.2365580000000003e-06 16.1875p 3.4371250000000001e-06 16.199999999999999p 2.6726270000000002e-06
+ 16.212499999999999p 1.9438809999999998e-06 16.225000000000001p 1.2516429999999999e-06 16.237500000000001p 5.9660890000000003e-07 16.25p -2.058708e-08 16.262499999999999p -5.9937189999999996e-07 16.274999999999999p -1.139236e-06 16.287500000000001p -1.639731e-06 16.300000000000001p -2.1004740000000002e-06 16.3125p -2.5211459999999999e-06 16.324999999999999p -2.9014899999999998e-06 16.337499999999999p -3.2413140000000002e-06 16.350000000000001p -3.54049e-06 16.362500000000001p -3.798954e-06 16.375p -4.0167040000000001e-06 16.387499999999999p -4.1938039999999997e-06 16.399999999999999p -4.3303760000000003e-06 16.412500000000001p -4.4266080000000003e-06 16.425000000000001p -4.4827479999999999e-06
+ 16.4375p -4.4991020000000003e-06 16.449999999999999p -4.4760370000000004e-06 16.462499999999999p -4.4139799999999999e-06 16.475000000000001p -4.3134120000000004e-06 16.487500000000001p -4.1748710000000003e-06 16.5p -3.9989479999999996e-06 16.512499999999999p -3.786291e-06 16.524999999999999p -3.5375949999999999e-06 16.537500000000001p -3.2536059999999998e-06 16.550000000000001p -2.935121e-06 16.5625p -2.5829790000000001e-06 16.575000000000003p -2.1980680000000001e-06 16.587499999999999p -1.781316e-06 16.599999999999998p -1.3336940000000001e-06 16.612500000000001p -8.5621129999999997e-07 16.625p -3.4991570000000002e-07 16.637500000000003p 1.8411039999999999e-07 16.649999999999999p 7.4475040000000002e-07
+ 16.662499999999998p 1.3308560000000001e-06 16.675000000000001p 1.941249e-06 16.6875p 2.5747230000000001e-06 16.700000000000003p 3.230046e-06 16.712499999999999p 3.9059610000000004e-06 16.724999999999998p 4.601189e-06 16.737500000000001p 5.3144310000000001e-06 16.75p 6.0443690000000003e-06 16.762499999999999p 6.7896689999999998e-06 16.775000000000002p 7.5489790000000001e-06 16.787499999999998p 8.3209379999999992e-06 16.800000000000001p 9.1041720000000001e-06 16.8125p 9.8972950000000006e-06 16.824999999999999p 1.069892e-05 16.837500000000002p 1.1507640000000001e-05 16.849999999999998p 1.232207e-05 16.862500000000001p 1.3140790000000001e-05 16.875p 1.39624e-05
+ 16.887499999999999p 1.4785499999999999e-05 16.900000000000002p 1.5608690000000001e-05 16.912499999999998p 1.6430569999999999e-05 16.925000000000001p 1.7249759999999999e-05 16.9375p 1.8064869999999998e-05 16.949999999999999p 1.887454e-05 16.962500000000002p 1.9677399999999999e-05 16.975000000000001p 2.0472110000000001e-05 16.987499999999997p 2.1257350000000001e-05 17p 2.2031809999999999e-05 17.012499999999999p 2.2794180000000001e-05 17.025000000000002p 2.3543209999999999e-05 17.037500000000001p 2.427765e-05 17.049999999999997p 2.499626e-05 17.0625p 2.5697870000000001e-05 17.074999999999999p 2.638129e-05 17.087500000000002p 2.704539e-05 17.100000000000001p 2.768907e-05
+ 17.112499999999997p 2.8311250000000001e-05 17.125p 2.8910890000000001e-05 17.137499999999999p 2.948699e-05 17.149999999999999p 3.003859e-05 17.162500000000001p 3.056476e-05 17.175000000000001p 3.1064620000000002e-05 17.1875p 3.1537320000000002e-05 17.199999999999999p 3.1982069999999998e-05 17.212499999999999p 3.2398109999999998e-05 17.225000000000001p 3.278473e-05 17.237500000000001p 3.3141269999999999e-05 17.25p 3.3467119999999998e-05 17.262499999999999p 3.3761699999999999e-05 17.274999999999999p 3.4024499999999999e-05 17.287500000000001p 3.425505e-05 17.300000000000001p 3.4452929999999999e-05 17.3125p 3.4617769999999997e-05 17.324999999999999p 3.4749270000000001e-05
+ 17.337499999999999p 3.4847149999999997e-05 17.350000000000001p 3.4911209999999999e-05 17.362500000000001p 3.4941270000000002e-05 17.375p 3.4937239999999998e-05 17.387499999999999p 3.4899060000000003e-05 17.399999999999999p 3.4826719999999998e-05 17.412500000000001p 3.4720259999999997e-05 17.425000000000001p 3.4579799999999997e-05 17.4375p 3.4405459999999998e-05 17.449999999999999p 3.4197460000000003e-05 17.462499999999999p 3.3956040000000001e-05 17.475000000000001p 3.3681499999999999e-05 17.487500000000001p 3.3374190000000002e-05 17.5p 3.3034490000000003e-05 17.512500000000003p 3.2662849999999998e-05 17.524999999999999p 3.2259750000000002e-05 17.537499999999998p 3.1825719999999997e-05 17.550000000000001p 3.1361349999999997e-05
+ 17.5625p 3.0867229999999997e-05 17.575000000000003p 3.0344039999999999e-05 17.587499999999999p 2.979246e-05 17.599999999999998p 2.921324e-05 17.612500000000001p 2.8607139999999999e-05 17.625p 2.7974990000000002e-05 17.637500000000003p 2.7317610000000002e-05 17.649999999999999p 2.663589e-05 17.662499999999998p 2.5930739999999998e-05 17.675000000000001p 2.5203099999999999e-05 17.6875p 2.4453929999999998e-05 17.699999999999999p 2.3684220000000001e-05 17.712500000000002p 2.2895010000000001e-05 17.724999999999998p 2.2087319999999999e-05 17.737500000000001p 2.126223e-05 17.75p 2.0420820000000001e-05 17.762499999999999p 1.9564200000000002e-05 17.775000000000002p 1.8693479999999998e-05
+ 17.787499999999998p 1.7809810000000001e-05 17.800000000000001p 1.6914340000000001e-05 17.8125p 1.6008219999999998e-05 17.824999999999999p 1.5092630000000001e-05 17.837500000000002p 1.4168750000000001e-05 17.849999999999998p 1.3237780000000001e-05 17.862500000000001p 1.2300899999999999e-05 17.875p 1.135932e-05 17.887499999999999p 1.0414220000000001e-05 17.900000000000002p 9.466826e-06 17.912500000000001p 8.5183200000000008e-06 17.924999999999997p 7.5699019999999998e-06 17.9375p 6.6227640000000002e-06 17.949999999999999p 5.6780919999999997e-06 17.962500000000002p 4.7370639999999998e-06 17.975000000000001p 3.800849e-06 17.987499999999997p 2.8706070000000001e-06 18p 1.9474819999999999e-06
+ 18.012499999999999p 1.0326089999999999e-06 18.025000000000002p 1.27106e-07 18.037500000000001p -7.6792640000000004e-07 18.049999999999997p -1.6514040000000001e-06 18.0625p -2.522261e-06 18.074999999999999p -3.379454e-06 18.087499999999999p -4.2219589999999999e-06 18.100000000000001p -5.0487779999999997e-06 18.112500000000001p -5.8589330000000002e-06 18.125p -6.6514759999999999e-06 18.137499999999999p -7.425481e-06 18.149999999999999p -8.1800529999999996e-06 18.162500000000001p -8.9143250000000004e-06 18.175000000000001p -9.6274569999999996e-06 18.1875p -1.0318639999999999e-05 18.199999999999999p -1.0987109999999999e-05 18.212499999999999p -1.1632110000000001e-05 18.225000000000001p -1.225294e-05
+ 18.237500000000001p -1.284892e-05 18.25p -1.341941e-05 18.262499999999999p -1.3963810000000001e-05 18.274999999999999p -1.448155e-05 18.287500000000001p -1.4972089999999999e-05 18.300000000000001p -1.5434960000000001e-05 18.3125p -1.5869690000000001e-05 18.324999999999999p -1.6275859999999998e-05 18.337499999999999p -1.6653109999999999e-05 18.350000000000001p -1.7001080000000001e-05 18.362500000000001p -1.7319499999999999e-05 18.375p -1.7608099999999998e-05 18.387499999999999p -1.7866670000000001e-05 18.399999999999999p -1.809502e-05 18.412500000000001p -1.8293039999999999e-05 18.425000000000001p -1.8460619999999999e-05 18.4375p -1.8597720000000001e-05 18.450000000000003p -1.8704320000000001e-05
+ 18.462499999999999p -1.8780450000000001e-05 18.474999999999998p -1.8826189999999999e-05 18.487500000000001p -1.8841649999999999e-05 18.5p -1.882698e-05 18.512500000000003p -1.878238e-05 18.524999999999999p -1.8708069999999999e-05 18.537499999999998p -1.8604329999999999e-05 18.550000000000001p -1.8471460000000002e-05 18.5625p -1.8309830000000001e-05 18.575000000000003p -1.811981e-05 18.587499999999999p -1.7901840000000001e-05 18.599999999999998p -1.765636e-05 18.612500000000001p -1.7383890000000001e-05 18.625p -1.708495e-05 18.637499999999999p -1.676011e-05 18.650000000000002p -1.6409969999999998e-05 18.662499999999998p -1.6035159999999999e-05 18.675000000000001p -1.5636350000000001e-05
+ 18.6875p -1.521423e-05 18.699999999999999p -1.476953e-05 18.712500000000002p -1.4303e-05 18.724999999999998p -1.381542e-05 18.737500000000001p -1.3307599999999999e-05 18.75p -1.278037e-05 18.762499999999999p -1.223458e-05 18.775000000000002p -1.167112e-05 18.787499999999998p -1.109089e-05 18.800000000000001p -1.04948e-05 18.8125p -9.8837970000000003e-06 18.824999999999999p -9.2588300000000006e-06 18.837500000000002p -8.6208730000000002e-06 18.850000000000001p -7.9709119999999997e-06 18.862499999999997p -7.3099449999999999e-06 18.875p -6.6389839999999999e-06 18.887499999999999p -5.9590479999999997e-06 18.900000000000002p -5.2711670000000002e-06
+ 18.912500000000001p -4.5763760000000001e-06 18.924999999999997p -3.8757190000000003e-06 18.9375p -3.17024e-06 18.949999999999999p -2.4609890000000001e-06 18.962500000000002p -1.7490150000000001e-06 18.975000000000001p -1.035368e-06 18.987499999999997p -3.2109560000000001e-07 19p 3.9275719999999999e-07 19.012499999999999p 1.1051509999999999e-06 19.024999999999999p 1.8150519999999999e-06 19.037500000000001p 2.5214340000000002e-06 19.050000000000001p 3.22328e-06 19.0625p 3.9195829999999999e-06 19.074999999999999p 4.6093489999999999e-06 19.087499999999999p 5.2915960000000002e-06 19.100000000000001p 5.9653570000000004e-06 19.112500000000001p 6.6296799999999997e-06 19.125p 7.2836309999999998e-06
+ 19.137499999999999p 7.9262939999999992e-06 19.149999999999999p 8.5567709999999998e-06 19.162500000000001p 9.1741870000000005e-06 19.175000000000001p 9.7776880000000001e-06 19.1875p 1.0366440000000001e-05 19.199999999999999p 1.0939640000000001e-05 19.212499999999999p 1.1496500000000001e-05 19.225000000000001p 1.203627e-05 19.237500000000001p 1.255821e-05 19.25p 1.3061630000000001e-05 19.262499999999999p 1.3545839999999999e-05 19.274999999999999p 1.4010210000000001e-05 19.287500000000001p 1.4454120000000001e-05 19.300000000000001p 1.4876989999999999e-05 19.3125p 1.527826e-05 19.324999999999999p 1.5657410000000001e-05 19.337499999999999p 1.6013949999999999e-05 19.350000000000001p 1.6347440000000001e-05
+ 19.362500000000001p 1.665744e-05 19.375p 1.6943569999999999e-05 19.387500000000003p 1.7205470000000001e-05 19.399999999999999p 1.7442830000000001e-05 19.412499999999998p 1.7655360000000001e-05 19.425000000000001p 1.7842800000000001e-05 19.4375p 1.8004950000000001e-05 19.450000000000003p 1.8141620000000001e-05 19.462499999999999p 1.825267e-05 19.474999999999998p 1.8337989999999999e-05 19.487500000000001p 1.8397500000000001e-05 19.5p 1.8431150000000001e-05 19.512500000000003p 1.8438960000000001e-05 19.524999999999999p 1.8420930000000001e-05 19.537499999999998p 1.837714e-05 19.550000000000001p 1.830768e-05 19.5625p 1.8212680000000001e-05 19.574999999999999p 1.80923e-05
+ 19.587500000000002p 1.7946740000000002e-05 19.599999999999998p 1.777623e-05 19.612500000000001p 1.7581029999999999e-05 19.625p 1.7361430000000002e-05 19.637499999999999p 1.7117750000000001e-05 19.650000000000002p 1.685034e-05 19.662499999999998p 1.6559579999999998e-05 19.675000000000001p 1.6245889999999999e-05 19.6875p 1.5909700000000001e-05 19.699999999999999p 1.555148e-05 19.712500000000002p 1.517172e-05 19.724999999999998p 1.477093e-05 19.737500000000001p 1.434967e-05 19.75p 1.390849e-05 19.762499999999999p 1.344799e-05 19.775000000000002p 1.2968780000000001e-05 19.787500000000001p 1.247149e-05 19.799999999999997p 1.195679e-05
+ 19.8125p 1.1425329999999999e-05 19.824999999999999p 1.087783e-05 19.837500000000002p 1.0314980000000001e-05 19.850000000000001p 9.7375109999999996e-06 19.862499999999997p 9.1461739999999995e-06 19.875p 8.5417240000000006e-06 19.887499999999999p 7.9249320000000002e-06 19.900000000000002p 7.2965829999999999e-06 19.912500000000001p 6.6574739999999999e-06 19.924999999999997p 6.0084120000000003e-06 19.9375p 5.350214e-06 19.949999999999999p 4.6837060000000003e-06 19.962499999999999p 4.0097199999999996e-06 19.975000000000001p 3.3290970000000002e-06 19.987500000000001p 2.6426829999999999e-06 20p 1.9513260000000001e-06 20.012499999999999p -3.2516229999999999e-06 20.024999999999999p -7.8684000000000008e-06
+ 20.037500000000001p -1.193146e-05 20.050000000000001p -1.550938e-05 20.0625p -1.867514e-05 20.074999999999999p -2.149607e-05 20.087499999999999p -2.4031309999999999e-05 20.100000000000001p -2.6331810000000002e-05 20.112500000000001p -2.8441059999999998e-05 20.125p -3.039603e-05 20.137499999999999p -3.2228050000000001e-05 20.149999999999999p -3.3963569999999999e-05 20.162500000000001p -3.5624889999999998e-05 20.175000000000001p -3.7230710000000003e-05 20.1875p -3.8796659999999998e-05 20.199999999999999p -4.0335759999999998e-05 20.212499999999999p -4.1858730000000002e-05 20.225000000000001p -4.3374400000000003e-05 20.237500000000001p -4.4889899999999999e-05 20.25p -4.6410940000000003e-05
+ 20.262499999999999p -4.7942029999999998e-05 20.274999999999999p -4.9486610000000002e-05 20.287500000000001p -5.1047210000000002e-05 20.300000000000001p -5.262561e-05 20.3125p -5.422292e-05 20.325000000000003p -5.5839669999999998e-05 20.337499999999999p -5.7475919999999998e-05 20.349999999999998p -5.913129e-05 20.362500000000001p -6.0805070000000003e-05 20.375p -6.2496219999999994e-05 20.387500000000003p -6.420346e-05 20.399999999999999p -6.5925269999999995e-05 20.412499999999998p -6.7659959999999997e-05 20.425000000000001p -6.9405669999999996e-05 20.4375p -7.1160410000000005e-05 20.450000000000003p -7.2922079999999996e-05 20.462499999999999p -7.4688479999999993e-05 20.474999999999998p -7.6457350000000001e-05
+ 20.487500000000001p -7.8226360000000004e-05 20.5p -7.999313e-05 20.512499999999999p -8.1755259999999997e-05 20.525000000000002p -8.351032e-05 20.537499999999998p -8.5255850000000001e-05 20.550000000000001p -8.6989410000000005e-05 20.5625p -8.8708540000000002e-05 20.574999999999999p -9.0410789999999998e-05 20.587500000000002p -9.2093739999999998e-05 20.599999999999998p -9.3754979999999998e-05 20.612500000000001p -9.5392130000000007e-05 20.625p -9.7002829999999994e-05 20.637499999999999p -9.8584780000000004e-05 20.650000000000002p -0.0001001357 20.662499999999998p -0.0001016533 20.675000000000001p -0.0001031355 20.6875p -0.0001045801 20.699999999999999p -0.0001059851
+ 20.712500000000002p -0.0001073484 20.725000000000001p -0.0001086682 20.737499999999997p -0.0001099424 20.75p -0.0001111693 20.762499999999999p -0.00011234709999999999 20.775000000000002p -0.0001134743 20.787500000000001p -0.0001145491 20.799999999999997p -0.0001155701 20.8125p -0.0001165359 20.824999999999999p -0.0001174451 20.837500000000002p -0.0001182965 20.850000000000001p -0.0001190888 20.862499999999997p -0.000119821 20.875p -0.0001204922 20.887499999999999p -0.00012110140000000001 20.899999999999999p -0.0001216479 20.912500000000001p -0.00012213090000000001 20.925000000000001p -0.00012254989999999999
+ 20.9375p -0.00012290430000000001 20.949999999999999p -0.00012319380000000001 20.962499999999999p -0.000123418 20.975000000000001p -0.0001235768 20.987500000000001p -0.00012366999999999999 21p -0.0001236977 21.012499999999999p -0.00011915249999999999 21.024999999999999p -0.0001151315 21.037500000000001p -0.0001116017 21.050000000000001p -0.00010849399999999999 21.0625p -0.0001057352 21.074999999999999p -0.00010325760000000001 21.087499999999999p -0.0001010021 21.100000000000001p -9.8917699999999997e-05 21.112500000000001p -9.6960900000000002e-05 21.125p -9.5094950000000007e-05 21.137499999999999p -9.3288839999999996e-05 21.149999999999999p -9.1516500000000004e-05
+ 21.162500000000001p -8.9756149999999996e-05 21.175000000000001p -8.7989689999999995e-05 21.1875p -8.6202199999999999e-05 21.199999999999999p -8.4381479999999997e-05 21.212499999999999p -8.2517700000000004e-05 21.225000000000001p -8.0603070000000005e-05 21.237500000000001p -7.8631549999999998e-05 21.25p -7.6598600000000002e-05 21.262500000000003p -7.4501019999999998e-05 21.274999999999999p -7.2336740000000004e-05 21.287499999999998p -7.0104669999999998e-05 21.300000000000001p -6.7804570000000003e-05 21.3125p -6.543694e-05 21.325000000000003p -6.3002930000000002e-05 21.337499999999999p -6.0504249999999999e-05 21.349999999999998p -5.7943070000000002e-05 21.362500000000001p -5.5322000000000003e-05 21.375p -5.2643999999999999e-05
+ 21.387500000000003p -4.9912359999999997e-05 21.399999999999999p -4.713062e-05 21.412499999999998p -4.4302570000000003e-05 21.425000000000001p -4.1432169999999997e-05 21.4375p -3.8523589999999998e-05 21.449999999999999p -3.5581119999999999e-05 21.462500000000002p -3.2609150000000003e-05 21.474999999999998p -2.9612200000000001e-05 21.487500000000001p -2.6594859999999999e-05 21.5p -2.3561759999999999e-05 21.512499999999999p -2.0517600000000002e-05 21.525000000000002p -1.746709e-05 21.537499999999998p -1.4414960000000001e-05 21.550000000000001p -1.136596e-05 21.5625p -8.3248020000000008e-06 21.574999999999999p -5.2961970000000003e-06 21.587500000000002p -2.2848219999999999e-06 21.599999999999998p 7.0468819999999997e-07
+ 21.612500000000001p 3.6677460000000001e-06 21.625p 6.5998230000000003e-06 21.637499999999999p 9.4964570000000003e-06 21.650000000000002p 1.235326e-05 21.662500000000001p 1.516592e-05 21.674999999999997p 1.7930229999999999e-05 21.6875p 2.0642060000000001e-05 21.699999999999999p 2.3297390000000001e-05 21.712500000000002p 2.5892320000000001e-05 21.725000000000001p 2.8423030000000001e-05 21.737499999999997p 3.0885859999999999e-05 21.75p 3.3277249999999997e-05 21.762499999999999p 3.5593770000000003e-05 21.775000000000002p 3.7832150000000003e-05 21.787500000000001p 3.9989230000000002e-05 21.799999999999997p 4.2061999999999998e-05 21.8125p 4.4047610000000002e-05 21.824999999999999p 4.5943360000000002e-05
+ 21.837499999999999p 4.774668e-05 21.850000000000001p 4.9455179999999999e-05 21.862500000000001p 5.1066639999999999e-05 21.875p 5.2578969999999997e-05 21.887499999999999p 5.3990270000000002e-05 21.899999999999999p 5.52988e-05 21.912500000000001p 5.6502980000000003e-05 21.925000000000001p 5.7601420000000002e-05 21.9375p 5.8592879999999998e-05 21.949999999999999p 5.9476309999999999e-05 21.962499999999999p 6.0250810000000003e-05 21.975000000000001p 6.0915660000000001e-05 21.987500000000001p 6.1470330000000002e-05 22p 6.1914439999999994e-05 22.012499999999999p 6.2247780000000003e-05 22.024999999999999p 6.247034e-05 22.037500000000001p 6.2582229999999994e-05 22.050000000000001p 6.2583770000000007e-05
+ 22.0625p 6.2475430000000004e-05 22.074999999999999p 6.2257840000000002e-05 22.087499999999999p 6.1931780000000001e-05 22.100000000000001p 6.1498220000000002e-05 22.112500000000001p 6.0958259999999999e-05 22.125p 6.0313170000000002e-05 22.137499999999999p 5.9564349999999998e-05 22.149999999999999p 5.8713360000000003e-05 22.162500000000001p 5.77619e-05 22.175000000000001p 5.6711810000000002e-05 22.1875p 5.5565069999999999e-05 22.200000000000003p 5.4323780000000002e-05 22.212499999999999p 5.2990189999999999e-05 22.224999999999998p 5.1566629999999997e-05 22.237500000000001p 5.0055610000000003e-05 22.25p 4.8459689999999999e-05 22.262500000000003p 4.6781589999999999e-05 22.274999999999999p 4.5024110000000002e-05
+ 22.287499999999998p 4.3190160000000003e-05 22.300000000000001p 4.1282729999999999e-05 22.3125p 3.9304929999999999e-05 22.325000000000003p 3.7259909999999999e-05 22.337499999999999p 3.515096e-05 22.349999999999998p 3.2981390000000002e-05 22.362500000000001p 3.075462e-05 22.375p 2.847411e-05 22.387499999999999p 2.6143400000000001e-05 22.400000000000002p 2.3766070000000001e-05 22.412499999999998p 2.1345769999999999e-05 22.425000000000001p 1.8886159999999999e-05 22.4375p 1.6390980000000001e-05 22.449999999999999p 1.386398e-05 22.462500000000002p 1.130895e-05 22.474999999999998p 8.7297060000000002e-06 22.487500000000001p 6.1300830000000001e-06 22.5p 3.513927e-06
+ 22.512499999999999p 8.8509989999999996e-07 22.525000000000002p -1.7525350000000001e-06 22.537499999999998p -4.3951109999999997e-06 22.550000000000001p -7.038767e-06 22.5625p -9.6796510000000008e-06 22.574999999999999p -1.231393e-05 22.587500000000002p -1.4937770000000001e-05 22.600000000000001p -1.754739e-05 22.612499999999997p -2.0139009999999999e-05 22.625p -2.2708909999999999e-05 22.637499999999999p -2.525338e-05 22.650000000000002p -2.7768760000000001e-05 22.662500000000001p -3.0251460000000001e-05 22.674999999999997p -3.2697899999999997e-05 22.6875p -3.5104590000000002e-05 22.699999999999999p -3.7468069999999999e-05 22.712500000000002p -3.9784989999999999e-05 22.725000000000001p -4.2052009999999997e-05
+ 22.737500000000001p -4.426591e-05 22.75p -4.6423520000000002e-05 22.762499999999999p -4.8521759999999997e-05 22.774999999999999p -5.0557640000000001e-05 22.787500000000001p -5.2528239999999999e-05 22.800000000000001p -5.4430749999999997e-05 22.8125p -5.6262460000000003e-05 22.824999999999999p -5.8020750000000002e-05 22.837499999999999p -5.970309e-05 22.850000000000001p -6.1307089999999994e-05 22.862500000000001p -6.2830429999999996e-05 22.875p -6.4270950000000005e-05 22.887499999999999p -6.5626569999999997e-05 22.899999999999999p -6.6895339999999999e-05 22.912500000000001p -6.8075430000000004e-05 22.925000000000001p -6.9165140000000002e-05 22.9375p -7.0162910000000006e-05 22.949999999999999p -7.1067269999999994e-05
+ 22.962499999999999p -7.1876929999999998e-05 22.975000000000001p -7.2590690000000002e-05 22.987500000000001p -7.3207510000000001e-05 23p -7.3726489999999999e-05 23.012499999999999p -7.4146849999999996e-05 23.024999999999999p -7.4467970000000004e-05 23.037500000000001p -7.4689339999999999e-05 23.050000000000001p -7.4810640000000001e-05 23.0625p -7.4831630000000006e-05 23.074999999999999p -7.4752259999999996e-05 23.087499999999999p -7.4572610000000006e-05 23.100000000000001p -7.4292879999999993e-05 23.112500000000001p -7.3913439999999999e-05 23.125p -7.3434790000000003e-05 23.137500000000003p -7.2857559999999996e-05 23.149999999999999p -7.2182530000000004e-05 23.162499999999998p -7.1410619999999998e-05 23.175000000000001p -7.0542869999999996e-05
+ 23.1875p -6.958047e-05 23.200000000000003p -6.8524729999999993e-05 23.212499999999999p -6.7377109999999996e-05 23.224999999999998p -6.6139179999999997e-05 23.237500000000001p -6.4812640000000006e-05 23.25p -6.3399300000000001e-05 23.262500000000003p -6.1901109999999997e-05 23.274999999999999p -6.0320130000000001e-05 23.287499999999998p -5.8658539999999997e-05 23.300000000000001p -5.6918600000000001e-05 23.3125p -5.5102709999999997e-05 23.324999999999999p -5.3213359999999998e-05 23.337500000000002p -5.1253130000000001e-05 23.349999999999998p -4.9224709999999997e-05 23.362500000000001p -4.7130859999999997e-05 23.375p -4.4974459999999998e-05 23.387499999999999p -4.2758420000000002e-05 23.400000000000002p -4.0485780000000003e-05
+ 23.412499999999998p -3.8159630000000002e-05 23.425000000000001p -3.578311e-05 23.4375p -3.3359450000000001e-05 23.449999999999999p -3.0891929999999997e-05 23.462500000000002p -2.8383869999999999e-05 23.474999999999998p -2.5838669999999998e-05 23.487500000000001p -2.325974e-05 23.5p -2.0650540000000001e-05 23.512499999999999p -1.801457e-05 23.525000000000002p -1.5355349999999999e-05 23.537500000000001p -1.2676440000000001e-05 23.549999999999997p -9.9814000000000007e-06 23.5625p -7.2738029999999996e-06 23.574999999999999p -4.5572420000000001e-06 23.587500000000002p -1.835307e-06 23.600000000000001p 8.8841260000000001e-07 23.612499999999997p 3.6103349999999999e-06 23.625p 6.3268899999999997e-06
+ 23.637499999999999p 9.0345229999999992e-06 23.650000000000002p 1.1729700000000001e-05 23.662500000000001p 1.440892e-05 23.675000000000001p 1.7068700000000001e-05 23.6875p 1.9705610000000001e-05 23.699999999999999p 2.2316250000000002e-05 23.712499999999999p 2.489726e-05 23.725000000000001p 2.744535e-05 23.737500000000001p 2.9957249999999999e-05 23.75p 3.2429779999999998e-05 23.762499999999999p 3.4859820000000003e-05 23.774999999999999p 3.7244289999999998e-05 23.787500000000001p 3.9580219999999999e-05 23.800000000000001p 4.1864669999999997e-05 23.8125p 4.4094819999999998e-05 23.824999999999999p 4.6267909999999999e-05 23.837499999999999p 4.8381260000000001e-05 23.850000000000001p 5.0432300000000002e-05
+ 23.862500000000001p 5.2418550000000003e-05 23.875p 5.43376e-05 23.887499999999999p 5.618716e-05 23.899999999999999p 5.7965050000000002e-05 23.912500000000001p 5.9669169999999999e-05 23.925000000000001p 6.1297550000000004e-05 23.9375p 6.284831e-05 23.949999999999999p 6.4319679999999999e-05 23.962499999999999p 6.5710029999999995e-05 23.975000000000001p 6.7017820000000002e-05 23.987500000000001p 6.8241640000000003e-05 24p 6.9380180000000002e-05 24.012499999999999p 7.0432279999999998e-05 24.024999999999999p 7.1396869999999999e-05 24.037500000000001p 7.2273010000000005e-05 24.050000000000001p 7.3059900000000002e-05 24.0625p 7.3756839999999994e-05 24.075000000000003p 7.4363269999999998e-05
+ 24.087499999999999p 7.4878739999999995e-05 24.099999999999998p 7.5302930000000002e-05 24.112500000000001p 7.5635629999999993e-05 24.125p 7.5876780000000004e-05 24.137500000000003p 7.6026419999999996e-05 24.149999999999999p 7.6084699999999993e-05 24.162499999999998p 7.6051930000000005e-05 24.175000000000001p 7.5928490000000003e-05 24.1875p 7.5714909999999996e-05 24.200000000000003p 7.5411830000000004e-05 24.212499999999999p 7.5019989999999996e-05 24.224999999999998p 7.4540260000000006e-05 24.237500000000001p 7.3973609999999993e-05 24.25p 7.3321110000000006e-05 24.262499999999999p 7.2583950000000005e-05 24.275000000000002p 7.1763419999999999e-05 24.287499999999998p 7.0860890000000004e-05 24.300000000000001p 6.9877870000000002e-05
+ 24.3125p 6.8815919999999994e-05 24.324999999999999p 6.7676720000000003e-05 24.337500000000002p 6.6462030000000004e-05 24.349999999999998p 6.5173690000000002e-05 24.362500000000001p 6.3813619999999996e-05 24.375p 6.2383849999999994e-05 24.387499999999999p 6.0886440000000003e-05 24.400000000000002p 5.9323549999999999e-05 24.412499999999998p 5.7697420000000002e-05 24.425000000000001p 5.6010320000000003e-05 24.4375p 5.4264619999999997e-05 24.449999999999999p 5.2462710000000002e-05 24.462500000000002p 5.0607079999999997e-05 24.475000000000001p 4.870022e-05 24.487499999999997p 4.6744720000000001e-05 24.5p 4.474317e-05 24.512499999999999p 4.2698219999999999e-05 24.525000000000002p 4.0612570000000003e-05
+ 24.537500000000001p 3.8488939999999999e-05 24.549999999999997p 3.6330069999999998e-05 24.5625p 3.4138730000000001e-05 24.574999999999999p 3.1917739999999997e-05 24.587500000000002p 2.9669899999999999e-05 24.600000000000001p 2.7398050000000001e-05 24.612500000000001p 2.510504e-05 24.625p 2.279372e-05 24.637499999999999p 2.0466949999999999e-05 24.649999999999999p 1.8127599999999999e-05 24.662500000000001p 1.577853e-05 24.675000000000001p 1.342259e-05 24.6875p 1.106263e-05 24.699999999999999p 8.7015070000000004e-06 24.712499999999999p 6.3420280000000004e-06 24.725000000000001p 3.9870059999999999e-06 24.737500000000001p 1.6392300000000001e-06 24.75p -6.9853750000000004e-07
+ 24.762499999999999p -3.023557e-06 24.774999999999999p -5.3331190000000001e-06 24.787500000000001p -7.6245459999999996e-06 24.800000000000001p -9.8951969999999998e-06 24.8125p -1.2142470000000001e-05 24.824999999999999p -1.4363790000000001e-05 24.837499999999999p -1.655665e-05 24.850000000000001p -1.8718560000000001e-05 24.862500000000001p -2.084711e-05 24.875p -2.2939910000000001e-05 24.887499999999999p -2.499465e-05 24.899999999999999p -2.7009049999999999e-05 24.912500000000001p -2.898091e-05 24.925000000000001p -3.0908080000000002e-05 24.9375p -3.2788479999999998e-05 24.949999999999999p -3.4620080000000003e-05 24.962499999999999p -3.6400940000000002e-05 24.975000000000001p -3.8129179999999999e-05
+ 24.987500000000001p -3.9802979999999997e-05 25p -4.1420600000000001e-05 25.012500000000003p -4.2980379999999998e-05 25.024999999999999p -4.4480749999999999e-05 25.037499999999998p -4.592018e-05 25.050000000000001p -4.7297260000000003e-05 25.0625p -4.8610650000000002e-05 25.075000000000003p -4.9859070000000003e-05 25.087499999999999p -5.104137e-05 25.099999999999998p -5.2156439999999997e-05 25.112500000000001p -5.3203289999999999e-05 25.125p -5.4181010000000003e-05 25.137500000000003p -5.5088769999999998e-05 25.149999999999999p -5.5925830000000001e-05 25.162499999999998p -5.6691560000000002e-05 25.175000000000001p -5.7385410000000002e-05 25.1875p -5.8006910000000003e-05 25.199999999999999p -5.855571e-05
+ 25.212500000000002p -5.903152e-05 25.224999999999998p -5.9434169999999999e-05 25.237500000000001p -5.9763570000000003e-05 25.25p -6.0019729999999999e-05 25.262499999999999p -6.0202750000000002e-05 25.275000000000002p -6.0312809999999997e-05 25.287499999999998p -6.0350209999999998e-05 25.300000000000001p -6.0315310000000002e-05 25.3125p -6.0208589999999997e-05 25.324999999999999p -6.003059e-05 25.337500000000002p -5.9781960000000002e-05 25.349999999999998p -5.9463429999999999e-05 25.362500000000001p -5.9075820000000003e-05 25.375p -5.8620040000000001e-05 25.387499999999999p -5.809706e-05 25.400000000000002p -5.7507960000000003e-05 25.412500000000001p -5.685388e-05 25.424999999999997p -5.6136059999999997e-05
+ 25.4375p -5.5355780000000001e-05 25.449999999999999p -5.4514439999999997e-05 25.462500000000002p -5.3613470000000002e-05 25.475000000000001p -5.2654400000000002e-05 25.487499999999997p -5.1638819999999999e-05 25.5p -5.0568359999999999e-05 25.512499999999999p -4.9444760000000002e-05 25.525000000000002p -4.8269770000000001e-05 25.537500000000001p -4.7045239999999998e-05 25.550000000000001p -4.577304e-05 25.5625p -4.4455110000000001e-05 25.574999999999999p -4.3093429999999998e-05 25.587499999999999p -4.1690039999999998e-05 25.600000000000001p -4.0247000000000003e-05 25.612500000000001p -3.8766429999999997e-05 25.625p -3.7250470000000003e-05 25.637499999999999p -3.5701309999999997e-05 25.649999999999999p -3.4121149999999998e-05
+ 25.662500000000001p -3.251224e-05 25.675000000000001p -3.0876819999999997e-05 25.6875p -2.9217190000000001e-05 25.699999999999999p -2.7535640000000001e-05 25.712499999999999p -2.5834490000000001e-05 25.725000000000001p -2.411604e-05 25.737500000000001p -2.2382640000000001e-05 25.75p -2.0636609999999999e-05 25.762499999999999p -1.8880289999999999e-05 25.774999999999999p -1.7116010000000001e-05 25.787500000000001p -1.5346090000000001e-05 25.800000000000001p -1.357285e-05 25.8125p -1.1798600000000001e-05 25.824999999999999p -1.0025620000000001e-05 25.837499999999999p -8.2561769999999994e-06 25.850000000000001p -6.4925290000000003e-06 25.862500000000001p -4.7368990000000001e-06 25.875p -2.9914849999999999e-06
+ 25.887499999999999p -1.2584549999999999e-06 25.899999999999999p 4.6005539999999999e-07 25.912500000000001p 2.1619450000000002e-06 25.925000000000001p 3.8451520000000004e-06 25.9375p 5.5076539999999998e-06 25.950000000000003p 7.1474730000000001e-06 25.962499999999999p 8.7626759999999993e-06 25.974999999999998p 1.0351380000000001e-05 25.987500000000001p 1.1911739999999999e-05 26p 1.344198e-05 26.012500000000003p 1.494037e-05 26.024999999999999p 1.6405239999999999e-05 26.037499999999998p 1.783498e-05 26.050000000000001p 1.9228030000000002e-05 26.0625p 2.0582889999999998e-05 26.075000000000003p 2.1898139999999999e-05 26.087499999999999p 2.3172409999999999e-05 26.099999999999998p 2.4404420000000001e-05
+ 26.112500000000001p 2.5592910000000001e-05 26.125p 2.673674e-05 26.137499999999999p 2.7834810000000001e-05 26.150000000000002p 2.8886109999999998e-05 26.162499999999998p 2.9889670000000001e-05 26.175000000000001p 3.0844630000000002e-05 26.1875p 3.1750169999999998e-05 26.199999999999999p 3.2605579999999997e-05 26.212500000000002p 3.341019e-05 26.224999999999998p 3.416341e-05 26.237500000000001p 3.4864750000000002e-05 26.25p 3.5513770000000003e-05 26.262499999999999p 3.6110109999999999e-05 26.275000000000002p 3.6653480000000003e-05 26.287499999999998p 3.714368e-05 26.300000000000001p 3.7580570000000002e-05 26.3125p 3.7964080000000003e-05 26.324999999999999p 3.8294239999999999e-05
+ 26.337500000000002p 3.8571110000000001e-05 26.350000000000001p 3.8794860000000001e-05 26.362499999999997p 3.8965699999999999e-05 26.375p 3.9083940000000003e-05 26.387499999999999p 3.9149939999999999e-05 26.400000000000002p 3.9164120000000001e-05 26.412500000000001p 3.9126979999999999e-05 26.424999999999997p 3.9039099999999997e-05 26.4375p 3.8901079999999998e-05 26.449999999999999p 3.8713629999999997e-05 26.462500000000002p 3.8477479999999997e-05 26.475000000000001p 3.8193459999999997e-05 26.487500000000001p 3.786242e-05 26.5p 3.7485279999999997e-05 26.512499999999999p 3.7063020000000002e-05 26.524999999999999p 3.6596669999999999e-05 26.537500000000001p 3.6087310000000003e-05 26.550000000000001p 3.5536059999999997e-05
+ 26.5625p 3.4944090000000002e-05 26.574999999999999p 3.4312620000000002e-05 26.587499999999999p 3.3642909999999997e-05 26.600000000000001p 3.2936260000000002e-05 26.612500000000001p 3.2193999999999997e-05 26.625p 3.1417510000000003e-05 26.637499999999999p 3.0608190000000002e-05 26.649999999999999p 2.976747e-05 26.662500000000001p 2.889683e-05 26.675000000000001p 2.7997750000000001e-05 26.6875p 2.707175e-05 26.699999999999999p 2.6120369999999999e-05 26.712499999999999p 2.514518e-05 26.725000000000001p 2.4147730000000001e-05 26.737500000000001p 2.3129630000000002e-05 26.75p 2.2092480000000001e-05 26.762499999999999p 2.1037900000000001e-05 26.774999999999999p 1.9967500000000002e-05
+ 26.787500000000001p 1.888292e-05 26.800000000000001p 1.7785790000000001e-05 26.8125p 1.6677750000000001e-05 26.824999999999999p 1.5560419999999999e-05 26.837499999999999p 1.4435450000000001e-05 26.850000000000001p 1.3304449999999999e-05 26.862500000000001p 1.216905e-05 26.875p 1.103086e-05 26.887500000000003p 9.8914720000000002e-06 26.899999999999999p 8.7524790000000005e-06 26.912499999999998p 7.6154500000000001e-06 26.925000000000001p 6.4819380000000003e-06 26.9375p 5.3534770000000001e-06 26.950000000000003p 4.231581e-06 26.962499999999999p 3.1177400000000001e-06 26.974999999999998p 2.013419e-06 26.987500000000001p 9.2005830000000002e-07 27p -1.609313e-07
+ 27.012500000000003p -1.2281679999999999e-06 27.024999999999999p -2.2803029999999999e-06 27.037499999999998p -3.316019e-06 27.050000000000001p -4.3340329999999998e-06 27.0625p -5.3330990000000004e-06 27.074999999999999p -6.3120069999999999e-06 27.087500000000002p -7.2695870000000001e-06 27.099999999999998p -8.2047089999999992e-06 27.112500000000001p -9.1162829999999996e-06 27.125p -1.000326e-05 27.137499999999999p -1.086464e-05 27.150000000000002p -1.1699459999999999e-05 27.162499999999998p -1.2506809999999999e-05 27.175000000000001p -1.328582e-05 27.1875p -1.403567e-05 27.199999999999999p -1.475558e-05 27.212500000000002p -1.5444840000000001e-05 27.224999999999998p -1.6102769999999999e-05
+ 27.237500000000001p -1.6728740000000001e-05 27.25p -1.7322190000000001e-05 27.262499999999999p -1.7882569999999998e-05 27.275000000000002p -1.840944e-05 27.287500000000001p -1.8902360000000001e-05 27.299999999999997p -1.936096e-05 27.3125p -1.9784919999999999e-05 27.324999999999999p -2.017399e-05 27.337500000000002p -2.0527950000000001e-05 27.350000000000001p -2.0846640000000001e-05 27.362499999999997p -2.1129939999999998e-05 27.375p -2.1377800000000001e-05 27.387499999999999p -2.159022e-05 27.400000000000002p -2.1767229999999999e-05 27.412500000000001p -2.1908930000000002e-05 27.425000000000001p -2.2015470000000001e-05 27.4375p -2.208704e-05 27.449999999999999p -2.2123879999999999e-05
+ 27.462499999999999p -2.2126290000000001e-05 27.475000000000001p -2.20946e-05 27.487500000000001p -2.202921e-05 27.5p -2.1930539999999999e-05 27.512499999999999p -2.1799070000000001e-05 27.524999999999999p -2.1635320000000001e-05 27.537500000000001p -2.1439850000000001e-05 27.550000000000001p -2.121327e-05 27.5625p -2.095624e-05 27.574999999999999p -2.066942e-05 27.587499999999999p -2.0353550000000001e-05 27.600000000000001p -2.0009390000000001e-05 27.612500000000001p -1.9637729999999999e-05 27.625p -1.9239410000000002e-05 27.637499999999999p -1.8815280000000001e-05 27.649999999999999p -1.8366250000000001e-05 27.662500000000001p -1.7893239999999999e-05 27.675000000000001p -1.73972e-05
+ 27.6875p -1.687911e-05 27.699999999999999p -1.6339980000000001e-05 27.712499999999999p -1.5780829999999998e-05 27.725000000000001p -1.520271e-05 27.737500000000001p -1.460669e-05 27.75p -1.399387e-05 27.762499999999999p -1.336534e-05 27.774999999999999p -1.272222e-05 27.787500000000001p -1.206565e-05 27.800000000000001p -1.1396779999999999e-05 27.8125p -1.071674e-05 27.825000000000003p -1.002672e-05 27.837499999999999p -9.3278650000000002e-06 27.849999999999998p -8.6213580000000003e-06 27.862500000000001p -7.90837e-06 27.875p -7.1900760000000002e-06 27.887500000000003p -6.4676499999999998e-06 27.899999999999999p -5.7422639999999999e-06
+ 27.912499999999998p -5.0150829999999998e-06 27.925000000000001p -4.2872680000000004e-06 27.9375p -3.5599730000000001e-06 27.949999999999999p -2.8343390000000001e-06 27.962499999999999p -2.1115e-06 27.974999999999998p -1.3925739999999999e-06 27.987500000000001p -6.786663e-07 28p 2.9134550000000001e-08 28.012499999999999p 7.2975679999999998e-07 28.025000000000002p 1.422148e-06 28.037499999999998p 2.1052749999999999e-06 28.050000000000001p 2.7781289999999999e-06 28.0625p 3.4397209999999998e-06 28.074999999999999p 4.0890890000000003e-06 28.087500000000002p 4.725295e-06 28.099999999999998p 5.3474300000000002e-06 28.112500000000001p 5.9546100000000004e-06 28.125p 6.5459829999999998e-06
+ 28.137499999999999p 7.1207259999999997e-06 28.150000000000002p 7.6780479999999996e-06 28.162499999999998p 8.2171899999999992e-06 28.175000000000001p 8.7374259999999999e-06 28.1875p 9.2380640000000004e-06 28.199999999999999p 9.7184479999999996e-06 28.212500000000002p 1.017796e-05 28.225000000000001p 1.061601e-05 28.237499999999997p 1.1032050000000001e-05 28.25p 1.1425570000000001e-05 28.262499999999999p 1.17961e-05 28.275000000000002p 1.214321e-05 28.287500000000001p 1.2466489999999999e-05 28.299999999999997p 1.2765609999999999e-05 28.3125p 1.304023e-05 28.324999999999999p 1.329008e-05 28.337500000000002p 1.3514939999999999e-05 28.350000000000001p 1.371459e-05
+ 28.362500000000001p 1.388888e-05 28.375p 1.4037699999999999e-05 28.387499999999999p 1.4160959999999999e-05 28.399999999999999p 1.425864e-05 28.412500000000001p 1.433073e-05 28.425000000000001p 1.4377280000000001e-05 28.4375p 1.439836e-05 28.449999999999999p 1.43941e-05 28.462499999999999p 1.436465e-05 28.475000000000001p 1.4310200000000001e-05 28.487500000000001p 1.4230990000000001e-05 28.5p 1.412729e-05 28.512499999999999p 1.3999389999999999e-05 28.524999999999999p 1.3847649999999999e-05 28.537500000000001p 1.3672419999999999e-05 28.550000000000001p 1.3474130000000001e-05 28.5625p 1.32532e-05 28.574999999999999p 1.3010120000000001e-05
+ 28.587499999999999p 1.274538e-05 28.600000000000001p 1.245953e-05 28.612500000000001p 1.215311e-05 28.625p 1.1826719999999999e-05 28.637499999999999p 1.148099e-05 28.649999999999999p 1.1116549999999999e-05 28.662500000000001p 1.0734070000000001e-05 28.675000000000001p 1.033425e-05 28.6875p 9.9178059999999999e-06 28.699999999999999p 9.4854689999999994e-06 28.712499999999999p 9.0379989999999995e-06 28.725000000000001p 8.5761739999999999e-06 28.737500000000001p 8.1007860000000005e-06 28.75p 7.6126480000000002e-06 28.762500000000003p 7.1125860000000003e-06 28.774999999999999p 6.6014400000000003e-06 28.787499999999998p 6.0800630000000001e-06 28.800000000000001p 5.5493189999999999e-06
+ 28.8125p 5.0100829999999999e-06 28.825000000000003p 4.4632379999999997e-06 28.837499999999999p 3.909675e-06 28.849999999999998p 3.3502909999999999e-06 28.862500000000001p 2.7859860000000001e-06 28.875p 2.2176670000000001e-06 28.887499999999999p 1.646239e-06 28.899999999999999p 1.072611e-06 28.912499999999998p 4.976894e-07 28.925000000000001p -7.7619960000000003e-08 28.9375p -6.5241519999999997e-07 28.949999999999999p -1.225799e-06 28.962500000000002p -1.7968779999999999e-06 28.974999999999998p -2.364769e-06 28.987500000000001p -2.9285940000000001e-06 29p -3.4874860000000001e-06 29.012499999999999p -4.0405889999999998e-06 29.025000000000002p -4.5870579999999998e-06
+ 29.037499999999998p -5.1260620000000002e-06 29.050000000000001p -5.6567819999999997e-06 29.0625p -6.1784159999999996e-06 29.074999999999999p -6.690179e-06 29.087500000000002p -7.191303e-06 29.099999999999998p -7.681036e-06 29.112500000000001p -8.1586500000000002e-06 29.125000000000004p -8.6234340000000008e-06 29.137499999999999p -9.0746990000000003e-06 29.149999999999999p -9.5117790000000002e-06 29.162500000000001p -9.9340319999999993e-06 29.174999999999997p -1.034084e-05 29.187500000000004p -1.0731600000000001e-05 29.199999999999999p -1.110576e-05 29.212499999999999p -1.146276e-05 29.225000000000001p -1.1802089999999999e-05 29.237499999999997p -1.2123269999999999e-05 29.250000000000004p -1.2425829999999999e-05
+ 29.262499999999999p -1.2709350000000001e-05 29.274999999999999p -1.2973430000000001e-05 29.287500000000001p -1.3217680000000001e-05 29.299999999999997p -1.344177e-05 29.312500000000004p -1.36454e-05 29.324999999999999p -1.3828270000000001e-05 29.337499999999999p -1.399014e-05 29.350000000000001p -1.41308e-05 29.362499999999997p -1.425006e-05 29.375000000000004p -1.434777e-05 29.387499999999999p -1.4423800000000001e-05 29.400000000000002p -1.447806e-05 29.412500000000001p -1.4510499999999999e-05 29.424999999999997p -1.4521100000000001e-05 29.4375p -1.450985e-05 29.449999999999999p -1.4476810000000001e-05 29.462500000000002p -1.4422030000000001e-05 29.475000000000001p -1.4345630000000001e-05
+ 29.487499999999997p -1.424773e-05 29.5p -1.41285e-05 29.512499999999999p -1.398814e-05 29.525000000000002p -1.3826869999999999e-05 29.537500000000001p -1.364494e-05 29.549999999999997p -1.344264e-05 29.5625p -1.322029e-05 29.574999999999999p -1.2978229999999999e-05 29.587500000000002p -1.271682e-05 29.600000000000001p -1.243647e-05 29.612499999999997p -1.213759e-05 29.625p -1.182065e-05 29.637499999999999p -1.14861e-05 29.650000000000002p -1.113446e-05 29.662500000000001p -1.076624e-05 29.674999999999997p -1.0381989999999999e-05 29.6875p -9.9822719999999994e-06 29.699999999999999p -9.5676820000000007e-06
+ 29.712500000000002p -9.1388249999999997e-06 29.724999999999998p -8.6963289999999994e-06 29.737499999999997p -8.2408390000000008e-06 29.75p -7.7730190000000003e-06 29.762499999999999p -7.2935469999999999e-06 29.775000000000002p -6.8031180000000002e-06 29.787499999999998p -6.3024400000000003e-06 29.800000000000004p -5.7922350000000001e-06 29.8125p -5.2732370000000001e-06 29.824999999999999p -4.7461899999999997e-06 29.837500000000002p -4.2118479999999997e-06 29.849999999999998p -3.670975e-06 29.862500000000004p -3.1243400000000001e-06 29.875p -2.5727220000000001e-06 29.887499999999999p -2.0169020000000002e-06 29.900000000000002p -1.457667e-06 29.912499999999998p -8.9580700000000005e-07 29.925000000000004p -3.3211340000000003e-07
+ 29.9375p 2.3262130000000001e-07 29.949999999999996p 7.9760529999999995e-07 29.962500000000002p 1.3620480000000001e-06 29.974999999999998p 1.9251610000000002e-06 29.987500000000001p 2.4861600000000002e-06 30p 3.044267e-06 30.012499999999996p 3.5987060000000001e-06 30.025000000000002p 4.1487120000000001e-06 30.037499999999998p 4.6935269999999997e-06 30.050000000000001p 5.2324000000000001e-06 30.0625p 5.7645919999999996e-06 30.074999999999996p 6.2893750000000002e-06 30.087500000000002p 6.806033e-06 30.099999999999998p 7.313863e-06 30.112500000000001p 7.8121769999999999e-06 30.125p 8.3002989999999997e-06 30.137500000000003p 8.7775720000000005e-06 30.150000000000002p 9.2433539999999995e-06
+ 30.162499999999998p 9.6970220000000007e-06 30.175000000000001p 1.013797e-05 30.1875p 1.056561e-05 30.200000000000003p 1.0979380000000001e-05 30.212500000000002p 1.137873e-05 30.224999999999998p 1.176314e-05 30.237500000000001p 1.2132109999999999e-05 30.25p 1.248515e-05 30.262500000000003p 1.28218e-05 30.274999999999999p 1.314165e-05 30.287499999999998p 1.3444270000000001e-05 30.300000000000001p 1.372929e-05 30.3125p 1.399634e-05 30.325000000000003p 1.42451e-05 30.337499999999999p 1.447525e-05 30.349999999999998p 1.468652e-05 30.362500000000001p 1.487865e-05 30.375p 1.505141e-05
+ 30.387500000000003p 1.5204610000000001e-05 30.399999999999999p 1.5338059999999999e-05 30.412499999999998p 1.5451639999999999e-05 30.425000000000001p 1.5545209999999999e-05 30.4375p 1.5618679999999999e-05 30.450000000000003p 1.5671999999999998e-05 30.462499999999999p 1.5705120000000001e-05 30.474999999999998p 1.5718050000000001e-05 30.487500000000001p 1.5710790000000001e-05 30.499999999999996p 1.5683389999999999e-05 30.512500000000003p 1.563594e-05 30.524999999999999p 1.556852e-05 30.537500000000001p 1.5481260000000001e-05 30.550000000000001p 1.5374320000000001e-05 30.562499999999996p 1.524787e-05 30.575000000000003p 1.510212e-05 30.587499999999999p 1.4937310000000001e-05 30.600000000000001p 1.475367e-05
+ 30.612500000000001p 1.45515e-05 30.624999999999996p 1.433109e-05 30.637500000000003p 1.409277e-05 30.649999999999999p 1.3836890000000001e-05 30.662500000000001p 1.356382e-05 30.675000000000001p 1.327395e-05 30.687499999999996p 1.29677e-05 30.700000000000003p 1.2645499999999999e-05 30.712499999999999p 1.2307799999999999e-05 30.725000000000001p 1.195508e-05 30.737500000000001p 1.158783e-05 30.749999999999996p 1.120655e-05 30.762499999999999p 1.0811780000000001e-05 30.774999999999999p 1.0404050000000001e-05 30.787500000000001p 9.9839309999999992e-06 30.800000000000001p 9.5519799999999996e-06 30.812499999999996p 9.1087869999999994e-06 30.824999999999999p 8.6549519999999997e-06
+ 30.837499999999999p 8.1910830000000004e-06 30.850000000000001p 7.7178030000000008e-06 30.862500000000001p 7.2357419999999999e-06 30.874999999999996p 6.7455419999999999e-06 30.887499999999999p 6.2478510000000001e-06 30.899999999999999p 5.7433270000000002e-06 30.912500000000001p 5.2326340000000002e-06 30.925000000000001p 4.7164399999999997e-06 30.937500000000004p 4.1954209999999996e-06 30.949999999999999p 3.6702550000000001e-06 30.962499999999999p 3.1416230000000001e-06 30.975000000000001p 2.6102099999999999e-06 30.987500000000001p 2.0767e-06 31.000000000000004p 1.5417790000000001e-06 31.012499999999999p 1.006131e-06 31.024999999999999p 4.7044070000000002e-07 31.037500000000001p -6.4611240000000006e-08 31.049999999999997p -5.9834660000000001e-07
+ 31.062500000000004p -1.130091e-06 31.074999999999999p -1.6591759999999999e-06 31.087499999999999p -2.1849379999999998e-06 31.100000000000001p -2.7067190000000002e-06 31.112499999999997p -3.2238719999999998e-06 31.125000000000004p -3.7357530000000001e-06 31.137499999999999p -4.2417319999999996e-06 31.149999999999999p -4.7411859999999996e-06 31.162500000000001p -5.2335040000000001e-06 31.174999999999997p -5.7180839999999999e-06 31.187500000000004p -6.1943400000000004e-06 31.199999999999999p -6.6616949999999998e-06 31.212499999999999p -7.1195869999999998e-06 31.225000000000001p -7.5674700000000004e-06 31.237499999999997p -8.0048100000000007e-06 31.250000000000004p -8.4310889999999995e-06 31.262499999999999p -8.8458079999999995e-06 31.275000000000002p -9.2484799999999999e-06
+ 31.287500000000001p -9.6386389999999995e-06 31.299999999999997p -1.0015839999999999e-05 31.3125p -1.0379640000000001e-05 31.324999999999999p -1.072963e-05 31.337500000000002p -1.106543e-05 31.350000000000001p -1.1386659999999999e-05 31.362499999999997p -1.169296e-05 31.375p -1.1984000000000001e-05 31.387499999999999p -1.225947e-05 31.400000000000002p -1.251908e-05 31.412500000000001p -1.2762559999999999e-05 31.424999999999997p -1.298967e-05 31.4375p -1.3200170000000001e-05 31.449999999999999p -1.339387e-05 31.462500000000002p -1.357058e-05 31.475000000000001p -1.3730149999999999e-05 31.487499999999997p -1.3872440000000001e-05 31.5p -1.399734e-05
+ 31.512499999999999p -1.410476e-05 31.525000000000002p -1.419463e-05 31.537500000000001p -1.426691e-05 31.549999999999997p -1.432157e-05 31.5625p -1.435863e-05 31.574999999999999p -1.437809e-05 31.587500000000002p -1.4380019999999999e-05 31.599999999999998p -1.4364470000000001e-05 31.612499999999997p -1.4331539999999999e-05 31.625p -1.428135e-05 31.637499999999999p -1.421403e-05 31.650000000000002p -1.412973e-05 31.662499999999998p -1.402863e-05 31.675000000000004p -1.391094e-05 31.6875p -1.377687e-05 31.699999999999999p -1.362666e-05 31.712500000000002p -1.3460570000000001e-05 31.724999999999998p -1.327889e-05
+ 31.737500000000004p -1.308189e-05 31.75p -1.286992e-05 31.762499999999999p -1.2643290000000001e-05 31.775000000000002p -1.240235e-05 31.787499999999998p -1.2147489999999999e-05 31.800000000000004p -1.1879070000000001e-05 31.8125p -1.1597509999999999e-05 31.824999999999996p -1.130322e-05 31.837500000000002p -1.099662e-05 31.849999999999998p -1.0678159999999999e-05 31.862500000000001p -1.0348300000000001e-05 31.875p -1.0007509999999999e-05 31.887499999999996p -9.6562700000000006e-06 31.900000000000002p -9.2950690000000004e-06 31.912499999999998p -8.9244129999999994e-06 31.925000000000001p -8.5448139999999999e-06 31.9375p -8.1567949999999992e-06 31.949999999999996p -7.7608860000000006e-06
+ 31.962500000000002p -7.3576249999999997e-06 31.974999999999998p -6.9475549999999996e-06 31.987500000000001p -6.5312290000000004e-06 32p -6.1092010000000001e-06 32.012500000000003p -5.6820330000000003e-06 32.024999999999999p -5.250288e-06 32.037500000000001p -4.8145339999999999e-06 32.050000000000004p -4.3753399999999997e-06 32.0625p -3.9332769999999997e-06 32.075000000000003p -3.488917e-06 32.087499999999999p -3.0428310000000001e-06 32.099999999999994p -2.5955899999999999e-06 32.112500000000004p -2.147763e-06 32.125p -1.6999170000000001e-06 32.137500000000003p -1.2526160000000001e-06 32.149999999999999p -8.0641909999999996e-07 32.162499999999994p -3.6188200000000001e-07 32.175000000000004p 8.0445150000000005e-08
+ 32.1875p 5.2001810000000001e-07 32.200000000000003p 9.562994e-07 32.212499999999999p 1.3887590000000001e-06 32.224999999999994p 1.816874e-06 32.237500000000004p 2.2401310000000002e-06 32.25p 2.6580260000000001e-06 32.262500000000003p 3.0700650000000001e-06 32.274999999999999p 3.475762e-06 32.287499999999994p 3.8746460000000001e-06 32.300000000000004p 4.2662550000000004e-06 32.3125p 4.65014e-06 32.325000000000003p 5.0258649999999997e-06 32.337499999999999p 5.3930050000000002e-06 32.349999999999994p 5.7511519999999996e-06 32.362499999999997p 6.0999099999999997e-06 32.375p 6.4388990000000001e-06 32.387500000000003p 6.7677520000000002e-06 32.399999999999999p 7.0861190000000001e-06
+ 32.412500000000001p 7.3936660000000004e-06 32.424999999999997p 7.690074e-06 32.4375p 7.9750409999999995e-06 32.450000000000003p 8.248281e-06 32.462499999999999p 8.5095269999999993e-06 32.475000000000001p 8.7585279999999992e-06 32.487499999999997p 8.9950490000000001e-06 32.5p 9.2188750000000007e-06 32.512500000000003p 9.4298079999999993e-06 32.524999999999999p 9.6276689999999995e-06 32.537500000000001p 9.8122939999999995e-06 32.549999999999997p 9.9835420000000001e-06 32.5625p 1.014129e-05 32.575000000000003p 1.028542e-05 32.587499999999999p 1.041586e-05 32.600000000000001p 1.0532519999999999e-05 32.612499999999997p 1.0635369999999999e-05 32.625p 1.0724360000000001e-05
+ 32.637500000000003p 1.0799480000000001e-05 32.649999999999999p 1.086074e-05 32.662500000000001p 1.090815e-05 32.674999999999997p 1.0941750000000001e-05 32.6875p 1.09616e-05 32.700000000000003p 1.0967780000000001e-05 32.712499999999999p 1.0960370000000001e-05 32.725000000000001p 1.0939479999999999e-05 32.737499999999997p 1.090525e-05 32.75p 1.08578e-05 32.762500000000003p 1.079729e-05 32.774999999999999p 1.072391e-05 32.787500000000001p 1.063783e-05 32.799999999999997p 1.053927e-05 32.8125p 1.0428439999999999e-05 32.825000000000003p 1.030558e-05 32.837499999999999p 1.017093e-05 32.850000000000001p 1.0024749999999999e-05
+ 32.862499999999997p 9.8673210000000003e-06 32.875p 9.6989249999999996e-06 32.887500000000003p 9.5198630000000006e-06 32.899999999999999p 9.330444e-06 32.912500000000001p 9.1309909999999999e-06 32.924999999999997p 8.921836e-06 32.9375p 8.7033220000000004e-06 32.950000000000003p 8.4758019999999999e-06 32.962499999999999p 8.239636e-06 32.975000000000001p 7.995196e-06 32.987499999999997p 7.7428589999999995e-06 33p 7.4830110000000003e-06 33.012500000000003p 7.2160449999999998e-06 33.024999999999999p 6.9423609999999998e-06 33.037500000000001p 6.6623620000000002e-06 33.049999999999997p 6.3764590000000002e-06 33.0625p 6.0850670000000001e-06 33.075000000000003p 5.7886050000000003e-06
+ 33.087499999999999p 5.4874939999999998e-06 33.100000000000001p 5.1821599999999999e-06 33.112499999999997p 4.8730310000000004e-06 33.125p 4.5605359999999999e-06 33.137500000000003p 4.2451049999999997e-06 33.150000000000006p 3.9271680000000002e-06 33.162500000000001p 3.6071589999999999e-06 33.174999999999997p 3.2855050000000001e-06 33.1875p 2.962638e-06 33.199999999999996p 2.638984e-06 33.212500000000006p 2.3149690000000001e-06 33.225000000000001p 1.9910149999999999e-06 33.237499999999997p 1.667542e-06 33.25p 1.3449649999999999e-06 33.262499999999996p 1.0236959999999999e-06 33.275000000000006p 7.0414e-07 33.287500000000001p 3.8669820000000002e-07 33.299999999999997p 7.1765489999999998e-08
+ 33.3125p -2.402696e-07 33.324999999999996p -5.4902530000000004e-07 33.337500000000006p -8.5412730000000004e-07 33.350000000000001p -1.155209e-06 33.362499999999997p -1.4519109999999999e-06 33.375p -1.7438849999999999e-06 33.387499999999996p -2.030789e-06 33.400000000000006p -2.3122909999999998e-06 33.412500000000001p -2.5880710000000001e-06 33.424999999999997p -2.8578150000000002e-06 33.4375p -3.1212229999999999e-06 33.449999999999996p -3.3780040000000002e-06 33.462499999999999p -3.6278790000000001e-06 33.475000000000001p -3.8705800000000001e-06 33.487499999999997p -4.1058499999999998e-06 33.5p -4.3334449999999996e-06 33.512499999999996p -4.5531329999999999e-06 33.524999999999999p -4.7646930000000003e-06
+ 33.537500000000001p -4.9679189999999998e-06 33.550000000000004p -5.1626159999999999e-06 33.5625p -5.3486029999999998e-06 33.574999999999996p -5.5257100000000002e-06 33.587499999999999p -5.6937820000000004e-06 33.600000000000001p -5.8526779999999997e-06 33.612500000000004p -6.0022690000000003e-06 33.625p -6.1424410000000003e-06 33.637499999999996p -6.2730909999999997e-06 33.649999999999999p -6.3941310000000001e-06 33.662500000000001p -6.5054889999999997e-06 33.675000000000004p -6.6071029999999997e-06 33.6875p -6.698927e-06 33.699999999999996p -6.780926e-06 33.712499999999999p -6.8530819999999996e-06 33.725000000000001p -6.9153880000000004e-06 33.737500000000004p -6.9678520000000002e-06 33.75p -7.0104930000000001e-06
+ 33.762499999999996p -7.0433449999999997e-06 33.774999999999999p -7.066454e-06 33.787500000000001p -7.0798810000000003e-06 33.800000000000004p -7.0836969999999997e-06 33.8125p -7.0779859999999999e-06 33.824999999999996p -7.0628460000000004e-06 33.837499999999999p -7.038385e-06 33.850000000000001p -7.0047250000000001e-06 33.862500000000004p -6.9619960000000003e-06 33.875p -6.9103440000000001e-06 33.887500000000003p -6.8499229999999998e-06 33.899999999999999p -6.7808969999999999e-06 33.912500000000001p -6.7034439999999996e-06 33.925000000000004p -6.6177479999999998e-06 33.9375p -6.5240060000000003e-06 33.950000000000003p -6.4224230000000001e-06 33.962499999999999p -6.3132129999999997e-06 33.974999999999994p -6.1965989999999999e-06
+ 33.987500000000004p -6.072812e-06 34p -5.942092e-06 34.012500000000003p -5.8046850000000003e-06 34.024999999999999p -5.6608470000000003e-06 34.037499999999994p -5.5108370000000002e-06 34.050000000000004p -5.3549229999999998e-06 34.0625p -5.1933779999999999e-06 34.075000000000003p -5.0264809999999998e-06 34.087499999999999p -4.8545160000000003e-06 34.099999999999994p -4.6777710000000002e-06 34.112500000000004p -4.4965390000000001e-06 34.125p -4.3111169999999999e-06 34.137500000000003p -4.1218049999999996e-06 34.149999999999999p -3.9289039999999999e-06 34.162499999999994p -3.732722e-06 34.175000000000004p -3.5335640000000002e-06 34.1875p -3.3317400000000001e-06 34.200000000000003p -3.1275600000000001e-06
+ 34.212499999999999p -2.9213350000000002e-06 34.224999999999994p -2.7133739999999998e-06 34.237499999999997p -2.5039899999999998e-06 34.25p -2.2934919999999999e-06 34.262500000000003p -2.0821899999999999e-06 34.274999999999999p -1.8703900000000001e-06 34.287500000000001p -1.658398e-06 34.299999999999997p -1.4465189999999999e-06 34.3125p -1.235051e-06 34.325000000000003p -1.0242930000000001e-06 34.337499999999999p -8.145392e-07 34.350000000000001p -6.0607870000000003e-07 34.362499999999997p -3.9919750000000001e-07 34.375p -1.9417649999999999e-07 34.387500000000003p 8.708267e-09 34.399999999999999p 2.0918630000000001e-07 34.412500000000001p 4.0699259999999998e-07 34.424999999999997p 6.0186860000000003e-07
+ 34.4375p 7.9356180000000004e-07 34.450000000000003p 9.818266e-07 34.462499999999999p 1.166424e-06 34.475000000000001p 1.347123e-06 34.487499999999997p 1.5236999999999999e-06 34.5p 1.6959379999999999e-06 34.512500000000003p 1.86363e-06 34.524999999999999p 2.026576e-06 34.537500000000001p 2.1845840000000002e-06 34.549999999999997p 2.337473e-06 34.5625p 2.4850680000000001e-06 34.575000000000003p 2.6272049999999999e-06 34.587499999999999p 2.7637299999999999e-06 34.600000000000001p 2.8944959999999999e-06 34.612499999999997p 3.019367e-06 34.625p 3.1382170000000001e-06 34.637500000000003p 3.2509289999999998e-06 34.649999999999999p 3.3573960000000001e-06
+ 34.662500000000001p 3.4575209999999999e-06 34.674999999999997p 3.5512169999999998e-06 34.6875p 3.638408e-06 34.700000000000003p 3.7190260000000002e-06 34.712499999999999p 3.793016e-06 34.725000000000001p 3.8603299999999997e-06 34.737499999999997p 3.9209309999999998e-06 34.75p 3.9747950000000001e-06 34.762500000000003p 4.0219039999999997e-06 34.774999999999999p 4.0622529999999998e-06 34.787500000000001p 4.0958440000000002e-06 34.799999999999997p 4.1226920000000001e-06 34.8125p 4.1428200000000001e-06 34.825000000000003p 4.1562600000000001e-06 34.837499999999999p 4.1630550000000002e-06 34.850000000000001p 4.1632570000000003e-06 34.862499999999997p 4.1569269999999996e-06 34.875p 4.1441349999999998e-06
+ 34.887500000000003p 4.1249600000000001e-06 34.899999999999999p 4.0994909999999998e-06 34.912500000000001p 4.0678219999999996e-06 34.924999999999997p 4.0300600000000003e-06 34.9375p 3.9863170000000001e-06 34.950000000000003p 3.9367139999999999e-06 34.962499999999999p 3.8813789999999999e-06 34.975000000000001p 3.8204489999999997e-06 34.987499999999997p 3.7540660000000001e-06 35p 3.68238e-06 35.012500000000003p 3.6055480000000001e-06 35.025000000000006p 3.5237339999999999e-06 35.037500000000001p 3.4371059999999998e-06 35.049999999999997p 3.3458389999999998e-06 35.0625p 3.250114e-06 35.074999999999996p 3.150117e-06 35.087500000000006p 3.0460370000000001e-06 35.100000000000001p 2.9380719999999999e-06
+ 35.112499999999997p 2.8264190000000001e-06 35.125p 2.7112829999999999e-06 35.137499999999996p 2.5928699999999998e-06 35.150000000000006p 2.471392e-06 35.162500000000001p 2.3470600000000001e-06 35.174999999999997p 2.2200930000000002e-06 35.1875p 2.0907070000000001e-06 35.199999999999996p 1.9591239999999998e-06 35.212500000000006p 1.8255660000000001e-06 35.225000000000001p 1.690255e-06 35.237499999999997p 1.553416e-06 35.25p 1.415275e-06 35.262499999999996p 1.276056e-06 35.275000000000006p 1.135985e-06 35.287500000000001p 9.9528719999999997e-07 35.299999999999997p 8.541866e-07 35.3125p 7.129066e-07 35.324999999999996p 5.7166929999999999e-07
+ 35.337499999999999p 4.3069520000000002e-07 35.350000000000001p 2.9020269999999999e-07 35.362499999999997p 1.5040830000000001e-07 35.375p 1.1525659999999999e-08 35.387499999999996p -1.2623429999999999e-07 35.399999999999999p -2.6266380000000002e-07 35.412500000000001p -3.975583e-07 35.425000000000004p -5.3071719999999998e-07 35.4375p -6.6194360000000005e-07 35.449999999999996p -7.91045e-07 35.462499999999999p -9.1783319999999997e-07 35.475000000000001p -1.042125e-06 35.487500000000004p -1.163741e-06 35.5p -1.282509e-06 35.512499999999996p -1.398261e-06 35.524999999999999p -1.5108349999999999e-06 35.537500000000001p -1.6200730000000001e-06 35.550000000000004p -1.7258259999999999e-06
+ 35.5625p -1.82795e-06 35.574999999999996p -1.9263059999999998e-06 35.587499999999999p -2.0207629999999998e-06 35.600000000000001p -2.1111960000000001e-06 35.612500000000004p -2.1974879999999998e-06 35.625p -2.2795270000000001e-06 35.637499999999996p -2.3572099999999999e-06 35.649999999999999p -2.4304410000000001e-06 35.662500000000001p -2.4991290000000001e-06 35.675000000000004p -2.5631929999999999e-06 35.6875p -2.622559e-06 35.699999999999996p -2.6771580000000001e-06 35.712499999999999p -2.726933e-06 35.725000000000001p -2.7718319999999999e-06 35.737500000000004p -2.8118089999999999e-06 35.75p -2.8468290000000002e-06 35.762500000000003p -2.876863e-06 35.774999999999999p -2.9018899999999998e-06
+ 35.787500000000001p -2.9218970000000001e-06 35.800000000000004p -2.936878e-06 35.8125p -2.946834e-06 35.825000000000003p -2.9517750000000002e-06 35.837499999999999p -2.9517189999999999e-06 35.849999999999994p -2.946689e-06 35.862500000000004p -2.9367179999999998e-06 35.875p -2.9218449999999999e-06 35.887500000000003p -2.9021160000000002e-06 35.899999999999999p -2.8775840000000002e-06 35.912499999999994p -2.8483100000000002e-06 35.925000000000004p -2.8143619999999999e-06 35.9375p -2.7758120000000001e-06 35.950000000000003p -2.7327429999999998e-06 35.962499999999999p -2.68524e-06 35.974999999999994p -2.633398e-06 35.987500000000004p -2.5773150000000001e-06 36p -2.5170959999999999e-06
+ 36.012500000000003p -2.4528539999999998e-06 36.024999999999999p -2.3847039999999999e-06 36.037499999999994p -2.3127680000000001e-06 36.050000000000004p -2.2371740000000001e-06 36.0625p -2.1580529999999999e-06 36.075000000000003p -2.0755420000000002e-06 36.087499999999999p -1.9897819999999999e-06 36.099999999999994p -1.90092e-06 36.112499999999997p -1.809103e-06 36.125p -1.7144860000000001e-06 36.137500000000003p -1.617225e-06 36.149999999999999p -1.51748e-06 36.162500000000001p -1.415415e-06 36.174999999999997p -1.3111959999999999e-06 36.1875p -1.20499e-06 36.200000000000003p -1.096969e-06 36.212499999999999p -9.8730560000000004e-07 36.225000000000001p -8.7617410000000004e-07
+ 36.237499999999997p -7.6375060000000005e-07 36.25p -6.5021240000000002e-07 36.262500000000003p -5.3573769999999997e-07 36.274999999999999p -4.205053e-07 36.287500000000001p -3.0469449999999998e-07 36.299999999999997p -1.8848500000000001e-07 36.3125p -7.2056109999999996e-08 36.325000000000003p 4.441316e-08 36.337499999999999p 1.607444e-07 36.350000000000001p 2.7676e-07 36.362499999999997p 3.9228350000000001e-07 36.375p 5.0713989999999998e-07 36.387500000000003p 6.2115589999999999e-07 36.399999999999999p 7.3415979999999997e-07 36.412500000000001p 8.4598229999999999e-07 36.424999999999997p 9.5645629999999995e-07 36.4375p 1.065417e-06 36.450000000000003p 1.1727039999999999e-06
+ 36.462499999999999p 1.278157e-06 36.475000000000001p 1.381622e-06 36.487499999999997p 1.482946e-06 36.5p 1.581982e-06 36.512500000000003p 1.6785849999999999e-06 36.524999999999999p 1.772615e-06 36.537500000000001p 1.863935e-06 36.549999999999997p 1.9524149999999999e-06 36.5625p 2.0379270000000001e-06 36.575000000000003p 2.12035e-06 36.587499999999999p 2.1995650000000002e-06 36.600000000000001p 2.275461e-06 36.612499999999997p 2.3479309999999998e-06 36.625p 2.416873e-06 36.637500000000003p 2.4821919999999999e-06 36.649999999999999p 2.543796e-06 36.662500000000001p 2.6015999999999998e-06 36.674999999999997p 2.6555269999999999e-06
+ 36.6875p 2.7055019999999998e-06 36.700000000000003p 2.7514590000000002e-06 36.712499999999999p 2.7933360000000002e-06 36.725000000000001p 2.8310789999999999e-06 36.737499999999997p 2.8646379999999998e-06 36.75p 2.893971e-06 36.762500000000003p 2.9190419999999998e-06 36.774999999999999p 2.9398210000000002e-06 36.787500000000001p 2.9562830000000001e-06 36.799999999999997p 2.9684120000000002e-06 36.8125p 2.9761950000000001e-06 36.825000000000003p 2.979629e-06 36.837499999999999p 2.9787139999999999e-06 36.850000000000001p 2.9734589999999999e-06 36.862499999999997p 2.9638770000000001e-06 36.875p 2.9499879999999998e-06 36.887499999999996p 2.9318180000000001e-06 36.900000000000006p 2.9094e-06
+ 36.912500000000001p 2.882771e-06 36.924999999999997p 2.8519760000000002e-06 36.9375p 2.8170650000000002e-06 36.949999999999996p 2.778094e-06 36.962500000000006p 2.7351229999999999e-06 36.975000000000001p 2.6882200000000001e-06 36.987499999999997p 2.637457e-06 37p 2.582911e-06 37.012499999999996p 2.5246660000000001e-06 37.025000000000006p 2.462809e-06 37.037500000000001p 2.3974320000000002e-06 37.049999999999997p 2.3286340000000001e-06 37.0625p 2.2565150000000001e-06 37.074999999999996p 2.1811830000000001e-06 37.087500000000006p 2.1027479999999998e-06 37.100000000000001p 2.0213239999999998e-06 37.112499999999997p 1.9370310000000001e-06 37.125p 1.849991e-06
+ 37.137499999999996p 1.7603290000000001e-06 37.150000000000006p 1.6681749999999999e-06 37.162500000000001p 1.5736620000000001e-06 37.174999999999997p 1.476924e-06 37.1875p 1.3781e-06 37.199999999999996p 1.277331e-06 37.212499999999999p 1.1747590000000001e-06 37.225000000000001p 1.0705299999999999e-06 37.237499999999997p 9.6479130000000006e-07 37.25p 8.5769129999999995e-07 37.262499999999996p 7.4938049999999997e-07 37.274999999999999p 6.4001060000000003e-07 37.287500000000001p 5.2973449999999998e-07 37.300000000000004p 4.1870569999999999e-07 37.3125p 3.0707849999999998e-07 37.324999999999996p 1.9500769999999999e-07 37.337499999999999p 8.2648110000000002e-08 37.350000000000001p -2.9845219999999998e-08
+ 37.362500000000004p -1.423176e-07 37.375p -2.5461469999999998e-07 37.387499999999996p -3.6658289999999998e-07 37.399999999999999p -4.7806939999999999e-07 37.412500000000001p -5.8892249999999997e-07 37.425000000000004p -6.9899149999999998e-07 37.4375p -8.081276e-07 37.449999999999996p -9.161833e-07 37.462499999999999p -1.0230129999999999e-06 37.475000000000001p -1.128474e-06 37.487500000000004p -1.2324240000000001e-06 37.5p -1.3347239999999999e-06 37.512499999999996p -1.4352400000000001e-06 37.524999999999999p -1.533837e-06 37.537500000000001p -1.6303840000000001e-06 37.550000000000004p -1.724755e-06 37.5625p -1.816826e-06 37.574999999999996p -1.9064770000000001e-06
+ 37.587499999999999p -1.9935890000000002e-06 37.600000000000001p -2.0780510000000002e-06 37.612500000000004p -2.1597529999999998e-06 37.625p -2.2385900000000002e-06 37.637500000000003p -2.314461e-06 37.649999999999999p -2.3872690000000002e-06 37.662500000000001p -2.4569230000000001e-06 37.675000000000004p -2.5233329999999999e-06 37.6875p -2.586418e-06 37.700000000000003p -2.6460979999999999e-06 37.712499999999999p -2.7023010000000002e-06 37.724999999999994p -2.7549570000000002e-06 37.737500000000004p -2.804003e-06 37.75p -2.8493800000000001e-06 37.762500000000003p -2.8910349999999998e-06 37.774999999999999p -2.9289189999999999e-06 37.787499999999994p -2.9629879999999999e-06 37.800000000000004p -2.9932060000000002e-06
+ 37.8125p -3.0195399999999999e-06 37.825000000000003p -3.0419609999999998e-06 37.837499999999999p -3.0604489999999998e-06 37.849999999999994p -3.0749870000000001e-06 37.862500000000004p -3.085562e-06 37.875p -3.0921699999999998e-06 37.887500000000003p -3.0948099999999999e-06 37.899999999999999p -3.0934860000000001e-06 37.912499999999994p -3.088209e-06 37.925000000000004p -3.0789939999999999e-06 37.9375p -3.0658599999999999e-06 37.950000000000003p -3.0488349999999998e-06 37.962499999999999p -3.0279479999999999e-06 37.974999999999994p -3.003236e-06 37.987499999999997p -2.9747390000000001e-06 38p -2.9425030000000001e-06 38.012500000000003p -2.9065789999999999e-06 38.024999999999999p -2.867022e-06
+ 38.037500000000001p -2.823892e-06 38.049999999999997p -2.7772540000000001e-06 38.0625p -2.7271760000000001e-06 38.075000000000003p -2.6737330000000002e-06 38.087499999999999p -2.6170020000000002e-06 38.100000000000001p -2.5570650000000001e-06 38.112499999999997p -2.4940070000000002e-06 38.125p -2.4279180000000002e-06 38.137500000000003p -2.3588920000000002e-06 38.149999999999999p -2.2870249999999999e-06 38.162500000000001p -2.2124190000000001e-06 38.174999999999997p -2.1351760000000001e-06 38.1875p -2.0554039999999999e-06 38.200000000000003p -1.9732119999999999e-06 38.212499999999999p -1.888713e-06 38.225000000000001p -1.8020230000000001e-06 38.237499999999997p -1.7132589999999999e-06 38.25p -1.622542e-06
+ 38.262500000000003p -1.529995e-06 38.274999999999999p -1.4357399999999999e-06 38.287500000000001p -1.339906e-06 38.299999999999997p -1.2426190000000001e-06 38.3125p -1.144009e-06 38.325000000000003p -1.0442060000000001e-06 38.337499999999999p -9.4334290000000001e-07 38.350000000000001p -8.4155170000000004e-07 38.362499999999997p -7.3896590000000001e-07 38.375p -6.3571950000000002e-07 38.387500000000003p -5.3194690000000003e-07 38.399999999999999p -4.2778269999999998e-07 38.412500000000001p -3.233614e-07 38.424999999999997p -2.188176e-07 38.4375p -1.142853e-07 38.450000000000003p -9.8981670000000006e-09 38.462499999999999p 9.4210879999999997e-08 38.475000000000001p 1.9790979999999999e-07
+ 38.487499999999997p 3.0106750000000002e-07 38.5p 4.0355430000000002e-07 38.512500000000003p 5.0524159999999997e-07 38.524999999999999p 6.0600260000000001e-07 38.537500000000001p 7.0571199999999999e-07 38.549999999999997p 8.0424649999999997e-07 38.5625p 9.0148470000000005e-07 38.575000000000003p 9.973076e-07 38.587499999999999p 1.091598e-06 38.600000000000001p 1.1842419999999999e-06 38.612499999999997p 1.275127e-06 38.625p 1.364145e-06 38.637500000000003p 1.4511890000000001e-06 38.649999999999999p 1.5361570000000001e-06 38.662500000000001p 1.6189470000000001e-06 38.674999999999997p 1.6994640000000001e-06 38.6875p 1.7776140000000001e-06 38.700000000000003p 1.8533060000000001e-06
+ 38.712499999999999p 1.9264549999999999e-06 38.725000000000001p 1.9969779999999999e-06 38.737499999999997p 2.0647950000000002e-06 38.75p 2.129832e-06 38.762499999999996p 2.1920170000000002e-06 38.775000000000006p 2.2512839999999999e-06 38.787500000000001p 2.3075680000000001e-06 38.799999999999997p 2.3608119999999998e-06 38.8125p 2.41096e-06 38.824999999999996p 2.457961e-06 38.837500000000006p 2.5017710000000002e-06 38.850000000000001p 2.5423460000000002e-06 38.862499999999997p 2.5796490000000001e-06 38.875p 2.6136470000000001e-06 38.887499999999996p 2.6443109999999999e-06 38.900000000000006p 2.671618e-06 38.912500000000001p 2.6955459999999999e-06 38.924999999999997p 2.7160820000000001e-06
+ 38.9375p 2.7332139999999999e-06 38.949999999999996p 2.7469349999999998e-06 38.962500000000006p 2.7572449999999998e-06 38.975000000000001p 2.7641439999999999e-06 38.987499999999997p 2.7676399999999998e-06 39p 2.7677440000000001e-06 39.012499999999996p 2.7644709999999998e-06 39.025000000000006p 2.757842e-06 39.037500000000001p 2.7478799999999999e-06 39.049999999999997p 2.7346130000000002e-06 39.0625p 2.7180749999999998e-06 39.074999999999996p 2.6983000000000001e-06 39.087499999999999p 2.67533e-06 39.100000000000001p 2.6492080000000002e-06 39.112500000000004p 2.6199839999999999e-06 39.125p 2.587708e-06 39.137499999999996p 2.5524369999999999e-06 39.149999999999999p 2.5142290000000002e-06
+ 39.162500000000001p 2.4731460000000001e-06 39.175000000000004p 2.4292559999999998e-06 39.1875p 2.382627e-06 39.199999999999996p 2.3333320000000002e-06 39.212499999999999p 2.2814450000000001e-06 39.225000000000001p 2.2270469999999998e-06 39.237500000000004p 2.1702169999999998e-06 39.25p 2.1110389999999998e-06 39.262499999999996p 2.0496010000000001e-06 39.274999999999999p 1.9859910000000001e-06 39.287500000000001p 1.9203009999999999e-06 39.300000000000004p 1.8526230000000001e-06 39.3125p 1.7830539999999999e-06 39.324999999999996p 1.711691e-06 39.337499999999999p 1.6386329999999999e-06 39.350000000000001p 1.5639810000000001e-06 39.362500000000004p 1.487838e-06 39.375p 1.410306e-06
+ 39.387499999999996p 1.3314920000000001e-06 39.399999999999999p 1.251501e-06 39.412500000000001p 1.1704400000000001e-06 39.425000000000004p 1.0884170000000001e-06 39.4375p 1.005539e-06 39.449999999999996p 9.2191699999999996e-07 39.462499999999999p 8.3765890000000003e-07 39.475000000000001p 7.5287440000000002e-07 39.487500000000004p 6.6767279999999999e-07 39.5p 5.821636e-07 39.512500000000003p 4.9645599999999998e-07 39.524999999999999p 4.1065850000000001e-07 39.537500000000001p 3.2487960000000001e-07 39.550000000000004p 2.3922679999999999e-07 39.5625p 1.53807e-07 39.575000000000003p 6.8725960000000003e-08 39.587499999999999p -1.5911410000000001e-08 39.599999999999994p -1.000015e-07
+ 39.612500000000004p -1.8344189999999999e-07 39.625p -2.6613179999999998e-07 39.637500000000003p -3.4797179999999998e-07 39.649999999999999p -4.2886430000000002e-07 39.662499999999994p -5.0871340000000001e-07 39.675000000000004p -5.8742520000000002e-07 39.6875p -6.6490790000000005e-07 39.700000000000003p -7.4107159999999999e-07 39.712499999999999p -8.1582900000000005e-07 39.724999999999994p -8.8909470000000003e-07 39.737500000000004p -9.6078600000000001e-07 39.75p -1.0308229999999999e-06 39.762500000000003p -1.0991279999999999e-06 39.774999999999999p -1.165626e-06 39.787499999999994p -1.230244e-06 39.800000000000004p -1.2929149999999999e-06 39.8125p -1.3535719999999999e-06 39.825000000000003p -1.4121499999999999e-06
+ 39.837499999999999p -1.468591e-06 39.849999999999994p -1.522837e-06 39.862499999999997p -1.5748350000000001e-06 39.875p -1.6245329999999999e-06 39.887500000000003p -1.671885e-06 39.899999999999999p -1.716847e-06 39.912500000000001p -1.7593780000000001e-06 39.924999999999997p -1.7994399999999999e-06 39.9375p -1.837001e-06 39.950000000000003p -1.87203e-06 39.962499999999999p -1.9044999999999999e-06 39.975000000000001p -1.9343869999999999e-06 39.987499999999997p -1.9616730000000001e-06 40p -1.9863400000000002e-06 40.012500000000003p -2.0083759999999999e-06 40.024999999999999p -2.0277710000000001e-06 40.037500000000001p -2.0445200000000002e-06 40.049999999999997p -2.0586200000000002e-06
+ 40.0625p -2.0700730000000002e-06 40.075000000000003p -2.078882e-06 40.087499999999999p -2.0850559999999998e-06 40.100000000000001p -2.088606e-06 40.112499999999997p -2.0895469999999999e-06 40.125p -2.0878959999999998e-06 40.137500000000003p -2.083675e-06 40.149999999999999p -2.076907e-06 40.162500000000001p -2.0676220000000001e-06 40.174999999999997p -2.0558479999999999e-06 40.1875p -2.041619e-06 40.200000000000003p -2.024973e-06 40.212499999999999p -2.005949e-06 40.225000000000001p -1.9845880000000001e-06 40.237499999999997p -1.9609359999999999e-06 40.25p -1.9350410000000002e-06 40.262500000000003p -1.9069530000000001e-06 40.274999999999999p -1.876724e-06
+ 40.287500000000001p -1.8444099999999999e-06 40.299999999999997p -1.810068e-06 40.3125p -1.773759e-06 40.325000000000003p -1.7355430000000001e-06 40.337499999999999p -1.6954849999999999e-06 40.350000000000001p -1.6536520000000001e-06 40.362499999999997p -1.6101099999999999e-06 40.375p -1.564929e-06 40.387500000000003p -1.51818e-06 40.399999999999999p -1.469936e-06 40.412500000000001p -1.420271e-06 40.424999999999997p -1.3692609999999999e-06 40.4375p -1.316982e-06 40.450000000000003p -1.2635109999999999e-06 40.462499999999999p -1.2089279999999999e-06 40.475000000000001p -1.1533119999999999e-06 40.487499999999997p -1.0967429999999999e-06 40.5p -1.039303e-06
+ 40.512500000000003p -9.8107210000000003e-07 40.524999999999999p -9.2213319999999997e-07 40.537500000000001p -8.6256849999999999e-07 40.549999999999997p -8.0246019999999998e-07 40.5625p -7.4189100000000001e-07 40.575000000000003p -6.8094329999999996e-07 40.587499999999999p -6.1969949999999996e-07 40.600000000000001p -5.5824180000000002e-07 40.612499999999997p -4.9665189999999995e-07 40.625p -4.3501119999999999e-07 40.637499999999996p -3.7340040000000002e-07 40.650000000000006p -3.1189960000000001e-07 40.662500000000001p -2.5058810000000001e-07 40.674999999999997p -1.8954439999999999e-07 40.6875p -1.288458e-07 40.699999999999996p -6.8568799999999999e-08 40.712500000000006p -8.788626e-09 40.725000000000001p 5.0420780000000001e-08
+ 40.737499999999997p 1.089868e-07 40.75p 1.6683820000000001e-07 40.762499999999996p 2.2390550000000001e-07 40.775000000000006p 2.8012040000000002e-07 40.787500000000001p 3.3541670000000002e-07 40.799999999999997p 3.897298e-07 40.8125p 4.4299690000000001e-07 40.824999999999996p 4.951572e-07 40.837500000000006p 5.4615169999999998e-07 40.850000000000001p 5.9592369999999998e-07 40.862499999999997p 6.4441830000000002e-07 40.875p 6.9158309999999997e-07 40.887499999999996p 7.3736769999999996e-07 40.900000000000006p 7.8172399999999999e-07 40.912500000000001p 8.2460619999999995e-07 40.924999999999997p 8.6597089999999995e-07 40.9375p 9.0577719999999996e-07 40.949999999999996p 9.4398639999999999e-07
+ 40.962499999999999p 9.805624999999999e-07 40.975000000000001p 1.0154719999999999e-06 40.987500000000004p 1.048683e-06 41p 1.080169e-06 41.012499999999996p 1.109902e-06 41.024999999999999p 1.1378590000000001e-06 41.037500000000001p 1.1640209999999999e-06 41.050000000000004p 1.1883680000000001e-06 41.0625p 1.2108839999999999e-06 41.074999999999996p 1.2315589999999999e-06 41.087499999999999p 1.25038e-06 41.100000000000001p 1.26734e-06 41.112500000000004p 1.2824340000000001e-06 41.125p 1.2956600000000001e-06 41.137499999999996p 1.307018e-06 41.149999999999999p 1.3165100000000001e-06 41.162500000000001p 1.3241420000000001e-06 41.175000000000004p 1.3299200000000001e-06
+ 41.1875p 1.3338559999999999e-06 41.199999999999996p 1.335962e-06 41.212499999999999p 1.336252e-06 41.225000000000001p 1.3347450000000001e-06 41.237500000000004p 1.331459e-06 41.25p 1.3264159999999999e-06 41.262499999999996p 1.3196409999999999e-06 41.274999999999999p 1.31116e-06 41.287500000000001p 1.301002e-06 41.300000000000004p 1.289196e-06 41.3125p 1.2757750000000001e-06 41.324999999999996p 1.260774e-06 41.337499999999999p 1.244229e-06 41.350000000000001p 1.226178e-06 41.362500000000004p 1.206661e-06 41.375p 1.1857200000000001e-06 41.387500000000003p 1.1633970000000001e-06 41.399999999999999p 1.1397380000000001e-06
+ 41.412500000000001p 1.114788e-06 41.425000000000004p 1.0885949999999999e-06 41.4375p 1.0612089999999999e-06 41.450000000000003p 1.0326779999999999e-06 41.462499999999999p 1.003055e-06 41.474999999999994p 9.7239080000000008e-07 41.487500000000004p 9.4073999999999999e-07 41.5p 9.0815639999999996e-07 41.512500000000003p 8.7469500000000004e-07 41.524999999999999p 8.4041170000000002e-07 41.537499999999994p 8.053628e-07 41.550000000000004p 7.6960549999999995e-07 41.5625p 7.3319720000000003e-07 41.575000000000003p 6.9619589999999995e-07 41.587499999999999p 6.5865989999999995e-07 41.599999999999994p 6.2064749999999997e-07 41.612500000000004p 5.8221760000000001e-07 41.625p 5.4342880000000003e-07
+ 41.637500000000003p 5.0433980000000004e-07 41.649999999999999p 4.6500920000000002e-07 41.662499999999994p 4.2549550000000003e-07 41.675000000000004p 3.8585690000000002e-07 41.6875p 3.4615120000000002e-07 41.700000000000003p 3.0643579999999999e-07 41.712499999999999p 2.6676780000000001e-07 41.724999999999994p 2.2720339999999999e-07 41.737499999999997p 1.8779839999999999e-07 41.75p 1.4860779999999999e-07 41.762500000000003p 1.096858e-07 41.774999999999999p 7.10859e-08 41.787500000000001p 3.2860390000000003e-08 41.799999999999997p -4.9392499999999999e-09 41.8125p -4.226263e-08 41.825000000000003p -7.9060510000000005e-08 41.837499999999999p -1.1528480000000001e-07 41.850000000000001p -1.5088869999999999e-07
+ 41.862499999999997p -1.8582670000000001e-07 41.875p -2.2005450000000001e-07 41.887500000000003p -2.535296e-07 41.899999999999999p -2.8621039999999999e-07 41.912500000000001p -3.1805729999999998e-07 41.924999999999997p -3.49032e-07 41.9375p -3.7909780000000001e-07 41.950000000000003p -4.082198e-07 41.962499999999999p -4.3636449999999999e-07 41.975000000000001p -4.6350040000000001e-07 41.987499999999997p -4.8959749999999997e-07 42p -5.1462759999999997e-07 42.012500000000003p -5.3856449999999999e-07 42.024999999999999p -5.6138360000000005e-07 42.037500000000001p -5.8306219999999997e-07 42.049999999999997p -6.035795e-07 42.0625p -6.2291659999999997e-07 42.075000000000003p -6.4105629999999997e-07
+ 42.087499999999999p -6.5798340000000002e-07 42.100000000000001p -6.7368480000000003e-07 42.112499999999997p -6.8814910000000005e-07 42.125p -7.0136680000000003e-07 42.137500000000003p -7.1333030000000003e-07 42.149999999999999p -7.240341e-07 42.162500000000001p -7.3347440000000004e-07 42.174999999999997p -7.4164939999999997e-07 42.1875p -7.4855909999999999e-07 42.200000000000003p -7.5420540000000002e-07 42.212499999999999p -7.5859209999999996e-07 42.225000000000001p -7.6172480000000002e-07 42.237499999999997p -7.6361090000000003e-07 42.25p -7.6425960000000002e-07 42.262500000000003p -7.6368180000000004e-07 42.274999999999999p -7.6189019999999999e-07 42.287500000000001p -7.5889909999999996e-07 42.299999999999997p -7.5472469999999997e-07
+ 42.3125p -7.4938449999999997e-07 42.325000000000003p -7.4289790000000002e-07 42.337499999999999p -7.3528560000000004e-07 42.350000000000001p -7.2657010000000002e-07 42.362499999999997p -7.1677500000000001e-07 42.375p -7.059256e-07 42.387500000000003p -6.9404850000000001e-07 42.399999999999999p -6.8117160000000004e-07 42.412500000000001p -6.6732419999999996e-07 42.424999999999997p -6.5253659999999999e-07 42.4375p -6.3684050000000004e-07 42.450000000000003p -6.2026849999999999e-07 42.462499999999999p -6.0285449999999999e-07 42.475000000000001p -5.8463320000000003e-07 42.487499999999997p -5.656403e-07 42.5p -5.4591249999999996e-07 42.512499999999996p -5.2548720000000004e-07 42.525000000000006p -5.0440270000000004e-07
+ 42.537500000000001p -4.8269769999999997e-07 42.549999999999997p -4.6041199999999998e-07 42.5625p -4.3758570000000001e-07 42.574999999999996p -4.1425930000000001e-07 42.587500000000006p -3.9047410000000002e-07 42.600000000000001p -3.662715e-07 42.612499999999997p -3.4169329999999999e-07 42.625p -3.1678169999999998e-07 42.637499999999996p -2.9157899999999999e-07 42.650000000000006p -2.6612759999999999e-07 42.662500000000001p -2.4046999999999998e-07 42.674999999999997p -2.146487e-07 42.6875p -1.8870620000000001e-07 42.699999999999996p -1.6268479999999999e-07 42.712500000000006p -1.3662669999999999e-07 42.725000000000001p -1.105738e-07 42.737499999999997p -8.4567770000000006e-08 42.75p -5.8649869999999997e-08
+ 42.762499999999996p -3.2860950000000003e-08 42.775000000000006p -7.2413859999999999e-09 42.787500000000001p 1.8168979999999999e-08 42.799999999999997p 4.3330880000000001e-08 42.8125p 6.8205710000000002e-08 42.824999999999996p 9.2755549999999996e-08 42.837499999999999p 1.169432e-07 42.850000000000001p 1.4073239999999999e-07 42.862500000000004p 1.640874e-07 42.875p 1.8697380000000001e-07 42.887499999999996p 2.093578e-07 42.899999999999999p 2.3120670000000001e-07 42.912500000000001p 2.5248879999999999e-07 42.925000000000004p 2.7317349999999999e-07 42.9375p 2.9323129999999999e-07 42.949999999999996p 3.1263379999999998e-07 42.962499999999999p 3.3135400000000002e-07 42.975000000000001p 3.4936559999999998e-07
+ 42.987500000000004p 3.6664419999999999e-07 43p 3.8316619999999999e-07 43.012499999999996p 3.9890940000000001e-07 43.024999999999999p 4.1385299999999999e-07 43.037500000000001p 4.2797759999999997e-07 43.050000000000004p 4.4126509999999999e-07 43.0625p 4.5369869999999999e-07 43.074999999999996p 4.6526309999999999e-07 43.087499999999999p 4.7594449999999998e-07 43.100000000000001p 4.8573029999999997e-07 43.112500000000004p 4.9460970000000003e-07 43.125p 5.0257299999999996e-07 43.137499999999996p 5.0961210000000002e-07 43.149999999999999p 5.1572039999999998e-07 43.162500000000001p 5.2089279999999999e-07 43.175000000000004p 5.2512550000000003e-07 43.1875p 5.2841630000000004e-07 43.199999999999996p 5.307644e-07
+ 43.212499999999999p 5.3217049999999999e-07 43.225000000000001p 5.3263670000000003e-07 43.237500000000004p 5.3216660000000003e-07 43.25p 5.3076499999999995e-07 43.262500000000003p 5.284385e-07 43.274999999999999p 5.2519470000000001e-07 43.287499999999994p 5.210428e-07 43.300000000000004p 5.1599320000000002e-07 43.3125p 5.1005780000000002e-07 43.325000000000003p 5.0324969999999998e-07 43.337499999999999p 4.9558309999999996e-07 43.349999999999994p 4.8707390000000005e-07 43.362500000000004p 4.7773869999999998e-07 43.375p 4.675957e-07 43.387500000000003p 4.5666410000000001e-07 43.399999999999999p 4.4496409999999998e-07 43.412499999999994p 4.3251710000000003e-07 43.425000000000004p 4.1934570000000003e-07
+ 43.4375p 4.054732e-07 43.450000000000003p 3.909242e-07 43.462499999999999p 3.7572389999999999e-07 43.474999999999994p 3.5989859999999999e-07 43.487500000000004p 3.4347549999999998e-07 43.5p 3.2648240000000002e-07 43.512500000000003p 3.0894789999999998e-07 43.524999999999999p 2.9090160000000002e-07 43.537499999999994p 2.723733e-07 43.550000000000004p 2.5339379999999999e-07 43.5625p 2.3399420000000001e-07 43.575000000000003p 2.142064e-07 43.587499999999999p 1.9406249999999999e-07 43.599999999999994p 1.735952e-07 43.612499999999997p 1.5283749999999999e-07 43.625p 1.318227e-07 43.637500000000003p 1.1058449999999999e-07 43.649999999999999p 8.9156700000000006e-08
+ 43.662500000000001p 6.7573259999999996e-08 43.674999999999997p 4.586832e-08 43.6875p 2.4076089999999999e-08 43.700000000000003p 2.2307660000000001e-09 43.712499999999999p -1.9633459999999999e-08 43.725000000000001p -4.1482489999999998e-08 43.737499999999997p -6.3282349999999996e-08 43.75p -8.4999249999999999e-08 43.762500000000003p -1.0659960000000001e-07 43.774999999999999p -1.280502e-07 43.787500000000001p -1.4931799999999999e-07 43.799999999999997p -1.703705e-07 43.8125p -1.9117540000000001e-07 43.825000000000003p -2.1170109999999999e-07 43.837499999999999p -2.3191639999999999e-07 43.850000000000001p -2.5179060000000001e-07 43.862499999999997p -2.7129370000000002e-07 43.875p -2.9039619999999999e-07
+ 43.887500000000003p -3.0906939999999999e-07 43.899999999999999p -3.2728530000000001e-07 43.912500000000001p -3.4501650000000001e-07 43.924999999999997p -3.6223669999999999e-07 43.9375p -3.7892019999999999e-07 43.950000000000003p -3.9504210000000002e-07 43.962499999999999p -4.1057850000000003e-07 43.975000000000001p -4.255066e-07 43.987499999999997p -4.398042e-07 44p -4.534503e-07 44.012500000000003p -4.6642480000000001e-07 44.024999999999999p -4.7870889999999996e-07 44.037500000000001p -4.9028449999999999e-07 44.049999999999997p -5.0113479999999998e-07 44.0625p -5.1124409999999996e-07 44.075000000000003p -5.2059769999999996e-07 44.087499999999999p -5.2918210000000003e-07 44.100000000000001p -5.3698509999999995e-07
+ 44.112499999999997p -5.4399540000000004e-07 44.125p -5.5020300000000002e-07 44.137500000000003p -5.5559919999999998e-07 44.149999999999999p -5.6017639999999999e-07 44.162500000000001p -5.6392820000000003e-07 44.174999999999997p -5.6684950000000001e-07 44.1875p -5.6893619999999999e-07 44.200000000000003p -5.7018560000000003e-07 44.212499999999999p -5.7059630000000001e-07 44.225000000000001p -5.7016789999999998e-07 44.237499999999997p -5.6890139999999996e-07 44.25p -5.6679880000000001e-07 44.262500000000003p -5.6386349999999996e-07 44.274999999999999p -5.6010000000000005e-07 44.287500000000001p -5.5551399999999998e-07 44.299999999999997p -5.5011240000000002e-07 44.3125p -5.4390310000000002e-07 44.325000000000003p -5.3689540000000004e-07
+ 44.337499999999999p -5.2909959999999997e-07 44.350000000000001p -5.2052700000000004e-07 44.362499999999997p -5.111902e-07 44.375p -5.0110270000000001e-07 44.387499999999996p -4.9027909999999998e-07 44.400000000000006p -4.7873510000000002e-07 44.412500000000001p -4.664872e-07 44.424999999999997p -4.535531e-07 44.4375p -4.3995119999999998e-07 44.449999999999996p -4.2570109999999997e-07 44.462500000000006p -4.1082309999999999e-07 44.475000000000001p -3.9533830000000002e-07 44.487499999999997p -3.7926869999999998e-07 44.5p -3.6263719999999998e-07 44.512499999999996p -3.4546719999999999e-07 44.525000000000006p -3.2778310000000001e-07 44.537500000000001p -3.096097e-07 44.549999999999997p -2.9097260000000003e-07
+ 44.5625p -2.7189799999999999e-07 44.574999999999996p -2.5241270000000002e-07 44.587500000000006p -2.3254399999999999e-07 44.600000000000001p -2.123195e-07 44.612499999999997p -1.9176750000000001e-07 44.625p -1.7091669999999999e-07 44.637499999999996p -1.49796e-07 44.650000000000006p -1.284347e-07 44.662500000000001p -1.068624e-07 44.674999999999997p -8.5109020000000004e-08 44.6875p -6.3204490000000005e-08 44.699999999999996p -4.1179020000000001e-08 44.712499999999999p -1.9062930000000001e-08 44.725000000000001p 3.1134279999999998e-09 44.737500000000004p 2.5319639999999999e-08 44.75p 4.752532e-08 44.762499999999996p 6.9700130000000004e-08 44.774999999999999p 9.1813850000000003e-08
+ 44.787500000000001p 1.138364e-07 44.800000000000004p 1.3573780000000001e-07 44.8125p 1.5748840000000001e-07 44.824999999999996p 1.7905870000000001e-07 44.837499999999999p 2.0041969999999999e-07 44.850000000000001p 2.2154259999999999e-07 44.862500000000004p 2.4239879999999999e-07 44.875p 2.6296049999999998e-07 44.887499999999996p 2.8319999999999999e-07 44.899999999999999p 3.0309040000000002e-07 44.912500000000001p 3.2260510000000001e-07 44.925000000000004p 3.4171810000000001e-07 44.9375p 3.6040410000000002e-07 44.949999999999996p 3.7863829999999998e-07 44.962499999999999p 3.9639670000000002e-07 44.975000000000001p 4.1365590000000002e-07 44.987500000000004p 4.303931e-07 45p 4.4658659999999998e-07
+ 45.012499999999996p 4.6221509999999998e-07 45.024999999999999p 4.772583e-07 45.037500000000001p 4.9169669999999998e-07 45.050000000000004p 5.0551160000000001e-07 45.0625p 5.1868539999999998e-07 45.074999999999996p 5.3120100000000002e-07 45.087499999999999p 5.4304259999999998e-07 45.100000000000001p 5.5419519999999998e-07 45.112500000000004p 5.6464459999999996e-07 45.125p 5.7437769999999995e-07 45.137500000000003p 5.8338259999999998e-07 45.149999999999999p 5.9164800000000003e-07 45.162499999999994p 5.9916379999999999e-07 45.175000000000004p 6.0592109999999998e-07 45.1875p 6.1191159999999996e-07 45.200000000000003p 6.1712859999999997e-07 45.212499999999999p 6.2156580000000004e-07 45.224999999999994p 6.2521859999999999e-07
+ 45.237500000000004p 6.2808300000000003e-07 45.25p 6.3015610000000001e-07 45.262500000000003p 6.3143629999999997e-07 45.274999999999999p 6.3192289999999999e-07 45.287499999999994p 6.3161620000000002e-07 45.300000000000004p 6.3051760000000004e-07 45.3125p 6.2862960000000002e-07 45.325000000000003p 6.2595570000000005e-07 45.337499999999999p 6.2250040000000004e-07 45.349999999999994p 6.1826910000000001e-07 45.362500000000004p 6.1326860000000004e-07 45.375p 6.0750620000000005e-07 45.387500000000003p 6.0099060000000004e-07 45.399999999999999p 5.9373109999999998e-07 45.412499999999994p 5.8573840000000002e-07 45.425000000000004p 5.7702370000000004e-07 45.4375p 5.6759929999999998e-07 45.450000000000003p 5.5747839999999995e-07
+ 45.462499999999999p 5.4667520000000003e-07 45.475000000000001p 5.3520449999999999e-07 45.487499999999997p 5.2308209999999999e-07 45.5p 5.1032459999999999e-07 45.512500000000003p 4.9694929999999996e-07 45.524999999999999p 4.8297430000000002e-07 45.537500000000001p 4.6841860000000001e-07 45.549999999999997p 4.533015e-07 45.5625p 4.3764349999999998e-07 45.575000000000003p 4.2146530000000003e-07 45.587499999999999p 4.0478850000000003e-07 45.600000000000001p 3.8763510000000001e-07 45.612499999999997p 3.700278e-07 45.625p 3.5198969999999999e-07 45.637500000000003p 3.3354460000000002e-07 45.649999999999999p 3.1471640000000002e-07 45.662500000000001p 2.9552970000000002e-07 45.674999999999997p 2.7600960000000003e-07
+ 45.6875p 2.5618120000000002e-07 45.700000000000003p 2.3607009999999999e-07 45.712499999999999p 2.157024e-07 45.725000000000001p 1.95104e-07 45.737499999999997p 1.7430150000000001e-07 45.75p 1.533213e-07 45.762500000000003p 1.3219010000000001e-07 45.774999999999999p 1.109348e-07 45.787500000000001p 8.9582190000000002e-08 45.799999999999997p 6.8159250000000002e-08 45.8125p 4.6692889999999998e-08 45.825000000000003p 2.5210019999999999e-08 45.837499999999999p 3.737465e-09 45.850000000000001p -1.769805e-08 45.862499999999997p -3.9069910000000003e-08 45.875p -6.0351710000000004e-08 45.887500000000003p -8.1517220000000005e-08 45.899999999999999p -1.025404e-07
+ 45.912500000000001p -1.233957e-07 45.924999999999997p -1.4405749999999999e-07 45.9375p -1.6450079999999999e-07 45.950000000000003p -1.8470089999999999e-07 45.962499999999999p -2.046334e-07 45.975000000000001p -2.2427459999999999e-07 45.987499999999997p -2.4360079999999997e-07 46p -2.6258930000000003e-07 46.012500000000003p -2.8121750000000001e-07 46.024999999999999p -2.994635e-07 46.037500000000001p -3.1730610000000001e-07 46.049999999999997p -3.347243e-07 46.0625p -3.5169819999999999e-07 46.075000000000003p -3.6820830000000001e-07 46.087499999999999p -3.8423559999999998e-07 46.100000000000001p -3.9976210000000002e-07 46.112499999999997p -4.1477029999999998e-07 46.125p -4.2924349999999999e-07
+ 46.137500000000003p -4.4316569999999998e-07 46.149999999999999p -4.5652159999999999e-07 46.162500000000001p -4.6929700000000002e-07 46.174999999999997p -4.8147799999999999e-07 46.1875p -4.9305189999999999e-07 46.200000000000003p -5.0400659999999997e-07 46.212499999999999p -5.14331e-07 46.225000000000001p -5.240146e-07 46.237499999999997p -5.3304799999999997e-07 46.25p -5.414225e-07 46.262499999999996p -5.4913040000000002e-07 46.275000000000006p -5.5616479999999997e-07 46.287500000000001p -5.6251950000000002e-07 46.299999999999997p -5.6818959999999999e-07 46.3125p -5.7317060000000005e-07 46.324999999999996p -5.7745939999999998e-07 46.337500000000006p -5.8105319999999999e-07 46.350000000000001p -5.8395070000000004e-07
+ 46.362499999999997p -5.8615089999999997e-07 46.375p -5.8765419999999999e-07 46.387499999999996p -5.8846149999999995e-07 46.400000000000006p -5.8857480000000003e-07 46.412500000000001p -5.8799679999999996e-07 46.424999999999997p -5.8673109999999998e-07 46.4375p -5.8478229999999995e-07 46.449999999999996p -5.8215559999999999e-07 46.462500000000006p -5.788571e-07 46.475000000000001p -5.7489389999999999e-07 46.487499999999997p -5.7027369999999996e-07 46.5p -5.6500500000000002e-07 46.512499999999996p -5.5909710000000004e-07 46.525000000000006p -5.5256019999999995e-07 46.537500000000001p -5.4540489999999999e-07 46.549999999999997p -5.3764299999999997e-07 46.5625p -5.2928650000000001e-07 46.574999999999996p -5.2034849999999998e-07
+ 46.587499999999999p -5.1084249999999995e-07 46.600000000000001p -5.0078269999999996e-07 46.612500000000004p -4.9018410000000001e-07 46.625p -4.7906200000000001e-07 46.637499999999996p -4.6743260000000001e-07 46.649999999999999p -4.553123e-07 46.662500000000001p -4.427184e-07 46.675000000000004p -4.2966829999999998e-07 46.6875p -4.1618039999999998e-07 46.699999999999996p -4.0227299999999999e-07 46.712499999999999p -3.879653e-07 46.725000000000001p -3.7327649999999997e-07 46.737500000000004p -3.5822640000000002e-07 46.75p -3.4283520000000002e-07 46.762499999999996p -3.2712319999999999e-07 46.774999999999999p -3.111112e-07 46.787500000000001p -2.9482020000000003e-07 46.800000000000004p -2.7827130000000002e-07
+ 46.8125p -2.6148609999999998e-07 46.824999999999996p -2.4448599999999998e-07 46.837499999999999p -2.272929e-07 46.850000000000001p -2.0992850000000001e-07 46.862500000000004p -1.9241499999999999e-07 46.875p -1.7477420000000001e-07 46.887499999999996p -1.5702820000000001e-07 46.899999999999999p -1.3919909999999999e-07 46.912500000000001p -1.2130899999999999e-07 46.925000000000004p -1.0337980000000001e-07 46.9375p -8.5433330000000001e-08 46.949999999999996p -6.7491529999999996e-08 46.962499999999999p -4.9576e-08 46.975000000000001p -3.1708259999999999e-08 46.987500000000004p -1.390963e-08 47p 3.7987910000000002e-09 47.012500000000003p 2.139614e-08 47.024999999999999p 3.8861820000000003e-08
+ 47.037499999999994p 5.6175519999999999e-08 47.050000000000004p 7.3317229999999995e-08 47.0625p 9.0267309999999996e-08 47.075000000000003p 1.070065e-07 47.087499999999999p 1.2351579999999999e-07 47.099999999999994p 1.3977669999999999e-07 47.112500000000004p 1.5577120000000001e-07 47.125p 1.714816e-07 47.137500000000003p 1.8689079999999999e-07 47.149999999999999p 2.0198210000000001e-07 47.162499999999994p 2.167392e-07 47.175000000000004p 2.311466e-07 47.1875p 2.451892e-07 47.200000000000003p 2.588523e-07 47.212499999999999p 2.7212199999999998e-07 47.224999999999994p 2.849848e-07 47.237500000000004p 2.9742799999999998e-07 47.25p 3.0943939999999999e-07
+ 47.262500000000003p 3.2100729999999999e-07 47.274999999999999p 3.3212090000000002e-07 47.287499999999994p 3.4276980000000001e-07 47.300000000000004p 3.5294440000000001e-07 47.3125p 3.6263569999999999e-07 47.325000000000003p 3.7183540000000002e-07 47.337499999999999p 3.8053589999999999e-07 47.350000000000001p 3.8873010000000001e-07 47.362499999999997p 3.9641170000000001e-07 47.375p 4.0357530000000002e-07 47.387500000000003p 4.1021579999999999e-07 47.399999999999999p 4.1632909999999999e-07 47.412500000000001p 4.2191159999999998e-07 47.424999999999997p 4.2696050000000002e-07 47.4375p 4.3147360000000002e-07 47.450000000000003p 4.3544949999999998e-07 47.462499999999999p 4.3888750000000002e-07 47.475000000000001p 4.4178729999999999e-07
+ 47.487499999999997p 4.4414969999999999e-07 47.5p 4.4597579999999999e-07 47.512500000000003p 4.4726769999999998e-07 47.524999999999999p 4.4802779999999998e-07 47.537500000000001p 4.482595e-07 47.549999999999997p 4.4796650000000002e-07 47.5625p 4.4715350000000002e-07 47.575000000000003p 4.4582540000000001e-07 47.587499999999999p 4.4398809999999998e-07 47.600000000000001p 4.4164799999999999e-07 47.612499999999997p 4.3881180000000001e-07 47.625p 4.354872e-07 47.637500000000003p 4.3168210000000001e-07 47.649999999999999p 4.2740519999999999e-07 47.662500000000001p 4.2266559999999999e-07 47.674999999999997p 4.1747289999999998e-07 47.6875p 4.1183730000000001e-07 47.700000000000003p 4.0576940000000001e-07
+ 47.712499999999999p 3.9928029999999999e-07 47.725000000000001p 3.9238150000000001e-07 47.737499999999997p 3.8508489999999999e-07 47.75p 3.7740290000000002e-07 47.762500000000003p 3.6934829999999998e-07 47.774999999999999p 3.6093419999999998e-07 47.787500000000001p 3.5217400000000001e-07 47.799999999999997p 3.4308160000000001e-07 47.8125p 3.3367100000000002e-07 47.825000000000003p 3.2395669999999999e-07 47.837499999999999p 3.1395319999999999e-07 47.850000000000001p 3.036756e-07 47.862499999999997p 2.9313900000000002e-07 47.875p 2.823586e-07 47.887500000000003p 2.7135e-07 47.899999999999999p 2.6012879999999998e-07 47.912500000000001p 2.4871099999999998e-07 47.924999999999997p 2.3711229999999999e-07
+ 47.9375p 2.253489e-07 47.950000000000003p 2.134368e-07 47.962499999999999p 2.0139219999999999e-07 47.975000000000001p 1.8923119999999999e-07 47.987499999999997p 1.7697e-07 48p 1.646248e-07 48.012500000000003p 1.522118e-07 48.024999999999999p 1.3974699999999999e-07 48.037500000000001p 1.272463e-07 48.049999999999997p 1.1472579999999999e-07 48.0625p 1.022012e-07 48.075000000000003p 8.9688120000000001e-08 48.087499999999999p 7.7202090000000001e-08 48.100000000000001p 6.4758430000000001e-08 48.112499999999997p 5.2372259999999998e-08 48.125p 4.0058500000000001e-08 48.137499999999996p 2.783181e-08 48.150000000000006p 1.5706640000000001e-08
+ 48.162500000000001p 3.6971539999999998e-09 48.174999999999997p -8.1827619999999998e-09 48.1875p -1.9919520000000002e-08 48.199999999999996p -3.1499839999999999e-08 48.212500000000006p -4.2910789999999999e-08 48.225000000000001p -5.4139739999999997e-08 48.237499999999997p -6.5174469999999996e-08 48.25p -7.6003090000000005e-08 48.262499999999996p -8.6614100000000003e-08 48.275000000000006p -9.6996409999999996e-08 48.287500000000001p -1.0713929999999999e-07 48.299999999999997p -1.170325e-07 48.3125p -1.2666630000000001e-07 48.324999999999996p -1.3603100000000001e-07 48.337500000000006p -1.451179e-07 48.350000000000001p -1.5391829999999999e-07 48.362499999999997p -1.6242420000000001e-07 48.375p -1.706281e-07
+ 48.387499999999996p -1.7852280000000001e-07 48.400000000000006p -1.8610160000000001e-07 48.412500000000001p -1.9335849999999999e-07 48.424999999999997p -2.0028779999999999e-07 48.4375p -2.068842e-07 48.449999999999996p -2.131432e-07 48.462499999999999p -2.1906049999999999e-07 48.475000000000001p -2.2463239999999999e-07 48.487500000000004p -2.2985580000000001e-07 48.5p -2.3472800000000001e-07 48.512499999999996p -2.3924670000000002e-07 48.524999999999999p -2.4341020000000002e-07 48.537500000000001p -2.472175e-07 48.550000000000004p -2.5066769999999998e-07 48.5625p -2.5376049999999998e-07 48.574999999999996p -2.5649640000000002e-07 48.587499999999999p -2.588759e-07 48.600000000000001p -2.6090029999999999e-07
+ 48.612500000000004p -2.6257120000000001e-07 48.625p -2.6389080000000001e-07 48.637499999999996p -2.6486169999999998e-07 48.649999999999999p -2.6548680000000002e-07 48.662500000000001p -2.657697e-07 48.675000000000004p -2.657142e-07 48.6875p -2.6532460000000001e-07 48.699999999999996p -2.6460560000000001e-07 48.712499999999999p -2.6356239999999998e-07 48.725000000000001p -2.6220039999999997e-07 48.737500000000004p -2.605255e-07 48.75p -2.5854399999999999e-07 48.762499999999996p -2.5626250000000001e-07 48.774999999999999p -2.536878e-07 48.787500000000001p -2.5082729999999998e-07 48.800000000000004p -2.4768849999999997e-07 48.8125p -2.4427920000000002e-07 48.824999999999996p -2.406078e-07
+ 48.837499999999999p -2.3668249999999999e-07 48.850000000000001p -2.3251200000000001e-07 48.862500000000004p -2.2810540000000001e-07 48.875p -2.234717e-07 48.887500000000003p -2.186204e-07 48.899999999999999p -2.1356099999999999e-07 48.912499999999994p -2.0830330000000001e-07 48.925000000000004p -2.0285720000000001e-07 48.9375p -1.972327e-07 48.950000000000003p -1.9144020000000001e-07 48.962499999999999p -1.8548990000000001e-07 48.974999999999994p -1.793923e-07 48.987500000000004p -1.7315780000000001e-07 49p -1.6679719999999999e-07 49.012500000000003p -1.60321e-07 49.024999999999999p -1.5374e-07 49.037499999999994p -1.4706490000000001e-07 49.050000000000004p -1.4030640000000001e-07
+ 49.0625p -1.3347520000000001e-07 49.075000000000003p -1.265822e-07 49.087499999999999p -1.1963790000000001e-07 49.099999999999994p -1.126529e-07 49.112500000000004p -1.056379e-07 49.125p -9.8603340000000002e-08 49.137500000000003p -9.1559569999999996e-08 49.149999999999999p -8.4516899999999996e-08 49.162499999999994p -7.7485470000000006e-08 49.175000000000004p -7.047531e-08 49.1875p -6.3496289999999995e-08 49.200000000000003p -5.6558140000000001e-08 49.212499999999999p -4.9670380000000003e-08 49.225000000000001p -4.2842380000000003e-08 49.237499999999997p -3.6083280000000003e-08 49.25p -2.940203e-08 49.262500000000003p -2.2807349999999999e-08 49.274999999999999p -1.6307749999999999e-08
+ 49.287500000000001p -9.9114659999999999e-09 49.299999999999997p -3.626507e-09 49.3125p 2.539388e-09 49.325000000000003p 8.5787460000000004e-09 49.337499999999999p 1.448437e-08 49.350000000000001p 2.024936e-08 49.362499999999997p 2.5867100000000001e-08 49.375p 3.1331260000000001e-08 49.387500000000003p 3.663584e-08 49.399999999999999p 4.177516e-08 49.412500000000001p 4.6743809999999997e-08 49.424999999999997p 5.1536760000000003e-08 49.4375p 5.6149270000000002e-08 49.450000000000003p 6.0576950000000004e-08 49.462499999999999p 6.4815739999999999e-08 49.475000000000001p 6.8861900000000006e-08 49.487499999999997p 7.2712060000000002e-08 49.5p 7.6363179999999998e-08
+ 49.512500000000003p 7.9812549999999997e-08 49.524999999999999p 8.3057819999999997e-08 49.537500000000001p 8.6096989999999997e-08 49.549999999999997p 8.8928370000000006e-08 49.5625p 9.1550659999999995e-08 49.575000000000003p 9.3962860000000001e-08 49.587499999999999p 9.6164349999999999e-08 49.600000000000001p 9.8154809999999993e-08 49.612499999999997p 9.9934290000000006e-08 49.625p 1.015031e-07 49.637500000000003p 1.028621e-07 49.649999999999999p 1.040121e-07 49.662500000000001p 1.0495459999999999e-07 49.674999999999997p 1.056911e-07 49.6875p 1.062238e-07 49.700000000000003p 1.065547e-07 49.712499999999999p 1.066866e-07 49.725000000000001p 1.066222e-07
+ 49.737499999999997p 1.063647e-07 49.75p 1.059175e-07 49.762500000000003p 1.052844e-07 49.774999999999999p 1.044692e-07 49.787500000000001p 1.034762e-07 49.799999999999997p 1.023099e-07 49.8125p 1.009748e-07 49.825000000000003p 9.9475969999999994e-08 49.837499999999999p 9.7818469999999994e-08 49.850000000000001p 9.600764e-08 49.862499999999997p 9.4049009999999994e-08 49.875p 9.19483e-08 49.887500000000003p 8.9711399999999997e-08 49.899999999999999p 8.734436e-08 49.912500000000001p 8.4853389999999997e-08 49.924999999999997p 8.2244839999999995e-08 49.9375p 7.9525200000000003e-08 49.950000000000003p 7.6701059999999999e-08
+ 49.962499999999999p 7.3779139999999993e-08 49.975000000000001p 7.0766260000000003e-08 49.987499999999997p 6.7669299999999998e-08 50p 6.4495240000000007e-08 50.012499999999996p 6.1251119999999996e-08 50.025000000000006p 5.7944010000000002e-08 50.037500000000001p 5.458105e-08 50.049999999999997p 5.1169380000000002e-08 50.0625p 4.7716190000000003e-08 50.074999999999996p 4.4228640000000003e-08 50.087500000000006p 4.0713890000000001e-08 50.100000000000001p 3.7179119999999997e-08 50.112499999999997p 3.3631430000000003e-08 50.125p 3.0077900000000001e-08 50.137499999999996p 2.6525580000000001e-08 50.150000000000006p 2.2981430000000001e-08 50.162500000000001p 1.945234e-08 50.174999999999997p 1.594513e-08
+ 50.1875p 1.2466519999999999e-08 50.199999999999996p 9.0231299999999992e-09 50.212500000000006p 5.6214569999999996e-09 50.225000000000001p 2.2678839999999999e-09 50.237499999999997p -1.0313400000000001e-09 50.25p -4.2701110000000002e-09 50.262499999999996p -7.4424710000000002e-09 50.275000000000006p -1.054262e-08 50.287500000000001p -1.356494e-08 50.299999999999997p -1.650397e-08 50.3125p -1.9354430000000001e-08 50.324999999999996p -2.2111259999999999e-08 50.337499999999999p -2.4769550000000002e-08 50.350000000000001p -2.7324639999999999e-08 50.362500000000004p -2.9772059999999999e-08 50.375p -3.2107550000000001e-08 50.387499999999996p -3.4327070000000003e-08 50.399999999999999p -3.6426840000000001e-08
+ 50.412500000000001p -3.8403270000000003e-08 50.425000000000004p -4.0253040000000003e-08 50.4375p -4.1973029999999998e-08 50.449999999999996p -4.3560420000000002e-08 50.462499999999999p -4.5012579999999999e-08 50.475000000000001p -4.6327170000000003e-08 50.487500000000004p -4.750209e-08 50.5p -4.8535499999999998e-08 50.512499999999996p -4.9425799999999998e-08 50.524999999999999p -5.0171659999999998e-08 50.537500000000001p -5.0772019999999999e-08 50.550000000000004p -5.1226070000000001e-08 50.5625p -5.1533239999999999e-08 50.574999999999996p -5.1693249999999999e-08 50.587499999999999p -5.1706070000000002e-08 50.600000000000001p -5.1571909999999998e-08 50.612500000000004p -5.1291260000000003e-08 50.625p -5.0864849999999998e-08
+ 50.637499999999996p -5.0293659999999998e-08 50.649999999999999p -4.9578930000000001e-08 50.662500000000001p -4.8722140000000003e-08 50.675000000000004p -4.7725019999999999e-08 50.6875p -4.6589520000000001e-08 50.699999999999996p -4.5317850000000001e-08 50.712499999999999p -4.3912430000000001e-08 50.725000000000001p -4.2375929999999999e-08 50.737500000000004p -4.071121e-08 50.75p -3.892137e-08 50.762500000000003p -3.7009709999999999e-08 50.774999999999999p -3.4979740000000003e-08 50.787499999999994p -3.2835169999999997e-08 50.800000000000004p -3.0579880000000001e-08 50.8125p -2.8217969999999999e-08 50.825000000000003p -2.5753680000000001e-08 50.837499999999999p -2.319145e-08 50.849999999999994p -2.0535860000000001e-08
+ 50.862500000000004p -1.7791669999999999e-08 50.875p -1.496377e-08 50.887500000000003p -1.205718e-08 50.899999999999999p -9.0770749999999999e-09 50.912499999999994p -6.0287370000000003e-09 50.925000000000004p -2.9175630000000001e-09 50.9375p 2.5094249999999998e-10 50.950000000000003p 3.4711809999999999e-09 50.962499999999999p 6.7374650000000004e-09 50.974999999999994p 1.004403e-08 50.987500000000004p 1.338505e-08 51p 1.6754630000000001e-08 51.012500000000003p 2.0146820000000001e-08 51.024999999999999p 2.355565e-08 51.037499999999994p 2.69751e-08 51.050000000000004p 3.0399139999999998e-08 51.0625p 3.382172e-08 51.075000000000003p 3.7236789999999997e-08
+ 51.087499999999999p 4.0638299999999999e-08 51.100000000000001p 4.4020239999999997e-08 51.112499999999997p 4.7376590000000003e-08 51.125p 5.0701380000000001e-08 51.137500000000003p 5.3988699999999998e-08 51.149999999999999p 5.7232670000000001e-08 51.162500000000001p 6.0427479999999997e-08 51.174999999999997p 6.3567390000000001e-08 51.1875p 6.6646730000000001e-08 51.200000000000003p 6.9659949999999994e-08 51.212499999999999p 7.2601549999999999e-08 51.225000000000001p 7.5466170000000003e-08 51.237499999999997p 7.8248549999999997e-08 51.25p 8.0943549999999996e-08 51.262500000000003p 8.3546150000000001e-08 51.274999999999999p 8.6051480000000002e-08 51.287500000000001p 8.8454799999999996e-08 51.299999999999997p 9.075155e-08
+ 51.3125p 9.2937269999999994e-08 51.325000000000003p 9.5007729999999999e-08 51.337499999999999p 9.6958810000000001e-08 51.350000000000001p 9.8786609999999998e-08 51.362499999999997p 1.004874e-07 51.375p 1.020576e-07 51.387500000000003p 1.0349389999999999e-07 51.399999999999999p 1.04793e-07 51.412500000000001p 1.0595220000000001e-07 51.424999999999997p 1.069685e-07 51.4375p 1.078395e-07 51.450000000000003p 1.0856280000000001e-07 51.462499999999999p 1.091363e-07 51.475000000000001p 1.095582e-07 51.487499999999997p 1.098267e-07 51.5p 1.099404e-07 51.512500000000003p 1.09898e-07 51.524999999999999p 1.0969870000000001e-07
+ 51.537500000000001p 1.093417e-07 51.549999999999997p 1.088263e-07 51.5625p 1.081524e-07 51.575000000000003p 1.073198e-07 51.587499999999999p 1.063288e-07 51.600000000000001p 1.051797e-07 51.612499999999997p 1.038732e-07 51.625p 1.0241009999999999e-07 51.637500000000003p 1.0079150000000001e-07 51.649999999999999p 9.901883e-08 51.662500000000001p 9.7093520000000002e-08 51.674999999999997p 9.5017400000000005e-08 51.6875p 9.2792439999999996e-08 51.700000000000003p 9.0420859999999995e-08 51.712499999999999p 8.7905099999999997e-08 51.725000000000001p 8.5247790000000003e-08 51.737499999999997p 8.2451770000000002e-08 51.75p 7.9520100000000005e-08
+ 51.762500000000003p 7.6456040000000006e-08 51.774999999999999p 7.3263020000000005e-08 51.787500000000001p 6.9944689999999996e-08 51.799999999999997p 6.6504859999999994e-08 51.8125p 6.2947530000000005e-08 51.825000000000003p 5.927689e-08 51.837500000000006p 5.549728e-08 51.850000000000001p 5.1613190000000001e-08 51.862499999999997p 4.7629299999999999e-08 51.875p 4.3550419999999998e-08 51.887499999999996p 3.9381489999999998e-08 51.900000000000006p 3.512762e-08 51.912500000000001p 3.0794010000000001e-08 51.924999999999997p 2.6385999999999999e-08 51.9375p 2.190906e-08 51.949999999999996p 1.7368740000000001e-08 51.962500000000006p 1.2770709999999999e-08 51.975000000000001p 8.1207069999999996e-09
+ 51.987499999999997p 3.4245720000000001e-09 52p -1.3117849999999999e-09 52.012499999999996p -6.0823879999999999e-09 52.025000000000006p -1.0881199999999999e-08 52.037500000000001p -1.5702139999999999e-08 52.049999999999997p -2.0539069999999999e-08 52.0625p -2.5385839999999998e-08 52.074999999999996p -3.0236239999999997e-08 52.087500000000006p -3.5084090000000001e-08 52.100000000000001p -3.9923150000000001e-08 52.112499999999997p -4.4747229999999997e-08 52.125p -4.9550100000000002e-08 52.137499999999996p -5.4325579999999998e-08 52.150000000000006p -5.9067500000000003e-08 52.162500000000001p -6.3769729999999995e-08 52.174999999999997p -6.8426170000000001e-08 52.1875p -7.3030779999999997e-08 52.199999999999996p -7.7577579999999993e-08
+ 52.212499999999999p -8.206064e-08 52.225000000000001p -8.6474109999999999e-08 52.237500000000004p -9.0812229999999993e-08 52.25p -9.5069329999999995e-08 52.262499999999996p -9.9239810000000006e-08 52.274999999999999p -1.033182e-07 52.287500000000001p -1.0729910000000001e-07 52.300000000000004p -1.1117730000000001e-07 52.3125p -1.149477e-07 52.324999999999996p -1.186053e-07 52.337499999999999p -1.221452e-07 52.350000000000001p -1.2556269999999999e-07 52.362500000000004p -1.2885320000000001e-07 52.375p -1.3201230000000001e-07 52.387499999999996p -1.350359e-07 52.399999999999999p -1.379198e-07 52.412500000000001p -1.4065999999999999e-07 52.425000000000004p -1.4325299999999999e-07
+ 52.4375p -1.456951e-07 52.449999999999996p -1.479831e-07 52.462499999999999p -1.5011359999999999e-07 52.475000000000001p -1.5208379999999999e-07 52.487500000000004p -1.5389089999999999e-07 52.5p -1.555323e-07 52.512499999999996p -1.570056e-07 52.524999999999999p -1.5830880000000001e-07 52.537500000000001p -1.5943979999999999e-07 52.550000000000004p -1.6039690000000001e-07 52.5625p -1.6117869999999999e-07 52.574999999999996p -1.6178370000000001e-07 52.587499999999999p -1.62211e-07 52.600000000000001p -1.6245970000000001e-07 52.612500000000004p -1.625291e-07 52.625p -1.624189e-07 52.637500000000003p -1.6212870000000001e-07 52.649999999999999p -1.6165879999999999e-07
+ 52.662499999999994p -1.6100919999999999e-07 52.675000000000004p -1.6018050000000001e-07 52.6875p -1.591733e-07 52.700000000000003p -1.579886e-07 52.712499999999999p -1.566276e-07 52.724999999999994p -1.5509139999999999e-07 52.737500000000004p -1.5338180000000001e-07 52.75p -1.515004e-07 52.762500000000003p -1.4944919999999999e-07 52.774999999999999p -1.4723049999999999e-07 52.787499999999994p -1.4484650000000001e-07 52.800000000000004p -1.423e-07 52.8125p -1.395936e-07 52.825000000000003p -1.367304e-07 52.837499999999999p -1.3371349999999999e-07 52.849999999999994p -1.3054630000000001e-07 52.862500000000004p -1.2723219999999999e-07 52.875p -1.237751e-07
+ 52.887500000000003p -1.201787e-07 52.899999999999999p -1.1644719999999999e-07 52.912499999999994p -1.125846e-07 52.925000000000004p -1.085955e-07 52.9375p -1.044842e-07 52.950000000000003p -1.002554e-07 52.962499999999999p -9.5913940000000002e-08 52.975000000000001p -9.1464709999999999e-08 52.987499999999997p -8.6912740000000002e-08 53p -8.2263199999999998e-08 53.012500000000003p -7.7521339999999999e-08 53.024999999999999p -7.2692560000000006e-08 53.037500000000001p -6.7782310000000004e-08 53.049999999999997p -6.279616e-08 53.0625p -5.7739749999999999e-08 53.075000000000003p -5.2618819999999998e-08 53.087499999999999p -4.743915e-08 53.100000000000001p -4.2206609999999997e-08
+ 53.112499999999997p -3.6927089999999999e-08 53.125p -3.1606550000000002e-08 53.137500000000003p -2.6251010000000001e-08 53.149999999999999p -2.0866470000000001e-08 53.162500000000001p -1.545901e-08 53.174999999999997p -1.0034700000000001e-08 53.1875p -4.5996070000000003e-09 53.200000000000003p 8.4016829999999998e-10 53.212499999999999p 6.2785469999999999e-09 53.225000000000001p 1.170946e-08 53.237499999999997p 1.712686e-08 53.25p 2.2524720000000002e-08 53.262500000000003p 2.7897040000000001e-08 53.274999999999999p 3.3237899999999997e-08 53.287500000000001p 3.854137e-08 53.299999999999997p 4.3801620000000002e-08 53.3125p 4.9012870000000002e-08 53.325000000000003p 5.4169400000000002e-08
+ 53.337499999999999p 5.9265580000000001e-08 53.350000000000001p 6.4295849999999994e-08 53.362499999999997p 6.9254740000000004e-08 53.375p 7.4136889999999995e-08 53.387500000000003p 7.8937019999999994e-08 53.399999999999999p 8.3649980000000005e-08 53.412500000000001p 8.8270710000000004e-08 53.424999999999997p 9.2794300000000007e-08 53.4375p 9.7215929999999999e-08 53.450000000000003p 1.0153090000000001e-07 53.462499999999999p 1.057348e-07 53.475000000000001p 1.09823e-07 53.487499999999997p 1.137915e-07 53.5p 1.17636e-07 53.512500000000003p 1.2135270000000001e-07 53.524999999999999p 1.249377e-07 53.537500000000001p 1.2838739999999999e-07 53.549999999999997p 1.3169839999999999e-07
+ 53.5625p 1.3486740000000001e-07 53.575000000000003p 1.3789120000000001e-07 53.587499999999999p 1.4076689999999999e-07 53.600000000000001p 1.434917e-07 53.612499999999997p 1.4606320000000001e-07 53.625p 1.4847870000000001e-07 53.637500000000003p 1.5073630000000001e-07 53.649999999999999p 1.5283379999999999e-07 53.662500000000001p 1.547693e-07 53.674999999999997p 1.5654139999999999e-07 53.6875p 1.5814839999999999e-07 53.700000000000003p 1.5958929999999999e-07 53.712500000000006p 1.6086279999999999e-07 53.725000000000001p 1.619682e-07 53.737499999999997p 1.6290470000000001e-07 53.75p 1.6367200000000001e-07 53.762499999999996p 1.6426960000000001e-07 53.775000000000006p 1.6469759999999999e-07
+ 53.787500000000001p 1.6495600000000001e-07 53.799999999999997p 1.6504519999999999e-07 53.8125p 1.6496550000000001e-07 53.824999999999996p 1.647178e-07 53.837500000000006p 1.6430289999999999e-07 53.850000000000001p 1.637218e-07 53.862499999999997p 1.6297580000000001e-07 53.875p 1.620662e-07 53.887499999999996p 1.6099480000000001e-07 53.900000000000006p 1.5976320000000001e-07 53.912500000000001p 1.583735e-07 53.924999999999997p 1.568277e-07 53.9375p 1.551282e-07 53.949999999999996p 1.5327730000000001e-07 53.962500000000006p 1.512778e-07 53.975000000000001p 1.4913229999999999e-07 53.987499999999997p 1.468438e-07 54p 1.4441540000000001e-07
+ 54.012499999999996p 1.418502e-07 54.025000000000006p 1.391517e-07 54.037500000000001p 1.3632320000000001e-07 54.049999999999997p 1.3336849999999999e-07 54.0625p 1.3029129999999999e-07 54.074999999999996p 1.2709540000000001e-07 54.087499999999999p 1.2378480000000001e-07 54.100000000000001p 1.2036349999999999e-07 54.112500000000004p 1.168358e-07 54.125p 1.132059e-07 54.137499999999996p 1.094783e-07 54.149999999999999p 1.0565729999999999e-07 54.162500000000001p 1.017476e-07 54.175000000000004p 9.7753669999999997e-08 54.1875p 9.3680279999999999e-08 54.199999999999996p 8.9532159999999995e-08 54.212499999999999p 8.5314120000000004e-08 54.225000000000001p 8.1031010000000003e-08
+ 54.237500000000004p 7.6687740000000001e-08 54.25p 7.2289259999999997e-08 54.262499999999996p 6.7840529999999994e-08 54.274999999999999p 6.3346570000000007e-08 54.287500000000001p 5.8812390000000003e-08 54.300000000000004p 5.4243030000000001e-08 54.3125p 4.9643540000000003e-08 54.324999999999996p 4.5018980000000001e-08 54.337499999999999p 4.0374379999999997e-08 54.350000000000001p 3.5714800000000002e-08 54.362500000000004p 3.1045240000000001e-08 54.375p 2.6370719999999998e-08 54.387499999999996p 2.1696219999999999e-08 54.399999999999999p 1.7026659999999998e-08 54.412500000000001p 1.2366979999999999e-08 54.425000000000004p 7.7220149999999994e-09 54.4375p 3.0965970000000001e-09 54.449999999999996p -1.5045180000000001e-09
+ 54.462499999999999p -6.0766280000000001e-09 54.475000000000001p -1.061509e-08 54.487500000000004p -1.5115349999999999e-08 54.5p -1.9572900000000001e-08 54.512500000000003p -2.398334e-08 54.524999999999999p -2.8342319999999999e-08 54.537499999999994p -3.2645610000000001e-08 54.550000000000004p -3.688906e-08 54.5625p -4.1068609999999997e-08 54.575000000000003p -4.5180309999999998e-08 54.587499999999999p -4.9220320000000003e-08 54.599999999999994p -5.3184890000000001e-08 54.612500000000004p -5.7070389999999999e-08 54.625p -6.0873320000000001e-08 54.637500000000003p -6.4590290000000004e-08 54.649999999999999p -6.8218010000000006e-08 54.662499999999994p -7.1753360000000003e-08 54.675000000000004p -7.5193299999999993e-08
+ 54.6875p -7.8534949999999999e-08 54.700000000000003p -8.1775549999999999e-08 54.712499999999999p -8.4912479999999994e-08 54.724999999999994p -8.7943269999999995e-08 54.737500000000004p -9.0865560000000006e-08 54.75p -9.3677150000000001e-08 54.762500000000003p -9.6375969999999999e-08 54.774999999999999p -9.89601e-08 54.787499999999994p -1.014278e-07 54.800000000000004p -1.037774e-07 54.8125p -1.060074e-07 54.825000000000003p -1.081165e-07 54.837499999999999p -1.101034e-07 54.850000000000001p -1.119673e-07 54.862499999999997p -1.13707e-07 54.875p -1.1532200000000001e-07 54.887500000000003p -1.168115e-07 54.899999999999999p -1.181752e-07
+ 54.912500000000001p -1.1941270000000001e-07 54.924999999999997p -1.2052379999999999e-07 54.9375p -1.2150860000000001e-07 54.950000000000003p -1.2236709999999999e-07 54.962499999999999p -1.230995e-07 54.975000000000001p -1.2370630000000001e-07 54.987499999999997p -1.24188e-07 55p -1.2454530000000001e-07 55.012500000000003p -1.2477889999999999e-07 55.024999999999999p -1.2488990000000001e-07 55.037500000000001p -1.2487910000000001e-07 55.049999999999997p -1.2474790000000001e-07 55.0625p -1.2449749999999999e-07 55.075000000000003p -1.2412940000000001e-07 55.087499999999999p -1.2364510000000001e-07 55.100000000000001p -1.2304620000000001e-07 55.112499999999997p -1.2233459999999999e-07 55.125p -1.215121e-07
+ 55.137500000000003p -1.2058070000000001e-07 55.149999999999999p -1.1954250000000001e-07 55.162500000000001p -1.1839960000000001e-07 55.174999999999997p -1.171544e-07 55.1875p -1.1580909999999999e-07 55.200000000000003p -1.143664e-07 55.212499999999999p -1.1282869999999999e-07 55.225000000000001p -1.111985e-07 55.237499999999997p -1.094788e-07 55.25p -1.076721e-07 55.262500000000003p -1.057813e-07 55.274999999999999p -1.038094e-07 55.287500000000001p -1.017592e-07 55.299999999999997p -9.9633789999999997e-08 55.3125p -9.7436249999999993e-08 55.325000000000003p -9.5169659999999995e-08 55.337499999999999p -9.2837180000000004e-08 55.350000000000001p -9.0441980000000004e-08
+ 55.362499999999997p -8.7987289999999999e-08 55.375p -8.5476369999999996e-08 55.387500000000003p -8.2912470000000006e-08 55.399999999999999p -8.0298910000000001e-08 55.412500000000001p -7.7638980000000005e-08 55.424999999999997p -7.4936019999999997e-08 55.4375p -7.2193350000000002e-08 55.450000000000003p -6.9414310000000002e-08 55.462499999999999p -6.6602230000000004e-08 55.475000000000001p -6.3760450000000001e-08 55.487499999999997p -6.0892289999999993e-08 55.5p -5.8001059999999997e-08 55.512500000000003p -5.5090039999999998e-08 55.524999999999999p -5.2162520000000001e-08 55.537500000000001p -4.9221750000000002e-08 55.549999999999997p -4.6270939999999999e-08 55.5625p -4.3313289999999999e-08 55.575000000000003p -4.0351939999999997e-08
+ 55.587500000000006p -3.7390039999999999e-08 55.600000000000001p -3.443063e-08 55.612499999999997p -3.1476769999999997e-08 55.625p -2.8531420000000001e-08 55.637499999999996p -2.5597530000000001e-08 55.650000000000006p -2.267797e-08 55.662500000000001p -1.977557e-08 55.674999999999997p -1.689307e-08 55.6875p -1.403319e-08 55.699999999999996p -1.119855e-08 55.712500000000006p -8.391725e-09 55.725000000000001p -5.6152080000000003e-09 55.737499999999997p -2.8714230000000001e-09 55.75p -1.627225e-10 55.762499999999996p 2.50862e-09 55.775000000000006p 5.1404080000000002e-09 55.787500000000001p 7.730523e-09 55.799999999999997p 1.0276930000000001e-08
+ 55.8125p 1.2777669999999999e-08 55.824999999999996p 1.5230880000000001e-08 55.837500000000006p 1.7634770000000002e-08 55.850000000000001p 1.9987650000000001e-08 55.862499999999997p 2.2287889999999999e-08 55.875p 2.453398e-08 55.887499999999996p 2.6724479999999999e-08 55.899999999999999p 2.8858039999999999e-08 55.912500000000001p 3.0933399999999998e-08 55.924999999999997p 3.2949409999999998e-08 55.9375p 3.4904969999999998e-08 55.949999999999996p 3.6799100000000003e-08 55.962499999999999p 3.8630899999999998e-08 55.975000000000001p 4.039957e-08 55.987500000000004p 4.210438e-08 56p 4.3744700000000003e-08 56.012499999999996p 4.5319999999999998e-08 56.024999999999999p 4.6829799999999999e-08
+ 56.037500000000001p 4.8273760000000002e-08 56.050000000000004p 4.9651579999999999e-08 56.0625p 5.0963059999999997e-08 56.074999999999996p 5.2208099999999999e-08 56.087499999999999p 5.3386659999999998e-08 56.100000000000001p 5.44988e-08 56.112500000000004p 5.5544640000000003e-08 56.125p 5.6524390000000002e-08 56.137499999999996p 5.7438330000000001e-08 56.149999999999999p 5.828684e-08 56.162500000000001p 5.9070329999999998e-08 56.175000000000004p 5.9789320000000003e-08 56.1875p 6.0444379999999997e-08 56.199999999999996p 6.1036150000000006e-08 56.212499999999999p 6.1565339999999998e-08 56.225000000000001p 6.2032729999999997e-08 56.237500000000004p 6.2439139999999999e-08 56.25p 6.278547e-08
+ 56.262499999999996p 6.3072659999999996e-08 56.274999999999999p 6.3301719999999997e-08 56.287500000000001p 6.34737e-08 56.300000000000004p 6.3589709999999996e-08 56.3125p 6.3650890000000003e-08 56.324999999999996p 6.3658450000000004e-08 56.337499999999999p 6.3613610000000004e-08 56.350000000000001p 6.3517669999999994e-08 56.362500000000004p 6.3371930000000004e-08 56.375p 6.3177729999999998e-08 56.387500000000003p 6.2936469999999999e-08 56.399999999999999p 6.2649550000000004e-08 56.412499999999994p 6.2318409999999994e-08 56.425000000000004p 6.1944500000000003e-08 56.4375p 6.1529309999999994e-08 56.450000000000003p 6.1074330000000001e-08 56.462499999999999p 6.0581090000000001e-08 56.474999999999994p 6.0051100000000005e-08
+ 56.487500000000004p 5.9485920000000002e-08 56.5p 5.8887080000000002e-08 56.512500000000003p 5.8256149999999997e-08 56.524999999999999p 5.7594670000000001e-08 56.537499999999994p 5.6904209999999999e-08 56.550000000000004p 5.6186329999999997e-08 56.5625p 5.5442569999999997e-08 56.575000000000003p 5.4674479999999998e-08 56.587499999999999p 5.38836e-08 56.599999999999994p 5.307146e-08 56.612500000000004p 5.2239560000000002e-08 56.625p 5.1389419999999999e-08 56.637500000000003p 5.0522489999999998e-08 56.649999999999999p 4.9640260000000003e-08 56.662499999999994p 4.8744160000000001e-08 56.675000000000004p 4.7835599999999997e-08 56.6875p 4.6915969999999998e-08 56.700000000000003p 4.5986650000000001e-08
+ 56.712499999999999p 4.5048969999999999e-08 56.725000000000001p 4.4104230000000003e-08 56.737499999999997p 4.3153709999999997e-08 56.75p 4.219865e-08 56.762500000000003p 4.1240249999999998e-08 56.774999999999999p 4.0279690000000001e-08 56.787500000000001p 3.9318100000000001e-08 56.799999999999997p 3.8356580000000002e-08 56.8125p 3.7396170000000001e-08 56.825000000000003p 3.64379e-08 56.837499999999999p 3.5482739999999997e-08 56.850000000000001p 3.4531630000000002e-08 56.862499999999997p 3.3585440000000001e-08 56.875p 3.2645030000000002e-08 56.887500000000003p 3.171119e-08 56.899999999999999p 3.0784690000000001e-08 56.912500000000001p 2.9866229999999998e-08 56.924999999999997p 2.8956489999999999e-08
+ 56.9375p 2.8056069999999999e-08 56.950000000000003p 2.7165569999999998e-08 56.962499999999999p 2.6285500000000001e-08 56.975000000000001p 2.541634e-08 56.987499999999997p 2.4558550000000001e-08 57p 2.3712500000000001e-08 57.012500000000003p 2.2878550000000001e-08 57.024999999999999p 2.2057e-08 57.037500000000001p 2.1248100000000002e-08 57.049999999999997p 2.0452079999999999e-08 57.0625p 1.9669090000000001e-08 57.075000000000003p 1.8899269999999999e-08 57.087499999999999p 1.8142699999999999e-08 57.100000000000001p 1.7399420000000001e-08 57.112499999999997p 1.666945e-08 57.125p 1.5952730000000001e-08 57.137500000000003p 1.5249210000000001e-08 57.149999999999999p 1.4558759999999999e-08
+ 57.162500000000001p 1.3881229999999999e-08 57.174999999999997p 1.321645e-08 57.1875p 1.256419e-08 57.200000000000003p 1.1924200000000001e-08 57.212499999999999p 1.12962e-08 57.225000000000001p 1.067988e-08 57.237499999999997p 1.0074890000000001e-08 57.25p 9.4808700000000006e-09 57.262500000000003p 8.8974129999999995e-09 57.274999999999999p 8.3241049999999993e-09 57.287500000000001p 7.7605019999999992e-09 57.299999999999997p 7.2061400000000001e-09 57.3125p 6.6605349999999999e-09 57.325000000000003p 6.1231830000000001e-09 57.337499999999999p 5.5935660000000001e-09 57.350000000000001p 5.0711500000000002e-09 57.362499999999997p 4.5553879999999997e-09 57.375p 4.0457200000000004e-09
+ 57.387500000000003p 3.5415790000000002e-09 57.399999999999999p 3.0423870000000002e-09 57.412500000000001p 2.5475610000000002e-09 57.424999999999997p 2.0565130000000001e-09 57.4375p 1.568652e-09 57.450000000000003p 1.0833840000000001e-09 57.462500000000006p 6.0011750000000002e-10 57.475000000000001p 1.1826160000000001e-10 57.487499999999997p -3.627707e-10 57.5p -8.4356100000000004e-10 57.512499999999996p -1.324685e-09 57.525000000000006p -1.806708e-09 57.537500000000001p -2.2901869999999998e-09 57.549999999999997p -2.775668e-09 57.5625p -3.2636830000000002e-09 57.574999999999996p -3.7547480000000003e-09 57.587500000000006p -4.2493659999999997e-09 57.600000000000001p -4.7480209999999998e-09
+ 57.612499999999997p -5.2511790000000002e-09 57.625p -5.7592850000000003e-09 57.637499999999996p -6.2727620000000004e-09 57.650000000000006p -6.792014e-09 57.662500000000001p -7.3174180000000003e-09 57.674999999999997p -7.8493259999999994e-09 57.6875p -8.3880659999999999e-09 57.699999999999996p -8.9339379999999992e-09 57.712500000000006p -9.4872139999999996e-09 57.725000000000001p -1.004814e-08 57.737499999999997p -1.0616919999999999e-08 57.75p -1.1193750000000001e-08 57.762499999999996p -1.177877e-08 57.774999999999999p -1.237211e-08 57.787500000000001p -1.2973849999999999e-08 57.799999999999997p -1.358405e-08 57.8125p -1.420272e-08 57.824999999999996p -1.482985e-08
+ 57.837499999999999p -1.5465400000000002e-08 57.850000000000001p -1.6109279999999999e-08 57.862500000000004p -1.6761369999999999e-08 57.875p -1.7421520000000001e-08 57.887499999999996p -1.8089550000000001e-08 57.899999999999999p -1.876522e-08 57.912500000000001p -1.944828e-08 57.925000000000004p -2.0138429999999999e-08 57.9375p -2.083535e-08 57.949999999999996p -2.1538679999999999e-08 57.962499999999999p -2.2247999999999998e-08 57.975000000000001p -2.29629e-08 57.987500000000004p -2.3682909999999999e-08 58p -2.4407519999999998e-08 58.012499999999996p -2.5136210000000002e-08 58.024999999999999p -2.5868409999999999e-08 58.037500000000001p -2.660353e-08 58.050000000000004p -2.7340940000000001e-08
+ 58.0625p -2.8079990000000001e-08 58.074999999999996p -2.8819989999999999e-08 58.087499999999999p -2.9560239999999998e-08 58.100000000000001p -3.0299989999999997e-08 58.112500000000004p -3.1038479999999997e-08 58.125p -3.1774910000000003e-08 58.137499999999996p -3.2508480000000003e-08 58.149999999999999p -3.3238359999999999e-08 58.162500000000001p -3.396367e-08 58.175000000000004p -3.4683549999999997e-08 58.1875p -3.5397089999999998e-08 58.199999999999996p -3.6103390000000001e-08 58.212499999999991p -3.6801509999999997e-08 58.225000000000001p -3.7490509999999997e-08 58.237500000000004p -3.8169430000000001e-08 58.250000000000007p -3.8837300000000002e-08 58.262499999999996p -3.949314e-08 58.274999999999999p -4.0135959999999997e-08
+ 58.287500000000001p -4.0764770000000001e-08 58.299999999999997p -4.1378560000000002e-08 58.3125p -4.1976329999999997e-08 58.325000000000003p -4.2557069999999998e-08 58.337499999999991p -4.3119760000000001e-08 58.349999999999994p -4.3663409999999997e-08 58.362500000000004p -4.418701e-08 58.375000000000007p -4.4689550000000001e-08 58.387499999999996p -4.517004e-08 58.399999999999999p -4.562749e-08 58.412500000000001p -4.6060930000000002e-08 58.424999999999997p -4.6469379999999999e-08 58.4375p -4.685189e-08 58.450000000000003p -4.7207520000000001e-08 58.462500000000006p -4.7535339999999998e-08 58.474999999999994p -4.7834450000000001e-08 58.487500000000004p -4.8103950000000002e-08 58.500000000000007p -4.8342979999999998e-08
+ 58.512499999999996p -4.8550690000000003e-08 58.524999999999999p -4.8726270000000002e-08 58.537500000000001p -4.88689e-08 58.549999999999997p -4.8977830000000002e-08 58.5625p -4.9052299999999998e-08 58.575000000000003p -4.9091619999999998e-08 58.587500000000006p -4.9095089999999999e-08 58.599999999999994p -4.9062070000000002e-08 58.612499999999997p -4.899194e-08 58.625000000000007p -4.8884120000000001e-08 58.637499999999996p -4.8738069999999999e-08 58.649999999999999p -4.8553280000000001e-08 58.662500000000001p -4.8329290000000002e-08 58.674999999999997p -4.8065659999999999e-08 58.6875p -4.7762000000000001e-08 58.700000000000003p -4.7417989999999998e-08 58.712500000000006p -4.7033299999999998e-08 58.724999999999994p -4.660768e-08
+ 58.737499999999997p -4.614091e-08 58.750000000000007p -4.5632839999999998e-08 58.762499999999996p -4.5083319999999997e-08 58.774999999999999p -4.4492289999999999e-08 58.787500000000001p -4.3859709999999997e-08 58.800000000000004p -4.3185610000000002e-08 58.8125p -4.2470040000000002e-08 58.825000000000003p -4.1713120000000003e-08 58.837500000000006p -4.0915019999999999e-08 58.849999999999994p -4.0075940000000002e-08 58.862499999999997p -3.919616e-08 58.875p -3.8275970000000002e-08 58.887499999999996p -3.7315750000000001e-08 58.899999999999999p -3.63159e-08 58.912500000000001p -3.527688e-08 58.925000000000004p -3.4199199999999998e-08 58.9375p -3.3083420000000001e-08 58.950000000000003p -3.1930149999999997e-08
+ 58.962500000000006p -3.0740040000000002e-08 58.974999999999994p -2.9513810000000001e-08 58.987499999999997p -2.8252190000000001e-08 59p -2.6956e-08 59.012499999999996p -2.562607e-08 59.024999999999999p -2.42633e-08 59.037500000000001p -2.2868639999999999e-08 59.050000000000004p -2.1443050000000002e-08 59.062499999999993p -1.9987569999999999e-08 59.075000000000003p -1.850327e-08 59.087500000000006p -1.699125e-08 59.099999999999994p -1.545268e-08 59.112499999999997p -1.3888729999999999e-08 59.125p -1.230064e-08 59.13750000000001p -1.0689680000000001e-08 59.149999999999999p -9.0571530000000004e-09 59.162500000000001p -7.404393e-09 59.175000000000004p -5.7327739999999999e-09
+ 59.187499999999993p -4.0437010000000003e-09 59.200000000000003p -2.338606e-09 59.212500000000006p -6.1895590000000004e-10 59.224999999999994p 1.1137600000000001e-09 59.237499999999997p 2.8580230000000002e-09 59.25p 4.6122919999999998e-09 59.262500000000003p 6.3750010000000003e-09 59.274999999999999p 8.1445660000000001e-09 59.287500000000001p 9.9193799999999997e-09 59.300000000000004p 1.169782e-08 59.312499999999993p 1.347825e-08 59.325000000000003p 1.5259010000000001e-08 59.337500000000006p 1.7038450000000001e-08 59.349999999999994p 1.8814880000000002e-08 59.362499999999997p 2.0586619999999999e-08 59.375p 2.2351980000000001e-08 59.387500000000003p 2.4109260000000001e-08 59.399999999999999p 2.5856780000000001e-08
+ 59.412500000000001p 2.759282e-08 59.425000000000004p 2.931569e-08 59.437499999999993p 3.1023699999999997e-08 59.449999999999996p 3.2715159999999997e-08 59.462500000000006p 3.4388379999999999e-08 59.474999999999994p 3.604169e-08 59.487499999999997p 3.7673430000000001e-08 59.5p 3.9281940000000001e-08 59.512500000000003p 4.0865589999999998e-08 59.524999999999999p 4.2422770000000002e-08 59.537500000000001p 4.3951859999999997e-08 59.550000000000004p 4.5451299999999998e-08 59.562499999999993p 4.6919510000000002e-08 59.574999999999996p 4.8354970000000002e-08 59.587500000000006p 4.975617e-08 59.600000000000009p 5.1121630000000001e-08 59.612499999999997p 5.2449899999999998e-08 59.625p 5.3739549999999999e-08
+ 59.637500000000003p 5.4989200000000001e-08 59.649999999999999p 5.6197490000000001e-08 59.662500000000001p 5.7363109999999998e-08 59.675000000000004p 5.8484769999999997e-08 59.687499999999993p 5.956125e-08 59.699999999999996p 6.0591329999999996e-08 59.712499999999999p 6.1573850000000004e-08 59.725000000000009p 6.2507719999999996e-08 59.737499999999997p 6.3391850000000001e-08 59.75p 6.4225219999999998e-08 59.762500000000003p 6.5006850000000006e-08 59.774999999999999p 6.5735830000000006e-08 59.787500000000001p 6.6411269999999998e-08 59.800000000000004p 6.703235e-08 59.812499999999993p 6.7598280000000004e-08 59.824999999999996p 6.8108359999999999e-08 59.837499999999999p 6.8561899999999997e-08 59.850000000000009p 6.8958310000000001e-08
+ 59.862499999999997p 6.9297009999999998e-08 59.875p 6.9577519999999995e-08 59.887500000000003p 6.9799380000000004e-08 59.899999999999991p 6.9962199999999999e-08 59.912500000000001p 7.0065659999999998e-08 59.925000000000004p 7.010949e-08 59.937500000000007p 7.0093479999999999e-08 59.949999999999996p 7.0017459999999999e-08 59.962499999999999p 6.9881350000000001e-08 59.975000000000001p 6.9685120000000003e-08 59.987499999999997p 6.9428789999999998e-08 60p 6.9112439999999998e-08 60.012500000000003p 6.8736220000000005e-08 60.024999999999991p 6.8300349999999995e-08 60.037500000000001p 6.7805070000000006e-08 60.050000000000004p 6.7250720000000001e-08 60.062500000000007p 6.6637679999999995e-08 60.074999999999996p 6.5966389999999995e-08
+ 60.087499999999999p 6.5237350000000003e-08 60.100000000000001p 6.4451129999999994e-08 60.112499999999997p 6.3608330000000002e-08 60.125p 6.2709630000000005e-08 60.137500000000003p 6.1755760000000003e-08 60.149999999999991p 6.0747499999999995e-08 60.162499999999994p 5.9685689999999996e-08 60.175000000000004p 5.8571230000000003e-08 60.187500000000007p 5.7405060000000003e-08 60.199999999999996p 5.6188170000000001e-08 60.212499999999999p 5.4921619999999998e-08 60.225000000000001p 5.3606499999999998e-08 60.237499999999997p 5.2243949999999998e-08 60.25p 5.0835180000000003e-08 60.262500000000003p 4.9381419999999999e-08 60.275000000000006p 4.7883949999999998e-08 60.287499999999994p 4.63441e-08 60.300000000000004p 4.4763250000000002e-08
+ 60.312500000000007p 4.31428e-08 60.324999999999996p 4.1484209999999997e-08 60.337499999999999p 3.9788949999999997e-08 60.350000000000001p 3.8058560000000002e-08 60.362499999999997p 3.6294589999999997e-08 60.375p 3.4498629999999998e-08 60.387500000000003p 3.2672310000000003e-08 60.400000000000006p 3.0817269999999997e-08 60.412499999999994p 2.8935200000000002e-08 60.425000000000004p 2.7027800000000001e-08 60.437500000000007p 2.5096799999999999e-08 60.449999999999996p 2.3143949999999999e-08 60.462499999999999p 2.1171020000000001e-08 60.475000000000001p 1.9179809999999999e-08 60.487499999999997p 1.7172109999999999e-08 60.5p 1.514976e-08 60.512500000000003p 1.311459e-08 60.525000000000006p 1.106845e-08
+ 60.537499999999994p 9.0131879999999998e-09 60.549999999999997p 6.9506709999999999e-09 60.562500000000007p 4.882767e-09 60.574999999999996p 2.8113489999999999e-09 60.587499999999999p 7.3828990000000001e-10 60.600000000000001p -1.334538e-09 60.612499999999997p -3.405263e-09 60.625p -5.4720199999999999e-09 60.637500000000003p -7.5329480000000003e-09 60.650000000000006p -9.5861939999999996e-09 60.662499999999994p -1.162992e-08 60.674999999999997p -1.366229e-08 60.687500000000007p -1.5681490000000001e-08 60.699999999999996p -1.7685710000000001e-08 60.712499999999999p -1.9673190000000001e-08 60.725000000000001p -2.1642140000000001e-08 60.737500000000004p -2.3590820000000001e-08 60.75p -2.551752e-08
+ 60.762500000000003p -2.742053e-08 60.775000000000006p -2.929819e-08 60.787499999999994p -3.1148839999999998e-08 60.799999999999997p -3.2970879999999999e-08 60.8125p -3.4762720000000002e-08 60.824999999999996p -3.6522810000000001e-08 60.837499999999999p -3.824962e-08 60.850000000000001p -3.9941679999999998e-08 60.862500000000004p -4.1597539999999999e-08 60.875p -4.3215790000000001e-08 60.887500000000003p -4.4795050000000001e-08 60.900000000000006p -4.6334000000000003e-08 60.912499999999994p -4.7831349999999999e-08 60.924999999999997p -4.9285859999999997e-08 60.9375p -5.0696320000000002e-08 60.949999999999996p -5.2061570000000002e-08 60.962499999999999p -5.3380519999999999e-08 60.975000000000001p -5.4652079999999998e-08
+ 60.987500000000004p -5.5875250000000003e-08 60.999999999999993p -5.704905e-08 61.012500000000003p -5.8172579999999999e-08 61.025000000000006p -5.9244950000000003e-08 61.037499999999994p -6.0265369999999996e-08 61.049999999999997p -6.1233049999999999e-08 61.0625p -6.214729e-08 61.075000000000003p -6.3007420000000005e-08 61.087499999999999p -6.3812840000000006e-08 61.100000000000001p -6.4562999999999994e-08 61.112500000000004p -6.5257380000000002e-08 61.124999999999993p -6.5895550000000005e-08 61.137500000000003p -6.6477109999999996e-08 61.150000000000006p -6.7001730000000007e-08 61.162499999999994p -6.7469109999999996e-08 61.174999999999997p -6.7879029999999998e-08 61.1875p -6.8231319999999993e-08 61.200000000000003p -6.8525849999999999e-08
+ 61.212499999999999p -6.8762550000000001e-08 61.225000000000001p -6.8941419999999997e-08 61.237500000000004p -6.9062500000000001e-08 61.249999999999993p -6.9125879999999995e-08 61.262499999999996p -6.9131709999999993e-08 61.275000000000006p -6.9080179999999998e-08 61.287499999999994p -6.8971559999999996e-08 61.299999999999997p -6.8806140000000006e-08 61.3125p -6.8584289999999994e-08 61.325000000000003p -6.8306409999999995e-08 61.337499999999999p -6.797295e-08 61.350000000000001p -6.7584430000000003e-08 61.362500000000004p -6.7141390000000004e-08 61.374999999999993p -6.6644440000000006e-08 61.387499999999996p -6.609422e-08 61.400000000000006p -6.5491439999999995e-08 61.412500000000009p -6.4836819999999996e-08 61.424999999999997p -6.4131160000000005e-08
+ 61.4375p -6.3375269999999997e-08 61.450000000000003p -6.2570039999999997e-08 61.462499999999999p -6.1716360000000004e-08 61.475000000000001p -6.0815179999999997e-08 61.487500000000004p -5.9867500000000003e-08 61.499999999999993p -5.8874330000000001e-08 61.512499999999996p -5.783674e-08 61.524999999999999p -5.6755830000000001e-08 61.537500000000009p -5.5632709999999999e-08 61.549999999999997p -5.4468549999999998e-08 61.5625p -5.3264550000000003e-08 61.575000000000003p -5.2021929999999998e-08 61.587499999999999p -5.0741930000000003e-08 61.600000000000001p -4.9425830000000001e-08 61.612500000000004p -4.8074930000000003e-08 61.624999999999993p -4.669057e-08 61.637499999999996p -4.5274079999999998e-08 61.649999999999999p -4.3826840000000001e-08
+ 61.662500000000009p -4.2350229999999999e-08 61.674999999999997p -4.0845670000000001e-08 61.6875p -3.931457e-08 61.700000000000003p -3.7758380000000002e-08 61.712499999999991p -3.6178540000000002e-08 61.725000000000001p -3.4576530000000002e-08 61.737500000000004p -3.2953809999999997e-08 61.749999999999993p -3.1311870000000001e-08 61.762499999999996p -2.9652210000000001e-08 61.774999999999999p -2.7976310000000001e-08 61.787500000000009p -2.6285689999999998e-08 61.799999999999997p -2.458185e-08 61.8125p -2.2866290000000001e-08 61.825000000000003p -2.114053e-08 61.837499999999991p -1.9406070000000001e-08 61.850000000000001p -1.766441e-08 61.862500000000004p -1.5917059999999999e-08 61.875000000000007p -1.41655e-08
+ 61.887499999999996p -1.241124e-08 61.899999999999999p -1.0655739999999999e-08 61.912500000000001p -8.9004830000000004e-09 61.924999999999997p -7.1469209999999999e-09 61.9375p -5.3965040000000002e-09 61.950000000000003p -3.6506649999999998e-09 61.962499999999991p -1.9108250000000002e-09 61.975000000000001p -1.783872e-10 61.987500000000004p 1.5452619999999999e-09 62.000000000000007p 3.2587550000000001e-09 62.012499999999996p 4.9607420000000002e-09 62.024999999999999p 6.6498929999999998e-09 62.037500000000001p 8.3249030000000006e-09 62.049999999999997p 9.9844859999999997e-09 62.0625p 1.1627379999999999e-08 62.075000000000003p 1.3252349999999999e-08 62.087499999999991p 1.4858190000000001e-08 62.099999999999994p 1.6443699999999999e-08
+ 62.112500000000004p 1.8007740000000001e-08 62.125000000000007p 1.954917e-08 62.137499999999996p 2.1066890000000001e-08 62.149999999999999p 2.255983e-08 62.162500000000001p 2.4026950000000001e-08 62.174999999999997p 2.5467239999999999e-08 62.1875p 2.687972e-08 62.200000000000003p 2.8263450000000001e-08 62.212500000000006p 2.961751e-08 62.224999999999994p 3.0941019999999999e-08 62.237500000000004p 3.223314e-08 62.250000000000007p 3.3493049999999997e-08 62.262499999999996p 3.4719980000000003e-08 62.274999999999999p 3.5913180000000003e-08 62.287500000000001p 3.707195e-08 62.299999999999997p 3.8195619999999998e-08 62.3125p 3.9283549999999998e-08 62.325000000000003p 4.0335129999999999e-08
+ 62.337500000000006p 4.1349819999999999e-08 62.349999999999994p 4.2327079999999998e-08 62.362499999999997p 4.326642e-08 62.375000000000007p 4.416739e-08 62.387499999999996p 4.5029570000000002e-08 62.399999999999999p 4.5852579999999999e-08 62.412500000000001p 4.6636069999999997e-08 62.424999999999997p 4.7379740000000001e-08 62.4375p 4.8083319999999997e-08 62.450000000000003p 4.8746570000000002e-08 62.462500000000006p 4.936928e-08 62.474999999999994p 4.9951310000000001e-08 62.487499999999997p 5.0492509999999997e-08 62.500000000000007p 5.0992800000000001e-08 62.512499999999996p 5.1452109999999998e-08 62.524999999999999p 5.1870420000000002e-08 62.537500000000001p 5.2247749999999999e-08 62.550000000000004p 5.2584129999999998e-08
+ 62.5625p 5.2879639999999999e-08 62.575000000000003p 5.3134390000000003e-08 62.587500000000006p 5.3348520000000003e-08 62.599999999999994p 5.3522199999999999e-08 62.612499999999997p 5.3655639999999999e-08 62.625p 5.3749079999999999e-08 62.637499999999996p 5.3802770000000002e-08 62.649999999999999p 5.3817010000000001e-08 62.662500000000001p 5.3792129999999998e-08 62.675000000000004p 5.3728470000000001e-08 62.6875p 5.3626420000000001e-08 62.700000000000003p 5.3486369999999999e-08 62.712500000000006p 5.3308760000000001e-08 62.724999999999994p 5.3094039999999998e-08 62.737499999999997p 5.2842700000000002e-08 62.75p 5.255524e-08 62.762499999999996p 5.2232190000000002e-08 62.774999999999999p 5.1874090000000001e-08
+ 62.787500000000001p 5.1481520000000003e-08 62.800000000000004p 5.1055060000000002e-08 62.812499999999993p 5.059534e-08 62.825000000000003p 5.0102980000000002e-08 62.837500000000006p 4.9578629999999998e-08 62.849999999999994p 4.9022949999999999e-08 62.862499999999997p 4.843663e-08 62.875p 4.782037e-08 62.88750000000001p 4.7174890000000002e-08 62.899999999999999p 4.6500900000000002e-08 62.912500000000001p 4.5799139999999997e-08 62.925000000000004p 4.5070389999999998e-08 62.937499999999993p 4.4315390000000002e-08 62.950000000000003p 4.353492e-08 62.962500000000006p 4.2729769999999999e-08 62.974999999999994p 4.1900740000000002e-08 62.987499999999997p 4.104863e-08 63p 4.0174239999999997e-08
+ 63.012500000000003p 3.9278399999999998e-08 63.024999999999999p 3.8361930000000001e-08 63.037500000000001p 3.7425659999999998e-08 63.050000000000004p 3.647041e-08 63.062499999999993p 3.5497040000000003e-08 63.075000000000003p 3.4506369999999997e-08 63.087500000000006p 3.3499259999999998e-08 63.099999999999994p 3.2476539999999999e-08 63.112499999999997p 3.1439049999999997e-08 63.125p 3.0387639999999998e-08 63.137500000000003p 2.9323159999999999e-08 63.149999999999999p 2.8246440000000002e-08 63.162500000000001p 2.715833e-08 63.175000000000004p 2.605967e-08 63.187499999999993p 2.495127e-08 63.199999999999996p 2.383399e-08 63.212500000000006p 2.2708639999999999e-08 63.224999999999994p 2.157604e-08
+ 63.237499999999997p 2.043701e-08 63.25p 1.9292360000000001e-08 63.262500000000003p 1.8142880000000001e-08 63.274999999999999p 1.6989379999999999e-08 63.287500000000001p 1.5832640000000001e-08 63.300000000000004p 1.467344e-08 63.312499999999993p 1.351255e-08 63.324999999999996p 1.2350729999999999e-08 63.337500000000006p 1.118873e-08 63.350000000000009p 1.0027300000000001e-08 63.362499999999997p 8.8671590000000003e-09 63.375p 7.7090399999999993e-09 63.387500000000003p 6.5536490000000001e-09 63.399999999999999p 5.4016849999999998e-09 63.412500000000001p 4.2538349999999999e-09 63.425000000000004p 3.1107749999999999e-09 63.437499999999993p 1.9731679999999999e-09 63.449999999999996p 8.4166470000000002e-10
+ 63.462499999999999p -2.830952e-10 63.475000000000009p -1.4004870000000001e-09 63.487499999999997p -2.5098970000000001e-09 63.5p -3.610726e-09 63.512500000000003p -4.7023869999999998e-09 63.524999999999999p -5.7843089999999999e-09 63.537500000000001p -6.8559300000000003e-09 63.550000000000004p -7.9167069999999999e-09 63.562499999999993p -8.9661059999999997e-09 63.574999999999996p -1.000361e-08 63.587499999999999p -1.1028709999999999e-08 63.600000000000009p -1.2040929999999999e-08 63.612499999999997p -1.3039780000000001e-08 63.625p -1.4024800000000001e-08 63.637500000000003p -1.499554e-08 63.649999999999991p -1.5951570000000001e-08 63.662500000000001p -1.6892470000000001e-08 63.675000000000004p -1.781783e-08
+ 63.687500000000007p -1.872726e-08 63.699999999999996p -1.9620379999999998e-08 63.712499999999999p -2.049682e-08 63.725000000000001p -2.135624e-08 63.737499999999997p -2.2198290000000001e-08 63.75p -2.3022650000000001e-08 63.762500000000003p -2.3829010000000001e-08 63.774999999999991p -2.4617060000000001e-08 63.787500000000001p -2.538654e-08 63.800000000000004p -2.6137149999999999e-08 63.812500000000007p -2.6868650000000002e-08 63.824999999999996p -2.758078e-08 63.837499999999999p -2.8273320000000001e-08 63.850000000000001p -2.8946039999999999e-08 63.862499999999997p -2.9598719999999999e-08 63.875p -3.0231179999999999e-08 63.887500000000003p -3.0843230000000001e-08 63.899999999999991p -3.143468e-08
+ 63.912499999999994p -3.200539e-08 63.925000000000004p -3.2555189999999997e-08 63.937500000000007p -3.3083949999999998e-08 63.949999999999996p -3.3591530000000003e-08 63.962499999999999p -3.4077830000000001e-08 63.975000000000001p -3.4542719999999997e-08 63.987499999999997p -3.4986110000000002e-08 64p -3.5407920000000003e-08 64.012500000000003p -3.5808059999999998e-08 64.025000000000006p -3.6186470000000001e-08 64.037499999999994p -3.6543079999999997e-08 64.049999999999997p -3.6877860000000003e-08 64.0625p -3.7190760000000002e-08 64.075000000000003p -3.7481740000000001e-08 64.087500000000006p -3.7750789999999998e-08 64.100000000000009p -3.7997900000000002e-08 64.112499999999997p -3.822305e-08 64.125p -3.842626e-08
+ 64.137500000000003p -3.860753e-08 64.150000000000006p -3.8766889999999997e-08 64.162499999999994p -3.8904370000000001e-08 64.174999999999997p -3.9019989999999998e-08 64.1875p -3.9113799999999998e-08 64.199999999999989p -3.9185870000000003e-08 64.212500000000006p -3.9236230000000002e-08 64.225000000000009p -3.9264960000000002e-08 64.237499999999997p -3.9272140000000001e-08 64.25p -3.9257840000000002e-08 64.262500000000003p -3.922215e-08 64.275000000000006p -3.9165159999999998e-08 64.287499999999994p -3.9086979999999998e-08 64.299999999999997p -3.8987709999999998e-08 64.3125p -3.8867469999999998e-08 64.324999999999989p -3.8726380000000001e-08 64.337500000000006p -3.856456e-08 64.350000000000009p -3.8382150000000001e-08
+ 64.362499999999997p -3.817929e-08 64.375p -3.7956119999999998e-08 64.387500000000003p -3.7712799999999997e-08 64.400000000000006p -3.7449480000000001e-08 64.412499999999994p -3.7166339999999999e-08 64.424999999999997p -3.6863530000000001e-08 64.4375p -3.6541250000000003e-08 64.449999999999989p -3.6199670000000001e-08 64.462499999999991p -3.5838980000000001e-08 64.475000000000009p -3.5459380000000002e-08 64.487500000000011p -3.5061070000000001e-08 64.5p -3.4644259999999999e-08 64.512500000000003p -3.420915e-08 64.525000000000006p -3.3755980000000002e-08 64.537499999999994p -3.328497e-08 64.549999999999997p -3.2796349999999997e-08 64.5625p -3.2290349999999999e-08 64.574999999999989p -3.1767230000000003e-08
+ 64.587499999999991p -3.122723e-08 64.600000000000009p -3.0670609999999999e-08 64.612500000000011p -3.0097629999999997e-08 64.625p -2.9508570000000002e-08 64.637500000000003p -2.8903689999999999e-08 64.650000000000006p -2.8283289999999999e-08 64.662499999999994p -2.7647650000000001e-08 64.674999999999997p -2.6997059999999999e-08 64.6875p -2.6331829999999999e-08 64.699999999999989p -2.565227e-08 64.712499999999991p -2.4958679999999999e-08 64.724999999999994p -2.4251389999999998e-08 64.737500000000011p -2.3530730000000001e-08 64.75p -2.2797019999999999e-08 64.762500000000003p -2.2050620000000001e-08 64.775000000000006p -2.1291860000000001e-08 64.787499999999994p -2.0521110000000001e-08 64.799999999999997p -1.9738709999999999e-08
+ 64.8125p -1.8945040000000001e-08 64.825000000000003p -1.814047e-08 64.837499999999991p -1.732538e-08 64.849999999999994p -1.650016e-08 64.862500000000011p -1.5665199999999999e-08 64.875p -1.4820890000000001e-08 64.887500000000003p -1.3967650000000001e-08 64.900000000000006p -1.310588e-08 64.912499999999994p -1.2236009999999999e-08 64.924999999999997p -1.1358449999999999e-08 64.9375p -1.0473649999999999e-08 64.950000000000003p -9.5820359999999993e-09 64.962499999999991p -8.6840530000000006e-09 64.974999999999994p -7.7801500000000007e-09 64.987500000000011p -6.8707839999999998e-09 65p -5.956416e-09 65.012500000000003p -5.0375129999999996e-09 65.025000000000006p -4.1145479999999998e-09
+ 65.037499999999994p -3.1880000000000002e-09 65.049999999999997p -2.258352e-09 65.0625p -1.3260919999999999e-09 65.075000000000003p -3.917162e-10 65.087499999999991p 5.4427799999999999e-10 65.099999999999994p 1.481386e-09 65.112499999999997p 2.419101e-09 65.125p 3.3569089999999998e-09 65.137500000000003p 4.2942930000000002e-09 65.150000000000006p 5.2307340000000002e-09 65.162500000000009p 6.1657049999999999e-09 65.174999999999997p 7.0986809999999996e-09 65.1875p 8.0291279999999997e-09 65.200000000000003p 8.9565139999999993e-09 65.212499999999991p 9.8803009999999998e-09 65.224999999999994p 1.079995e-08 65.237499999999997p 1.171492e-08 65.25p 1.262467e-08
+ 65.262500000000003p 1.3528649999999999e-08 65.275000000000006p 1.4426310000000001e-08 65.287500000000009p 1.5317109999999999e-08 65.299999999999997p 1.620051e-08 65.3125p 1.7075950000000001e-08 65.325000000000003p 1.7942879999999999e-08 65.337499999999991p 1.880076e-08 65.349999999999994p 1.9649039999999999e-08 65.362499999999997p 2.0487170000000001e-08 65.375p 2.1314620000000001e-08 65.387500000000003p 2.213083e-08 65.400000000000006p 2.293528e-08 65.412500000000009p 2.372741e-08 65.424999999999997p 2.4506709999999999e-08 65.4375p 2.5272629999999999e-08 65.450000000000003p 2.6024650000000001e-08 65.462499999999991p 2.6762239999999999e-08 65.474999999999994p 2.7484899999999999e-08
+ 65.487499999999997p 2.8192110000000001e-08 65.5p 2.888336e-08 65.512500000000003p 2.9558150000000001e-08 65.525000000000006p 3.0215979999999998e-08 65.537500000000009p 3.0856379999999997e-08 65.549999999999997p 3.1478849999999999e-08 65.5625p 3.2082930000000001e-08 65.575000000000003p 3.2668160000000003e-08 65.587499999999991p 3.3234070000000001e-08 65.599999999999994p 3.3780219999999999e-08 65.612499999999997p 3.4306180000000001e-08 65.625p 3.481152e-08 65.637500000000003p 3.5295820000000003e-08 65.650000000000006p 3.575868e-08 65.662500000000009p 3.6199699999999997e-08 65.674999999999997p 3.6618499999999998e-08 65.6875p 3.7014709999999998e-08 65.700000000000003p 3.7387970000000001e-08
+ 65.712499999999991p 3.7737939999999998e-08 65.724999999999994p 3.8064290000000002e-08 65.737499999999997p 3.8366699999999999e-08 65.75p 3.8644860000000001e-08 65.762500000000003p 3.8898489999999999e-08 65.775000000000006p 3.9127310000000003e-08 65.787500000000009p 3.9331060000000003e-08 65.799999999999997p 3.9509509999999997e-08 65.8125p 3.966241e-08 65.825000000000003p 3.9789570000000003e-08 65.837499999999991p 3.9890790000000002e-08 65.849999999999994p 3.9965879999999997e-08 65.862499999999997p 4.0014689999999998e-08 65.875p 4.0037080000000002e-08 65.887500000000003p 4.0032930000000003e-08 65.900000000000006p 4.0002109999999998e-08 65.912500000000009p 3.994455e-08 65.924999999999997p 3.9860179999999999e-08
+ 65.9375p 3.9748940000000001e-08 65.950000000000003p 3.9610810000000002e-08 65.962500000000006p 3.9445759999999998e-08 65.974999999999994p 3.9253819999999998e-08 65.987499999999997p 3.9034990000000002e-08 66p 3.8789329999999997e-08 66.012499999999989p 3.8516900000000001e-08 66.025000000000006p 3.8217789999999998e-08 66.037500000000009p 3.7892099999999998e-08 66.049999999999997p 3.7539950000000001e-08 66.0625p 3.7161499999999998e-08 66.075000000000003p 3.6756910000000001e-08 66.087500000000006p 3.6326359999999999e-08 66.099999999999994p 3.5870069999999999e-08 66.112499999999997p 3.5388240000000003e-08 66.125p 3.4881139999999998e-08 66.137499999999989p 3.4349030000000002e-08 66.150000000000006p 3.3792189999999997e-08
+ 66.162500000000009p 3.3210930000000003e-08 66.174999999999997p 3.2605570000000003e-08 66.1875p 3.1976469999999999e-08 66.200000000000003p 3.1323979999999997e-08 66.212500000000006p 3.0648499999999998e-08 66.224999999999994p 2.9950420000000002e-08 66.237499999999997p 2.9230169999999999e-08 66.25p 2.8488180000000001e-08 66.262499999999989p 2.7724929999999999e-08 66.275000000000006p 2.6940890000000001e-08 66.287500000000009p 2.613654e-08 66.300000000000011p 2.531242e-08 66.3125p 2.4469039999999998e-08 66.325000000000003p 2.3606960000000001e-08 66.337500000000006p 2.2726749999999999e-08 66.349999999999994p 2.182897e-08 66.362499999999997p 2.0914240000000002e-08 66.375p 1.9983159999999999e-08
+ 66.387499999999989p 1.9036360000000001e-08 66.399999999999991p 1.8074480000000001e-08 66.412500000000009p 1.709819e-08 66.425000000000011p 1.6108139999999999e-08 66.4375p 1.5105030000000002e-08 66.450000000000003p 1.408955e-08 66.462500000000006p 1.30624e-08 66.474999999999994p 1.202432e-08 66.487499999999997p 1.097602e-08 66.5p 9.9182610000000004e-09 66.512499999999989p 8.8517830000000008e-09 66.524999999999991p 7.7773489999999995e-09 66.537500000000009p 6.6957310000000003e-09 66.550000000000011p 5.607708e-09 66.5625p 4.5140639999999996e-09 66.575000000000003p 3.4155939999999998e-09 66.587500000000006p 2.313098e-09 66.599999999999994p 1.2073789999999999e-09
+ 66.612499999999997p 9.924934e-11 66.625p -1.0104770000000001e-09 66.637500000000003p -2.1209810000000002e-09 66.649999999999991p -3.231442e-09 66.662499999999994p -4.3410339999999999e-09 66.675000000000011p -5.4489329999999998e-09 66.6875p -6.5543119999999997e-09 66.700000000000003p -7.6563420000000007e-09 66.712500000000006p -8.7541980000000004e-09 66.724999999999994p -9.8470539999999994e-09 66.737499999999997p -1.093408e-08 66.75p -1.201447e-08 66.762500000000003p -1.308739e-08 66.774999999999991p -1.415203e-08 66.787499999999994p -1.5207570000000001e-08 66.800000000000011p -1.6253230000000001e-08 66.8125p -1.728819e-08 66.825000000000003p -1.831166e-08
+ 66.837500000000006p -1.9322849999999999e-08 66.849999999999994p -2.0321e-08 66.862499999999997p -2.1305330000000001e-08 66.875p -2.2275080000000002e-08 66.887500000000003p -2.32295e-08 66.899999999999991p -2.416785e-08 66.912499999999994p -2.5089399999999999e-08 66.924999999999997p -2.5993450000000001e-08 66.9375p -2.6879279999999999e-08 66.950000000000003p -2.77462e-08 66.962500000000006p -2.859355e-08 66.974999999999994p -2.942064e-08 66.987499999999997p -3.0226850000000002e-08 67p -3.1011530000000002e-08 67.012500000000003p -3.177407e-08 67.024999999999991p -3.2513879999999997e-08 67.037499999999994p -3.3230360000000003e-08 67.049999999999997p -3.3922959999999999e-08
+ 67.0625p -3.459112e-08 67.075000000000003p -3.5234330000000002e-08 67.087500000000006p -3.5852069999999998e-08 67.100000000000009p -3.6443849999999997e-08 67.112499999999997p -3.7009200000000002e-08 67.125p -3.7547679999999997e-08 67.137500000000003p -3.8058859999999999e-08 67.149999999999991p -3.8542319999999998e-08 67.162499999999994p -3.89977e-08 67.174999999999997p -3.9424609999999999e-08 67.1875p -3.9822729999999999e-08 67.200000000000003p -4.019173e-08 67.212500000000006p -4.053131e-08 67.225000000000009p -4.0841210000000002e-08 67.237499999999997p -4.1121179999999999e-08 67.25p -4.1370989999999997e-08 67.262500000000003p -4.1590439999999999e-08 67.274999999999991p -4.1779349999999999e-08
+ 67.287499999999994p -4.193756e-08 67.299999999999997p -4.206496e-08 67.3125p -4.2161430000000001e-08 67.325000000000003p -4.2226890000000003e-08 67.337500000000006p -4.2261289999999997e-08 67.350000000000009p -4.22646e-08 67.362499999999997p -4.2236799999999999e-08 67.375p -4.217793e-08 67.387500000000003p -4.2088010000000003e-08 67.399999999999991p -4.196712e-08 67.412499999999994p -4.1815360000000003e-08 67.424999999999997p -4.1632829999999998e-08 67.4375p -4.141968e-08 67.450000000000003p -4.117607e-08 67.462500000000006p -4.0902200000000002e-08 67.475000000000009p -4.0598269999999997e-08 67.487499999999997p -4.0264520000000003e-08 67.5p -3.9901219999999998e-08
+ 67.512500000000003p -3.9508650000000001e-08 67.524999999999991p -3.9087120000000003e-08 67.537499999999994p -3.8636950000000001e-08 67.549999999999997p -3.8158499999999997e-08 67.5625p -3.7652139999999997e-08 67.575000000000003p -3.7118279999999999e-08 67.587500000000006p -3.6557319999999997e-08 67.600000000000009p -3.5969720000000001e-08 67.612499999999997p -3.5355919999999997e-08 67.625p -3.471642e-08 67.637500000000003p -3.405171e-08 67.649999999999991p -3.3362320000000001e-08 67.662499999999994p -3.2648779999999999e-08 67.674999999999997p -3.1911650000000002e-08 67.6875p -3.1151510000000003e-08 67.700000000000003p -3.0368959999999999e-08 67.712500000000006p -2.9564609999999998e-08 67.725000000000009p -2.8739079999999999e-08
+ 67.737499999999997p -2.789302e-08 67.75p -2.702709e-08 67.762500000000003p -2.614197e-08 67.775000000000006p -2.523834e-08 67.787499999999994p -2.431692e-08 67.799999999999997p -2.3378410000000001e-08 67.8125p -2.2423550000000002e-08 67.825000000000003p -2.1453079999999999e-08 67.837500000000006p -2.0467750000000001e-08 67.850000000000009p -1.9468329999999999e-08 67.862499999999997p -1.8455579999999998e-08 67.875p -1.7430310000000001e-08 67.887500000000003p -1.639328e-08 67.900000000000006p -1.5345319999999999e-08 67.912499999999994p -1.428722e-08 67.924999999999997p -1.3219799999999999e-08 67.9375p -1.2143879999999999e-08 67.949999999999989p -1.1060289999999999e-08
+ 67.962500000000006p -9.9698559999999997e-09 67.975000000000009p -8.8734159999999997e-09 67.987499999999997p -7.7718090000000004e-09 68p -6.6658749999999998e-09 68.012500000000003p -5.5564570000000003e-09 68.025000000000006p -4.4444000000000001e-09 68.037499999999994p -3.3305499999999998e-09 68.049999999999997p -2.2157499999999999e-09 68.0625p -1.100845e-09 68.074999999999989p 1.332191e-11 68.087500000000006p 1.125911e-09 68.100000000000009p 2.236084e-09 68.112499999999997p 3.3430069999999999e-09 68.125p 4.4458499999999999e-09 68.137500000000003p 5.5437880000000001e-09 68.150000000000006p 6.6360019999999996e-09 68.162499999999994p 7.7216789999999998e-09 68.174999999999997p 8.8000109999999996e-09
+ 68.1875p 9.8701999999999993e-09 68.199999999999989p 1.093145e-08 68.212499999999991p 1.1982990000000001e-08 68.225000000000009p 1.3024039999999999e-08 68.237500000000011p 1.405384e-08 68.25p 1.5071629999999999e-08 68.262500000000003p 1.607667e-08 68.275000000000006p 1.7068240000000001e-08 68.287499999999994p 1.804561e-08 68.299999999999997p 1.9008089999999999e-08 68.3125p 1.9954969999999999e-08 68.324999999999989p 2.0885590000000001e-08 68.337499999999991p 2.1799279999999999e-08 68.350000000000009p 2.2695380000000001e-08 68.362500000000011p 2.3573269999999999e-08 68.375p 2.4432329999999999e-08 68.387500000000003p 2.527196e-08 68.400000000000006p 2.6091570000000002e-08
+ 68.412499999999994p 2.6890600000000001e-08 68.424999999999997p 2.7668490000000001e-08 68.4375p 2.8424710000000002e-08 68.449999999999989p 2.915874e-08 68.462499999999991p 2.9870100000000001e-08 68.474999999999994p 3.0558310000000001e-08 68.487500000000011p 3.1222900000000002e-08 68.5p 3.1863429999999997e-08 68.512500000000003p 3.2479500000000003e-08 68.525000000000006p 3.3070700000000002e-08 68.537499999999994p 3.363665e-08 68.549999999999997p 3.4176989999999999e-08 68.5625p 3.4691390000000001e-08 68.575000000000003p 3.5179529999999997e-08 68.587499999999991p 3.564112e-08 68.599999999999994p 3.6075870000000003e-08 68.612500000000011p 3.648355e-08 68.625p 3.6863910000000003e-08
+ 68.637500000000003p 3.7216750000000001e-08 68.650000000000006p 3.7541880000000001e-08 68.662499999999994p 3.7839130000000001e-08 68.674999999999997p 3.8108369999999998e-08 68.6875p 3.8349449999999999e-08 68.700000000000003p 3.8562289999999998e-08 68.712499999999991p 3.8746810000000002e-08 68.724999999999994p 3.8902940000000002e-08 68.737500000000011p 3.9030659999999998e-08 68.75p 3.9129949999999998e-08 68.762500000000003p 3.9200799999999997e-08 68.775000000000006p 3.9243270000000003e-08 68.787499999999994p 3.9257389999999997e-08 68.799999999999997p 3.9243230000000003e-08 68.8125p 3.9200889999999999e-08 68.825000000000003p 3.9130489999999998e-08 68.837499999999991p 3.9032150000000003e-08 68.849999999999994p 3.8906030000000001e-08
+ 68.862499999999997p 3.8752299999999998e-08 68.875p 3.8571170000000003e-08 68.887500000000003p 3.8362839999999999e-08 68.900000000000006p 3.8127549999999998e-08 68.912500000000009p 3.7865560000000002e-08 68.924999999999997p 3.7577130000000001e-08 68.9375p 3.726256e-08 68.950000000000003p 3.6922160000000003e-08 68.962499999999991p 3.6556259999999997e-08 68.974999999999994p 3.6165199999999997e-08 68.987499999999997p 3.5749340000000001e-08 69p 3.5309069999999998e-08 69.012500000000003p 3.4844780000000001e-08 69.025000000000006p 3.4356889999999999e-08 69.037500000000009p 3.3845830000000003e-08 69.049999999999997p 3.3312029999999997e-08 69.0625p 3.2755970000000003e-08 69.075000000000003p 3.2178110000000001e-08
+ 69.087499999999991p 3.1578940000000002e-08 69.099999999999994p 3.0958970000000003e-08 69.112499999999997p 3.0318699999999999e-08 69.125p 2.9658680000000002e-08 69.137500000000003p 2.8979429999999999e-08 69.150000000000006p 2.8281520000000001e-08 69.162500000000009p 2.75655e-08 69.174999999999997p 2.6831959999999999e-08 69.1875p 2.6081470000000001e-08 69.200000000000003p 2.531463e-08 69.212499999999991p 2.453206e-08 69.224999999999994p 2.3734349999999998e-08 69.237499999999997p 2.292213e-08 69.25p 2.2096040000000001e-08 69.262500000000003p 2.125671e-08 69.275000000000006p 2.0404779999999999e-08 69.287500000000009p 1.9540910000000001e-08 69.299999999999997p 1.866575e-08
+ 69.3125p 1.7779970000000001e-08 69.325000000000003p 1.6884230000000001e-08 69.337499999999991p 1.5979200000000001e-08 69.349999999999994p 1.506555e-08 69.362499999999997p 1.4143979999999999e-08 69.375p 1.321514e-08 69.387500000000003p 1.227974e-08 69.400000000000006p 1.133845e-08 69.412500000000009p 1.039195e-08 69.424999999999997p 9.4409450000000006e-09 69.4375p 8.486107e-09 69.450000000000003p 7.5281280000000007e-09 69.462499999999991p 6.5676909999999996e-09 69.474999999999994p 5.6054809999999999e-09 69.487499999999997p 4.6421790000000003e-09 69.5p 3.678466e-09 69.512500000000003p 2.7150180000000002e-09 69.525000000000006p 1.752508e-09
+ 69.537500000000009p 7.9160750000000005e-10 69.549999999999997p -1.6701929999999999e-10 69.5625p -1.1227110000000001e-09 69.575000000000003p -2.074812e-09 69.587499999999991p -3.022673e-09 69.599999999999994p -3.9656490000000004e-09 69.612499999999997p -4.9031020000000004e-09 69.625p -5.8344009999999999e-09 69.637500000000003p -6.7589240000000001e-09 69.650000000000006p -7.6760530000000007e-09 69.662500000000009p -8.5851829999999992e-09 69.674999999999997p -9.4857120000000005e-09 69.6875p -1.037705e-08 69.700000000000003p -1.125862e-08 69.712500000000006p -1.212984e-08 69.724999999999994p -1.2990160000000001e-08 69.737499999999997p -1.383902e-08 69.75p -1.467588e-08
+ 69.762499999999989p -1.5500210000000001e-08 69.775000000000006p -1.63115e-08 69.787500000000009p -1.7109229999999998e-08 69.799999999999997p -1.7892910000000001e-08 69.8125p -1.8662050000000001e-08 69.825000000000003p -1.9416190000000001e-08 69.837500000000006p -2.0154859999999999e-08 69.849999999999994p -2.0877620000000001e-08 69.862499999999997p -2.1584039999999999e-08 69.875p -2.2273689999999999e-08 69.887499999999989p -2.294617e-08 69.900000000000006p -2.360108e-08 69.912500000000009p -2.4238050000000001e-08 69.924999999999997p -2.4856709999999999e-08 69.9375p -2.5456710000000001e-08 69.950000000000003p -2.6037720000000001e-08 69.962500000000006p -2.6599400000000001e-08 69.974999999999994p -2.7141459999999999e-08
+ 69.987499999999997p -2.76636e-08 70p -2.8165540000000001e-08 70.012499999999989p -2.8647020000000001e-08 70.025000000000006p -2.9107790000000001e-08 70.037500000000009p -2.9547609999999999e-08 70.050000000000011p -2.9966280000000002e-08 70.0625p -3.0363579999999998e-08 70.075000000000003p -3.0739330000000001e-08 70.087500000000006p -3.1093349999999998e-08 70.099999999999994p -3.1425479999999999e-08 70.112499999999997p -3.1735599999999999e-08 70.125p -3.2023560000000001e-08 70.137499999999989p -3.2289249999999999e-08 70.149999999999991p -3.2532589999999999e-08 70.162500000000009p -3.2753480000000003e-08 70.175000000000011p -3.2951859999999998e-08 70.1875p -3.3127689999999998e-08 70.200000000000003p -3.3280910000000003e-08
+ 70.212500000000006p -3.3411520000000001e-08 70.224999999999994p -3.3519510000000001e-08 70.237499999999997p -3.3604879999999997e-08 70.25p -3.3667659999999998e-08 70.262499999999989p -3.3707880000000001e-08 70.274999999999991p -3.3725599999999999e-08 70.287500000000009p -3.3720889999999999e-08 70.300000000000011p -3.3693819999999999e-08 70.3125p -3.3644489999999997e-08 70.325000000000003p -3.3573010000000002e-08 70.337500000000006p -3.3479499999999999e-08 70.349999999999994p -3.3364090000000002e-08 70.362499999999997p -3.3226950000000001e-08 70.375p -3.3068219999999999e-08 70.387500000000003p -3.2888089999999999e-08 70.399999999999991p -3.2686740000000003e-08 70.412499999999994p -3.2464380000000001e-08 70.425000000000011p -3.2221219999999998e-08
+ 70.4375p -3.195748e-08 70.450000000000003p -3.1673419999999997e-08 70.462500000000006p -3.1369259999999998e-08 70.474999999999994p -3.1045289999999998e-08 70.487499999999997p -3.0701769999999999e-08 70.5p -3.0338979999999998e-08 70.512500000000003p -2.9957219999999999e-08 70.524999999999991p -2.955681e-08 70.537499999999994p -2.9138049999999999e-08 70.550000000000011p -2.870127e-08 70.5625p -2.824681e-08 70.575000000000003p -2.7775019999999999e-08 70.587500000000006p -2.7286250000000001e-08 70.599999999999994p -2.6780880000000002e-08 70.612499999999997p -2.6259260000000001e-08 70.625p -2.572179e-08 70.637500000000003p -2.516886e-08 70.649999999999991p -2.4600860000000001e-08
+ 70.662499999999994p -2.4018210000000001e-08 70.674999999999997p -2.3421330000000001e-08 70.6875p -2.281062e-08 70.700000000000003p -2.2186520000000001e-08 70.712500000000006p -2.1549470000000001e-08 70.724999999999994p -2.089991e-08 70.737499999999997p -2.0238289999999999e-08 70.75p -1.9565059999999999e-08 70.762500000000003p -1.8880679999999999e-08 70.774999999999991p -1.8185619999999999e-08 70.787499999999994p -1.7480350000000001e-08 70.799999999999997p -1.6765340000000001e-08 70.8125p -1.604106e-08 70.825000000000003p -1.530802e-08 70.837500000000006p -1.456668e-08 70.850000000000009p -1.3817540000000001e-08 70.862499999999997p -1.3061089999999999e-08 70.875p -1.2297840000000001e-08
+ 70.887500000000003p -1.1528270000000001e-08 70.899999999999991p -1.07529e-08 70.912499999999994p -9.9722169999999996e-09 70.924999999999997p -9.1867330000000007e-09 70.9375p -8.3969520000000003e-09 70.950000000000003p -7.603383e-09 70.962500000000006p -6.8065330000000002e-09 70.975000000000009p -6.0069119999999997e-09 70.987499999999997p -5.2050269999999996e-09 71p -4.4013879999999996e-09 71.012500000000003p -3.5965040000000002e-09 71.024999999999991p -2.7908810000000001e-09 71.037499999999994p -1.9850279999999999e-09 71.049999999999997p -1.179449e-09 71.0625p -3.7464949999999999e-10 71.075000000000003p 4.2886830000000002e-10 71.087500000000006p 1.2306039999999999e-09 71.100000000000009p 2.030059e-09
+ 71.112499999999997p 2.8267379999999999e-09 71.125p 3.6201479999999999e-09 71.137500000000003p 4.4098000000000002e-09 71.149999999999991p 5.1952059999999999e-09 71.162499999999994p 5.9758849999999998e-09 71.174999999999997p 6.751357e-09 71.1875p 7.5211470000000005e-09 71.200000000000003p 8.2847860000000007e-09 71.212500000000006p 9.0418070000000005e-09 71.225000000000009p 9.7917500000000006e-09 71.237499999999997p 1.053416e-08 71.25p 1.126858e-08 71.262500000000003p 1.1994579999999999e-08 71.274999999999991p 1.271171e-08 71.287499999999994p 1.3419539999999999e-08 71.299999999999997p 1.411764e-08 71.3125p 1.480559e-08 71.325000000000003p 1.5482990000000001e-08
+ 71.337500000000006p 1.6149419999999999e-08 71.350000000000009p 1.680448e-08 71.362499999999997p 1.7447790000000001e-08 71.375p 1.807896e-08 71.387500000000003p 1.8697610000000001e-08 71.399999999999991p 1.930338e-08 71.412499999999994p 1.98959e-08 71.424999999999997p 2.0474819999999999e-08 71.4375p 2.1039810000000001e-08 71.450000000000003p 2.159053e-08 71.462500000000006p 2.2126640000000001e-08 71.475000000000009p 2.2647840000000001e-08 71.487499999999997p 2.3153819999999999e-08 71.5p 2.364428e-08 71.512500000000003p 2.411894e-08 71.525000000000006p 2.4577509999999999e-08 71.537499999999994p 2.5019719999999998e-08 71.549999999999997p 2.544533e-08
+ 71.5625p 2.585408e-08 71.575000000000003p 2.6245729999999999e-08 71.587500000000006p 2.6620049999999999e-08 71.600000000000009p 2.6976839999999999e-08 71.612499999999997p 2.7315879999999999e-08 71.625p 2.7636980000000001e-08 71.637500000000003p 2.7939960000000001e-08 71.650000000000006p 2.8224640000000001e-08 71.662499999999994p 2.8490859999999999e-08 71.674999999999997p 2.873847e-08 71.6875p 2.896732e-08 71.699999999999989p 2.91773e-08 71.712500000000006p 2.9368289999999998e-08 71.725000000000009p 2.954018e-08 71.737499999999997p 2.9692880000000001e-08 71.75p 2.9826300000000002e-08 71.762500000000003p 2.9940370000000001e-08 71.775000000000006p 3.003505e-08
+ 71.787499999999994p 3.0110270000000003e-08 71.799999999999997p 3.016602e-08 71.8125p 3.0202259999999998e-08 71.824999999999989p 3.0218980000000001e-08 71.837500000000006p 3.0216180000000002e-08 71.850000000000009p 3.019388e-08 71.862500000000011p 3.015211e-08 71.875p 3.0090889999999999e-08 71.887500000000003p 3.0010279999999999e-08 71.900000000000006p 2.9910339999999997e-08 71.912499999999994p 2.979114e-08 71.924999999999997p 2.965277e-08 71.9375p 2.949532e-08 71.949999999999989p 2.9318890000000001e-08 71.962499999999991p 2.9123620000000001e-08 71.975000000000009p 2.890962e-08 71.987500000000011p 2.8677049999999999e-08 72p 2.8426049999999999e-08
+ 72.012500000000003p 2.8156800000000001e-08 72.025000000000006p 2.7869470000000001e-08 72.037499999999994p 2.7564240000000002e-08 72.049999999999997p 2.7241320000000002e-08 72.0625p 2.6900920000000001e-08 72.074999999999989p 2.6543259999999998e-08 72.087499999999991p 2.616857e-08 72.100000000000009p 2.5777099999999999e-08 72.112500000000011p 2.5369099999999999e-08 72.125p 2.4944820000000002e-08 72.137500000000003p 2.4504559999999999e-08 72.150000000000006p 2.4048590000000001e-08 72.162499999999994p 2.3577200000000001e-08 72.174999999999997p 2.3090699999999998e-08 72.1875p 2.258941e-08 72.199999999999989p 2.2073650000000001e-08 72.212499999999991p 2.1543750000000001e-08 72.224999999999994p 2.1000049999999999e-08
+ 72.237500000000011p 2.0442900000000001e-08 72.25p 1.9872669999999999e-08 72.262500000000003p 1.9289719999999999e-08 72.275000000000006p 1.869442e-08 72.287499999999994p 1.808717e-08 72.299999999999997p 1.746835e-08 72.3125p 1.683837e-08 72.325000000000003p 1.6197629999999998e-08 72.337499999999991p 1.5546549999999999e-08 72.349999999999994p 1.4885540000000001e-08 72.362500000000011p 1.421504e-08 72.375p 1.3535490000000001e-08 72.387500000000003p 1.284731e-08 72.400000000000006p 1.215096e-08 72.412499999999994p 1.144689e-08 72.424999999999997p 1.073555e-08 72.4375p 1.001742e-08 72.450000000000003p 9.2929520000000005e-09
+ 72.462499999999991p 8.5626229999999992e-09 72.474999999999994p 7.8269090000000003e-09 72.487500000000011p 7.086289e-09 72.5p 6.3412460000000002e-09 72.512500000000003p 5.5922669999999996e-09 72.525000000000006p 4.8398409999999996e-09 72.537499999999994p 4.0844610000000001e-09 72.549999999999997p 3.3266220000000001e-09 72.5625p 2.5668190000000001e-09 72.575000000000003p 1.8055520000000001e-09 72.587499999999991p 1.043319e-09 72.599999999999994p 2.8062280000000002e-10 72.612499999999997p -4.8203640000000001e-10 72.625p -1.2441559999999999e-09 72.637500000000003p -2.0052350000000001e-09 72.650000000000006p -2.7647700000000002e-09 72.662500000000009p -3.5222610000000001e-09 72.674999999999997p -4.2772069999999998e-09
+ 72.6875p -5.0291089999999999e-09 72.700000000000003p -5.777469e-09 72.712499999999991p -6.521791e-09 72.724999999999994p -7.2615830000000002e-09 72.737499999999997p -7.9963529999999993e-09 72.75p -8.7256120000000002e-09 72.762500000000003p -9.4488769999999996e-09 72.775000000000006p -1.0165670000000001e-08 72.787500000000009p -1.08755e-08 72.799999999999997p -1.1577910000000001e-08 72.8125p -1.2272420000000001e-08 72.825000000000003p -1.2958570000000001e-08 72.837499999999991p -1.36359e-08 72.849999999999994p -1.4303960000000001e-08 72.862499999999997p -1.4962300000000002e-08 72.875p -1.561048e-08 72.887500000000003p -1.624806e-08 72.900000000000006p -1.6874609999999999e-08
+ 72.912500000000009p -1.748972e-08 72.924999999999997p -1.8092969999999999e-08 72.9375p -1.8683950000000001e-08 72.950000000000003p -1.9262270000000001e-08 72.962499999999991p -1.982753e-08 72.974999999999994p -2.0379349999999999e-08 72.987499999999997p -2.091736e-08 73p -2.1441190000000001e-08 73.012500000000003p -2.1950489999999999e-08 73.025000000000006p -2.2444920000000001e-08 73.037500000000009p -2.2924129999999999e-08 73.049999999999997p -2.33878e-08 73.0625p -2.383562e-08 73.075000000000003p -2.4267280000000001e-08 73.087499999999991p -2.468249e-08 73.099999999999994p -2.5080959999999999e-08 73.112499999999997p -2.5462420000000001e-08 73.125p -2.5826609999999998e-08
+ 73.137500000000003p -2.6173279999999999e-08 73.150000000000006p -2.6502189999999999e-08 73.162500000000009p -2.6813119999999998e-08 73.174999999999997p -2.710585e-08 73.1875p -2.7380189999999999e-08 73.200000000000003p -2.7635930000000001e-08 73.212499999999991p -2.7872909999999999e-08 73.224999999999994p -2.809097e-08 73.237499999999997p -2.8289940000000001e-08 73.25p -2.846969e-08 73.262500000000003p -2.8630110000000001e-08 73.275000000000006p -2.8771069999999999e-08 73.287500000000009p -2.8892469999999999e-08 73.299999999999997p -2.8994239999999999e-08 73.3125p -2.9076300000000001e-08 73.325000000000003p -2.9138589999999999e-08 73.337499999999991p -2.9181070000000001e-08 73.349999999999994p -2.9203700000000002e-08
+ 73.362499999999997p -2.9206480000000001e-08 73.375p -2.918938e-08 73.387500000000003p -2.915244e-08 73.400000000000006p -2.9095659999999999e-08 73.412500000000009p -2.9019079999999999e-08 73.424999999999997p -2.892277e-08 73.4375p -2.8806770000000001e-08 73.450000000000003p -2.867117e-08 73.462500000000006p -2.8516070000000001e-08 73.474999999999994p -2.8341559999999999e-08 73.487499999999997p -2.8147770000000001e-08 73.5p -2.793483e-08 73.512499999999989p -2.7702880000000001e-08 73.525000000000006p -2.7452089999999999e-08 73.537500000000009p -2.7182620000000001e-08 73.549999999999997p -2.6894660000000001e-08 73.5625p -2.6588410000000001e-08 73.575000000000003p -2.6264079999999998e-08
+ 73.587500000000006p -2.59219e-08 73.599999999999994p -2.556209e-08 73.612499999999997p -2.5184910000000001e-08 73.625p -2.4790630000000001e-08 73.637499999999989p -2.43795e-08 73.650000000000006p -2.3951820000000001e-08 73.662500000000009p -2.3507889999999999e-08 73.674999999999997p -2.3047999999999999e-08 73.6875p -2.2572489999999999e-08 73.700000000000003p -2.2081669999999999e-08 73.712500000000006p -2.1575899999999999e-08 73.724999999999994p -2.1055519999999999e-08 73.737499999999997p -2.052089e-08 73.75p -1.997239e-08 73.762499999999989p -1.9410400000000002e-08 73.774999999999991p -1.8835299999999999e-08 73.787500000000009p -1.8247510000000002e-08 73.800000000000011p -1.7647420000000001e-08
+ 73.8125p -1.7035460000000001e-08 73.825000000000003p -1.6412060000000001e-08 73.837500000000006p -1.5777639999999998e-08 73.849999999999994p -1.5132650000000002e-08 73.862499999999997p -1.4477549999999999e-08 73.875p -1.381278e-08 73.887499999999989p -1.313882e-08 73.899999999999991p -1.2456129999999999e-08 73.912500000000009p -1.1765179999999999e-08 73.925000000000011p -1.1066470000000001e-08 73.9375p -1.0360480000000001e-08 73.950000000000003p -9.6477079999999993e-09 73.962500000000006p -8.9286440000000008e-09 73.974999999999994p -8.2037949999999994e-09 73.987499999999997p -7.4736669999999994e-09 74p -6.7387700000000003e-09 74.012499999999989p -5.9996190000000001e-09 74.024999999999991p -5.2567300000000003e-09
+ 74.037500000000009p -4.5106220000000001e-09 74.050000000000011p -3.7618169999999996e-09 74.0625p -3.010839e-09 74.075000000000003p -2.258212e-09 74.087500000000006p -1.5044629999999999e-09 74.099999999999994p -7.5011889999999995e-10 74.112499999999997p 4.2939589999999998e-12 74.125p 7.5824800000000003e-10 74.137500000000003p 1.511216e-09 74.149999999999991p 2.2626730000000001e-09 74.162499999999994p 3.0120940000000001e-09 74.175000000000011p 3.7589549999999997e-09 74.1875p 4.5027349999999998e-09 74.200000000000003p 5.2429150000000004e-09 74.212500000000006p 5.9789779999999997e-09 74.224999999999994p 6.710412e-09 74.237499999999997p 7.4367069999999999e-09 74.25p 8.1573559999999992e-09
+ 74.262500000000003p 8.8718570000000007e-09 74.274999999999991p 9.5797129999999999e-09 74.287499999999994p 1.028043e-08 74.300000000000011p 1.097353e-08 74.3125p 1.165852e-08 74.325000000000003p 1.233492e-08 74.337500000000006p 1.3002279999999999e-08 74.349999999999994p 1.366012e-08 74.362499999999997p 1.430799e-08 74.375p 1.494544e-08 74.387500000000003p 1.5572029999999998e-08 74.399999999999991p 1.6187330000000001e-08 74.412499999999994p 1.6790909999999999e-08 74.424999999999997p 1.7382359999999999e-08 74.4375p 1.7961270000000001e-08 74.450000000000003p 1.8527240000000001e-08 74.462500000000006p 1.9079880000000001e-08 74.474999999999994p 1.9618810000000001e-08
+ 74.487499999999997p 2.0143669999999999e-08 74.5p 2.06541e-08 74.512500000000003p 2.1149740000000001e-08 74.524999999999991p 2.1630259999999999e-08 74.537499999999994p 2.209533e-08 74.549999999999997p 2.2544639999999999e-08 74.5625p 2.297789e-08 74.575000000000003p 2.3394780000000001e-08 74.587500000000006p 2.3795029999999999e-08 74.600000000000009p 2.4178369999999999e-08 74.612499999999997p 2.4544550000000001e-08 74.625p 2.4893319999999999e-08 74.637500000000003p 2.5224459999999999e-08 74.649999999999991p 2.553774e-08 74.662499999999994p 2.5832960000000001e-08 74.674999999999997p 2.6109930000000001e-08 74.6875p 2.6368459999999999e-08 74.700000000000003p 2.6608400000000001e-08
+ 74.712500000000006p 2.6829590000000001e-08 74.725000000000009p 2.7031890000000001e-08 74.737499999999997p 2.721518e-08 74.75p 2.7379349999999999e-08 74.762500000000003p 2.7524289999999999e-08 74.774999999999991p 2.764993e-08 74.787499999999994p 2.7756190000000002e-08 74.799999999999997p 2.784302e-08 74.8125p 2.7910369999999999e-08 74.825000000000003p 2.7958229999999998e-08 74.837500000000006p 2.798657e-08 74.850000000000009p 2.7995389999999999e-08 74.862499999999997p 2.7984709999999999e-08 74.875p 2.795455e-08 74.887500000000003p 2.7904970000000001e-08 74.899999999999991p 2.7835999999999999e-08 74.912499999999994p 2.7747730000000001e-08 74.924999999999997p 2.7640229999999999e-08
+ 74.9375p 2.7513609999999999e-08 74.950000000000003p 2.7367970000000001e-08 74.962500000000006p 2.720343e-08 74.975000000000009p 2.7020130000000001e-08 74.987499999999997p 2.681823e-08 75p 2.6597889999999999e-08 75.012500000000003p 2.6359280000000001e-08 75.024999999999991p 2.6102590000000001e-08 75.037499999999994p 2.5828020000000001e-08 75.049999999999997p 2.553579e-08 75.0625p 2.5226129999999999e-08 75.075000000000003p 2.489928e-08 75.087500000000006p 2.4555480000000001e-08 75.100000000000009p 2.4194989999999999e-08 75.112499999999997p 2.3818100000000001e-08 75.125p 2.3425089999999999e-08 75.137500000000003p 2.3016259999999999e-08 75.149999999999991p 2.2591899999999999e-08
+ 75.162499999999994p 2.2152350000000001e-08 75.174999999999997p 2.1697930000000001e-08 75.1875p 2.1228980000000001e-08 75.200000000000003p 2.0745840000000001e-08 75.212500000000006p 2.024888e-08 75.225000000000009p 1.9738469999999999e-08 75.237499999999997p 1.9214980000000001e-08 75.25p 1.8678790000000001e-08 75.262500000000003p 1.813031e-08 75.275000000000006p 1.7569929999999999e-08 75.287499999999994p 1.699806e-08 75.299999999999997p 1.641513e-08 75.3125p 1.582155e-08 75.325000000000003p 1.5217760000000001e-08 75.337500000000006p 1.4604190000000001e-08 75.350000000000009p 1.3981299999999999e-08 75.362499999999997p 1.3349529999999999e-08 75.375p 1.2709340000000001e-08
+ 75.387500000000003p 1.20612e-08 75.400000000000006p 1.140556e-08 75.412499999999994p 1.074289e-08 75.424999999999997p 1.007369e-08 75.4375p 9.3984130000000001e-09 75.449999999999989p 8.7175540000000008e-09 75.462500000000006p 8.0315979999999996e-09 75.475000000000009p 7.3410319999999996e-09 75.487499999999997p 6.6463479999999997e-09 75.5p 5.9480389999999998e-09 75.512500000000003p 5.2465990000000002e-09 75.525000000000006p 4.542526e-09 75.537499999999994p 3.8363169999999997e-09 75.549999999999997p 3.1284690000000001e-09 75.5625p 2.4194809999999999e-09 75.574999999999989p 1.70985e-09 75.587500000000006p 1.000075e-09 75.600000000000009p 2.9065249999999999e-10
+ 75.612500000000011p -4.1792220000000002e-10 75.625p -1.1251549999999999e-09 75.637500000000003p -1.830553e-09 75.650000000000006p -2.533626e-09 75.662499999999994p -3.2338870000000002e-09 75.674999999999997p -3.9308510000000002e-09 75.6875p -4.624037e-09 75.699999999999989p -5.3129670000000004e-09 75.712499999999991p -5.9971670000000002e-09 75.725000000000009p -6.6761680000000003e-09 75.737500000000011p -7.3495040000000003e-09 75.75p -8.0167150000000001e-09 75.762500000000003p -8.6773470000000003e-09 75.775000000000006p -9.3309499999999999e-09 75.787499999999994p -9.9770799999999996e-09 75.799999999999997p -1.0615300000000001e-08 75.8125p -1.124518e-08 75.824999999999989p -1.18663e-08
+ 75.837499999999991p -1.247823e-08 75.850000000000009p -1.308057e-08 75.862500000000011p -1.367292e-08 75.875p -1.4254880000000001e-08 75.887500000000003p -1.4826060000000001e-08 75.900000000000006p -1.5386089999999999e-08 75.912499999999994p -1.5934600000000002e-08 75.924999999999997p -1.647123e-08 75.9375p -1.699563e-08 75.949999999999989p -1.750744e-08 75.962499999999991p -1.8006350000000002e-08 75.974999999999994p -1.8492030000000001e-08 75.987500000000011p -1.8964170000000002e-08 76p -1.9422460000000001e-08 76.012500000000003p -1.986661e-08 76.025000000000006p -2.0296340000000001e-08 76.037499999999994p -2.0711380000000001e-08 76.049999999999997p -2.1111470000000001e-08
+ 76.0625p -2.1496349999999998e-08 76.075000000000003p -2.1865800000000001e-08 76.087499999999991p -2.2219580000000002e-08 76.099999999999994p -2.2557489999999999e-08 76.112500000000011p -2.2879299999999999e-08 76.125p -2.3184840000000001e-08 76.137500000000003p -2.347393e-08 76.150000000000006p -2.3746379999999998e-08 76.162499999999994p -2.4002060000000001e-08 76.174999999999997p -2.4240810000000001e-08 76.1875p -2.4462500000000002e-08 76.200000000000003p -2.4667009999999998e-08 76.212499999999991p -2.4854229999999999e-08 76.224999999999994p -2.5024069999999999e-08 76.237500000000011p -2.5176440000000001e-08 76.25p -2.5311270000000001e-08 76.262500000000003p -2.5428510000000002e-08 76.275000000000006p -2.5528100000000001e-08
+ 76.287499999999994p -2.5610009999999999e-08 76.299999999999997p -2.5674229999999999e-08 76.3125p -2.5720729999999999e-08 76.325000000000003p -2.5749530000000001e-08 76.337499999999991p -2.5760629999999999e-08 76.349999999999994p -2.5754069999999999e-08 76.362499999999997p -2.5729880000000001e-08 76.375p -2.568812e-08 76.387500000000003p -2.5628849999999999e-08 76.400000000000006p -2.5552130000000001e-08 76.412500000000009p -2.5458070000000001e-08 76.424999999999997p -2.5346760000000002e-08 76.4375p -2.5218300000000001e-08 76.450000000000003p -2.5072830000000001e-08 76.462499999999991p -2.491047e-08 76.474999999999994p -2.473137e-08 76.487499999999997p -2.4535679999999999e-08 76.5p -2.4323569999999999e-08
+ 76.512500000000003p -2.4095219999999999e-08 76.525000000000006p -2.3850819999999999e-08 76.537500000000009p -2.3590570000000001e-08 76.549999999999997p -2.3314670000000001e-08 76.5625p -2.302334e-08 76.575000000000003p -2.271682e-08 76.587499999999991p -2.2395339999999999e-08 76.599999999999994p -2.2059150000000001e-08 76.612499999999997p -2.1708519999999999e-08 76.625p -2.1343699999999999e-08 76.637500000000003p -2.096498e-08 76.650000000000006p -2.0572639999999999e-08 76.662500000000009p -2.0166980000000001e-08 76.674999999999997p -1.9748289999999999e-08 76.6875p -1.9316890000000002e-08 76.700000000000003p -1.8873099999999998e-08 76.712499999999991p -1.8417239999999999e-08 76.724999999999994p -1.794965e-08
+ 76.737499999999997p -1.7470679999999999e-08 76.75p -1.6980649999999999e-08 76.762500000000003p -1.647994e-08 76.775000000000006p -1.59689e-08 76.787500000000009p -1.5447900000000002e-08 76.799999999999997p -1.491732e-08 76.8125p -1.4377520000000001e-08 76.825000000000003p -1.382891e-08 76.837499999999991p -1.327185e-08 76.849999999999994p -1.270676e-08 76.862499999999997p -1.2134029999999999e-08 76.875p -1.155405e-08 76.887500000000003p -1.096724e-08 76.900000000000006p -1.0374020000000001e-08 76.912500000000009p -9.7747809999999995e-09 76.924999999999997p -9.1699540000000006e-09 76.9375p -8.5599550000000008e-09 76.950000000000003p -7.9452089999999998e-09
+ 76.962499999999991p -7.3261379999999999e-09 76.974999999999994p -6.7031689999999998e-09 76.987499999999997p -6.0767309999999999e-09 77p -5.4472530000000003e-09 77.012500000000003p -4.8151660000000004e-09 77.025000000000006p -4.1809010000000002e-09 77.037500000000009p -3.5448910000000001e-09 77.049999999999997p -2.907567e-09 77.0625p -2.269361e-09 77.075000000000003p -1.6307049999999999e-09 77.087499999999991p -9.9203069999999995e-10 77.099999999999994p -3.5376760000000002e-10 77.112499999999997p 2.8365540000000001e-10 77.125p 9.1981069999999997e-10 77.137500000000003p 1.554273e-09 77.150000000000006p 2.1866179999999998e-09 77.162500000000009p 2.816425e-09 77.174999999999997p 3.4432760000000001e-09
+ 77.1875p 4.0667540000000003e-09 77.200000000000003p 4.6864480000000003e-09 77.212500000000006p 5.3019469999999997e-09 77.224999999999994p 5.9128469999999998e-09 77.237499999999997p 6.5187450000000001e-09 77.25p 7.1192450000000003e-09 77.262499999999989p 7.7139530000000004e-09 77.275000000000006p 8.3024820000000003e-09 77.287500000000009p 8.8844470000000006e-09 77.299999999999997p 9.4594710000000001e-09 77.3125p 1.0027180000000001e-08 77.325000000000003p 1.058721e-08 77.337500000000006p 1.1139200000000001e-08 77.349999999999994p 1.168279e-08 77.362499999999997p 1.221763e-08 77.375p 1.2743380000000001e-08 77.387499999999989p 1.3259709999999999e-08 77.400000000000006p 1.376629e-08
+ 77.412500000000009p 1.4262789999999999e-08 77.424999999999997p 1.47489e-08 77.4375p 1.5224320000000001e-08 77.450000000000003p 1.5688739999999999e-08 77.462500000000006p 1.6141880000000001e-08 77.474999999999994p 1.6583450000000001e-08 77.487499999999997p 1.7013179999999999e-08 77.5p 1.7430790000000002e-08 77.512499999999989p 1.7836040000000001e-08 77.524999999999991p 1.8228670000000001e-08 77.537500000000009p 1.8608450000000001e-08 77.550000000000011p 1.8975130000000001e-08 77.5625p 1.932851e-08 77.575000000000003p 1.966836e-08 77.587500000000006p 1.9994480000000001e-08 77.599999999999994p 2.0306690000000002e-08 77.612499999999997p 2.0604780000000001e-08 77.625p 2.0888590000000001e-08
+ 77.637499999999989p 2.115796e-08 77.649999999999991p 2.1412720000000001e-08 77.662500000000009p 2.1652739999999999e-08 77.675000000000011p 2.1877870000000001e-08 77.6875p 2.2087999999999999e-08 77.700000000000003p 2.2282999999999998e-08 77.712500000000006p 2.246277e-08 77.724999999999994p 2.2627209999999999e-08 77.737499999999997p 2.2776249999999999e-08 77.75p 2.29098e-08 77.762499999999989p 2.3027809999999998e-08 77.774999999999991p 2.313022e-08 77.787500000000009p 2.3216979999999999e-08 77.800000000000011p 2.3288069999999999e-08 77.8125p 2.334346e-08 77.825000000000003p 2.338313e-08 77.837500000000006p 2.3407100000000001e-08 77.849999999999994p 2.3415360000000001e-08
+ 77.862499999999997p 2.3407930000000001e-08 77.875p 2.3384849999999999e-08 77.887500000000003p 2.3346160000000001e-08 77.899999999999991p 2.3291899999999999e-08 77.912499999999994p 2.322213e-08 77.925000000000011p 2.3136920000000002e-08 77.9375p 2.3036360000000001e-08 77.950000000000003p 2.292053e-08 77.962500000000006p 2.278954e-08 77.974999999999994p 2.264349e-08 77.987499999999997p 2.248251e-08 78p 2.2306709999999999e-08 78.012500000000003p 2.2116250000000001e-08 78.024999999999991p 2.191127e-08 78.037499999999994p 2.1691930000000001e-08 78.050000000000011p 2.1458390000000001e-08 78.0625p 2.1210819999999999e-08 78.075000000000003p 2.0949429999999999e-08
+ 78.087500000000006p 2.0674389999999999e-08 78.099999999999994p 2.0385909999999999e-08 78.112499999999997p 2.0084200000000001e-08 78.125p 1.9769490000000001e-08 78.137500000000003p 1.944199e-08 78.149999999999991p 1.9101939999999999e-08 78.162499999999994p 1.8749590000000001e-08 78.174999999999997p 1.838519e-08 78.1875p 1.8008999999999999e-08 78.200000000000003p 1.7621279999999999e-08 78.212500000000006p 1.72223e-08 78.225000000000009p 1.6812350000000001e-08 78.237499999999997p 1.6391719999999999e-08 78.25p 1.596069e-08 78.262500000000003p 1.5519570000000001e-08 78.274999999999991p 1.5068660000000002e-08 78.287499999999994p 1.4608280000000001e-08 78.299999999999997p 1.413875e-08
+ 78.3125p 1.366038e-08 78.325000000000003p 1.317352e-08 78.337500000000006p 1.267848e-08 78.350000000000009p 1.2175620000000001e-08 78.362499999999997p 1.1665270000000001e-08 78.375p 1.1147789999999999e-08 78.387500000000003p 1.062353e-08 78.399999999999991p 1.009284e-08 78.412499999999994p 9.5560819999999993e-09 78.424999999999997p 9.0136260000000004e-09 78.4375p 8.4658360000000002e-09 78.450000000000003p 7.9130829999999994e-09 78.462500000000006p 7.3557399999999997e-09 78.475000000000009p 6.7941829999999999e-09 78.487499999999997p 6.22879e-09 78.5p 5.6599410000000001e-09 78.512500000000003p 5.0880190000000001e-09 78.524999999999991p 4.5134070000000003e-09
+ 78.537499999999994p 3.936489e-09 78.549999999999997p 3.357653e-09 78.5625p 2.7772840000000002e-09 78.575000000000003p 2.1957700000000002e-09 78.587500000000006p 1.613499e-09 78.600000000000009p 1.0308580000000001e-09 78.612499999999997p 4.4823559999999999e-10 78.625p -1.339824e-10 78.637500000000003p -7.1540919999999997e-10 78.649999999999991p -1.2956589999999999e-09 78.662499999999994p -1.8743489999999999e-09 78.674999999999997p -2.4510940000000001e-09 78.6875p -3.0255150000000002e-09 78.700000000000003p -3.5972330000000001e-09 78.712500000000006p -4.1658699999999998e-09 78.725000000000009p -4.7310520000000003e-09 78.737499999999997p -5.2924070000000002e-09 78.75p -5.8495660000000001e-09
+ 78.762500000000003p -6.4021649999999997e-09 78.774999999999991p -6.9498390000000002e-09 78.787499999999994p -7.4922319999999997e-09 78.799999999999997p -8.0289869999999995e-09 78.8125p -8.5597549999999999e-09 78.825000000000003p -9.0841879999999992e-09 78.837500000000006p -9.6019459999999999e-09 78.850000000000009p -1.011269e-08 78.862499999999997p -1.0616089999999999e-08 78.875p -1.1111819999999999e-08 78.887500000000003p -1.159955e-08 78.899999999999991p -1.2078970000000001e-08 78.912499999999994p -1.2549769999999999e-08 78.924999999999997p -1.301165e-08 78.9375p -1.346431e-08 78.950000000000003p -1.390745e-08 78.962500000000006p -1.43408e-08 78.975000000000009p -1.476406e-08
+ 78.987499999999997p -1.5176980000000001e-08 79p -1.557929e-08 79.012500000000003p -1.5970720000000001e-08 79.025000000000006p -1.6351040000000001e-08 79.037499999999994p -1.671999e-08 79.049999999999997p -1.707735e-08 79.0625p -1.7422890000000001e-08 79.075000000000003p -1.7756389999999999e-08 79.087500000000006p -1.8077639999999999e-08 79.100000000000009p -1.8386430000000001e-08 79.112499999999997p -1.8682580000000001e-08 79.125p -1.89659e-08 79.137500000000003p -1.9236209999999998e-08 79.150000000000006p -1.949335e-08 79.162499999999994p -1.9737150000000001e-08 79.174999999999997p -1.996748e-08 79.1875p -2.0184169999999999e-08 79.199999999999989p -2.0387120000000001e-08
+ 79.212500000000006p -2.0576189999999999e-08 79.225000000000009p -2.0751269999999998e-08 79.237499999999997p -2.0912249999999999e-08 79.25p -2.105905e-08 79.262500000000003p -2.1191580000000001e-08 79.275000000000006p -2.130976e-08 79.287499999999994p -2.1413530000000001e-08 79.299999999999997p -2.1502829999999999e-08 79.3125p -2.1577620000000001e-08 79.324999999999989p -2.163786e-08 79.337500000000006p -2.168352e-08 79.350000000000009p -2.1714590000000001e-08 79.362500000000011p -2.1731050000000001e-08 79.375p -2.1732920000000001e-08 79.387500000000003p -2.17202e-08 79.400000000000006p -2.1692909999999999e-08 79.412499999999994p -2.1651089999999999e-08 79.424999999999997p -2.1594779999999999e-08
+ 79.4375p -2.1524020000000001e-08 79.449999999999989p -2.1438889999999999e-08 79.462499999999991p -2.1339440000000001e-08 79.475000000000009p -2.1225760000000001e-08 79.487500000000011p -2.1097929999999999e-08 79.5p -2.0956059999999998e-08 79.512500000000003p -2.0800250000000001e-08 79.525000000000006p -2.0630619999999999e-08 79.537499999999994p -2.0447290000000001e-08 79.549999999999997p -2.0250400000000001e-08 79.5625p -2.0040089999999998e-08 79.574999999999989p -1.9816520000000001e-08 79.587499999999991p -1.9579839999999999e-08 79.600000000000009p -1.9330229999999999e-08 79.612500000000011p -1.9067860000000001e-08 79.625p -1.8792929999999999e-08 79.637500000000003p -1.8505619999999998e-08 79.650000000000006p -1.8206129999999999e-08
+ 79.662499999999994p -1.789469e-08 79.674999999999997p -1.7571509999999999e-08 79.6875p -1.723681e-08 79.699999999999989p -1.6890840000000001e-08 79.712499999999991p -1.653382e-08 79.724999999999994p -1.616602e-08 79.737500000000011p -1.5787679999999999e-08 79.75p -1.539907e-08 79.762500000000003p -1.500047e-08 79.775000000000006p -1.4592129999999999e-08 79.787499999999994p -1.4174360000000001e-08 79.799999999999997p -1.374743e-08 79.8125p -1.331164e-08 79.825000000000003p -1.286729e-08 79.837499999999991p -1.241468e-08 79.849999999999994p -1.1954140000000001e-08 79.862500000000011p -1.148596e-08 79.875p -1.101049e-08
+ 79.887500000000003p -1.052803e-08 79.900000000000006p -1.0038920000000001e-08 79.912499999999994p -9.5434960000000008e-09 79.924999999999997p -9.0420970000000003e-09 79.9375p -8.5350640000000005e-09 79.950000000000003p -8.0227429999999992e-09 79.962499999999991p -7.5054819999999998e-09 79.974999999999994p -6.9836359999999996e-09 79.987499999999997p -6.4575580000000004e-09 80p -5.9276069999999998e-09 80.012500000000003p -5.394142e-09 80.025000000000006p -4.8575270000000002e-09 80.037499999999994p -4.3181259999999998e-09 80.049999999999997p -3.7763040000000003e-09 80.0625p -3.2324289999999999e-09 80.075000000000003p -2.6868689999999999e-09 80.087499999999991p -2.1399939999999998e-09 80.099999999999994p -1.592173e-09
+ 80.112499999999997p -1.0437780000000001e-09 80.125p -4.9517960000000002e-10 80.137500000000003p 5.3252689999999999e-11 80.150000000000006p 6.0114819999999998e-10 80.162500000000009p 1.148137e-09 80.174999999999997p 1.693851e-09 80.1875p 2.2379219999999999e-09 80.200000000000003p 2.7799829999999999e-09 80.212499999999991p 3.31967e-09 80.224999999999994p 3.8566190000000004e-09 80.237499999999997p 4.3904710000000004e-09 80.25p 4.9208649999999998e-09 80.262500000000003p 5.4474470000000001e-09 80.275000000000006p 5.969863e-09 80.287500000000009p 6.4877620000000002e-09 80.299999999999997p 7.0007969999999999e-09 80.3125p 7.5086249999999992e-09 80.325000000000003p 8.0109069999999999e-09
+ 80.337499999999991p 8.5073059999999996e-09 80.349999999999994p 8.9974910000000004e-09 80.362499999999997p 9.4811350000000007e-09 80.375p 9.9579149999999999e-09 80.387500000000003p 1.042751e-08 80.400000000000006p 1.088962e-08 80.412500000000009p 1.134392e-08 80.424999999999997p 1.179012e-08 80.4375p 1.222792e-08 80.450000000000003p 1.265702e-08 80.462499999999991p 1.307716e-08 80.474999999999994p 1.3488039999999999e-08 80.487499999999997p 1.38894e-08 80.5p 1.4280959999999999e-08 80.512500000000003p 1.466249e-08 80.525000000000006p 1.5033710000000001e-08 80.537500000000009p 1.5394390000000001e-08 80.549999999999997p 1.5744289999999998e-08
+ 80.5625p 1.608319e-08 80.575000000000003p 1.6410849999999999e-08 80.587499999999991p 1.6727070000000001e-08 80.599999999999994p 1.7031650000000001e-08 80.612499999999997p 1.7324369999999999e-08 80.625p 1.760506e-08 80.637500000000003p 1.7873540000000001e-08 80.650000000000006p 1.8129619999999999e-08 80.662500000000009p 1.837315e-08 80.674999999999997p 1.8603969999999999e-08 80.6875p 1.8821929999999999e-08 80.700000000000003p 1.90269e-08 80.712499999999991p 1.9218740000000001e-08 80.724999999999994p 1.9397340000000001e-08 80.737499999999997p 1.956259e-08 80.75p 1.9714379999999999e-08 80.762500000000003p 1.985263e-08 80.775000000000006p 1.9977240000000001e-08
+ 80.787500000000009p 2.0088149999999999e-08 80.799999999999997p 2.0185290000000002e-08 80.8125p 2.0268599999999999e-08 80.825000000000003p 2.0338049999999999e-08 80.837499999999991p 2.0393589999999999e-08 80.849999999999994p 2.0435200000000002e-08 80.862499999999997p 2.0462870000000001e-08 80.875p 2.047658e-08 80.887500000000003p 2.047634e-08 80.900000000000006p 2.046216e-08 80.912500000000009p 2.0434059999999999e-08 80.924999999999997p 2.0392070000000001e-08 80.9375p 2.0336240000000001e-08 80.950000000000003p 2.026661e-08 80.962500000000006p 2.018325e-08 80.974999999999994p 2.0086209999999999e-08 80.987499999999997p 1.9975590000000001e-08 81p 1.9851460000000001e-08
+ 81.012499999999989p 1.9713930000000001e-08 81.025000000000006p 1.95631e-08 81.037500000000009p 1.939908e-08 81.049999999999997p 1.9221999999999998e-08 81.0625p 1.9032000000000001e-08 81.075000000000003p 1.88292e-08 81.087500000000006p 1.861377e-08 81.099999999999994p 1.8385859999999998e-08 81.112499999999997p 1.814564e-08 81.125p 1.789329e-08 81.137499999999989p 1.7628979999999999e-08 81.150000000000006p 1.7352910000000001e-08 81.162500000000009p 1.7065280000000001e-08 81.174999999999997p 1.6766299999999999e-08 81.1875p 1.645618e-08 81.200000000000003p 1.613515e-08 81.212500000000006p 1.5803430000000001e-08 81.224999999999994p 1.5461259999999999e-08
+ 81.237499999999997p 1.5108890000000001e-08 81.25p 1.474656e-08 81.262499999999989p 1.437454e-08 81.274999999999991p 1.3993090000000001e-08 81.287500000000009p 1.3602480000000001e-08 81.300000000000011p 1.3202979999999999e-08 81.3125p 1.279488e-08 81.325000000000003p 1.2378469999999999e-08 81.337500000000006p 1.195403e-08 81.349999999999994p 1.152187e-08 81.362499999999997p 1.1082289999999999e-08 81.375p 1.063561e-08 81.387499999999989p 1.018212e-08 81.399999999999991p 9.7221559999999994e-09 81.412500000000009p 9.2560339999999996e-09 81.425000000000011p 8.7840789999999998e-09 81.4375p 8.3066230000000001e-09 81.450000000000003p 7.8239959999999998e-09
+ 81.462500000000006p 7.3365359999999999e-09 81.474999999999994p 6.8445820000000002e-09 81.487499999999997p 6.3484760000000004e-09 81.5p 5.8485609999999998e-09 81.512499999999989p 5.3451859999999998e-09 81.524999999999991p 4.8386990000000004e-09 81.537500000000009p 4.3294499999999998e-09 81.550000000000011p 3.8177919999999997e-09 81.5625p 3.3040779999999998e-09 81.575000000000003p 2.7886629999999999e-09 81.587500000000006p 2.2719030000000001e-09 81.599999999999994p 1.754152e-09 81.612499999999997p 1.2357690000000001e-09 81.625p 7.17108e-10 81.637500000000003p 1.9852650000000001e-10 81.649999999999991p -3.1962010000000001e-10 81.662499999999994p -8.3697670000000002e-10 81.675000000000011p -1.3531890000000001e-09
+ 81.6875p -1.8679040000000002e-09 81.700000000000003p -2.3807699999999998e-09 81.712500000000006p -2.891437e-09 81.724999999999994p -3.3995570000000001e-09 81.737499999999997p -3.9047850000000002e-09 81.75p -4.4067749999999996e-09 81.762500000000003p -4.9051889999999998e-09 81.774999999999991p -5.3996869999999999e-09 81.787499999999994p -5.8899339999999998e-09 81.800000000000011p -6.3755989999999999e-09 81.8125p -6.8563530000000003e-09 81.825000000000003p -7.331873e-09 81.837500000000006p -7.8018370000000003e-09 81.849999999999994p -8.2659289999999999e-09 81.862499999999997p -8.7238380000000005e-09 81.875p -9.175256e-09 81.887500000000003p -9.6198809999999996e-09 81.899999999999991p -1.005742e-08
+ 81.912499999999994p -1.048757e-08 81.924999999999997p -1.0910050000000001e-08 81.9375p -1.1324580000000001e-08 81.950000000000003p -1.1730890000000001e-08 81.962500000000006p -1.2128699999999999e-08 81.975000000000009p -1.251776e-08 81.987499999999997p -1.28978e-08 82p -1.326857e-08 82.012500000000003p -1.3629840000000001e-08 82.024999999999991p -1.398137e-08 82.037499999999994p -1.432292e-08 82.049999999999997p -1.465427e-08 82.0625p -1.4975210000000001e-08 82.075000000000003p -1.5285530000000001e-08 82.087500000000006p -1.558504e-08 82.100000000000009p -1.5873529999999999e-08 82.112499999999997p -1.6150819999999999e-08 82.125p -1.6416740000000001e-08
+ 82.137500000000003p -1.6671129999999999e-08 82.149999999999991p -1.6913810000000001e-08 82.162499999999994p -1.714463e-08 82.174999999999997p -1.7363459999999999e-08 82.1875p -1.7570159999999999e-08 82.200000000000003p -1.7764599999999999e-08 82.212500000000006p -1.7946659999999999e-08 82.225000000000009p -1.8116229999999999e-08 82.237499999999997p -1.8273209999999998e-08 82.25p -1.8417519999999999e-08 82.262500000000003p -1.8549069999999999e-08 82.274999999999991p -1.8667780000000001e-08 82.287499999999994p -1.8773579999999998e-08 82.299999999999997p -1.886643e-08 82.3125p -1.894628e-08 82.325000000000003p -1.9013079999999999e-08 82.337500000000006p -1.906681e-08 82.350000000000009p -1.9107450000000001e-08
+ 82.362499999999997p -1.9134979999999999e-08 82.375p -1.914941e-08 82.387500000000003p -1.915074e-08 82.399999999999991p -1.913899e-08 82.412499999999994p -1.9114179999999999e-08 82.424999999999997p -1.9076350000000001e-08 82.4375p -1.902554e-08 82.450000000000003p -1.89618e-08 82.462500000000006p -1.8885190000000001e-08 82.475000000000009p -1.8795780000000001e-08 82.487499999999997p -1.8693659999999999e-08 82.5p -1.8578889999999998e-08 82.512500000000003p -1.845159e-08 82.524999999999991p -1.8311850000000001e-08 82.537499999999994p -1.8159790000000001e-08 82.549999999999997p -1.799553e-08 82.5625p -1.781919e-08 82.575000000000003p -1.7630909999999999e-08
+ 82.587500000000006p -1.7430840000000001e-08 82.600000000000009p -1.7219129999999999e-08 82.612499999999997p -1.699594e-08 82.625p -1.6761440000000002e-08 82.637500000000003p -1.65158e-08 82.649999999999991p -1.6259210000000001e-08 82.662499999999994p -1.599185e-08 82.674999999999997p -1.5713929999999998e-08 82.6875p -1.542564e-08 82.700000000000003p -1.5127210000000001e-08 82.712500000000006p -1.481884e-08 82.725000000000009p -1.450076e-08 82.737499999999997p -1.417321e-08 82.75p -1.3836410000000001e-08 82.762500000000003p -1.349061e-08 82.775000000000006p -1.313607e-08 82.787499999999994p -1.2773019999999999e-08 82.799999999999997p -1.2401740000000001e-08
+ 82.8125p -1.2022490000000001e-08 82.825000000000003p -1.163554e-08 82.837500000000006p -1.1241159999999999e-08 82.850000000000009p -1.0839629999999999e-08 82.862499999999997p -1.043124e-08 82.875p -1.001627e-08 82.887500000000003p -9.5950229999999999e-09 82.900000000000006p -9.1677869999999997e-09 82.912499999999994p -8.7348629999999995e-09 82.924999999999997p -8.2965560000000005e-09 82.9375p -7.8531719999999995e-09 82.949999999999989p -7.4050199999999997e-09 82.962500000000006p -6.9524139999999996e-09 82.975000000000009p -6.4956669999999996e-09 82.987499999999997p -6.0350970000000003e-09 83p -5.5710240000000001e-09 83.012500000000003p -5.1037680000000002e-09 83.025000000000006p -4.6336540000000001e-09
+ 83.037499999999994p -4.1610060000000003e-09 83.049999999999997p -3.6861489999999998e-09 83.0625p -3.20941e-09 83.074999999999989p -2.7311169999999998e-09 83.087500000000006p -2.2515990000000001e-09 83.100000000000009p -1.771183e-09 83.112500000000011p -1.2901979999999999e-09 83.125p -8.0897299999999997e-10 83.137500000000003p -3.2783640000000002e-10 83.150000000000006p 1.5288429999999999e-10 83.162499999999994p 6.328622e-10 83.174999999999997p 1.1117710000000001e-09 83.1875p 1.5892870000000001e-09 83.199999999999989p 2.0650859999999999e-09 83.212499999999991p 2.5388460000000001e-09 83.225000000000009p 3.0102479999999998e-09 83.237500000000011p 3.4789740000000001e-09 83.25p 3.9447089999999998e-09
+ 83.262500000000003p 4.4071400000000001e-09 83.275000000000006p 4.8659560000000004e-09 83.287499999999994p 5.3208509999999998e-09 83.299999999999997p 5.771519e-09 83.3125p 6.2176610000000001e-09 83.324999999999989p 6.6589799999999997e-09 83.337499999999991p 7.0951809999999998e-09 83.350000000000009p 7.5259749999999993e-09 83.362500000000011p 7.9510760000000006e-09 83.375p 8.3702040000000004e-09 83.387500000000003p 8.7830809999999993e-09 83.400000000000006p 9.1894350000000001e-09 83.412499999999994p 9.5890000000000007e-09 83.424999999999997p 9.9815129999999999e-09 83.4375p 1.036672e-08 83.449999999999989p 1.0744360000000001e-08 83.462499999999991p 1.11142e-08 83.474999999999994p 1.147599e-08
+ 83.487500000000011p 1.182949e-08 83.5p 1.2174489999999999e-08 83.512500000000003p 1.251075e-08 83.525000000000006p 1.283807e-08 83.537499999999994p 1.3156219999999999e-08 83.549999999999997p 1.346501e-08 83.5625p 1.376424e-08 83.575000000000003p 1.405373e-08 83.587499999999991p 1.433328e-08 83.599999999999994p 1.460272e-08 83.612500000000011p 1.4861890000000001e-08 83.625p 1.511061e-08 83.637500000000003p 1.534875e-08 83.650000000000006p 1.5576140000000002e-08 83.662499999999994p 1.5792649999999999e-08 83.674999999999997p 1.599816e-08 83.6875p 1.6192520000000001e-08 83.700000000000003p 1.6375640000000002e-08
+ 83.712499999999991p 1.6547400000000001e-08 83.724999999999994p 1.670769e-08 83.737499999999997p 1.685643e-08 83.75p 1.6993529999999999e-08 83.762500000000003p 1.711892e-08 83.775000000000006p 1.7232529999999999e-08 83.787499999999994p 1.7334280000000001e-08 83.799999999999997p 1.7424139999999999e-08 83.8125p 1.7502059999999999e-08 83.825000000000003p 1.7568009999999999e-08 83.837499999999991p 1.7621940000000001e-08 83.849999999999994p 1.766385e-08 83.862499999999997p 1.7693729999999999e-08 83.875p 1.7711559999999999e-08 83.887500000000003p 1.7717350000000001e-08 83.900000000000006p 1.7711130000000001e-08 83.912500000000009p 1.76929e-08 83.924999999999997p 1.7662690000000001e-08
+ 83.9375p 1.7620550000000002e-08 83.950000000000003p 1.756652e-08 83.962499999999991p 1.750065e-08 83.974999999999994p 1.742301e-08 83.987499999999997p 1.7333649999999999e-08 84p 1.723267e-08 84.012500000000003p 1.7120139999999999e-08 84.025000000000006p 1.699615e-08 84.037500000000009p 1.686081e-08 84.049999999999997p 1.6714220000000001e-08 84.0625p 1.65565e-08 84.075000000000003p 1.638777e-08 84.087499999999991p 1.620816e-08 84.099999999999994p 1.6017810000000001e-08 84.112499999999997p 1.581685e-08 84.125p 1.5605450000000001e-08 84.137500000000003p 1.538375e-08 84.150000000000006p 1.515193e-08
+ 84.162500000000009p 1.4910150000000001e-08 84.174999999999997p 1.4658590000000001e-08 84.1875p 1.4397439999999999e-08 84.200000000000003p 1.412688e-08 84.212499999999991p 1.384712e-08 84.224999999999994p 1.3558340000000001e-08 84.237499999999997p 1.326077e-08 84.25p 1.2954610000000001e-08 84.262500000000003p 1.264008e-08 84.275000000000006p 1.231741e-08 84.287500000000009p 1.198683e-08 84.299999999999997p 1.1648569999999999e-08 84.3125p 1.130288e-08 84.325000000000003p 1.0949980000000001e-08 84.337499999999991p 1.0590140000000001e-08 84.349999999999994p 1.0223609999999999e-08 84.362499999999997p 9.850642e-09 84.375p 9.4714979999999992e-09
+ 84.387500000000003p 9.0864440000000004e-09 84.400000000000006p 8.695749e-09 84.412500000000009p 8.2996829999999997e-09 84.424999999999997p 7.8985240000000006e-09 84.4375p 7.4925469999999992e-09 84.450000000000003p 7.082036e-09 84.462499999999991p 6.6672730000000004e-09 84.474999999999994p 6.2485439999999996e-09 84.487499999999997p 5.826139e-09 84.5p 5.4003470000000001e-09 84.512500000000003p 4.9714620000000003e-09 84.525000000000006p 4.5397769999999997e-09 84.537500000000009p 4.1055870000000004e-09 84.549999999999997p 3.6691910000000001e-09 84.5625p 3.2308849999999999e-09 84.575000000000003p 2.7909680000000001e-09 84.587500000000006p 2.3497400000000002e-09 84.599999999999994p 1.9075010000000002e-09
+ 84.612499999999997p 1.464551e-09 84.625p 1.021189e-09 84.637500000000003p 5.7771770000000004e-10 84.650000000000006p 1.3443500000000001e-10 84.662500000000009p -3.083595e-10 84.674999999999997p -7.5036730000000003e-10 84.6875p -1.191291e-09 84.700000000000003p -1.6308340000000001e-09 84.712500000000006p -2.0687019999999999e-09 84.724999999999994p -2.5045999999999998e-09 84.737499999999997p -2.9382380000000002e-09 84.75p -3.369325e-09 84.762499999999989p -3.7975740000000002e-09 84.775000000000006p -4.222699e-09 84.787500000000009p -4.6444180000000002e-09 84.799999999999997p -5.0624499999999996e-09 84.8125p -5.4765189999999997e-09 84.825000000000003p -5.8863490000000001e-09
+ 84.837500000000006p -6.29167e-09 84.849999999999994p -6.692214e-09 84.862499999999997p -7.0877170000000003e-09 84.875p -7.4779189999999998e-09 84.887499999999989p -7.8625640000000006e-09 84.900000000000006p -8.2413990000000006e-09 84.912500000000009p -8.6141770000000004e-09 84.924999999999997p -8.980654e-09 84.9375p -9.3405900000000007e-09 84.950000000000003p -9.6937519999999993e-09 84.962500000000006p -1.003991e-08 84.974999999999994p -1.037884e-08 84.987499999999997p -1.0710320000000001e-08 85p -1.103415e-08 85.012499999999989p -1.13501e-08 85.024999999999991p -1.1657979999999999e-08 85.037500000000009p -1.195759e-08 85.050000000000011p -1.2248739999999999e-08
+ 85.0625p -1.253125e-08 85.075000000000003p -1.280493e-08 85.087500000000006p -1.306961e-08 85.099999999999994p -1.332513e-08 85.112499999999997p -1.3571320000000001e-08 85.125p -1.380804e-08 85.137499999999989p -1.403512e-08 85.149999999999991p -1.425244e-08 85.162500000000009p -1.445986e-08 85.175000000000011p -1.465725e-08 85.1875p -1.4844489999999999e-08 85.200000000000003p -1.502147e-08 85.212500000000006p -1.5188089999999999e-08 85.224999999999994p -1.5344229999999999e-08 85.237499999999997p -1.5489820000000001e-08 85.25p -1.5624769999999999e-08 85.262499999999989p -1.5748990000000001e-08 85.274999999999991p -1.5862430000000001e-08
+ 85.287500000000009p -1.5965010000000001e-08 85.300000000000011p -1.605669e-08 85.3125p -1.6137409999999999e-08 85.325000000000003p -1.6207129999999999e-08 85.337500000000006p -1.626582e-08 85.349999999999994p -1.631346e-08 85.362499999999997p -1.635003e-08 85.375p -1.637551e-08 85.387500000000003p -1.6389900000000001e-08 85.399999999999991p -1.6393210000000001e-08 85.412499999999994p -1.6385459999999999e-08 85.425000000000011p -1.6366640000000001e-08 85.4375p -1.6336810000000002e-08 85.450000000000003p -1.6295979999999999e-08 85.462500000000006p -1.6244200000000001e-08 85.474999999999994p -1.6181530000000001e-08 85.487499999999997p -1.6108000000000001e-08 85.5p -1.6023699999999999e-08
+ 85.512500000000003p -1.592868e-08 85.524999999999991p -1.5823019999999999e-08 85.537499999999994p -1.5706819999999998e-08 85.550000000000011p -1.5580149999999999e-08 85.5625p -1.544313e-08 85.575000000000003p -1.5295849999999999e-08 85.587500000000006p -1.5138420000000001e-08 85.599999999999994p -1.4970969999999999e-08 85.612499999999997p -1.479362e-08 85.625p -1.4606500000000001e-08 85.637500000000003p -1.4409749999999999e-08 85.649999999999991p -1.420351e-08 85.662499999999994p -1.398794e-08 85.674999999999997p -1.376318e-08 85.6875p -1.352941e-08 85.700000000000003p -1.3286789999999999e-08 85.712500000000006p -1.3035499999999999e-08 85.725000000000009p -1.277571e-08
+ 85.737499999999997p -1.250761e-08 85.75p -1.2231390000000001e-08 85.762500000000003p -1.194725e-08 85.774999999999991p -1.165538e-08 85.787499999999994p -1.1355999999999999e-08 85.799999999999997p -1.104931e-08 85.8125p -1.073553e-08 85.825000000000003p -1.0414890000000001e-08 85.837500000000006p -1.0087590000000001e-08 85.850000000000009p -9.7538759999999994e-09 85.862499999999997p -9.4139759999999998e-09 85.875p -9.0681259999999993e-09 85.887500000000003p -8.7165660000000002e-09 85.899999999999991p -8.3595400000000007e-09 85.912499999999994p -7.9972939999999998e-09 85.924999999999997p -7.6300789999999999e-09 85.9375p -7.2581480000000004e-09 85.950000000000003p -6.8817570000000003e-09
+ 85.962500000000006p -6.5011639999999999e-09 85.975000000000009p -6.1166310000000001e-09 85.987499999999997p -5.7284219999999998e-09 86p -5.3368030000000001e-09 86.012500000000003p -4.94204e-09 86.024999999999991p -4.5444050000000001e-09 86.037499999999994p -4.144167e-09 86.049999999999997p -3.7416000000000004e-09 86.0625p -3.3369770000000001e-09 86.075000000000003p -2.9305740000000002e-09 86.087500000000006p -2.5226659999999999e-09 86.100000000000009p -2.1135299999999998e-09 86.112499999999997p -1.703443e-09 86.125p -1.2926819999999999e-09 86.137500000000003p -8.8152540000000004e-10 86.149999999999991p -4.702503e-10 86.162499999999994p -5.9133949999999999e-11 86.174999999999997p 3.5154670000000002e-10
+ 86.1875p 7.6151530000000002e-10 86.200000000000003p 1.170496e-09 86.212500000000006p 1.5782159999999999e-09 86.225000000000009p 1.984399e-09 86.237499999999997p 2.3887760000000001e-09 86.25p 2.791074e-09 86.262500000000003p 3.1910249999999999e-09 86.274999999999991p 3.588362e-09 86.287499999999994p 3.982821e-09 86.299999999999997p 4.3741369999999998e-09 86.3125p 4.7620519999999999e-09 86.325000000000003p 5.1463069999999996e-09 86.337500000000006p 5.5266469999999996e-09 86.350000000000009p 5.902821e-09 86.362499999999997p 6.2745780000000002e-09 86.375p 6.641673e-09 86.387500000000003p 7.0038639999999999e-09 86.399999999999991p 7.3609119999999998e-09
+ 86.412499999999994p 7.7125809999999998e-09 86.424999999999997p 8.0586409999999993e-09 86.4375p 8.3988639999999993e-09 86.450000000000003p 8.7330259999999995e-09 86.462500000000006p 9.0609100000000003e-09 86.475000000000009p 9.3823000000000006e-09 86.487499999999997p 9.6969869999999999e-09 86.5p 1.000477e-08 86.512500000000003p 1.030544e-08 86.525000000000006p 1.05988e-08 86.537499999999994p 1.088468e-08 86.549999999999997p 1.116287e-08 86.5625p 1.143321e-08 86.574999999999989p 1.169551e-08 86.587500000000006p 1.1949620000000001e-08 86.600000000000009p 1.219536e-08 86.612499999999997p 1.243258e-08 86.625p 1.266113e-08
+ 86.637500000000003p 1.288087e-08 86.650000000000006p 1.309165e-08 86.662499999999994p 1.329334e-08 86.674999999999997p 1.348582e-08 86.6875p 1.366897e-08 86.699999999999989p 1.3842659999999999e-08 86.712500000000006p 1.40068e-08 86.725000000000009p 1.416129e-08 86.737499999999997p 1.430603e-08 86.75p 1.4440919999999999e-08 86.762500000000003p 1.4565910000000001e-08 86.775000000000006p 1.4680890000000001e-08 86.787499999999994p 1.478583e-08 86.799999999999997p 1.488064e-08 86.8125p 1.4965279999999999e-08 86.824999999999989p 1.5039700000000001e-08 86.837500000000006p 1.5103859999999999e-08 86.850000000000009p 1.5157729999999999e-08
+ 86.862500000000011p 1.5201290000000001e-08 86.875p 1.523451e-08 86.887500000000003p 1.5257380000000001e-08 86.900000000000006p 1.5269910000000002e-08 86.912499999999994p 1.5272079999999998e-08 86.924999999999997p 1.5263920000000001e-08 86.9375p 1.524544e-08 86.949999999999989p 1.5216650000000001e-08 86.962499999999991p 1.51776e-08 86.975000000000009p 1.5128320000000001e-08 86.987500000000011p 1.5068849999999999e-08 87p 1.4999240000000001e-08 87.012500000000003p 1.4919559999999999e-08 87.025000000000006p 1.4829869999999999e-08 87.037499999999994p 1.4730230000000001e-08 87.049999999999997p 1.4620730000000001e-08 87.0625p 1.450144e-08 87.074999999999989p 1.437248e-08
+ 87.087499999999991p 1.423391e-08 87.100000000000009p 1.4085869999999999e-08 87.112500000000011p 1.392844e-08 87.125p 1.3761760000000001e-08 87.137500000000003p 1.3585940000000001e-08 87.150000000000006p 1.3401110000000001e-08 87.162499999999994p 1.320741e-08 87.174999999999997p 1.300497e-08 87.1875p 1.2793949999999999e-08 87.199999999999989p 1.257449e-08 87.212499999999991p 1.2346759999999999e-08 87.224999999999994p 1.2110909999999999e-08 87.237500000000011p 1.186712e-08 87.25p 1.161555e-08 87.262500000000003p 1.1356389999999999e-08 87.275000000000006p 1.1089830000000001e-08 87.287499999999994p 1.081604e-08 87.299999999999997p 1.053522e-08
+ 87.3125p 1.024758e-08 87.325000000000003p 9.9533070000000001e-09 87.337499999999991p 9.6526139999999999e-09 87.349999999999994p 9.3457120000000006e-09 87.362500000000011p 9.0328140000000008e-09 87.375p 8.7141390000000008e-09 87.387500000000003p 8.3899110000000008e-09 87.400000000000006p 8.0603539999999994e-09 87.412499999999994p 7.7256970000000002e-09 87.424999999999997p 7.386174e-09 87.4375p 7.04202e-09 87.450000000000003p 6.6934730000000002e-09 87.462499999999991p 6.3407749999999997e-09 87.474999999999994p 5.9841690000000001e-09 87.487499999999997p 5.6239010000000003e-09 87.5p 5.2602200000000003e-09 87.512500000000003p 4.8933760000000003e-09 87.525000000000006p 4.523622e-09
+ 87.537499999999994p 4.1512109999999997e-09 87.549999999999997p 3.7764000000000003e-09 87.5625p 3.3994449999999999e-09 87.575000000000003p 3.020605e-09 87.587499999999991p 2.640139e-09 87.599999999999994p 2.2583060000000002e-09 87.612499999999997p 1.8753680000000001e-09 87.625p 1.4915850000000001e-09 87.637500000000003p 1.10722e-09 87.650000000000006p 7.2253389999999999e-10 87.662500000000009p 3.3778800000000001e-10 87.674999999999997p -4.6756140000000003e-11 87.6875p -4.3083759999999999e-10 87.700000000000003p -8.1419600000000001e-10 87.712499999999991p -1.1965719999999999e-09 87.724999999999994p -1.5777060000000001e-09 87.737499999999997p -1.957342e-09 87.75p -2.3352229999999998e-09
+ 87.762500000000003p -2.711094e-09 87.775000000000006p -3.0847020000000001e-09 87.787500000000009p -3.455796e-09 87.799999999999997p -3.8241259999999997e-09 87.8125p -4.1894460000000002e-09 87.825000000000003p -4.5515089999999998e-09 87.837499999999991p -4.9100749999999997e-09 87.849999999999994p -5.264903e-09 87.862499999999997p -5.6157559999999996e-09 87.875p -5.9624e-09 87.887500000000003p -6.3046040000000004e-09 87.900000000000006p -6.6421410000000003e-09 87.912500000000009p -6.9747870000000003e-09 87.924999999999997p -7.3023200000000001e-09 87.9375p -7.6245239999999993e-09 87.950000000000003p -7.9411859999999995e-09 87.962499999999991p -8.2520959999999992e-09 87.974999999999994p -8.5570509999999998e-09
+ 87.987499999999997p -8.8558479999999995e-09 88p -9.1482929999999994e-09 88.012500000000003p -9.4341930000000006e-09 88.025000000000006p -9.713361e-09 88.037500000000009p -9.9856150000000006e-09 88.049999999999997p -1.025078e-08 88.0625p -1.0508680000000001e-08 88.075000000000003p -1.075915e-08 88.087499999999991p -1.100202e-08 88.099999999999994p -1.123715e-08 88.112499999999997p -1.146438e-08 88.125p -1.1683559999999999e-08 88.137500000000003p -1.189455e-08 88.150000000000006p -1.209723e-08 88.162500000000009p -1.229145e-08 88.174999999999997p -1.247711e-08 88.1875p -1.2654079999999999e-08 88.200000000000003p -1.2822249999999999e-08
+ 88.212499999999991p -1.2981519999999999e-08 88.224999999999994p -1.3131790000000001e-08 88.237499999999997p -1.327296e-08 88.25p -1.340496e-08 88.262500000000003p -1.3527700000000001e-08 88.275000000000006p -1.364112e-08 88.287500000000009p -1.374513e-08 88.299999999999997p -1.3839690000000001e-08 88.3125p -1.392474e-08 88.325000000000003p -1.400023e-08 88.337500000000006p -1.406612e-08 88.349999999999994p -1.4122389999999999e-08 88.362499999999997p -1.4168989999999999e-08 88.375p -1.4205919999999999e-08 88.387500000000003p -1.4233150000000001e-08 88.400000000000006p -1.425069e-08 88.412500000000009p -1.425852e-08 88.424999999999997p -1.4256660000000001e-08
+ 88.4375p -1.424511e-08 88.450000000000003p -1.42239e-08 88.462500000000006p -1.4193059999999999e-08 88.474999999999994p -1.4152599999999999e-08 88.487499999999997p -1.4102580000000001e-08 88.5p -1.404304e-08 88.512499999999989p -1.397403e-08 88.525000000000006p -1.3895610000000001e-08 88.537500000000009p -1.3807830000000001e-08 88.549999999999997p -1.371078e-08 88.5625p -1.3604530000000001e-08 88.575000000000003p -1.3489160000000001e-08 88.587500000000006p -1.336476e-08 88.599999999999994p -1.3231429999999999e-08 88.612499999999997p -1.3089270000000001e-08 88.625p -1.293838e-08 88.637499999999989p -1.277887e-08 88.650000000000006p -1.2610879999999999e-08
+ 88.662500000000009p -1.2434509999999999e-08 88.674999999999997p -1.22499e-08 88.6875p -1.205718e-08 88.700000000000003p -1.1856509999999999e-08 88.712500000000006p -1.1648009999999999e-08 88.724999999999994p -1.143184e-08 88.737499999999997p -1.120816e-08 88.75p -1.097713e-08 88.762499999999989p -1.073892e-08 88.774999999999991p -1.049369e-08 88.787500000000009p -1.024162e-08 88.800000000000011p -9.9828869999999995e-09 88.8125p -9.717679e-09 88.825000000000003p -9.4461829999999995e-09 88.837500000000006p -9.1685890000000006e-09 88.849999999999994p -8.8850950000000003e-09 88.862499999999997p -8.5958990000000006e-09 88.875p -8.3012050000000002e-09
+ 88.887499999999989p -8.0012200000000006e-09 88.899999999999991p -7.6961539999999994e-09 88.912500000000009p -7.3862210000000001e-09 88.925000000000011p -7.0716360000000002e-09 88.9375p -6.7526199999999998e-09 88.950000000000003p -6.4293950000000002e-09 88.962500000000006p -6.1021850000000001e-09 88.974999999999994p -5.7712169999999997e-09 88.987499999999997p -5.4367209999999997e-09 89p -5.0989280000000001e-09 89.012499999999989p -4.7580720000000001e-09 89.024999999999991p -4.4143889999999998e-09 89.037500000000009p -4.0681149999999999e-09 89.050000000000011p -3.7194880000000001e-09 89.0625p -3.3687490000000001e-09 89.075000000000003p -3.016139e-09 89.087500000000006p -2.6618990000000002e-09 89.099999999999994p -2.306272e-09
+ 89.112499999999997p -1.9495020000000002e-09 89.125p -1.5918320000000001e-09 89.137500000000003p -1.2335070000000001e-09 89.149999999999991p -8.7477090000000005e-10 89.162499999999994p -5.1586789999999995e-10 89.175000000000011p -1.570424e-10 89.1875p 2.0146190000000001e-10 89.200000000000003p 5.5940160000000005e-10 89.212500000000006p 9.1653420000000003e-10 89.224999999999994p 1.2726180000000001e-09 89.237499999999997p 1.6274120000000001e-09 89.25p 1.9806760000000002e-09 89.262500000000003p 2.3321729999999999e-09 89.274999999999991p 2.6816659999999999e-09 89.287499999999994p 3.028919e-09 89.300000000000011p 3.3736990000000001e-09 89.3125p 3.7157749999999998e-09 89.325000000000003p 4.0549169999999998e-09
+ 89.337500000000006p 4.3908990000000003e-09 89.349999999999994p 4.7234959999999996e-09 89.362499999999997p 5.0524859999999998e-09 89.375p 5.3776500000000003e-09 89.387500000000003p 5.6987710000000001e-09 89.399999999999991p 6.0156359999999997e-09 89.412499999999994p 6.3280339999999997e-09 89.424999999999997p 6.6357600000000003e-09 89.4375p 6.9386080000000001e-09 89.450000000000003p 7.2363799999999998e-09 89.462500000000006p 7.5288790000000003e-09 89.475000000000009p 7.8159130000000007e-09 89.487499999999997p 8.0972930000000004e-09 89.5p 8.372834e-09 89.512500000000003p 8.6423570000000002e-09 89.524999999999991p 8.9056859999999996e-09 89.537499999999994p 9.1626479999999994e-09 89.549999999999997p 9.4130779999999997e-09
+ 89.5625p 9.656813e-09 89.575000000000003p 9.8936949999999995e-09 89.587500000000006p 1.012357e-08 89.600000000000009p 1.03463e-08 89.612499999999997p 1.0561720000000001e-08 89.625p 1.076972e-08 89.637500000000003p 1.097015e-08 89.649999999999991p 1.116288e-08 89.662499999999994p 1.1347799999999999e-08 89.674999999999997p 1.152479e-08 89.6875p 1.169374e-08 89.700000000000003p 1.185455e-08 89.712500000000006p 1.20071e-08 89.725000000000009p 1.215132e-08 89.737499999999997p 1.228711e-08 89.75p 1.24144e-08 89.762500000000003p 1.2533089999999999e-08 89.774999999999991p 1.264313e-08
+ 89.787499999999994p 1.2744449999999999e-08 89.799999999999997p 1.2836999999999999e-08 89.8125p 1.2920710000000001e-08 89.825000000000003p 1.299555e-08 89.837500000000006p 1.306147e-08 89.850000000000009p 1.311844e-08 89.862499999999997p 1.316643e-08 89.875p 1.320542e-08 89.887500000000003p 1.3235389999999999e-08 89.899999999999991p 1.325635e-08 89.912499999999994p 1.326827e-08 89.924999999999997p 1.327117e-08 89.9375p 1.3265049999999999e-08 89.950000000000003p 1.324993e-08 89.962500000000006p 1.3225840000000001e-08 89.975000000000009p 1.319279e-08 89.987499999999997p 1.315082e-08 90p 1.309998e-08
+ 90.012500000000003p 1.3040299999999999e-08 90.024999999999991p 1.2971830000000001e-08 90.037499999999994p 1.289465e-08 90.049999999999997p 1.28088e-08 90.0625p 1.271436e-08 90.075000000000003p 1.26114e-08 90.087500000000006p 1.2499999999999999e-08 90.100000000000009p 1.2380249999999999e-08 90.112499999999997p 1.225225e-08 90.125p 1.211608e-08 90.137500000000003p 1.197185e-08 90.149999999999991p 1.181966e-08 90.162499999999994p 1.1659639999999999e-08 90.174999999999997p 1.1491900000000001e-08 90.1875p 1.131656e-08 90.200000000000003p 1.113375e-08 90.212500000000006p 1.094361e-08 90.225000000000009p 1.0746270000000001e-08
+ 90.237499999999997p 1.0541880000000001e-08 90.25p 1.033058e-08 90.262500000000003p 1.011253e-08 90.275000000000006p 9.8878760000000008e-09 90.287499999999994p 9.6567890000000006e-09 90.299999999999997p 9.4194289999999993e-09 90.3125p 9.175967e-09 90.324999999999989p 8.926576e-09 90.337500000000006p 8.6714310000000004e-09 90.350000000000009p 8.4107139999999998e-09 90.362499999999997p 8.1446080000000003e-09 90.375p 7.8733010000000004e-09 90.387500000000003p 7.596984e-09 90.400000000000006p 7.3158509999999996e-09 90.412499999999994p 7.0300979999999997e-09 90.424999999999997p 6.7399259999999999e-09 90.4375p 6.4455369999999999e-09 90.449999999999989p 6.1471370000000002e-09
+ 90.462500000000006p 5.8449320000000002e-09 90.475000000000009p 5.5391330000000002e-09 90.487499999999997p 5.2299530000000003e-09 90.5p 4.9176050000000004e-09 90.512500000000003p 4.6023060000000004e-09 90.525000000000006p 4.2842720000000004e-09 90.537499999999994p 3.963725e-09 90.549999999999997p 3.640884e-09 90.5625p 3.3159719999999999e-09 90.574999999999989p 2.9892110000000002e-09 90.587500000000006p 2.6608270000000001e-09 90.600000000000009p 2.331043e-09 90.612500000000011p 2.0000870000000001e-09 90.625p 1.668183e-09 90.637500000000003p 1.335559e-09 90.650000000000006p 1.0024419999999999e-09 90.662499999999994p 6.6905670000000005e-10 90.674999999999997p 3.3563169999999998e-10
+ 90.6875p 2.392676e-12 90.699999999999989p -3.3043420000000001e-10 90.712499999999991p -6.6262360000000004e-10 90.725000000000009p -9.9395070000000008e-10 90.737500000000011p -1.324192e-09 90.75p -1.653124e-09 90.762500000000003p -1.9805259999999999e-09 90.775000000000006p -2.3061769999999999e-09 90.787499999999994p -2.6298589999999999e-09 90.799999999999997p -2.9513540000000002e-09 90.8125p -3.270446e-09 90.824999999999989p -3.586923e-09 90.837499999999991p -3.900573e-09 90.850000000000009p -4.2111869999999997e-09 90.862500000000011p -4.518557e-09 90.875p -4.8224789999999998e-09 90.887500000000003p -5.1227509999999998e-09 90.900000000000006p -5.419175e-09
+ 90.912499999999994p -5.7115540000000002e-09 90.924999999999997p -5.999694e-09 90.9375p -6.2834060000000003e-09 90.950000000000003p -6.5625030000000002e-09 90.962499999999991p -6.8368009999999997e-09 90.974999999999994p -7.1061200000000003e-09 90.987500000000011p -7.3702840000000004e-09 91p -7.6291210000000005e-09 91.012500000000003p -7.8824600000000001e-09 91.025000000000006p -8.1301390000000003e-09 91.037499999999994p -8.3719950000000005e-09 91.049999999999997p -8.6078720000000006e-09 91.0625p -8.8376180000000001e-09 91.075000000000003p -9.0610849999999998e-09 91.087499999999991p -9.2781290000000002e-09 91.099999999999994p -9.4886109999999999e-09 91.112500000000011p -9.6923960000000005e-09 91.125p -9.8893559999999994e-09
+ 91.137500000000003p -1.0079369999999999e-08 91.150000000000006p -1.0262299999999999e-08 91.162499999999994p -1.043806e-08 91.174999999999997p -1.060651e-08 91.1875p -1.0767569999999999e-08 91.200000000000003p -1.0921119999999999e-08 91.212499999999991p -1.106708e-08 91.224999999999994p -1.1205360000000001e-08 91.237499999999997p -1.133587e-08 91.25p -1.1458529999999999e-08 91.262500000000003p -1.1573270000000001e-08 91.275000000000006p -1.1680020000000001e-08 91.287499999999994p -1.1778719999999999e-08 91.299999999999997p -1.186932e-08 91.3125p -1.195175e-08 91.325000000000003p -1.202599e-08 91.337499999999991p -1.209198e-08 91.349999999999994p -1.214969e-08
+ 91.362499999999997p -1.2199099999999999e-08 91.375p -1.224018e-08 91.387500000000003p -1.227291e-08 91.400000000000006p -1.2297290000000001e-08 91.412500000000009p -1.23133e-08 91.424999999999997p -1.2320940000000001e-08 91.4375p -1.2320229999999999e-08 91.450000000000003p -1.231117e-08 91.462499999999991p -1.229378e-08 91.474999999999994p -1.226808e-08 91.487499999999997p -1.2234099999999999e-08 91.5p -1.2191880000000001e-08 91.512500000000003p -1.2141440000000001e-08 91.525000000000006p -1.208285e-08 91.537500000000009p -1.201613e-08 91.549999999999997p -1.194137e-08 91.5625p -1.18586e-08 91.575000000000003p -1.1767899999999999e-08
+ 91.587499999999991p -1.1669339999999999e-08 91.599999999999994p -1.1563000000000001e-08 91.612499999999997p -1.1448959999999999e-08 91.625p -1.1327310000000001e-08 91.637500000000003p -1.119813e-08 91.650000000000006p -1.1061530000000001e-08 91.662500000000009p -1.09176e-08 91.674999999999997p -1.076645e-08 91.6875p -1.0608200000000001e-08 91.700000000000003p -1.044296e-08 91.712499999999991p -1.027086e-08 91.724999999999994p -1.0092e-08 91.737499999999997p -9.9065389999999993e-09 91.75p -9.7145920000000003e-09 91.762500000000003p -9.5163029999999996e-09 91.775000000000006p -9.3118139999999995e-09 91.787500000000009p -9.1012710000000003e-09 91.799999999999997p -8.8848229999999996e-09
+ 91.8125p -8.6626259999999994e-09 91.825000000000003p -8.4348359999999998e-09 91.837499999999991p -8.2016140000000006e-09 91.849999999999994p -7.963125e-09 91.862499999999997p -7.7195380000000006e-09 91.875p -7.4710219999999999e-09 91.887500000000003p -7.2177530000000004e-09 91.900000000000006p -6.9599080000000004e-09 91.912500000000009p -6.6976670000000004e-09 91.924999999999997p -6.4312129999999999e-09 91.9375p -6.160731e-09 91.950000000000003p -5.8864090000000002e-09 91.962499999999991p -5.6084380000000003e-09 91.974999999999994p -5.3270100000000002e-09 91.987499999999997p -5.04232e-09 92p -4.7545640000000002e-09 92.012500000000003p -4.463942e-09 92.025000000000006p -4.170653e-09
+ 92.037500000000009p -3.8748979999999997e-09 92.049999999999997p -3.576882e-09 92.0625p -3.2768069999999998e-09 92.075000000000003p -2.9748809999999999e-09 92.087500000000006p -2.671309e-09 92.099999999999994p -2.3662990000000001e-09 92.112499999999997p -2.0600579999999998e-09 92.125p -1.752796e-09 92.137500000000003p -1.4447210000000001e-09 92.150000000000006p -1.136044e-09 92.162500000000009p -8.2697249999999996e-10 92.174999999999997p -5.1771730000000002e-10 92.1875p -2.0848739999999999e-10 92.200000000000003p 1.0050800000000001e-10 92.212500000000006p 4.0906030000000003e-10 92.224999999999994p 7.1696120000000004e-10 92.237499999999997p 1.0240029999999999e-09 92.25p 1.32998e-09
+ 92.262499999999989p 1.6346849999999999e-09 92.275000000000006p 1.9379149999999999e-09 92.287500000000009p 2.2394670000000002e-09 92.299999999999997p 2.5391369999999999e-09 92.3125p 2.836726e-09 92.325000000000003p 3.1320349999999999e-09 92.337500000000006p 3.4248669999999999e-09 92.349999999999994p 3.715027e-09 92.362499999999997p 4.0023220000000001e-09 92.375p 4.2865609999999996e-09 92.387499999999989p 4.5675559999999999e-09 92.400000000000006p 4.8451199999999999e-09 92.412500000000009p 5.1190700000000002e-09 92.424999999999997p 5.3892250000000001e-09 92.4375p 5.6554069999999999e-09 92.450000000000003p 5.9174399999999998e-09 92.462500000000006p 6.1751529999999998e-09 92.474999999999994p 6.4283750000000001e-09
+ 92.487499999999997p 6.6769419999999997e-09 92.5p 6.92069e-09 92.512499999999989p 7.1594610000000003e-09 92.524999999999991p 7.3931e-09 92.537500000000009p 7.6214529999999997e-09 92.550000000000011p 7.8443730000000004e-09 92.5625p 8.0617160000000001e-09 92.575000000000003p 8.2733410000000002e-09 92.587500000000006p 8.4791130000000006e-09 92.599999999999994p 8.6788980000000001e-09 92.612499999999997p 8.8725689999999994e-09 92.625p 9.0600020000000004e-09 92.637499999999989p 9.2410779999999999e-09 92.649999999999991p 9.4156810000000006e-09 92.662500000000009p 9.5837019999999993e-09 92.675000000000011p 9.7450339999999998e-09 92.6875p 9.8995770000000001e-09 92.700000000000003p 1.0047229999999999e-08
+ 92.712500000000006p 1.0187909999999999e-08 92.724999999999994p 1.0321520000000001e-08 92.737499999999997p 1.044799e-08 92.75p 1.056723e-08 92.762499999999989p 1.067918e-08 92.774999999999991p 1.078376e-08 92.787499999999994p 1.0880919999999999e-08 92.800000000000011p 1.0970599999999999e-08 92.8125p 1.105274e-08 92.825000000000003p 1.1127300000000001e-08 92.837500000000006p 1.119423e-08 92.849999999999994p 1.125351e-08 92.862499999999997p 1.13051e-08 92.875p 1.134898e-08 92.887500000000003p 1.1385109999999999e-08 92.899999999999991p 1.14135e-08 92.912499999999994p 1.143412e-08 92.925000000000011p 1.144698e-08
+ 92.9375p 1.145207e-08 92.950000000000003p 1.1449400000000001e-08 92.962500000000006p 1.1438979999999999e-08 92.974999999999994p 1.1420830000000001e-08 92.987499999999997p 1.1394959999999999e-08 93p 1.136141e-08 93.012500000000003p 1.1320210000000001e-08 93.024999999999991p 1.1271390000000001e-08 93.037499999999994p 1.121499e-08 93.050000000000011p 1.1151059999999999e-08 93.0625p 1.107966e-08 93.075000000000003p 1.1000840000000001e-08 93.087500000000006p 1.0914669999999999e-08 93.099999999999994p 1.0821200000000001e-08 93.112499999999997p 1.072052e-08 93.125p 1.0612689999999999e-08 93.137500000000003p 1.04978e-08 93.149999999999991p 1.037594e-08
+ 93.162499999999994p 1.02472e-08 93.174999999999997p 1.0111660000000001e-08 93.1875p 9.9694420000000001e-09 93.200000000000003p 9.8206350000000002e-09 93.212500000000006p 9.6653529999999992e-09 93.225000000000009p 9.5037069999999995e-09 93.237499999999997p 9.3358140000000003e-09 93.25p 9.1617960000000007e-09 93.262500000000003p 8.9817770000000007e-09 93.274999999999991p 8.7958870000000002e-09 93.287499999999994p 8.6042569999999997e-09 93.299999999999997p 8.4070250000000001e-09 93.3125p 8.2043299999999995e-09 93.325000000000003p 7.9963169999999994e-09 93.337500000000006p 7.7831309999999997e-09 93.350000000000009p 7.5649249999999995e-09 93.362499999999997p 7.3418510000000001e-09 93.375p 7.1140660000000004e-09
+ 93.387500000000003p 6.8817289999999997e-09 93.399999999999991p 6.6450050000000001e-09 93.412499999999994p 6.4040569999999998e-09 93.424999999999997p 6.1590539999999998e-09 93.4375p 5.9101669999999999e-09 93.450000000000003p 5.6575700000000003e-09 93.462500000000006p 5.4014359999999999e-09 93.475000000000009p 5.1419440000000002e-09 93.487499999999997p 4.8792750000000002e-09 93.5p 4.6136079999999999e-09 93.512500000000003p 4.3451279999999996e-09 93.524999999999991p 4.0740209999999999e-09 93.537499999999994p 3.800472e-09 93.549999999999997p 3.52467e-09 93.5625p 3.246804e-09 93.575000000000003p 2.9670660000000001e-09 93.587500000000006p 2.6856460000000001e-09 93.600000000000009p 2.4027380000000001e-09
+ 93.612499999999997p 2.1185340000000002e-09 93.625p 1.8332300000000001e-09 93.637500000000003p 1.547019e-09 93.649999999999991p 1.2600970000000001e-09 93.662499999999994p 9.7265810000000005e-10 93.674999999999997p 6.8489890000000004e-10 93.6875p 3.970142e-10 93.700000000000003p 1.091994e-10 93.712500000000006p -1.783507e-10 93.725000000000009p -4.6544139999999998e-10 93.737499999999997p -7.5187869999999999e-10 93.75p -1.037469e-09 93.762500000000003p -1.3220210000000001e-09 93.774999999999991p -1.6053410000000001e-09 93.787499999999994p -1.8872400000000002e-09 93.799999999999997p -2.167528e-09 93.8125p -2.4460170000000001e-09 93.825000000000003p -2.7225199999999998e-09
+ 93.837500000000006p -2.9968530000000002e-09 93.850000000000009p -3.2688310000000001e-09 93.862499999999997p -3.5382740000000001e-09 93.875p -3.8050019999999998e-09 93.887500000000003p -4.0688359999999997e-09 93.899999999999991p -4.3296020000000002e-09 93.912499999999994p -4.5871269999999999e-09 93.924999999999997p -4.8412390000000002e-09 93.9375p -5.0917699999999997e-09 93.950000000000003p -5.3385559999999998e-09 93.962500000000006p -5.581432e-09 93.975000000000009p -5.8202390000000003e-09 93.987499999999997p -6.0548189999999997e-09 94p -6.2850200000000003e-09 94.012500000000003p -6.5106889999999997e-09 94.025000000000006p -6.7316789999999997e-09 94.037499999999994p -6.9478460000000001e-09 94.049999999999997p -7.1590489999999997e-09
+ 94.0625p -7.3651499999999999e-09 94.074999999999989p -7.5660159999999999e-09 94.087500000000006p -7.7615170000000002e-09 94.100000000000009p -7.9515270000000004e-09 94.112499999999997p -8.1359220000000008e-09 94.125p -8.3145860000000007e-09 94.137500000000003p -8.4874029999999996e-09 94.150000000000006p -8.6542630000000004e-09 94.162499999999994p -8.8150590000000005e-09 94.174999999999997p -8.9696909999999994e-09 94.1875p -9.1180610000000006e-09 94.199999999999989p -9.2600740000000003e-09 94.212500000000006p -9.3956439999999992e-09 94.225000000000009p -9.5246839999999994e-09 94.237499999999997p -9.6471150000000006e-09 94.25p -9.7628630000000005e-09 94.262500000000003p -9.8718559999999994e-09 94.275000000000006p -9.9740289999999998e-09
+ 94.287499999999994p -1.006932e-08 94.299999999999997p -1.015767e-08 94.3125p -1.023903e-08 94.324999999999989p -1.031336e-08 94.337500000000006p -1.038061e-08 94.350000000000009p -1.044074e-08 94.362500000000011p -1.049372e-08 94.375p -1.0539529999999999e-08 94.387500000000003p -1.0578130000000001e-08 94.400000000000006p -1.060952e-08 94.412499999999994p -1.063368e-08 94.424999999999997p -1.065061e-08 94.4375p -1.0660290000000001e-08 94.449999999999989p -1.0662740000000001e-08 94.462499999999991p -1.0657950000000001e-08 94.475000000000009p -1.0645940000000001e-08 94.487500000000011p -1.062674e-08 94.5p -1.060035e-08
+ 94.512500000000003p -1.05668e-08 94.525000000000006p -1.052613e-08 94.537499999999994p -1.047838e-08 94.549999999999997p -1.042357e-08 94.5625p -1.036177e-08 94.574999999999989p -1.029301e-08 94.587499999999991p -1.021735e-08 94.600000000000009p -1.0134859999999999e-08 94.612500000000011p -1.0045599999999999e-08 94.625p -9.9496280000000003e-09 94.637500000000003p -9.8470250000000001e-09 94.650000000000006p -9.7378690000000005e-09 94.662499999999994p -9.6222390000000002e-09 94.674999999999997p -9.5002220000000003e-09 94.6875p -9.3719079999999999e-09 94.700000000000003p -9.2373929999999998e-09 94.712499999999991p -9.0967730000000008e-09 94.724999999999994p -8.9501519999999996e-09
+ 94.737500000000011p -8.7976360000000002e-09 94.75p -8.639336e-09 94.762500000000003p -8.4753650000000003e-09 94.775000000000006p -8.3058419999999993e-09 94.787499999999994p -8.1308870000000005e-09 94.799999999999997p -7.9506269999999997e-09 94.8125p -7.7651889999999994e-09 94.825000000000003p -7.5747050000000003e-09 94.837499999999991p -7.3793099999999998e-09 94.849999999999994p -7.1791430000000002e-09 94.862500000000011p -6.9743439999999998e-09 94.875p -6.7650590000000003e-09 94.887500000000003p -6.5514330000000001e-09 94.900000000000006p -6.3336179999999997e-09 94.912499999999994p -6.1117660000000003e-09 94.924999999999997p -5.8860309999999997e-09 94.9375p -5.6565719999999999e-09 94.950000000000003p -5.4235489999999996e-09
+ 94.962499999999991p -5.1871229999999999e-09 94.974999999999994p -4.947458e-09 94.987499999999997p -4.704723e-09 95p -4.4590830000000004e-09 95.012500000000003p 9.1940330000000007e-06 95.025000000000006p 1.7191420000000001e-05 95.037499999999994p 2.405704e-05 95.049999999999997p 2.993392e-05 95.0625p 3.4973939999999997e-05 95.075000000000003p 3.9317280000000002e-05 95.087499999999991p 4.3087270000000001e-05 95.099999999999994p 4.6390410000000003e-05 95.112499999999997p 4.9317850000000001e-05 95.125p 5.1947360000000001e-05 95.137500000000003p 5.434506e-05 95.150000000000006p 5.6567080000000001e-05 95.162500000000009p 5.8660969999999998e-05 95.174999999999997p 6.0666910000000001e-05
+ 95.1875p 6.2618760000000001e-05 95.200000000000003p 6.4544959999999997e-05 95.212499999999991p 6.6469289999999997e-05 95.224999999999994p 6.8411520000000002e-05 95.237499999999997p 7.0388020000000006e-05 95.25p 7.2412169999999996e-05 95.262500000000003p 7.4494860000000001e-05 95.275000000000006p 7.6644770000000006e-05 95.287500000000009p 7.8868730000000001e-05 95.299999999999997p 8.1171959999999999e-05 95.3125p 8.3558269999999994e-05 95.325000000000003p 8.6030309999999996e-05 95.337499999999991p 8.8589699999999996e-05 95.349999999999994p 9.1237160000000005e-05 95.362499999999997p 9.3972669999999994e-05 95.375p 9.6795559999999996e-05 95.387500000000003p 9.9704570000000005e-05 95.400000000000006p 0.000102698
+ 95.412500000000009p 0.0001057737 95.424999999999997p 0.00010892929999999999 95.4375p 0.0001121618 95.450000000000003p 0.00011546829999999999 95.462499999999991p 0.00011884560000000001 95.474999999999994p 0.00012229020000000001 95.487499999999997p 0.0001257985 95.5p 0.00012936680000000001 95.512500000000003p 0.0001329913 95.525000000000006p 0.00013666819999999999 95.537500000000009p 0.0001403935 95.549999999999997p 0.00014416320000000001 95.5625p 0.00014797329999999999 95.575000000000003p 0.00015181980000000001 95.587499999999991p 0.00015569870000000001 95.599999999999994p 0.0001596061 95.612499999999997p 0.00016353790000000001 95.625p 0.0001674902
+ 95.637500000000003p 0.00017145920000000001 95.650000000000006p 0.000175441 95.662500000000009p 0.0001794318 95.674999999999997p 0.00018342799999999999 95.6875p 0.000187426 95.700000000000003p 0.00019142230000000001 95.712499999999991p 0.00019541329999999999 95.724999999999994p 0.00019939590000000001 95.737499999999997p 0.00020336679999999999 95.75p 0.0002073229 95.762500000000003p 0.00021126120000000001 95.775000000000006p 0.00021517880000000001 95.787500000000009p 0.0002190731 95.799999999999997p 0.00022294139999999999 95.8125p 0.00022678140000000001 95.825000000000003p 0.00023059059999999999 95.837500000000006p 0.000234367 95.849999999999994p 0.00023810850000000001
+ 95.862499999999997p 0.0002418133 95.875p 0.00024547970000000002 95.887500000000003p 0.00024910619999999998 95.900000000000006p 0.00025269140000000001 95.912500000000009p 0.00025623410000000002 95.924999999999997p 0.0002597333 95.9375p 0.00026318810000000001 95.950000000000003p 0.00026659790000000002 95.962500000000006p 0.00026996209999999998 95.974999999999994p 0.00027328040000000001 95.987499999999997p 0.00027655259999999999 96p 0.00027977880000000001 96.012499999999989p 0.00027376089999999999 96.025000000000006p 0.00026889850000000001 96.037500000000009p 0.0002651229 96.049999999999997p 0.0002622918 96.0625p 0.0002602541 96.075000000000003p 0.00025887060000000001
+ 96.087500000000006p 0.00025801909999999999 96.099999999999994p 0.00025759440000000002 96.112499999999997p 0.00025750689999999999 96.125p 0.00025768010000000002 96.137499999999989p 0.00025804970000000002 96.150000000000006p 0.00025856129999999997 96.162500000000009p 0.00025916920000000003 96.174999999999997p 0.00025983510000000002 96.1875p 0.00026052710000000001 96.200000000000003p 0.0002612189 96.212500000000006p 0.00026188870000000002 96.224999999999994p 0.00026251900000000001 96.237499999999997p 0.00026309560000000002 96.25p 0.00026360720000000003 96.262499999999989p 0.00026404530000000002 96.274999999999991p 0.00026440330000000002 96.287500000000009p 0.00026467670000000001 96.300000000000011p 0.00026486229999999998
+ 96.3125p 0.00026495849999999999 96.325000000000003p 0.0002649649 96.337500000000006p 0.00026488180000000002 96.349999999999994p 0.00026471060000000002 96.362499999999997p 0.00026445320000000001 96.375p 0.00026411229999999999 96.387499999999989p 0.00026369099999999998 96.399999999999991p 0.00026319270000000001 96.412500000000009p 0.00026262129999999999 96.425000000000011p 0.00026198079999999998 96.4375p 0.0002612755 96.450000000000003p 0.0002605099 96.462500000000006p 0.00025968870000000002 96.474999999999994p 0.00025881649999999999 96.487499999999997p 0.00025789790000000002 96.5p 0.00025693789999999998 96.512499999999989p 0.0002559412 96.524999999999991p 0.00025491259999999998
+ 96.537499999999994p 0.00025385670000000003 96.550000000000011p 0.00025277820000000001 96.5625p 0.0002516819 96.575000000000003p 0.00025057220000000003 96.587500000000006p 0.0002494536 96.599999999999994p 0.00024833039999999998 96.612499999999997p 0.00024720709999999997 96.625p 0.00024608779999999998 96.637500000000003p 0.00024497640000000002 96.649999999999991p 0.0002438772 96.662499999999994p 0.00024279379999999999 96.675000000000011p 0.00024173 96.6875p 0.00024068949999999999 96.700000000000003p 0.00023967580000000001 96.712500000000006p 0.00023869230000000001 96.724999999999994p 0.00023774230000000001 96.737499999999997p 0.0002368289 96.75p 0.00023595530000000001
+ 96.762500000000003p 0.00023512439999999999 96.774999999999991p 0.00023433899999999999 96.787499999999994p 0.0002336018 96.800000000000011p 0.0002329156 96.8125p 0.00023228269999999999 96.825000000000003p 0.00023170570000000001 96.837500000000006p 0.00023118689999999999 96.849999999999994p 0.0002307284 96.862499999999997p 0.00023033259999999999 96.875p 0.00023000129999999999 96.887500000000003p 0.00022973660000000001 96.899999999999991p 0.0002295404 96.912499999999994p 0.0002294144 96.924999999999997p 0.00022936039999999999 96.9375p 0.00022938010000000001 96.950000000000003p 0.00022947500000000001 96.962500000000006p 0.00022964670000000001 96.975000000000009p 0.00022989660000000001
+ 96.987499999999997p 0.0002302262 97p 0.00023063669999999999 97.012500000000003p 0.0002311294 97.024999999999991p 0.00023170570000000001 97.037499999999994p 0.00023236660000000001 97.049999999999997p 0.00023311330000000001 97.0625p 0.000233947 97.075000000000003p 0.00023486859999999999 97.087500000000006p 0.0002358792 97.100000000000009p 0.00023697980000000001 97.112499999999997p 0.00023817139999999999 97.125p 0.0002394548 97.137500000000003p 0.00024083089999999999 97.149999999999991p 0.0002423007 97.162499999999994p 0.0002438649 97.174999999999997p 0.00024552439999999998 97.1875p 0.00024728 97.200000000000003p 0.00024913239999999997
+ 97.212500000000006p 0.00025108230000000001 97.225000000000009p 0.0002531306 97.237499999999997p 0.00025527779999999999 97.25p 0.00025752480000000003 97.262500000000003p 0.0002598721 97.274999999999991p 0.0002623204 97.287499999999994p 0.00026487039999999998 97.299999999999997p 0.00026752250000000003 97.3125p 0.00027027749999999998 97.325000000000003p 0.00027313579999999998 97.337500000000006p 0.00027609789999999998 97.350000000000009p 0.00027916440000000001 97.362499999999997p 0.00028233579999999999 97.375p 0.00028561230000000002 97.387500000000003p 0.00028899440000000002 97.399999999999991p 0.0002924825 97.412499999999994p 0.00029607670000000001 97.424999999999997p 0.00029977740000000001
+ 97.4375p 0.00030358460000000001 97.450000000000003p 0.00030749850000000002 97.462500000000006p 0.00031151909999999999 97.475000000000009p 0.00031564620000000001 97.487499999999997p 0.00031987980000000002 97.5p 0.00032421959999999998 97.512500000000003p 0.00032866509999999999 97.524999999999991p 0.000333216 97.537499999999994p 0.00033787139999999998 97.549999999999997p 0.00034263069999999999 97.5625p 0.00034749279999999997 97.575000000000003p 0.00035245680000000002 97.587500000000006p 0.00035752119999999998 97.600000000000009p 0.00036268450000000001 97.612499999999997p 0.000367945 97.625p 0.00037330080000000002 97.637500000000003p 0.00037874959999999999 97.649999999999991p 0.00038428890000000003
+ 97.662499999999994p 0.00038991600000000003 97.674999999999997p 0.00039562769999999998 97.6875p 0.00040142059999999998 97.700000000000003p 0.000407291 97.712500000000006p 0.00041323469999999998 97.725000000000009p 0.00041924729999999997 97.737499999999997p 0.00042532369999999999 97.75p 0.0004314586 97.762500000000003p 0.00043764630000000002 97.775000000000006p 0.00044388039999999999 97.787499999999994p 0.00045015430000000002 97.799999999999997p 0.00045646070000000003 97.8125p 0.0004627918 97.824999999999989p 0.00046913929999999998 97.837500000000006p 0.00047549449999999998 97.850000000000009p 0.000481848 97.862499999999997p 0.00048818990000000002 97.875p 0.00049450959999999995
+ 97.887500000000003p 0.00050079620000000004 97.900000000000006p 0.00050703810000000005 97.912499999999994p 0.00051322309999999997 97.924999999999997p 0.0005193385 97.9375p 0.00052537120000000002 97.949999999999989p 0.00053130750000000002 97.962500000000006p 0.0005371331 97.975000000000009p 0.00054283339999999997 97.987499999999997p 0.00054839349999999995 98p 0.00055379789999999995 98.012500000000003p 0.00055903080000000002 98.025000000000006p 0.00056407630000000005 98.037499999999994p 0.0005689181 98.049999999999997p 0.00057353989999999995 98.0625p 0.00057792520000000003 98.074999999999989p 0.00058205759999999996 98.087500000000006p 0.0005859207 98.100000000000009p 0.0005894982
+ 98.112500000000011p 0.00059277419999999997 98.125p 0.00059573289999999995 98.137500000000003p 0.00059835900000000002 98.150000000000006p 0.00060063789999999998 98.162499999999994p 0.00060255529999999995 98.174999999999997p 0.00060409769999999997 98.1875p 0.00060525240000000005 98.199999999999989p 0.00060600740000000001 98.212499999999991p 0.00060635189999999996 98.225000000000009p 0.00060627589999999996 98.237500000000011p 0.0006057705 98.25p 0.0006048281 98.262500000000003p 0.00060344200000000004 98.275000000000006p 0.00060160710000000002 98.287499999999994p 0.00059931939999999999 98.299999999999997p 0.00059657630000000002 98.3125p 0.00059337639999999998 98.324999999999989p 0.00058971990000000003
+ 98.337499999999991p 0.00058560820000000001 98.350000000000009p 0.00058104420000000003 98.362500000000011p 0.00057603199999999998 98.375p 0.00057057720000000002 98.387500000000003p 0.00056468649999999996 98.400000000000006p 0.00055836799999999995 98.412499999999994p 0.00055163100000000002 98.424999999999997p 0.00054448590000000002 98.4375p 0.00053694419999999999 98.450000000000003p 0.00052901840000000005 98.462499999999991p 0.00052072209999999997 98.474999999999994p 0.0005120697 98.487500000000011p 0.00050307620000000005 98.5p 0.00049375760000000004 98.512500000000003p 0.0004841305 98.525000000000006p 0.00047421179999999999 98.537499999999994p 0.00046401930000000002 98.549999999999997p 0.00045357090000000002
+ 98.5625p 0.0004428848 98.575000000000003p 0.0004319797 98.587499999999991p 0.00042087420000000002 98.599999999999994p 0.00040958709999999997 98.612500000000011p 0.00039813750000000002 98.625p 0.000386544 98.637500000000003p 0.00037482550000000002 98.650000000000006p 0.00036300070000000001 98.662499999999994p 0.00035108790000000002 98.674999999999997p 0.00033910560000000001 98.6875p 0.0003270716 98.700000000000003p 0.00031500369999999997 98.712499999999991p 0.00030291930000000001 98.724999999999994p 0.00029083549999999998 98.737499999999997p 0.00027876890000000002 98.75p 0.00026673579999999999 98.762500000000003p 0.00025475219999999998 98.775000000000006p 0.00024283360000000001
+ 98.787499999999994p 0.00023099509999999999 98.799999999999997p 0.0002192513 98.8125p 0.00020761649999999999 98.825000000000003p 0.00019610459999999999 98.837499999999991p 0.00018472900000000001 98.849999999999994p 0.00017350269999999999 98.862499999999997p 0.00016243830000000001 98.875p 0.0001515481 98.887500000000003p 0.00014084389999999999 98.900000000000006p 0.00013033709999999999 98.912500000000009p 0.00012003879999999999 98.924999999999997p 0.0001099597 98.9375p 0.0001001102 98.950000000000003p 9.0500299999999998e-05 98.962499999999991p 8.113963e-05 98.974999999999994p 7.2037549999999999e-05 98.987499999999997p 6.3203080000000003e-05 99p 5.4644929999999998e-05
+ 99.012500000000003p 4.6371500000000001e-05 99.025000000000006p 3.8390870000000003e-05 99.037500000000009p 3.0710850000000001e-05 99.049999999999997p 2.3338909999999998e-05 99.0625p 1.6282250000000002e-05 99.075000000000003p 9.5477640000000002e-06 99.087499999999991p 3.1420499999999998e-06 99.099999999999994p -2.9286030000000001e-06 99.112499999999997p -8.6582100000000002e-06 99.125p -1.40411e-05 99.137500000000003p -1.9071920000000001e-05 99.150000000000006p -2.3745640000000001e-05 99.162500000000009p -2.805759e-05 99.174999999999997p -3.2003430000000001e-05 99.1875p -3.5579169999999998e-05 99.200000000000003p -3.8781220000000002e-05 99.212499999999991p -4.160637e-05 99.224999999999994p -4.4051799999999997e-05
+ 99.237499999999997p -4.6115120000000003e-05 99.25p -4.7794370000000002e-05 99.262500000000003p -4.9088039999999998e-05 99.275000000000006p -4.9995070000000003e-05 99.287500000000009p -5.0514889999999999e-05 99.299999999999997p -5.0647440000000002e-05 99.3125p -5.0393119999999998e-05 99.325000000000003p -4.9752900000000003e-05 99.337499999999991p -4.8728260000000003e-05 99.349999999999994p -4.7321209999999998e-05 99.362499999999997p -4.5534319999999997e-05 99.375p -4.3370710000000002e-05 99.387500000000003p -4.0834049999999999e-05 99.400000000000006p -3.7928590000000001e-05 99.412500000000009p -3.4659100000000002e-05 99.424999999999997p -3.1030920000000003e-05 99.4375p -2.7049920000000001e-05 99.450000000000003p -2.2722509999999999e-05
+ 99.462499999999991p -1.8055610000000001e-05 99.474999999999994p -1.3056619999999999e-05 99.487499999999997p -7.7334279999999994e-06 99.5p -2.0943890000000001e-06 99.512500000000003p 3.8517279999999998e-06 99.525000000000006p 1.0095750000000001e-05 99.537500000000009p 1.6628119999999999e-05 99.549999999999997p 2.343894e-05 99.5625p 3.0518010000000002e-05 99.575000000000003p 3.7854819999999997e-05 99.587500000000006p 4.5438619999999997e-05 99.599999999999994p 5.325842e-05 99.612499999999997p 6.1303049999999996e-05 99.625p 6.9561150000000004e-05 99.637500000000003p 7.8021220000000006e-05 99.650000000000006p 8.6671640000000002e-05 99.662500000000009p 9.5500679999999997e-05 99.674999999999997p 0.0001044966
+ 99.6875p 0.00011364740000000001 99.700000000000003p 0.00012294129999999999 99.712500000000006p 0.00013236629999999999 99.724999999999994p 0.00014191050000000001 99.737499999999997p 0.00015156189999999999 99.75p 0.0001613086 99.762499999999989p 0.00017113870000000001 99.775000000000006p 0.00018104039999999999 99.787500000000009p 0.0001910018 99.799999999999997p 0.0002010112 99.8125p 0.00021105700000000001 99.825000000000003p 0.00022112769999999999 99.837500000000006p 0.0002312119 99.849999999999994p 0.0002412983 99.862499999999997p 0.00025137590000000001 99.875p 0.00026143379999999999 99.887499999999989p 0.0002714614 99.900000000000006p 0.0002814483
+ 99.912500000000009p 0.00029138450000000001 99.924999999999997p 0.00030126000000000003 99.9375p 0.00031106569999999999 99.950000000000003p 0.00032079230000000002 99.962500000000006p 0.0003304313 99.974999999999994p 0.00033997470000000002 99.987499999999997p 0.00034941459999999997 100p 0.00035874399999999998 100.01249999999999p 0.00036795630000000001 100.02499999999999p 0.00037704550000000001 100.03750000000001p 0.0003860062 100.05000000000001p 0.0003948337 100.0625p 0.00040352390000000001 100.075p 0.0004120735 100.08750000000001p 0.00042047969999999999 100.09999999999999p 0.0004287405 100.1125p 0.00043685490000000001 100.125p 0.00044482229999999998
+ 100.13749999999999p 0.00045264289999999999 100.14999999999999p 0.0004603179 100.16250000000001p 0.00046784890000000002 100.17500000000001p 0.00047523859999999999 100.1875p 0.0004824901 100.2p 0.0004896074 100.21250000000001p 0.00049659520000000003 100.22499999999999p 0.00050345879999999998 100.2375p 0.00051020429999999999 100.25p 0.00051683809999999997 100.26249999999999p 0.00052336760000000005 100.27499999999999p 0.0005298004 100.28749999999999p 0.00053614489999999999 100.30000000000001p 0.00054240970000000001 100.3125p 0.00054860409999999999 100.325p 0.00055473749999999998 100.33750000000001p 0.00056081990000000003 100.34999999999999p 0.00056686129999999999
+ 100.3625p 0.00057287210000000002 100.375p 0.0005788627 100.3875p 0.00058484390000000002 100.39999999999999p 0.00059082619999999998 100.41249999999999p 0.00059682029999999996 100.42500000000001p 0.00060283649999999999 100.4375p 0.00060888540000000001 100.45p 0.00061497690000000002 100.46250000000001p 0.00062112080000000002 100.47499999999999p 0.00062732659999999998 100.4875p 0.00063360320000000001 100.5p 0.00063995890000000002 100.5125p 0.00064640159999999999 100.52499999999999p 0.00065293830000000004 100.53749999999999p 0.00065957519999999999 100.55000000000001p 0.00066631779999999999 100.5625p 0.00067317050000000002 100.575p 0.00068013660000000001
+ 100.58750000000001p 0.00068721839999999999 100.59999999999999p 0.00069441670000000002 100.6125p 0.00070173139999999995 100.625p 0.00070916049999999997 100.6375p 0.0007167009 100.64999999999999p 0.00072434750000000003 100.66249999999999p 0.00073209390000000005 100.675p 0.00073993170000000001 100.6875p 0.00074785070000000001 100.7p 0.00075583889999999998 100.71250000000001p 0.00076388210000000005 100.72500000000001p 0.00077196429999999998 100.7375p 0.00078006750000000002 100.75p 0.00078817130000000005 100.7625p 0.00079625349999999998 100.77499999999999p 0.00080428970000000005 100.78749999999999p 0.00081225350000000004 100.8p 0.00082011639999999999
+ 100.8125p 0.00082784820000000002 100.825p 0.00083541680000000001 100.83750000000001p 0.00084278809999999995 100.85000000000001p 0.00084992689999999996 100.8625p 0.00085679639999999997 100.875p 0.00086335869999999996 100.8875p 0.00086957500000000004 100.89999999999999p 0.00087540580000000005 100.91249999999999p 0.00088081119999999997 100.925p 0.00088575139999999997 100.9375p 0.00089018660000000005 100.95p 0.00089407769999999998 100.96250000000001p 0.00089738679999999996 100.97500000000001p 0.00090007680000000004 100.9875p 0.00090211250000000001 101p 0.00090346079999999997 101.0125p 0.00090409069999999999 101.02499999999999p 0.00090397389999999995
+ 101.03749999999999p 0.00090308499999999998 101.05p 0.00090140170000000005 101.0625p 0.00089890529999999997 101.075p 0.00089558050000000005 101.08750000000001p 0.00089141570000000002 101.10000000000001p 0.00088640340000000005 101.1125p 0.00088053980000000001 101.125p 0.00087382479999999999 101.1375p 0.00086626270000000004 101.14999999999999p 0.00085786110000000005 101.16249999999999p 0.00084863159999999996 101.175p 0.00083858909999999997 101.1875p 0.00082775199999999996 101.2p 0.00081614169999999996 101.21250000000001p 0.00080378260000000005 101.22500000000001p 0.00079070150000000005 101.2375p 0.00077692769999999998 101.25p 0.00076249249999999998
+ 101.2625p 0.00074742869999999998 101.27499999999999p 0.00073177069999999999 101.28749999999999p 0.00071555420000000004 101.3p 0.00069881529999999998 101.3125p 0.00068159099999999995 101.325p 0.00066391859999999998 101.33750000000001p 0.00064583520000000005 101.35000000000001p 0.00062737790000000002 101.3625p 0.00060858349999999995 101.375p 0.00058948799999999999 101.3875p 0.00057012679999999996 101.39999999999999p 0.00055053440000000001 101.41249999999999p 0.00053074429999999998 101.425p 0.00051078899999999999 101.4375p 0.00049069960000000003 101.45p 0.0004705062 101.46250000000001p 0.00045023740000000001 101.47500000000001p 0.00042992060000000002
+ 101.4875p 0.00040958180000000001 101.5p 0.00038924579999999998 101.5125p 0.00036893590000000001 101.52500000000001p 0.0003486742 101.53749999999999p 0.00032848170000000001 101.55p 0.00030837779999999998 101.5625p 0.00028838110000000002 101.57499999999999p 0.00026850879999999999 101.58750000000001p 0.00024877720000000001 101.60000000000001p 0.00022920150000000001 101.6125p 0.0002097961 101.625p 0.00019057429999999999 101.6375p 0.00017154870000000001 101.65000000000001p 0.00015273120000000001 101.66249999999999p 0.0001341329 101.675p 0.00011576450000000001 101.6875p 9.7635850000000001e-05 101.69999999999999p 7.9756509999999995e-05
+ 101.71250000000001p 6.2135549999999998e-05 101.72500000000001p 4.4781670000000003e-05 101.7375p 2.7703280000000002e-05 101.75p 1.0908500000000001e-05 101.7625p -5.5947409999999996e-06 101.77500000000001p -2.179868e-05 101.78749999999999p -3.7695650000000002e-05 101.8p -5.327809e-05 101.8125p -6.8538420000000002e-05 101.82499999999999p -8.3469100000000004e-05 101.83750000000001p -9.8062520000000007e-05 101.85000000000001p -0.000112311 101.86250000000001p -0.00012620679999999999 101.875p -0.0001397421 101.8875p -0.00015290869999999999 101.90000000000001p -0.0001656986 101.91249999999999p -0.00017810349999999999 101.925p -0.00019011479999999999
+ 101.9375p -0.00020172389999999999 101.94999999999999p -0.00021292199999999999 101.96249999999999p -0.0002237002 101.97500000000001p -0.0002340492 101.98750000000001p -0.00024395990000000001 102p -0.00025342289999999998 102.0125p -0.00026242870000000001 102.02500000000001p -0.00027096789999999998 102.03749999999999p -0.00027903090000000003 102.05p -0.0002866082 102.0625p -0.00029369029999999998 102.07499999999999p -0.00030026789999999999 102.08749999999999p -0.00030633169999999999 102.10000000000001p -0.00031187260000000003 102.11250000000001p -0.00031688179999999998 102.125p -0.00032135090000000001 102.1375p -0.00032527149999999998 102.15000000000001p -0.00032863590000000001
+ 102.16249999999999p -0.0003314368 102.175p -0.0003336673 102.1875p -0.00033532119999999998 102.2p -0.00033639279999999998 102.21249999999999p -0.00033687719999999998 102.22499999999999p -0.00033677019999999998 102.23750000000001p -0.00033606819999999998 102.25p -0.00033476870000000001 102.2625p -0.00033286980000000002 102.27500000000001p -0.00033037069999999999 102.28749999999999p -0.00032727150000000003 102.3p -0.00032357309999999999 102.3125p -0.00031927769999999999 102.325p -0.00031438819999999999 102.33749999999999p -0.00030890870000000001 102.34999999999999p -0.00030284430000000002 102.36250000000001p -0.00029620120000000002 102.375p -0.00028898649999999998
+ 102.3875p -0.00028120849999999998 102.40000000000001p -0.00027287649999999997 102.41249999999999p -0.00026400080000000002 102.425p -0.0002545925 102.4375p -0.0002446638 102.45p -0.00023422800000000001 102.46249999999999p -0.0002232991 102.47499999999999p -0.00021189200000000001 102.4875p -0.0002000223 102.5p -0.00018770660000000001 102.5125p -0.000174962 102.52500000000001p -0.0001618065 102.53749999999999p -0.0001482585 102.55p -0.00013433710000000001 102.5625p -0.0001200619 102.575p -0.0001054529 102.58749999999999p -9.0530539999999999e-05 102.59999999999999p -7.5315740000000004e-05
+ 102.6125p -5.982959e-05 102.625p -4.4093500000000001e-05 102.6375p -2.8129100000000001e-05 102.65000000000001p -1.19582e-05 102.66250000000001p 4.3972409999999997e-06 102.675p 2.0915180000000001e-05 102.6875p 3.7573500000000002e-05 102.7p 5.4350040000000003e-05 102.71249999999999p 7.1222659999999995e-05 102.72499999999999p 8.8169210000000003e-05 102.7375p 0.00010516760000000001 102.75p 0.0001221959 102.7625p 0.00013923209999999999 102.77500000000001p 0.00015625440000000001 102.78750000000001p 0.0001732413 102.8p 0.00019017130000000001 102.8125p 0.00020702310000000001 102.825p 0.00022377559999999999
+ 102.83749999999999p 0.0002404083 102.84999999999999p 0.00025690039999999998 102.8625p 0.00027323199999999999 102.875p 0.00028938329999999998 102.8875p 0.00030533490000000002 102.90000000000001p 0.00032106780000000002 102.91250000000001p 0.00033656380000000001 102.925p 0.00035180500000000001 102.9375p 0.00036677420000000001 102.95p 0.00038145479999999999 102.96249999999999p 0.00039583119999999999 102.97499999999999p 0.00040988830000000001 102.9875p 0.00042361200000000002 103p 0.0004369892 103.0125p 0.00045000759999999998 103.02500000000001p 0.00046265610000000002 103.03750000000001p 0.00047492489999999998 103.05p 0.00048680490000000001
+ 103.0625p 0.00049828869999999996 103.075p 0.00050936980000000002 103.08749999999999p 0.00052004340000000001 103.09999999999999p 0.00053030579999999996 103.1125p 0.00054015460000000003 103.125p 0.00054958909999999999 103.1375p 0.00055860980000000001 103.15000000000001p 0.00056721880000000003 103.16250000000001p 0.00057541929999999997 103.175p 0.0005832163 103.1875p 0.00059061599999999997 103.2p 0.00059762580000000001 103.21249999999999p 0.00060425479999999998 103.22499999999999p 0.00061051289999999999 103.2375p 0.00061641159999999996 103.25p 0.0006219633 103.2625p 0.00062718170000000001 103.27500000000001p 0.00063208120000000001
+ 103.28750000000001p 0.00063667719999999995 103.3p 0.00064098620000000003 103.3125p 0.00064502509999999995 103.325p 0.00064881159999999999 103.33750000000001p 0.00065236380000000004 103.34999999999999p 0.00065570039999999997 103.3625p 0.00065884020000000001 103.375p 0.00066180259999999995 103.3875p 0.00066460670000000001 103.40000000000001p 0.00066727189999999997 103.41250000000001p 0.00066981750000000002 103.425p 0.00067226250000000003 103.4375p 0.00067462570000000001 103.45p 0.00067692550000000005 103.46250000000001p 0.00067918000000000004 103.47499999999999p 0.00068140650000000002 103.4875p 0.00068362179999999998 103.5p 0.00068584199999999998
+ 103.51249999999999p 0.00068808240000000004 103.52500000000001p 0.00069035730000000005 103.53750000000001p 0.00069268019999999995 103.55p 0.00069506340000000002 103.5625p 0.00069751830000000005 103.575p 0.00070005510000000003 103.58750000000001p 0.0007026825 103.59999999999999p 0.00070540830000000003 103.6125p 0.00070823870000000005 103.625p 0.00071117860000000001 103.63749999999999p 0.00071423139999999999 103.65000000000001p 0.00071739890000000004 103.66250000000001p 0.00072068160000000002 103.67500000000001p 0.0007240781 103.6875p 0.00072758549999999995 103.7p 0.00073119920000000004 103.71250000000001p 0.00073491300000000002 103.72499999999999p 0.00073871869999999999
+ 103.7375p 0.00074260649999999999 103.75p 0.00074656500000000003 103.76249999999999p 0.00075058069999999995 103.77499999999999p 0.00075463859999999995 103.78750000000001p 0.00075872169999999998 103.80000000000001p 0.00076281160000000005 103.8125p 0.00076688790000000004 103.825p 0.00077092890000000002 103.83750000000001p 0.00077491089999999995 103.84999999999999p 0.00077880919999999995 103.8625p 0.00078259740000000003 103.875p 0.00078624789999999999 103.88749999999999p 0.00078973219999999998 103.89999999999999p 0.00079302039999999999 103.91250000000001p 0.00079608200000000004 103.92500000000001p 0.00079888599999999995 103.9375p 0.00080140069999999999 103.95p 0.00080359430000000003
+ 103.96250000000001p 0.00080543490000000004 103.97499999999999p 0.00080689089999999998 103.9875p 0.00080793100000000001 104p 0.00080852470000000005 104.01249999999999p 0.00080864239999999996 104.02499999999999p 0.00080825570000000004 104.03749999999999p 0.00080733759999999997 104.05000000000001p 0.00080586259999999995 104.0625p 0.00080380730000000002 104.075p 0.00080115009999999996 104.08750000000001p 0.00079787200000000003 104.09999999999999p 0.00079395590000000003 104.1125p 0.00078938789999999999 104.125p 0.00078415620000000001 104.1375p 0.00077825219999999996 104.14999999999999p 0.00077166989999999998 104.16249999999999p 0.00076440630000000002 104.17500000000001p 0.00075646130000000004
+ 104.1875p 0.00074783749999999996 104.2p 0.00073854059999999997 104.21250000000001p 0.0007285789 104.22499999999999p 0.00071796329999999995 104.2375p 0.00070670740000000002 104.25p 0.0006948271 104.2625p 0.00068234049999999998 104.27499999999999p 0.00066926799999999999 104.28749999999999p 0.00065563160000000004 104.30000000000001p 0.00064145520000000004 104.3125p 0.00062676409999999996 104.325p 0.00061158519999999995 104.33750000000001p 0.00059594599999999998 104.34999999999999p 0.00057987550000000005 104.3625p 0.00056340299999999997 104.375p 0.00054655860000000004 104.3875p 0.00052937259999999995 104.39999999999999p 0.00051187580000000002
+ 104.41249999999999p 0.00049409880000000005 104.425p 0.00047607230000000001 104.4375p 0.00045782659999999998 104.45p 0.00043939180000000002 104.46250000000001p 0.00042079779999999999 104.47500000000001p 0.00040207360000000001 104.4875p 0.00038324779999999997 104.5p 0.00036434850000000002 104.5125p 0.00034540290000000001 104.52499999999999p 0.00032643759999999999 104.53749999999999p 0.00030747830000000002 104.55p 0.00028854999999999999 104.5625p 0.00026967700000000001 104.575p 0.0002508826 104.58750000000001p 0.0002321895 104.60000000000001p 0.0002136196 104.6125p 0.0001951938 104.625p 0.00017693259999999999
+ 104.6375p 0.0001588556 104.64999999999999p 0.0001409816 104.66249999999999p 0.00012332900000000001 104.675p 0.00010591540000000001 104.6875p 8.8757780000000005e-05 104.7p 7.1872639999999996e-05 104.71250000000001p 5.5275909999999998e-05 104.72500000000001p 3.8983010000000003e-05 104.7375p 2.300891e-05 104.75p 7.3681160000000003e-06 104.7625p -7.9252899999999995e-06 104.77499999999999p -2.285761e-05 104.78749999999999p -3.7415520000000003e-05 104.8p -5.1586060000000001e-05 104.8125p -6.5356600000000004e-05 104.825p -7.8714839999999997e-05 104.83750000000001p -9.1648800000000002e-05 104.85000000000001p -0.0001041468
+ 104.8625p -0.00011619749999999999 104.875p -0.00012778989999999999 104.8875p -0.00013891319999999999 104.89999999999999p -0.000149557 104.91249999999999p -0.0001597112 104.925p -0.00016936619999999999 104.9375p -0.00017851259999999999 104.95p -0.00018714130000000001 104.96250000000001p -0.0001952438 104.97500000000001p -0.0002028121 104.9875p -0.0002098383 105p -0.00021631520000000001 105.0125p -0.00023143449999999999 105.02499999999999p -0.0002447905 105.03749999999999p -0.00025644699999999998 105.05p -0.0002665419 105.0625p -0.00027522270000000001 105.075p -0.0002826258
+ 105.08750000000001p -0.00028887139999999998 105.10000000000001p -0.00029406339999999998 105.1125p -0.00029829139999999998 105.125p -0.00030163199999999997 105.1375p -0.00030415100000000001 105.14999999999999p -0.00030590510000000001 105.16249999999999p -0.00030694290000000003 105.175p -0.00030730660000000002 105.1875p -0.00030703289999999998 105.2p -0.00030615360000000002 105.21250000000001p -0.00030469690000000001 105.22500000000001p -0.00030268770000000002 105.2375p -0.00030014799999999997 105.25p -0.00029709810000000001 105.2625p -0.00029355599999999999 105.27500000000001p -0.00028953879999999999 105.28749999999999p -0.00028506210000000002 105.3p -0.00028014069999999998
+ 105.3125p -0.00027478879999999999 105.32499999999999p -0.0002690201 105.33750000000001p -0.00026284790000000001 105.35000000000001p -0.0002562854 105.3625p -0.00024934540000000002 105.375p -0.0002420411 105.3875p -0.00023438530000000001 105.40000000000001p -0.00022639120000000001 105.41249999999999p -0.00021807200000000001 105.425p -0.00020944099999999999 105.4375p -0.00020051189999999999 105.44999999999999p -0.0001912983 105.46250000000001p -0.0001818143 105.47500000000001p -0.00017207419999999999 105.4875p -0.00016209230000000001 105.5p -0.0001518833 105.5125p -0.0001414621 105.52500000000001p -0.0001308437
+ 105.53749999999999p -0.0001200433 105.55p -0.0001090764 105.5625p -9.7958539999999997e-05 105.57499999999999p -8.6705350000000002e-05 105.58749999999999p -7.5332630000000007e-05 105.60000000000001p -6.3856219999999995e-05 105.61250000000001p -5.2292049999999997e-05 105.625p -4.0656060000000003e-05 105.6375p -2.896421e-05 105.65000000000001p -1.7232450000000001e-05 105.66249999999999p -5.4766899999999997e-06 105.675p 6.2872060000000003e-06 105.6875p 1.8043450000000001e-05 105.69999999999999p 2.9776350000000002e-05 105.71249999999999p 4.1470300000000002e-05 105.72500000000001p 5.3109850000000001e-05 105.73750000000001p 6.4679660000000001e-05 105.75p 7.6164529999999994e-05
+ 105.7625p 8.7549450000000003e-05 105.77500000000001p 9.8819550000000002e-05 105.78749999999999p 0.0001099601 105.8p 0.00012095669999999999 105.8125p 0.0001317949 105.82499999999999p 0.00014246070000000001 105.83749999999999p 0.00015294000000000001 105.85000000000001p 0.0001632193 105.86250000000001p 0.00017328499999999999 105.875p 0.00018312379999999999 105.8875p 0.00019272270000000001 105.90000000000001p 0.0002020689 105.91249999999999p 0.0002111499 105.925p 0.00021995350000000001 105.9375p 0.00022846779999999999 105.95p 0.00023668110000000001 105.96249999999999p 0.0002445821 105.97499999999999p 0.00025215989999999999
+ 105.98750000000001p 0.00025940389999999999 106p 0.00026630419999999999 106.0125p 0.00028204910000000002 106.02500000000001p 0.00029622999999999997 106.03749999999999p 0.0003089077 106.05p 0.00032021680000000001 106.0625p 0.00033030149999999997 106.075p 0.00033929480000000002 106.08749999999999p 0.00034731360000000001 106.09999999999999p 0.00035445829999999998 106.11250000000001p 0.00036081470000000001 106.125p 0.00036645599999999998 106.1375p 0.00037144419999999998 106.15000000000001p 0.00037583199999999999 106.16249999999999p 0.0003796645 106.175p 0.0003829797 106.1875p 0.00038581020000000001 106.2p 0.00038818400000000002
+ 106.21249999999999p 0.00039012500000000001 106.22499999999999p 0.00039165370000000002 106.2375p 0.00039278810000000001 106.25p 0.0003935438 106.2625p 0.00039393460000000001 106.27500000000001p 0.00039397260000000002 106.28749999999999p 0.00039366899999999997 106.3p 0.00039303359999999998 106.3125p 0.00039207579999999998 106.325p 0.0003908041 106.33749999999999p 0.00038922670000000003 106.34999999999999p 0.00038735110000000001 106.3625p 0.00038518500000000002 106.375p 0.00038273540000000002 106.3875p 0.00038000939999999997 106.40000000000001p 0.00037701409999999999 106.41250000000001p 0.00037375610000000002 106.425p 0.00037024239999999998
+ 106.4375p 0.0003664796 106.45p 0.00036247450000000001 106.46249999999999p 0.00035823369999999998 106.47499999999999p 0.0003537638 106.4875p 0.00034907139999999998 106.5p 0.00034416299999999998 106.5125p 0.00033904509999999998 106.52500000000001p 0.00033372410000000001 106.53750000000001p 0.00032820620000000001 106.55p 0.00032249770000000001 106.5625p 0.00031660450000000001 106.575p 0.00031053279999999998 106.58749999999999p 0.00030428829999999999 106.59999999999999p 0.00029787679999999998 106.6125p 0.00029130360000000001 106.625p 0.0002845743 106.6375p 0.00027769399999999999 106.65000000000001p 0.00027066770000000001
+ 106.66250000000001p 0.0002635003 106.675p 0.00025619640000000001 106.6875p 0.0002487605 106.7p 0.00024119690000000001 106.71249999999999p 0.00023350970000000001 106.72499999999999p 0.00022570270000000001 106.7375p 0.0002177797 106.75p 0.00020974430000000001 106.7625p 0.0002015997 106.77500000000001p 0.0001933491 106.78750000000001p 0.00018499569999999999 106.8p 0.0001765421 106.8125p 0.0001679912 106.825p 0.0001593454 106.83749999999999p 0.0001506073 106.84999999999999p 0.000141779 106.8625p 0.0001328627 106.875p 0.00012386060000000001
+ 106.8875p 0.0001147745 106.90000000000001p 0.00010560640000000001 106.91250000000001p 9.6357899999999994e-05 106.925p 8.7030860000000004e-05 106.9375p 7.76269e-05 106.95p 6.8147599999999998e-05 106.96249999999999p 5.8594529999999998e-05 106.97499999999999p 4.896922e-05 106.9875p 3.9273190000000001e-05 107p 2.9507939999999999e-05 107.0125p 1.9674960000000001e-05 107.02500000000001p 9.7757860000000005e-06 107.03750000000001p -1.8804899999999999e-07 107.05p -1.0214969999999999e-05 107.0625p -2.0303349999999999e-05 107.075p -3.0451509999999999e-05 107.08750000000001p -4.0657710000000003e-05 107.09999999999999p -5.0920100000000001e-05
+ 107.1125p -6.1236769999999994e-05 107.125p -7.1605669999999996e-05 107.1375p -8.2024640000000003e-05 107.15000000000001p -9.2491399999999993e-05 107.16250000000001p -0.0001030035 107.175p -0.00011355830000000001 107.1875p -0.000124153 107.2p -0.0001347846 107.21250000000001p -0.00014545000000000001 107.22499999999999p -0.00015614559999999999 107.2375p -0.00016686770000000001 107.25p -0.00017761240000000001 107.26249999999999p -0.00018837540000000001 107.27500000000001p -0.0001991521 107.28750000000001p -0.00020993760000000001 107.3p -0.00022072659999999999 107.3125p -0.00023151350000000001 107.325p -0.00024229230000000001
+ 107.33750000000001p -0.00025305640000000001 107.34999999999999p -0.00026379920000000001 107.3625p -0.00027451310000000003 107.375p -0.00028519050000000001 107.38749999999999p -0.00029582300000000002 107.40000000000001p -0.000306402 107.41250000000001p -0.0003169181 107.42500000000001p -0.00032736149999999998 107.4375p -0.00033772199999999999 107.45p -0.00034798860000000002 107.46250000000001p -0.00035814990000000002 107.47499999999999p -0.0003681941 107.4875p -0.00037810870000000001 107.5p -0.00038788069999999997 107.51249999999999p -0.00039749650000000001 107.52499999999999p -0.00040694229999999997 107.53750000000001p -0.00041620349999999998 107.55000000000001p -0.00042526519999999999
+ 107.5625p -0.00043411209999999999 107.575p -0.00044272849999999999 107.58750000000001p -0.00045109840000000001 107.59999999999999p -0.00045920539999999999 107.6125p -0.00046703309999999998 107.625p -0.00047456460000000001 107.63749999999999p -0.00048178320000000002 107.64999999999999p -0.00048867210000000003 107.66250000000001p -0.0004952143 107.67500000000001p -0.00050139330000000004 107.6875p -0.00050719250000000001 107.7p -0.00051259570000000004 107.71250000000001p -0.00051758710000000005 107.72499999999999p -0.00052215129999999999 107.7375p -0.00052627350000000002 107.75p -0.00052993949999999995 107.76249999999999p -0.00053313589999999999 107.77499999999999p -0.00053585009999999997
+ 107.78749999999999p -0.00053807020000000004 107.80000000000001p -0.00053978559999999997 107.8125p -0.00054098660000000002 107.825p -0.00054166450000000003 107.83750000000001p -0.00054181189999999999 107.84999999999999p -0.00054142280000000001 107.8625p -0.00054049209999999998 107.875p -0.00053901630000000001 107.8875p -0.0005369932 107.89999999999999p -0.00053442180000000004 107.91249999999999p -0.00053130259999999998 107.92500000000001p -0.00052763750000000002 107.9375p -0.00052342960000000005 107.95p -0.00051868349999999999 107.96250000000001p -0.00051340480000000002 107.97499999999999p -0.00050760080000000003 107.9875p -0.00050127959999999997 108p -0.00049445079999999996
+ 108.0125p -0.00048712469999999999 108.02499999999999p -0.00047931299999999998 108.03749999999999p -0.00047102819999999998 108.05000000000001p -0.00046228369999999999 108.0625p -0.00045309359999999999 108.075p -0.00044347290000000002 108.08750000000001p -0.00043343709999999998 108.09999999999999p -0.00042300239999999999 108.1125p -0.0004121854 108.125p -0.00040100299999999998 108.1375p -0.00038947260000000002 108.14999999999999p -0.00037761179999999997 108.16249999999999p -0.00036543840000000002 108.175p -0.00035297010000000001 108.1875p -0.00034022499999999999 108.2p -0.00032722090000000001 108.21250000000001p -0.0003139757 108.22500000000001p -0.00030050710000000002
+ 108.2375p -0.00028683259999999998 108.25p -0.00027296969999999999 108.2625p -0.00025893539999999999 108.27499999999999p -0.00024474680000000001 108.28749999999999p -0.0002304203 108.3p -0.00021597230000000001 108.3125p -0.0002014188 108.325p -0.00018677550000000001 108.33750000000001p -0.0001720577 108.35000000000001p -0.00015728030000000001 108.3625p -0.0001424582 108.375p -0.0001276056 108.3875p -0.0001127366 108.39999999999999p -9.7864919999999993e-05 108.41249999999999p -8.3003970000000005e-05 108.425p -6.8166929999999995e-05 108.4375p -5.3366679999999997e-05 108.45p -3.8615860000000001e-05
+ 108.46250000000001p -2.3926870000000001e-05 108.47500000000001p -9.311919e-06 108.4875p 5.2170019999999998e-06 108.5p 1.964806e-05 108.5125p 3.396959e-05 108.52499999999999p 4.8170059999999999e-05 108.53749999999999p 6.223805e-05 108.55p 7.6162259999999998e-05 108.5625p 8.9931479999999996e-05 108.575p 0.0001035346 108.58750000000001p 0.00011696040000000001 108.60000000000001p 0.0001301981 108.6125p 0.00014323649999999999 108.625p 0.0001560648 108.6375p 0.000168672 108.64999999999999p 0.00018104739999999999 108.66249999999999p 0.00019317999999999999 108.675p 0.00020505910000000001
+ 108.6875p 0.00021667400000000001 108.7p 0.00022801399999999999 108.71250000000001p 0.0002390685 108.72500000000001p 0.00024982699999999999 108.7375p 0.00026027910000000001 108.75p 0.00027041450000000002 108.7625p 0.00028022319999999998 108.77499999999999p 0.0002896951 108.78749999999999p 0.00029882059999999998 108.8p 0.00030759020000000001 108.8125p 0.00031599459999999998 108.825p 0.00032402499999999997 108.83750000000001p 0.0003316727 108.85000000000001p 0.00033892960000000001 108.8625p 0.00034578799999999998 108.875p 0.0003522404 108.8875p 0.00035828010000000003 108.89999999999999p 0.00036390069999999998
+ 108.91249999999999p 0.00036909660000000001 108.925p 0.00037386260000000002 108.9375p 0.00037819410000000003 108.95p 0.00038208730000000002 108.96250000000001p 0.00038553900000000001 108.97500000000001p 0.00038854690000000001 108.9875p 0.00039110909999999998 109p 0.0003932246 109.0125p 0.00039489339999999998 109.02500000000001p 0.00039611600000000001 109.03749999999999p 0.00039689370000000002 109.05p 0.00039722880000000001 109.0625p 0.000397124 109.07499999999999p 0.00039658329999999999 109.08750000000001p 0.00039561099999999998 109.10000000000001p 0.00039421239999999999 109.1125p 0.00039239359999999998 109.125p 0.00039016110000000001
+ 109.1375p 0.00038752250000000002 109.15000000000001p 0.00038448570000000002 109.16249999999999p 0.00038105950000000001 109.175p 0.00037725310000000001 109.1875p 0.00037307630000000001 109.19999999999999p 0.0003685397 109.21250000000001p 0.00036365380000000002 109.22500000000001p 0.00035843019999999998 109.2375p 0.00035288030000000002 109.25p 0.00034701630000000001 109.2625p 0.00034085050000000003 109.27500000000001p 0.0003343954 109.28749999999999p 0.00032766389999999999 109.3p 0.00032066890000000001 109.3125p 0.0003134236 109.32499999999999p 0.00030594109999999998 109.33749999999999p 0.00029823490000000001 109.35000000000001p 0.00029031800000000002
+ 109.36250000000001p 0.00028220399999999998 109.375p 0.00027390580000000002 109.3875p 0.00026543690000000001 109.40000000000001p 0.00025681009999999998 109.41249999999999p 0.00024803850000000002 109.425p 0.00023913480000000001 109.4375p 0.0002301115 109.44999999999999p 0.00022098119999999999 109.46249999999999p 0.0002117559 109.47500000000001p 0.00020244769999999999 109.48750000000001p 0.0001930682 109.5p 0.00018362909999999999 109.5125p 0.00017414129999999999 109.52500000000001p 0.0001646161 109.53749999999999p 0.0001550639 109.55p 0.0001454952 109.5625p 0.00013592030000000001 109.57499999999999p 0.00012634890000000001
+ 109.58749999999999p 0.0001167906 109.60000000000001p 0.0001072548 109.61250000000001p 9.7750550000000002e-05 109.625p 8.8286650000000006e-05 109.6375p 7.8871650000000002e-05 109.65000000000001p 6.9513830000000001e-05 109.66249999999999p 6.0221250000000002e-05 109.675p 5.1001719999999998e-05 109.6875p 4.1862820000000003e-05 109.7p 3.2811899999999997e-05 109.71249999999999p 2.3856089999999999e-05 109.72499999999999p 1.5002330000000001e-05 109.73750000000001p 6.2573229999999998e-06 109.75p -2.3724010000000002e-06 109.7625p -1.0880509999999999e-05 109.77500000000001p -1.9260860000000001e-05 109.78749999999999p -2.750749e-05 109.8p -3.5614600000000003e-05
+ 109.8125p -4.3576569999999997e-05 109.825p -5.1387929999999998e-05 109.83749999999999p -5.9043399999999998e-05 109.84999999999999p -6.6537829999999994e-05 109.86250000000001p -7.3866250000000004e-05 109.875p -8.1023810000000002e-05 109.8875p -8.800584e-05 109.90000000000001p -9.4807830000000006e-05 109.91249999999999p -0.0001014254 109.925p -0.00010785429999999999 109.9375p -0.00011409049999999999 109.95p -0.0001201301 109.96249999999999p -0.0001259694 109.97499999999999p -0.0001316047 109.9875p -0.00013703270000000001 110p -0.0001422501 110.0125p -0.0001472538 110.02500000000001p -0.000152041
+ 110.03749999999999p -0.00015660890000000001 110.05p -0.00016095510000000001 110.0625p -0.00016507730000000001 110.075p -0.0001689734 110.08749999999999p -0.00017264139999999999 110.09999999999999p -0.00017607979999999999 110.1125p -0.00017928710000000001 110.125p -0.00018226209999999999 110.1375p -0.0001850039 110.15000000000001p -0.00018751170000000001 110.16250000000001p -0.00018978509999999999 110.175p -0.00019182389999999999 110.1875p -0.0001936281 110.2p -0.00019519820000000001 110.21249999999999p -0.00019653469999999999 110.22499999999999p -0.00019763840000000001 110.2375p -0.00019851060000000001 110.25p -0.0001991528
+ 110.2625p -0.00019956649999999999 110.27500000000001p -0.00019975390000000001 110.28750000000001p -0.00019971729999999999 110.3p -0.00019945919999999999 110.3125p -0.00019898250000000001 110.325p -0.0001982904 110.33749999999999p -0.00019738620000000001 110.34999999999999p -0.0001962737 110.3625p -0.00019495680000000001 110.375p -0.0001934398 110.3875p -0.0001917272 110.40000000000001p -0.0001898236 110.41250000000001p -0.00018773410000000001 110.425p -0.0001854638 110.4375p -0.0001830182 110.45p -0.00018040290000000001 110.46249999999999p -0.00017762370000000001 110.47499999999999p -0.00017468679999999999
+ 110.4875p -0.00017159820000000001 110.5p -0.0001683643 110.5125p -0.00016499179999999999 110.52500000000001p -0.0001614873 110.53750000000001p -0.0001578575 110.55p -0.00015410940000000001 110.5625p -0.00015024999999999999 110.575p -0.0001462864 110.58749999999999p -0.0001422258 110.59999999999999p -0.00013807540000000001 110.6125p -0.0001338426 110.625p -0.00012953469999999999 110.6375p -0.00012515890000000001 110.65000000000001p -0.0001207228 110.66250000000001p -0.0001162336 110.675p -0.0001116986 110.6875p -0.0001071253 110.7p -0.0001025208
+ 110.71249999999999p -9.7892309999999999e-05 110.72499999999999p -9.3247080000000002e-05 110.7375p -8.8592130000000004e-05 110.75p -8.3934450000000004e-05 110.7625p -7.9280939999999998e-05 110.77500000000001p -7.4638359999999997e-05 110.78750000000001p -7.0013399999999996e-05 110.8p -6.5412570000000002e-05 110.8125p -6.0842289999999998e-05 110.825p -5.6308809999999999e-05 110.83750000000001p -5.1818240000000001e-05 110.84999999999999p -4.7376529999999998e-05 110.8625p -4.2989460000000003e-05 110.875p -3.8662619999999999e-05 110.8875p -3.4401460000000003e-05 110.90000000000001p -3.021121e-05 110.91250000000001p -2.6096910000000002e-05 110.925p -2.2063430000000002e-05
+ 110.9375p -1.811541e-05 110.95p -1.42573e-05 110.96250000000001p -1.049332e-05 110.97499999999999p -6.8275049999999998e-06 110.9875p -3.2636500000000001e-06 111p 1.9466190000000001e-07 111.01249999999999p 3.544073e-06 111.02500000000001p 6.7814510000000003e-06 111.03750000000001p 9.9038899999999995e-06 111.05p 1.290871e-05 111.0625p 1.5793479999999999e-05 111.075p 1.8555970000000001e-05 111.08750000000001p 2.119419e-05 111.09999999999999p 2.3706419999999999e-05 111.1125p 2.6091109999999999e-05 111.125p 2.8346990000000001e-05 111.13749999999999p 3.0473000000000001e-05 111.15000000000001p 3.2468310000000003e-05
+ 111.16250000000001p 3.4332329999999999e-05 111.17500000000001p 3.606469e-05 111.1875p 3.7665240000000003e-05 111.2p 3.9134039999999998e-05 111.21250000000001p 4.0471410000000001e-05 111.22499999999999p 4.167786e-05 111.2375p 4.2754099999999998e-05 111.25p 4.3701069999999999e-05 111.26249999999999p 4.4519920000000002e-05 111.27499999999999p 4.5211979999999999e-05 111.28750000000001p 4.5778800000000003e-05 111.30000000000001p 4.6222099999999999e-05 111.3125p 4.6543810000000001e-05 111.325p 4.6746029999999998e-05 111.33750000000001p 4.6831040000000002e-05 111.34999999999999p 4.6801280000000001e-05 111.3625p 4.665937e-05 111.375p 4.6408079999999999e-05
+ 111.38749999999999p 4.6050339999999998e-05 111.39999999999999p 4.5589220000000002e-05 111.41250000000001p 4.5027919999999998e-05 111.42500000000001p 4.4369800000000003e-05 111.4375p 4.3618310000000003e-05 111.45p 4.2777049999999997e-05 111.46250000000001p 4.18497e-05 111.47499999999999p 4.0840080000000001e-05 111.4875p 3.975207e-05 111.5p 3.8589669999999999e-05 111.51249999999999p 3.7356929999999997e-05 111.52499999999999p 3.6057989999999999e-05 111.53749999999999p 3.4697070000000002e-05 111.55000000000001p 3.3278409999999997e-05 111.5625p 3.1806349999999997e-05 111.575p 3.0285220000000001e-05 111.58750000000001p 2.871943e-05 111.59999999999999p 2.711339e-05
+ 111.6125p 2.5471540000000001e-05 111.625p 2.3798340000000002e-05 111.6375p 2.2098240000000001e-05 111.64999999999999p 2.0375690000000001e-05 111.66249999999999p 1.863514e-05 111.67500000000001p 1.6881020000000001e-05 111.6875p 1.511774e-05 111.7p 1.334967e-05 111.71250000000001p 1.158115e-05 111.72499999999999p 9.8164699999999995e-06 111.7375p 8.0598789999999997e-06 111.75p 6.3155629999999998e-06 111.7625p 4.5876449999999997e-06 111.77499999999999p 2.8801810000000001e-06 111.78749999999999p 1.19715e-06 111.8p -4.575495e-07 111.8125p -2.0801039999999999e-06 111.825p -3.666794e-06
+ 111.83750000000001p -5.2139960000000003e-06 111.84999999999999p -6.7181890000000002e-06 111.8625p -8.1759599999999999e-06 111.875p -9.5840059999999998e-06 111.8875p -1.0939139999999999e-05 111.89999999999999p -1.2238299999999999e-05 111.91249999999999p -1.347855e-05 111.925p -1.4657079999999999e-05 111.9375p -1.5771199999999999e-05 111.95p -1.6818369999999999e-05 111.96250000000001p -1.7796200000000001e-05 111.97500000000001p -1.870242e-05 111.9875p -1.9534909999999999e-05 112p -2.0291710000000002e-05 112.0125p -2.097101e-05 112.02499999999999p -2.1571119999999999e-05 112.03749999999999p -2.2090550000000001e-05 112.05p -2.252793e-05
+ 112.0625p -2.288207e-05 112.075p -2.315193e-05 112.08750000000001p -2.3336620000000001e-05 112.10000000000001p -2.3435430000000001e-05 112.1125p -2.3447789999999999e-05 112.125p -2.3373309999999999e-05 112.1375p -2.3211739999999999e-05 112.14999999999999p -2.2963e-05 112.16249999999999p -2.2627180000000001e-05 112.175p -2.2204500000000001e-05 112.1875p -2.1695380000000001e-05 112.2p -2.1100349999999999e-05 112.21250000000001p -2.0420140000000001e-05 112.22500000000001p -1.9655590000000001e-05 112.2375p -1.8807720000000001e-05 112.25p -1.7877689999999999e-05 112.2625p -1.6866820000000001e-05 112.27499999999999p -1.577654e-05
+ 112.28749999999999p -1.4608450000000001e-05 112.3p -1.33643e-05 112.3125p -1.204593e-05 112.325p -1.065535e-05 112.33750000000001p -9.1946819999999993e-06 112.35000000000001p -7.6661820000000003e-06 112.3625p -6.0722159999999997e-06 112.375p -4.4152730000000002e-06 112.3875p -2.6979500000000001e-06 112.39999999999999p -9.2295620000000003e-07 112.41249999999999p 9.0689979999999996e-07 112.425p 2.7887090000000001e-06 112.4375p 4.7194680000000003e-06 112.45p 6.6960849999999999e-06 112.46250000000001p 8.7153850000000002e-06 112.47500000000001p 1.077411e-05 112.4875p 1.2868940000000001e-05 112.5p 1.499646e-05
+ 112.5125p 1.7153229999999999e-05 112.52499999999999p 1.933572e-05 112.53749999999999p 2.1540350000000001e-05 112.55p 2.3763519999999998e-05 112.5625p 2.6001559999999999e-05 112.575p 2.8250769999999999e-05 112.58750000000001p 3.0507440000000001e-05 112.60000000000001p 3.2767810000000002e-05 112.6125p 3.5028119999999999e-05 112.625p 3.7284569999999997e-05 112.6375p 3.9533400000000003e-05 112.64999999999999p 4.1770800000000003e-05 112.66249999999999p 4.3992999999999997e-05 112.675p 4.6196229999999999e-05 112.6875p 4.8376720000000002e-05 112.7p 5.0530740000000003e-05 112.71250000000001p 5.2654590000000002e-05 112.72500000000001p 5.4744599999999998e-05
+ 112.7375p 5.6797130000000001e-05 112.75p 5.8808599999999998e-05 112.7625p 6.0775469999999999e-05 112.77500000000001p 6.2694259999999998e-05 112.78749999999999p 6.4561560000000006e-05 112.8p 6.637402e-05 112.8125p 6.8128350000000006e-05 112.82499999999999p 6.9821360000000006e-05 112.83750000000001p 7.1449939999999998e-05 112.85000000000001p 7.301105e-05 112.8625p 7.4501759999999996e-05 112.875p 7.5919230000000005e-05 112.8875p 7.7260729999999999e-05 112.90000000000001p 7.8523619999999996e-05 112.91249999999999p 7.9705379999999996e-05 112.925p 8.0803609999999994e-05 112.9375p 8.1816030000000006e-05 112.94999999999999p 8.2740450000000002e-05
+ 112.96250000000001p 8.3574850000000002e-05 112.97500000000001p 8.4317309999999994e-05 112.9875p 8.4966050000000003e-05 113p 8.5519409999999994e-05 113.0125p 8.5975889999999997e-05 113.02500000000001p 8.6334099999999997e-05 113.03749999999999p 8.6592820000000004e-05 113.05p 8.6750959999999994e-05 113.0625p 8.6807549999999995e-05 113.07499999999999p 8.6761800000000007e-05 113.08749999999999p 8.6613039999999995e-05 113.10000000000001p 8.6360750000000005e-05 113.11250000000001p 8.6004579999999998e-05 113.125p 8.5544279999999999e-05 113.1375p 8.4979800000000002e-05 113.15000000000001p 8.4311179999999999e-05 113.16249999999999p 8.3538660000000004e-05 113.175p 8.2662570000000002e-05
+ 113.1875p 8.168343e-05 113.19999999999999p 8.0601880000000004e-05 113.21249999999999p 7.9418679999999998e-05 113.22500000000001p 7.8134779999999995e-05 113.23750000000001p 7.6751209999999999e-05 113.25p 7.526918e-05 113.2625p 7.3689999999999994e-05 113.27500000000001p 7.2015130000000003e-05 113.28749999999999p 7.0246150000000002e-05 113.3p 6.838476e-05 113.3125p 6.6432780000000004e-05 113.32499999999999p 6.439216e-05 113.33749999999999p 6.2264959999999998e-05 113.35000000000001p 6.005335e-05 113.36250000000001p 5.7759610000000002e-05 113.375p 5.5386120000000003e-05 113.3875p 5.2935369999999999e-05 113.40000000000001p 5.0409940000000003e-05
+ 113.41249999999999p 4.7812509999999997e-05 113.425p 4.5145860000000001e-05 113.4375p 4.2412849999999998e-05 113.45p 3.9616400000000002e-05 113.46249999999999p 3.6759559999999997e-05 113.47499999999999p 3.384541e-05 113.48750000000001p 3.0877129999999998e-05 113.5p 2.785795e-05 113.5125p 2.4791179999999999e-05 113.52500000000001p 2.1680189999999999e-05 113.53749999999999p 1.85284e-05 113.55p 1.533929e-05 113.5625p 1.211638e-05 113.575p 8.8632580000000004e-06 113.58749999999999p 5.583525e-06 113.59999999999999p 2.2808409999999999e-06 113.61250000000001p -1.041104e-06 113.625p -4.3785889999999998e-06
+ 113.6375p -7.7278680000000001e-06 113.65000000000001p -1.108517e-05 113.66249999999999p -1.44467e-05 113.675p -1.7808650000000001e-05 113.6875p -2.11672e-05 113.7p -2.4518530000000001e-05 113.71249999999999p -2.7858800000000002e-05 113.72499999999999p -3.1184179999999997e-05 113.7375p -3.4490840000000001e-05 113.75p -3.777495e-05 113.7625p -4.1032709999999998e-05 113.77500000000001p -4.4260320000000002e-05 113.78750000000001p -4.7453999999999997e-05 113.8p -5.0609989999999998e-05 113.8125p -5.3724580000000003e-05 113.825p -5.6794060000000003e-05 113.83749999999999p -5.9814780000000001e-05 113.84999999999999p -6.2783129999999994e-05
+ 113.8625p -6.5695509999999995e-05 113.875p -6.8548419999999997e-05 113.8875p -7.1338369999999999e-05 113.90000000000001p -7.4061959999999994e-05 113.91250000000001p -7.6715830000000004e-05 113.925p -7.9296700000000003e-05 113.9375p -8.1801339999999995e-05 113.95p -8.4226620000000006e-05 113.96249999999999p -8.6569489999999998e-05 113.97499999999999p -8.8826950000000005e-05 113.9875p -9.0996140000000004e-05 114p -9.307424e-05 114.0125p -9.5058569999999996e-05 114.02500000000001p -9.694653e-05 114.03750000000001p -9.8735629999999999e-05 114.05p -0.00010042350000000001 114.0625p -0.0001020078 114.075p -0.0001034865
+ 114.08749999999999p -0.0001048576 114.09999999999999p -0.000106119 114.1125p -0.0001072691 114.125p -0.0001083062 114.1375p -0.00010922879999999999 114.15000000000001p -0.0001100356 114.16250000000001p -0.0001107253 114.175p -0.0001112968 114.1875p -0.0001117492 114.2p -0.00011208169999999999 114.21249999999999p -0.0001122937 114.22499999999999p -0.0001123848 114.2375p -0.0001123545 114.25p -0.0001122027 114.2625p -0.00011192940000000001 114.27500000000001p -0.00011153459999999999 114.28750000000001p -0.0001110189 114.3p -0.0001103824
+ 114.3125p -0.0001096259 114.325p -0.0001087502 114.33749999999999p -0.0001077561 114.34999999999999p -0.0001066447 114.3625p -0.0001054172 114.375p -0.000104075 114.3875p -0.0001026196 114.40000000000001p -0.0001010527 114.41250000000001p -9.9376069999999997e-05 114.425p -9.7591690000000002e-05 114.4375p -9.5701630000000001e-05 114.45p -9.370812e-05 114.46249999999999p -9.161351e-05 114.47499999999999p -8.942028e-05 114.4875p -8.7131030000000005e-05 114.5p -8.4748500000000004e-05 114.5125p -8.2275510000000003e-05 114.52500000000001p -7.9715029999999994e-05
+ 114.53750000000001p -7.7070120000000001e-05 114.55p -7.4343940000000001e-05 114.5625p -7.1539740000000005e-05 114.575p -6.8660890000000005e-05 114.58750000000001p -6.5710829999999996e-05 114.59999999999999p -6.2693069999999996e-05 114.6125p -5.9611219999999997e-05 114.625p -5.6468970000000002e-05 114.6375p -5.327005e-05 114.65000000000001p -5.0018259999999999e-05 114.66250000000001p -4.671748e-05 114.675p -4.3371609999999997e-05 114.6875p -3.9984629999999999e-05 114.7p -3.6560519999999998e-05 114.71250000000001p -3.3103340000000001e-05 114.72499999999999p -2.9617140000000001e-05 114.7375p -2.6106029999999999e-05 114.75p -2.2574119999999999e-05
+ 114.76249999999999p -1.9025539999999999e-05 114.77500000000001p -1.5464419999999999e-05 114.78750000000001p -1.1894909999999999e-05 114.8p -8.3211439999999994e-06 114.8125p -4.7472650000000004e-06 114.825p -1.1773909999999999e-06 114.83750000000001p 2.38437e-06 114.84999999999999p 5.933935e-06 114.8625p 9.4672449999999995e-06 114.875p 1.298027e-05 114.88749999999999p 1.646903e-05 114.90000000000001p 1.9929579999999998e-05 114.91250000000001p 2.3357999999999999e-05 114.92500000000001p 2.6750450000000001e-05 114.9375p 3.0103139999999999e-05 114.95p 3.341232e-05 114.96250000000001p 3.6674339999999998e-05 114.97499999999999p 3.9885590000000002e-05
+ 114.9875p 4.3042540000000003e-05 115p 4.6141740000000002e-05 115.01249999999999p 4.9179820000000001e-05 115.02499999999999p 5.2153510000000002e-05 115.03750000000001p 5.5059619999999999e-05 115.05000000000001p 5.7895040000000003e-05 115.0625p 6.0656779999999997e-05 115.075p 6.334193e-05 115.08750000000001p 6.5947719999999993e-05 115.09999999999999p 6.8471440000000006e-05 115.1125p 7.0910529999999993e-05 115.125p 7.3262530000000001e-05 115.13749999999999p 7.55251e-05 115.14999999999999p 7.7696019999999997e-05 115.16250000000001p 7.9773179999999996e-05 115.17500000000001p 8.1754620000000006e-05 115.1875p 8.3638499999999996e-05 115.2p 8.5423090000000005e-05
+ 115.21250000000001p 8.7106810000000005e-05 115.22499999999999p 8.8688220000000004e-05 115.2375p 9.0165990000000003e-05 115.25p 9.1538950000000002e-05 115.26249999999999p 9.2806049999999996e-05 115.27499999999999p 9.3966380000000001e-05 115.28749999999999p 9.5019190000000006e-05 115.30000000000001p 9.5963839999999994e-05 115.3125p 9.6799849999999998e-05 115.325p 9.7526850000000006e-05 115.33750000000001p 9.8144650000000006e-05 115.34999999999999p 9.8653160000000003e-05 115.3625p 9.9052440000000003e-05 115.375p 9.9342709999999994e-05 115.3875p 9.9524289999999998e-05 115.39999999999999p 9.9597640000000006e-05 115.41249999999999p 9.9563369999999994e-05 115.42500000000001p 9.9422209999999999e-05
+ 115.4375p 9.9175009999999999e-05 115.45p 9.8822759999999996e-05 115.46250000000001p 9.8366559999999998e-05 115.47499999999999p 9.7807629999999997e-05 115.4875p 9.7147330000000006e-05 115.5p 9.6387110000000005e-05 115.5125p 9.5528549999999995e-05 115.52499999999999p 9.4573309999999999e-05 115.53749999999999p 9.3523180000000005e-05 115.55p 9.2380049999999997e-05 115.5625p 9.1145910000000005e-05 115.575p 8.9822819999999998e-05 115.58750000000001p 8.8412950000000005e-05 115.59999999999999p 8.6918559999999995e-05 115.6125p 8.5341979999999996e-05 115.625p 8.3685629999999999e-05 115.6375p 8.1951980000000003e-05 115.64999999999999p 8.0143599999999996e-05
+ 115.66249999999999p 7.826311e-05 115.675p 7.6313189999999999e-05 115.6875p 7.4296579999999995e-05 115.7p 7.2216070000000006e-05 115.71250000000001p 7.0074520000000003e-05 115.72500000000001p 6.7874789999999995e-05 115.7375p 6.561983e-05 115.75p 6.3312580000000006e-05 115.7625p 6.0956060000000001e-05 115.77499999999999p 5.8553269999999999e-05 115.78749999999999p 5.6107270000000002e-05 115.8p 5.3621130000000003e-05 115.8125p 5.1097919999999999e-05 115.825p 4.8540749999999998e-05 115.83750000000001p 4.5952719999999999e-05 115.85000000000001p 4.3336939999999998e-05 115.8625p 4.069652e-05 115.875p 3.8034570000000001e-05
+ 115.8875p 3.535419e-05 115.89999999999999p 3.2658489999999998e-05 115.91249999999999p 2.9950529999999999e-05 115.925p 2.7233399999999999e-05 115.9375p 2.451014e-05 115.95p 2.1783780000000002e-05 115.96250000000001p 1.905733e-05 115.97500000000001p 1.6333749999999999e-05 115.9875p 1.3616e-05 116p 1.090699e-05 116.0125p 8.209603e-06 116.02499999999999p 5.5266749999999999e-06 116.03749999999999p 2.861008e-06 116.05p 2.1535870000000001e-07 116.0625p -2.407561e-06 116.075p -5.0050859999999998e-06 116.08750000000001p -7.5746030000000002e-06 116.10000000000001p -1.0113550000000001e-05
+ 116.1125p -1.261942e-05 116.125p -1.508976e-05 116.1375p -1.7522179999999998e-05 116.14999999999999p -1.9914339999999999e-05 116.16249999999999p -2.2263980000000001e-05 116.175p -2.456888e-05 116.1875p -2.682692e-05 116.2p -2.9036009999999998e-05 116.21250000000001p -3.1194159999999997e-05 116.22500000000001p -3.3299429999999997e-05 116.2375p -3.5349960000000003e-05 116.25p -3.7343969999999998e-05 116.2625p -3.9279749999999999e-05 116.27499999999999p -4.1155670000000001e-05 116.28749999999999p -4.2970170000000002e-05 116.3p -4.4721780000000001e-05 116.3125p -4.6409110000000003e-05 116.325p -4.8030839999999997e-05
+ 116.33750000000001p -4.9585759999999999e-05 116.35000000000001p -5.1072709999999997e-05 116.3625p -5.2490639999999998e-05 116.375p -5.3838570000000001e-05 116.3875p -5.5115619999999999e-05 116.39999999999999p -5.6320989999999998e-05 116.41249999999999p -5.745397e-05 116.42499999999998p -5.8513939999999998e-05 116.43749999999999p -5.9500360000000001e-05 116.45p -6.0412789999999998e-05 116.46250000000001p -6.1250880000000005e-05 116.47500000000001p -6.2014350000000004e-05 116.48750000000001p -6.2703040000000002e-05 116.50000000000001p -6.3316840000000006e-05 116.51249999999999p -6.3855770000000004e-05 116.52499999999999p -6.4319920000000002e-05 116.53749999999999p -6.4709449999999998e-05 116.55p -6.5024639999999997e-05
+ 116.5625p -6.5265839999999997e-05 116.575p -6.5433480000000002e-05 116.58750000000001p -6.5528090000000006e-05 116.59999999999999p -6.5550269999999999e-05 116.6125p -6.5500720000000003e-05 116.625p -6.5380190000000001e-05 116.6375p -6.518955e-05 116.65000000000001p -6.4929719999999997e-05 116.66250000000001p -6.4601709999999996e-05 116.67499999999998p -6.4206590000000002e-05 116.68749999999999p -6.3745530000000004e-05 116.69999999999999p -6.3219750000000004e-05 116.71250000000001p -6.2630539999999999e-05 116.72500000000001p -6.1979260000000002e-05 116.73750000000001p -6.1267350000000006e-05 116.75000000000001p -6.0496289999999998e-05 116.76249999999999p -5.966763e-05 116.77499999999999p -5.8782990000000002e-05
+ 116.78749999999999p -5.7844019999999998e-05 116.8p -5.6852450000000001e-05 116.8125p -5.5810029999999998e-05 116.825p -5.4718590000000001e-05 116.83750000000001p -5.3579970000000003e-05 116.84999999999999p -5.2396089999999997e-05 116.8625p -5.1168880000000003e-05 116.875p -4.9900310000000001e-05 116.8875p -4.8592399999999999e-05 116.90000000000001p -4.7247180000000003e-05 116.91250000000001p -4.586671e-05 116.92500000000001p -4.4453080000000002e-05 116.93749999999999p -4.30084e-05 116.94999999999999p -4.1534800000000001e-05 116.96249999999999p -4.0034419999999999e-05 116.97500000000001p -3.8509420000000002e-05 116.98750000000001p -3.6961949999999999e-05 117.00000000000001p -3.5394179999999999e-05
+ 117.01249999999999p -3.3808279999999998e-05 117.02499999999999p -3.2206419999999999e-05 117.03749999999999p -3.0590779999999997e-05 117.05p -2.8963500000000001e-05 117.0625p -2.7326729999999999e-05 117.075p -2.5682629999999999e-05 117.08750000000001p -2.4033299999999999e-05 117.09999999999999p -2.2380859999999998e-05 117.1125p -2.0727400000000001e-05 117.125p -1.9074970000000001e-05 117.1375p -1.7425609999999999e-05 117.15000000000001p -1.578133e-05 117.16250000000001p -1.414411e-05 117.17500000000001p -1.25159e-05 117.18749999999999p -1.089861e-05 117.19999999999999p -9.2940990000000003e-06 117.21249999999999p -7.7042130000000004e-06 117.22499999999999p -6.1307380000000002e-06
+ 117.23750000000001p -4.5754229999999998e-06 117.25000000000001p -3.0399680000000001e-06 117.26250000000002p -1.526028e-06 117.27499999999999p -3.5204939999999997e-08 117.28749999999999p 1.430947e-06 117.3p 2.870927e-06 117.3125p 4.2832909999999997e-06 117.325p 5.6666460000000001e-06 117.33750000000001p 7.0196609999999999e-06 117.34999999999999p 8.3410599999999994e-06 117.3625p 9.6296270000000006e-06 117.375p 1.0884210000000001e-05 117.3875p 1.2103700000000001e-05 117.40000000000001p 1.328709e-05 117.41250000000001p 1.4433390000000001e-05 117.42500000000001p 1.5541700000000001e-05 117.43749999999999p 1.661118e-05 117.44999999999999p 1.764106e-05
+ 117.46249999999999p 1.8630610000000002e-05 117.47499999999999p 1.957919e-05 117.4875p 2.0486229999999999e-05 117.50000000000001p 2.1351189999999999e-05 117.51250000000002p 2.217364e-05 117.52499999999999p 2.2953180000000001e-05 117.53749999999999p 2.3689500000000001e-05 117.55p 2.4382330000000001e-05 117.5625p 2.5031480000000001e-05 117.575p 2.563682e-05 117.58750000000001p 2.6198289999999999e-05 117.60000000000001p 2.6715880000000001e-05 117.6125p 2.7189650000000001e-05 117.625p 2.761971e-05 117.6375p 2.800625e-05 117.65000000000001p 2.834949e-05 117.66250000000001p 2.8649740000000001e-05 117.67500000000001p 2.8907329999999999e-05
+ 117.68749999999999p 2.9122690000000001e-05 117.69999999999999p 2.9296270000000001e-05 117.71249999999999p 2.9428569999999999e-05 117.72499999999999p 2.952017e-05 117.7375p 2.9571670000000001e-05 117.75p 2.9583739999999999e-05 117.76250000000002p 2.9557080000000001e-05 117.77499999999999p 2.9492439999999998e-05 117.78749999999999p 2.9390620000000001e-05 117.8p 2.9252459999999999e-05 117.8125p 2.9078829999999999e-05 117.825p 2.8870650000000001e-05 117.83750000000001p 2.862886e-05 117.85000000000001p 2.8354450000000001e-05 117.86249999999998p 2.8048429999999999e-05 117.875p 2.7711859999999999e-05 117.8875p 2.7345800000000002e-05 117.90000000000001p 2.6951350000000001e-05
+ 117.91250000000001p 2.6529650000000001e-05 117.92500000000001p 2.6081840000000001e-05 117.93750000000001p 2.560908e-05 117.94999999999999p 2.5112560000000001e-05 117.96249999999999p 2.459349e-05 117.97499999999999p 2.405308e-05 117.9875p 2.3492570000000001e-05 118p 2.2913180000000001e-05 118.0125p 2.231618e-05 118.02499999999999p 2.1702800000000002e-05 118.03749999999999p 2.1074330000000001e-05 118.05p 2.0432010000000001e-05 118.0625p 1.9777100000000001e-05 118.075p 1.9110879999999999e-05 118.08750000000001p 1.8434600000000001e-05 118.10000000000001p 1.7749510000000001e-05 118.11249999999998p 1.7056870000000001e-05 118.12499999999999p 1.6357909999999999e-05
+ 118.1375p 1.565386e-05 118.15000000000001p 1.494594e-05 118.16250000000001p 1.4235349999999999e-05 118.17500000000001p 1.35233e-05 118.18750000000001p 1.2810940000000001e-05 118.19999999999999p 1.209943e-05 118.21249999999999p 1.1389920000000001e-05 118.22499999999999p 1.0683509999999999e-05 118.2375p 9.9813050000000008e-06 118.25p 9.28437e-06 118.2625p 8.5937530000000004e-06 118.27500000000002p 7.9104710000000006e-06 118.28749999999999p 7.2355170000000003e-06 118.3p 6.5698549999999998e-06 118.3125p 5.9144209999999996e-06 118.325p 5.2701170000000004e-06 118.33750000000001p 4.6378169999999997e-06 118.35000000000001p 4.0183619999999997e-06
+ 118.36249999999998p 3.4125590000000001e-06 118.37499999999999p 2.8211820000000001e-06 118.38749999999999p 2.2449700000000001e-06 118.40000000000001p 1.684625e-06 118.41250000000001p 1.140817e-06 118.42500000000001p 6.1417459999999996e-07 118.43750000000001p 1.052929e-07 118.44999999999999p -3.8527239999999998e-07 118.46249999999999p -8.5700310000000003e-07 118.47499999999999p -1.309419e-06 118.4875p -1.7420800000000001e-06 118.5p -2.1545829999999998e-06 118.5125p -2.5465659999999998e-06 118.52500000000001p -2.9177040000000001e-06 118.53749999999999p -3.267714e-06 118.55p -3.5963499999999999e-06 118.5625p -3.9034069999999997e-06 118.575p -4.1887180000000003e-06
+ 118.58750000000001p -4.4521570000000002e-06 118.60000000000001p -4.6936339999999999e-06 118.61249999999998p -4.9131009999999998e-06 118.62499999999999p -5.1105469999999998e-06 118.63749999999999p -5.285997e-06 118.65000000000001p -5.4395180000000003e-06 118.66250000000001p -5.57121e-06 118.67500000000001p -5.6812129999999996e-06 118.68750000000001p -5.7697019999999996e-06 118.69999999999999p -5.8368870000000002e-06 118.71249999999999p -5.8830140000000002e-06 118.72499999999999p -5.9083620000000003e-06 118.7375p -5.9132450000000002e-06 118.75p -5.89801e-06 118.7625p -5.8630340000000001e-06 118.77500000000001p -5.8087269999999997e-06 118.78749999999999p -5.7355289999999997e-06 118.8p -5.6439089999999999e-06
+ 118.8125p -5.5343630000000004e-06 118.825p -5.4074180000000002e-06 118.83750000000001p -5.2636239999999997e-06 118.85000000000001p -5.1035579999999998e-06 118.86250000000001p -4.927819e-06 118.87499999999999p -4.7370319999999997e-06 118.88749999999999p -4.531841e-06 118.89999999999999p -4.3129139999999998e-06 118.91250000000001p -4.0809339999999998e-06 118.92500000000001p -3.8366060000000004e-06 118.93750000000001p -3.5806500000000002e-06 118.94999999999999p -3.313802e-06 118.96249999999999p -3.0368139999999998e-06 118.97499999999999p -2.7504470000000002e-06 118.9875p -2.4554779999999999e-06 119p -2.1526910000000001e-06 119.0125p -1.8428820000000001e-06 119.02500000000001p -1.5268520000000001e-06
+ 119.03749999999999p -1.20541e-06 119.05p -8.7936840000000004e-07 119.0625p -5.4954420000000002e-07 119.075p -2.1675629999999999e-07 119.08750000000001p 1.181761e-07 119.10000000000001p 4.5443399999999998e-07 119.11250000000001p 7.912006e-07 119.12499999999999p 1.127662e-06 119.13749999999999p 1.4630110000000001e-06 119.14999999999999p 1.796442e-06 119.16249999999999p 2.1271619999999999e-06 119.17500000000001p 2.4543840000000001e-06 119.18750000000001p 2.7773300000000001e-06 119.20000000000002p 3.0952349999999999e-06 119.21249999999999p 3.4073450000000002e-06 119.22499999999999p 3.7129219999999998e-06 119.2375p 4.0112400000000001e-06 119.25p 4.3015899999999998e-06
+ 119.2625p 4.5832810000000003e-06 119.27500000000001p 4.8556380000000004e-06 119.28749999999999p 5.1180080000000002e-06 119.3p 5.3697560000000003e-06 119.3125p 5.6102699999999999e-06 119.325p 5.8389579999999996e-06 119.33750000000001p 6.055253e-06 119.35000000000001p 6.258612e-06 119.36250000000001p 6.4485150000000004e-06 119.37499999999999p 6.6244690000000001e-06 119.38749999999999p 6.7860069999999999e-06 119.39999999999999p 6.9326880000000002e-06 119.41249999999999p 7.0641010000000001e-06 119.425p 7.1798600000000002e-06 119.43750000000001p 7.2796109999999998e-06 119.45000000000002p 7.3630270000000002e-06 119.46249999999999p 7.4298119999999999e-06 119.47499999999999p 7.4796980000000001e-06
+ 119.4875p 7.5124509999999998e-06 119.5p 7.5278649999999996e-06 119.5125p 7.5257650000000001e-06 119.52500000000001p 7.5060099999999996e-06 119.53750000000001p 7.468487e-06 119.55p 7.4131159999999998e-06 119.5625p 7.3398499999999997e-06 119.575p 7.2486710000000004e-06 119.58750000000001p 7.1395949999999999e-06 119.60000000000001p 7.0126660000000001e-06 119.61250000000001p 6.867964e-06 119.62499999999999p 6.7055950000000003e-06 119.63749999999999p 6.5257019999999997e-06 119.64999999999999p 6.328452e-06 119.66249999999999p 6.1140469999999996e-06 119.675p 5.8827170000000003e-06 119.6875p 5.634723e-06 119.70000000000002p 5.370353e-06
+ 119.71249999999999p 5.0899250000000002e-06 119.72499999999999p 4.7937840000000001e-06 119.7375p 4.4823049999999998e-06 119.75p 4.1558860000000003e-06 119.7625p 3.8149550000000001e-06 119.77500000000001p 3.4599629999999999e-06 119.78750000000001p 3.0913860000000002e-06 119.79999999999998p 2.7097250000000001e-06 119.8125p 2.315503e-06 119.825p 1.909268e-06 119.83750000000001p 1.4915869999999999e-06 119.85000000000001p 1.0630480000000001e-06 119.86250000000001p 6.242587e-07 119.87500000000001p 1.7584690000000001e-07 119.88749999999999p -2.81543e-07 119.89999999999999p -7.4724930000000003e-07 119.91249999999999p -1.2205950000000001e-06 119.925p -1.7008869999999999e-06
+ 119.9375p -2.1874200000000001e-06 119.95p -2.6794760000000001e-06 119.96249999999999p -3.1763239999999998e-06 119.97499999999999p -3.6772239999999999e-06 119.9875p -4.1814250000000004e-06 120p -4.6881710000000001e-06 120.0125p -5.196694e-06 120.02500000000001p -5.7062249999999997e-06 120.03750000000001p -6.2159869999999997e-06 120.04999999999998p -6.7252009999999998e-06 120.06249999999999p -7.2330860000000003e-06 120.075p -7.7388570000000004e-06 120.08750000000001p -8.2417320000000003e-06 120.10000000000001p -8.7409279999999995e-06 120.11250000000001p -9.2356670000000001e-06 120.12500000000001p -9.7251699999999992e-06 120.13749999999999p -1.0208670000000001e-05 120.14999999999999p -1.068539e-05
+ 120.16249999999999p -1.115458e-05 120.175p -1.161549e-05 120.1875p -1.206737e-05 120.2p -1.2509499999999999e-05 120.21250000000001p -1.2941150000000001e-05 120.22499999999999p -1.336161e-05 120.2375p -1.377019e-05 120.25p -1.4166210000000001e-05 120.2625p -1.4549000000000001e-05 120.27500000000001p -1.491792e-05 120.28750000000001p -1.5272339999999999e-05 120.29999999999998p -1.5611640000000001e-05 120.31249999999999p -1.5935220000000001e-05 120.32499999999999p -1.6242530000000001e-05 120.33750000000001p -1.6532999999999999e-05 120.35000000000001p -1.6806109999999999e-05 120.36250000000001p -1.7061340000000002e-05 120.37500000000001p -1.7298220000000001e-05
+ 120.38749999999999p -1.751629e-05 120.39999999999999p -1.771511e-05 120.41249999999999p -1.789427e-05 120.425p -1.8053399999999999e-05 120.4375p -1.819213e-05 120.45p -1.8310130000000001e-05 120.46250000000001p -1.8407109999999999e-05 120.47499999999999p -1.8482799999999999e-05 120.4875p -1.8536940000000001e-05 120.5p -1.8569330000000001e-05 120.5125p -1.8579790000000001e-05 120.52500000000001p -1.8568149999999999e-05 120.53750000000001p -1.8534289999999999e-05 120.55000000000001p -1.847812e-05 120.56249999999999p -1.839957e-05 120.57499999999999p -1.8298609999999999e-05 120.58749999999999p -1.8175240000000001e-05 120.60000000000001p -1.8029479999999999e-05
+ 120.61250000000001p -1.7861400000000001e-05 120.62500000000001p -1.767108e-05 120.63749999999999p -1.7458649999999999e-05 120.64999999999999p -1.722425e-05 120.66249999999999p -1.6968060000000002e-05 120.675p -1.6690299999999998e-05 120.6875p -1.6391210000000001e-05 120.7p -1.607106e-05 120.71250000000001p -1.573015e-05 120.72499999999999p -1.5368810000000002e-05 120.7375p -1.4987389999999999e-05 120.75p -1.458628e-05 120.7625p -1.416589e-05 120.77500000000001p -1.372667e-05 120.78750000000001p -1.326908e-05 120.80000000000001p -1.279362e-05 120.81249999999999p -1.230079e-05 120.82499999999999p -1.1791140000000001e-05
+ 120.83749999999999p -1.126525e-05 120.85000000000001p -1.072369e-05 120.86250000000001p -1.016708e-05 120.87500000000001p -9.5960519999999999e-06 120.88749999999999p -9.0112590000000008e-06 120.89999999999999p -8.4133729999999992e-06 120.91249999999999p -7.8030880000000004e-06 120.925p -7.1811120000000001e-06 120.9375p -6.5481729999999997e-06 120.95p -5.9050129999999999e-06 120.96250000000001p -5.2523910000000003e-06 120.97499999999999p -4.5910779999999998e-06 120.9875p -3.9218600000000003e-06 121p -3.2455329999999999e-06 121.0125p -2.5629040000000002e-06 121.02500000000001p -1.874791e-06 121.03750000000001p -1.182021e-06 121.05000000000001p -4.8542519999999998e-07
+ 121.06249999999999p 2.141553e-07 121.07499999999999p 9.1587590000000002e-07 121.08749999999999p 1.6188869999999999e-06 121.09999999999999p 2.322338e-06 121.11250000000001p 3.025374e-06 121.12500000000001p 3.7271409999999999e-06 121.13750000000002p 4.4267859999999997e-06 121.14999999999999p 5.1234559999999998e-06 121.16249999999999p 5.8163020000000002e-06 121.175p 6.5044799999999996e-06 121.1875p 7.1871500000000003e-06 121.2p 7.863478e-06 121.21250000000001p 8.5326390000000003e-06 121.22499999999999p 9.1938160000000004e-06 121.2375p 9.8462000000000007e-06 121.25p 1.0489000000000001e-05 121.2625p 1.112142e-05 121.27500000000001p 1.17427e-05
+ 121.28750000000001p 1.2352069999999999e-05 121.30000000000001p 1.29488e-05 121.31249999999999p 1.353216e-05 121.32499999999999p 1.410144e-05 121.33749999999999p 1.4655940000000001e-05 121.34999999999999p 1.5194999999999999e-05 121.3625p 1.5717960000000002e-05 121.37500000000001p 1.62242e-05 121.38750000000002p 1.671309e-05 121.39999999999999p 1.7184060000000001e-05 121.41249999999999p 1.7636529999999998e-05 121.425p 1.8069969999999999e-05 121.4375p 1.8483860000000002e-05 121.45p 1.8877710000000001e-05 121.46250000000001p 1.9251049999999999e-05 121.47500000000001p 1.9603439999999999e-05 121.4875p 1.9934479999999999e-05 121.5p 2.0243769999999999e-05
+ 121.5125p 2.0530960000000001e-05 121.52500000000001p 2.079573e-05 121.53750000000001p 2.1037769999999998e-05 121.55000000000001p 2.125681e-05 121.56249999999999p 2.1452609999999999e-05 121.57499999999999p 2.1624960000000001e-05 121.58749999999999p 2.1773669999999999e-05 121.59999999999999p 2.1898610000000001e-05 121.6125p 2.1999630000000001e-05 121.625p 2.2076659999999999e-05 121.63750000000002p 2.2129630000000001e-05 121.64999999999999p 2.2158509999999999e-05 121.66249999999999p 2.2163299999999998e-05 121.675p 2.2144020000000001e-05 121.6875p 2.2100739999999999e-05 121.7p 2.2033549999999998e-05 121.71250000000001p 2.1942549999999999e-05 121.72500000000001p 2.1827909999999999e-05
+ 121.73749999999998p 2.16898e-05 121.75p 2.1528409999999999e-05 121.7625p 2.134399e-05 121.77500000000001p 2.113679e-05 121.78750000000001p 2.0907109999999999e-05 121.80000000000001p 2.0655240000000001e-05 121.81250000000001p 2.0381550000000001e-05 121.82499999999999p 2.0086390000000001e-05 121.83749999999999p 1.977016e-05 121.84999999999999p 1.943326e-05 121.8625p 1.9076149999999999e-05 121.875p 1.8699280000000001e-05 121.8875p 1.830314e-05 121.89999999999999p 1.7888239999999999e-05 121.91249999999999p 1.7455100000000002e-05 121.925p 1.7004280000000001e-05 121.9375p 1.6536339999999999e-05 121.95p 1.6051859999999998e-05
+ 121.96250000000001p 1.5551459999999999e-05 121.97500000000001p 1.5035750000000001e-05 121.98749999999998p 1.450537e-05 121.99999999999999p 1.396097e-05 122.0125p 1.340322e-05 122.02500000000001p 1.28328e-05 122.03750000000001p 1.22504e-05 122.05000000000001p 1.165673e-05 122.06250000000001p 1.1052490000000001e-05 122.07499999999999p 1.0438410000000001e-05 122.08749999999999p 9.8152319999999997e-06 122.09999999999999p 9.1836850000000005e-06 122.1125p 8.5445189999999996e-06 122.125p 7.8984879999999995e-06 122.1375p 7.246348e-06 122.15000000000001p 6.5888619999999999e-06 122.16249999999999p 5.9267950000000002e-06 122.175p 5.2609120000000002e-06
+ 122.1875p 4.5919820000000002e-06 122.2p 3.9207730000000001e-06 122.21250000000001p 3.248051e-06 122.22500000000001p 2.5745819999999998e-06 122.23749999999998p 1.9011290000000001e-06 122.24999999999999p 1.2284510000000001e-06 122.26249999999999p 5.5730390000000001e-07 122.27500000000001p -1.115637e-07 122.28750000000001p -7.7740779999999998e-07 122.30000000000001p -1.4394919999999999e-06 122.31250000000001p -2.0970879999999999e-06 122.32499999999999p -2.7494739999999998e-06 122.33749999999999p -3.3959419999999999e-06 122.34999999999999p -4.0357909999999999e-06 122.3625p -4.6683309999999996e-06 122.375p -5.2928850000000004e-06 122.3875p -5.908789e-06 122.40000000000001p -6.5153909999999999e-06
+ 122.41249999999999p -7.1120550000000003e-06 122.425p -7.6981559999999999e-06 122.4375p -8.2730890000000004e-06 122.45p -8.8362629999999992e-06 122.46250000000001p -9.3871020000000008e-06 122.47500000000001p -9.9250489999999997e-06 122.48750000000001p -1.044957e-05 122.49999999999999p -1.0960130000000001e-05 122.51249999999999p -1.145624e-05 122.52499999999999p -1.193742e-05 122.53750000000001p -1.24032e-05 122.55000000000001p -1.285314e-05 122.56250000000001p -1.328681e-05 122.57499999999999p -1.370383e-05 122.58749999999999p -1.41038e-05 122.59999999999999p -1.4486379999999999e-05 122.6125p -1.485123e-05 122.625p -1.519804e-05
+ 122.6375p -1.5526509999999998e-05 122.65000000000001p -1.5836389999999999e-05 122.66249999999999p -1.612744e-05 122.675p -1.6399419999999999e-05 122.6875p -1.665216e-05 122.7p -1.6885470000000001e-05 122.71250000000001p -1.7099210000000001e-05 122.72500000000001p -1.729326e-05 122.73750000000001p -1.7467509999999999e-05 122.74999999999999p -1.7621890000000001e-05 122.76249999999999p -1.7756350000000002e-05 122.77499999999999p -1.787087e-05 122.78749999999999p -1.7965420000000001e-05 122.80000000000001p -1.804005e-05 122.81250000000001p -1.809478e-05 122.82500000000002p -1.8129679999999999e-05 122.83749999999999p -1.814485e-05 122.84999999999999p -1.8140389999999999e-05
+ 122.8625p -1.8116440000000001e-05 122.875p -1.8073159999999999e-05 122.8875p -1.8010720000000002e-05 122.90000000000001p -1.792933e-05 122.91249999999999p -1.7829199999999999e-05 122.925p -1.7710580000000001e-05 122.9375p -1.757374e-05 122.95p -1.741895e-05 122.96250000000001p -1.7246509999999999e-05 122.97500000000001p -1.705676e-05 122.98750000000001p -1.6850020000000001e-05 122.99999999999999p -1.6626659999999998e-05 123.01249999999999p -1.6387050000000001e-05 123.02499999999999p -1.6131579999999998e-05 123.03749999999999p -1.586067e-05 123.05p -1.5574730000000001e-05 123.06250000000001p -1.52742e-05 123.07500000000002p -1.4959540000000001e-05
+ 123.08749999999999p -1.463121e-05 123.09999999999999p -1.42897e-05 123.1125p -1.3935500000000001e-05 123.125p -1.35691e-05 123.1375p -1.319103e-05 123.15000000000001p -1.280182e-05 123.16250000000001p -1.2401979999999999e-05 123.175p -1.199208e-05 123.1875p -1.157265e-05 123.2p -1.114426e-05 123.21250000000001p -1.0707480000000001e-05 123.22500000000001p -1.026286e-05 123.23750000000001p -9.8110020000000002e-06 123.24999999999999p -9.3524700000000003e-06 123.26249999999999p -8.8878509999999993e-06 123.27499999999999p -8.4177310000000005e-06 123.28749999999999p -7.942699e-06 123.3p -7.4633449999999999e-06
+ 123.31250000000001p -6.9802569999999998e-06 123.32500000000002p -6.4940250000000001e-06 123.33749999999999p -6.0052380000000003e-06 123.34999999999999p -5.5144829999999996e-06 123.3625p -5.0223430000000003e-06 123.375p -4.5294000000000002e-06 123.3875p -4.03623e-06 123.40000000000001p -3.5434069999999998e-06 123.41250000000001p -3.0514959999999998e-06 123.42499999999998p -2.5610589999999999e-06 123.4375p -2.0726510000000002e-06 123.45p -1.5868180000000001e-06 123.46250000000001p -1.1040989999999999e-06 123.47500000000001p -6.2502580000000004e-07 123.48750000000001p -1.5011839999999999e-07 123.49999999999999p 3.2011119999999998e-07 123.51249999999999p 7.8516189999999998e-07 123.52499999999999p 1.244543e-06
+ 123.53749999999999p 1.6977770000000001e-06 123.55p 2.1443949999999998e-06 123.5625p 2.5839430000000001e-06 123.57500000000002p 3.0159799999999999e-06 123.58749999999999p 3.4400780000000001e-06 123.59999999999999p 3.8558210000000004e-06 123.6125p 4.2628099999999999e-06 123.625p 4.6606589999999996e-06 123.6375p 5.0489970000000004e-06 123.65000000000001p 5.4274680000000001e-06 123.66250000000001p 5.7957329999999997e-06 123.67499999999998p 6.1534679999999996e-06 123.6875p 6.5003630000000001e-06 123.7p 6.8361289999999998e-06 123.71250000000001p 7.1604890000000002e-06 123.72500000000001p 7.4731859999999999e-06 123.73750000000001p 7.7739780000000003e-06 123.75000000000001p 8.0626410000000002e-06
+ 123.76249999999999p 8.3389689999999995e-06 123.77499999999999p 8.6027710000000007e-06 123.78749999999999p 8.853875e-06 123.8p 9.092126e-06 123.8125p 9.3173880000000004e-06 123.825p 9.5295389999999992e-06 123.83749999999999p 9.7284779999999999e-06 123.84999999999999p 9.9141190000000008e-06 123.8625p 1.008639e-05 123.875p 1.024525e-05 123.8875p 1.0390659999999999e-05 123.90000000000001p 1.05226e-05 123.91250000000001p 1.0641080000000001e-05 123.92499999999998p 1.07461e-05 123.93749999999999p 1.08377e-05 123.95p 1.0915939999999999e-05 123.96250000000001p 1.098088e-05 123.97500000000001p 1.1032589999999999e-05
+ 123.98750000000001p 1.107118e-05 124.00000000000001p 1.109675e-05 124.01249999999999p 1.1109429999999999e-05 124.02499999999999p 1.110936e-05 124.03749999999999p 1.10967e-05 124.05p 1.107161e-05 124.0625p 1.1034280000000001e-05 124.075p 1.0984909999999999e-05 124.08750000000001p 1.0923689999999999e-05 124.09999999999999p 1.0850840000000001e-05 124.1125p 1.076661e-05 124.125p 1.0671230000000001e-05 124.1375p 1.056496e-05 124.15000000000001p 1.044806e-05 124.16250000000001p 1.03208e-05 124.17499999999998p 1.018347e-05 124.18749999999999p 1.0036370000000001e-05 124.19999999999999p 9.8797910000000002e-06
+ 124.21250000000001p 9.7140459999999997e-06 124.22500000000001p 9.5394530000000005e-06 124.23750000000001p 9.3563379999999995e-06 124.25000000000001p 9.1650329999999998e-06 124.26249999999999p 8.9658749999999999e-06 124.27499999999999p 8.7592079999999993e-06 124.28749999999999p 8.5453820000000003e-06 124.3p 8.3247509999999996e-06 124.3125p 8.0976720000000005e-06 124.325p 7.8645079999999992e-06 124.33750000000001p 7.6256240000000001e-06 124.34999999999999p 7.3813890000000001e-06 124.3625p 7.1321730000000004e-06 124.375p 6.87835e-06 124.3875p 6.6202910000000003e-06 124.40000000000001p 6.3583739999999997e-06 124.41250000000001p 6.092972e-06 124.42500000000001p 5.8244609999999999e-06
+ 124.43749999999999p 5.5532170000000003e-06 124.44999999999999p 5.2796119999999997e-06 124.46249999999999p 5.0040190000000002e-06 124.47500000000001p 4.7268089999999998e-06 124.48750000000001p 4.4483500000000004e-06 124.50000000000001p 4.1690079999999996e-06 124.51249999999999p 3.8891450000000004e-06 124.52499999999999p 3.60912e-06 124.53749999999999p 3.3292880000000001e-06 124.55p 3.05e-06 124.5625p 2.7716010000000001e-06 124.575p 2.4944319999999998e-06 124.58750000000001p 2.218829e-06 124.59999999999999p 1.9451199999999999e-06 124.6125p 1.6736289999999999e-06 124.625p 1.4046719999999999e-06 124.6375p 1.1385580000000001e-06 124.65000000000001p 8.7559040000000004e-07
+ 124.66250000000001p 6.1606340000000002e-07 124.67500000000001p 3.602637e-07 124.68749999999999p 1.0847029999999999e-07 124.69999999999999p -1.3904659999999999e-07 124.71249999999999p -3.8202550000000002e-07 124.72499999999999p -6.202136e-07 124.73750000000001p -8.5336759999999995e-07 124.75000000000001p -1.0812529999999999e-06 124.76250000000002p -1.3036469999999999e-06 124.77499999999999p -1.5203329999999999e-06 124.78749999999999p -1.731107e-06 124.8p -1.9357750000000001e-06 124.8125p -2.1341539999999998e-06 124.825p -2.3260689999999998e-06 124.83750000000001p -2.5113590000000001e-06 124.84999999999999p -2.6898699999999999e-06 124.8625p -2.8614630000000001e-06 124.875p -3.0260060000000001e-06
+ 124.8875p -3.183381e-06 124.90000000000001p -3.333481e-06 124.91250000000001p -3.4762069999999998e-06 124.92500000000001p -3.6114759999999998e-06 124.93749999999999p -3.739212e-06 124.94999999999999p -3.8593520000000002e-06 124.96249999999999p -3.9718449999999996e-06 124.97499999999999p -4.0766510000000004e-06 124.9875p -4.1737390000000004e-06 125.00000000000001p -4.2630910000000003e-06 125.01250000000002p -4.3447010000000003e-06 125.02499999999999p -4.4185710000000002e-06 125.03749999999999p -4.4847170000000003e-06 125.05p -4.5431629999999996e-06 125.0625p -4.5939460000000002e-06 125.075p -4.6371120000000004e-06 125.08750000000001p -4.6727180000000002e-06 125.10000000000001p -4.7008300000000004e-06
+ 125.1125p -4.7215259999999999e-06 125.125p -4.7348909999999997e-06 125.1375p -4.7410239999999998e-06 125.15000000000001p -4.7400280000000003e-06 125.16250000000001p -4.7320200000000003e-06 125.17500000000001p -4.7171210000000001e-06 125.18749999999999p -4.6954659999999997e-06 125.19999999999999p -4.6671940000000002e-06 125.21249999999999p -4.6324540000000001e-06 125.22499999999999p -4.5914039999999999e-06 125.2375p -4.544205e-06 125.25p -4.4910319999999999e-06 125.26250000000002p -4.43206e-06 125.27499999999999p -4.3674760000000003e-06 125.28749999999999p -4.2974700000000004e-06 125.3p -4.222239e-06 125.3125p -4.1419860000000004e-06 125.325p -4.0569180000000001e-06
+ 125.33750000000001p -3.9672480000000004e-06 125.35000000000001p -3.8731929999999996e-06 125.36249999999998p -3.7749749999999998e-06 125.375p -3.6728179999999999e-06 125.3875p -3.566951e-06 125.40000000000001p -3.4576059999999999e-06 125.41250000000001p -3.3450160000000002e-06 125.42500000000001p -3.229418e-06 125.43750000000001p -3.1110509999999999e-06 125.44999999999999p -2.990155e-06 125.46249999999999p -2.8669699999999998e-06 125.47499999999999p -2.741739e-06 125.4875p -2.614703e-06 125.5p -2.486106e-06 125.5125p -2.3561889999999999e-06 125.52499999999999p -2.2251940000000001e-06 125.53749999999999p -2.0933610000000001e-06 125.55p -1.9609289999999999e-06
+ 125.5625p -1.828135e-06 125.575p -1.6952140000000001e-06 125.58750000000001p -1.5624000000000001e-06 125.60000000000001p -1.429921e-06 125.61249999999998p -1.298004e-06 125.62499999999999p -1.1668739999999999e-06 125.6375p -1.036749e-06 125.65000000000001p -9.0784499999999999e-07 125.66250000000001p -7.803733e-07 125.67500000000001p -6.545405e-07 125.68750000000001p -5.3054819999999998e-07 125.69999999999999p -4.0859290000000002e-07 125.71249999999999p -2.8886559999999999e-07 125.72499999999999p -1.715516e-07 125.7375p -5.6830349999999999e-08 125.75p 5.5124950000000003e-08 125.7625p 1.6414750000000001e-07 125.77500000000002p 2.7007700000000002e-07
+ 125.78749999999999p 3.7276000000000001e-07 125.8p 4.7205019999999998e-07 125.8125p 5.6780810000000004e-07 125.825p 6.5990190000000004e-07 125.83750000000001p 7.4820699999999997e-07 125.85000000000001p 8.3260640000000001e-07 125.86249999999998p 9.1299109999999999e-07 125.87499999999999p 9.8925969999999992e-07 125.88749999999999p 1.061319e-06 125.90000000000001p 1.1290830000000001e-06 125.91250000000001p 1.192475e-06 125.92500000000001p 1.2514260000000001e-06 125.93750000000001p 1.305875e-06 125.94999999999999p 1.355769e-06 125.96249999999999p 1.4010640000000001e-06 125.97499999999999p 1.4417239999999999e-06 125.9875p 1.477722e-06 126p 1.509037e-06
+ 126.0125p 1.5356589999999999e-06 126.02500000000001p 1.5575839999999999e-06 126.03749999999999p 1.574818e-06 126.05p 1.587374e-06 126.0625p 1.5952730000000001e-06 126.075p 1.598545e-06 126.08750000000001p 1.597226e-06 126.10000000000001p 1.5913619999999999e-06 126.11249999999998p 1.5810040000000001e-06 126.12499999999999p 1.566212e-06 126.13749999999999p 1.547054e-06 126.15000000000001p 1.523604e-06 126.16250000000001p 1.4959430000000001e-06 126.17500000000001p 1.4641600000000001e-06 126.18750000000001p 1.428349e-06 126.19999999999999p 1.388611e-06 126.21249999999999p 1.3450550000000001e-06 126.22499999999999p 1.2977929999999999e-06
+ 126.2375p 1.2469450000000001e-06 126.25p 1.192637e-06 126.2625p 1.1349970000000001e-06 126.27500000000001p 1.0741630000000001e-06 126.28749999999999p 1.010274e-06 126.3p 9.4347569999999999e-07 126.3125p 8.7391699999999995e-07 126.325p 8.0175159999999997e-07 126.33750000000001p 7.2713679999999997e-07 126.35000000000001p 6.5023350000000001e-07 126.36250000000001p 5.712058e-07 126.37499999999999p 4.9022109999999997e-07 126.38749999999999p 4.0744909999999998e-07 126.39999999999999p 3.2306220000000002e-07 126.41250000000001p 2.372349e-07 126.42500000000001p 1.5014350000000001e-07 126.43750000000001p 6.1965889999999998e-08 126.44999999999999p -2.7118840000000001e-08
+ 126.46249999999999p -1.169305e-07 126.47499999999999p -2.0728839999999999e-07 126.4875p -2.9801130000000001e-07 126.5p -3.8891800000000002e-07 126.5125p -4.7982740000000002e-07 126.52500000000001p -5.7055889999999998e-07 126.53749999999999p -6.6093290000000001e-07 126.55p -7.5077050000000001e-07 126.5625p -8.3989449999999995e-07 126.575p -9.2812909999999995e-07 126.58750000000001p -1.0153010000000001e-06 126.60000000000001p -1.1012369999999999e-06 126.61250000000001p -1.18577e-06 126.62499999999999p -1.2687320000000001e-06 126.63749999999999p -1.349961e-06 126.64999999999999p -1.4292950000000001e-06 126.66249999999999p -1.506579e-06 126.67500000000001p -1.5816579999999999e-06
+ 126.68750000000001p -1.654385e-06 126.70000000000002p -1.7246129999999999e-06 126.71249999999999p -1.7922030000000001e-06 126.72499999999999p -1.8570190000000001e-06 126.7375p -1.9189299999999999e-06 126.75p -1.977809e-06 126.7625p -2.0335359999999998e-06 126.77500000000001p -2.0859950000000001e-06 126.78749999999999p -2.1350770000000001e-06 126.8p -2.1806770000000001e-06 126.8125p -2.2226979999999999e-06 126.825p -2.2610469999999999e-06 126.83750000000001p -2.2956379999999999e-06 126.85000000000001p -2.3263920000000001e-06 126.86250000000001p -2.3532359999999999e-06 126.87499999999999p -2.3761029999999999e-06 126.88749999999999p -2.394933e-06 126.89999999999999p -2.4096720000000001e-06
+ 126.91249999999999p -2.4202749999999999e-06 126.925p -2.4267029999999999e-06 126.93750000000001p -2.4289210000000001e-06 126.95000000000002p -2.4269060000000002e-06 126.96249999999999p -2.4206379999999999e-06 126.97499999999999p -2.4101060000000002e-06 126.9875p -2.3953050000000001e-06 127p -2.3762389999999998e-06 127.0125p -2.3529170000000002e-06 127.02500000000001p -2.3253559999999998e-06 127.03750000000001p -2.2935799999999998e-06 127.05p -2.2576190000000001e-06 127.0625p -2.2175119999999999e-06 127.075p -2.1733029999999999e-06 127.08750000000001p -2.1250430000000001e-06 127.10000000000001p -2.07279e-06 127.11250000000001p -2.0166100000000002e-06 127.12499999999999p -1.9565729999999999e-06
+ 127.13749999999999p -1.892757e-06 127.14999999999999p -1.8252459999999999e-06 127.16249999999999p -1.7541300000000001e-06 127.175p -1.6795049999999999e-06 127.1875p -1.6014729999999999e-06 127.20000000000002p -1.5201399999999999e-06 127.21249999999999p -1.435621e-06 127.22499999999999p -1.3480329999999999e-06 127.2375p -1.2575e-06 127.25p -1.1641490000000001e-06 127.2625p -1.068114e-06 127.27500000000001p -9.6953179999999994e-07 127.28750000000001p -8.6854419999999996e-07 127.29999999999998p -7.652967e-07 127.3125p -6.5993870000000001e-07 127.325p -5.5262309999999995e-07 127.33750000000001p -4.4350610000000002e-07 127.35000000000001p -3.3274689999999999e-07
+ 127.36250000000001p -2.205074e-07 127.37500000000001p -1.069521e-07 127.38749999999999p 7.7522729999999999e-09 127.39999999999999p 1.2343709999999999e-07 127.41249999999999p 2.3993200000000001e-07 127.425p 3.5706520000000001e-07 127.4375p 4.7466380000000001e-07 127.45p 5.9255420000000004e-07 127.46249999999999p 7.1056189999999999e-07 127.47499999999999p 8.2851230000000003e-07 127.4875p 9.4623079999999996e-07 127.5p 1.063543e-06 127.5125p 1.1802750000000001e-06 127.52500000000001p 1.296254e-06 127.53750000000001p 1.4113079999999999e-06 127.54999999999998p 1.525267e-06 127.56249999999999p 1.637961e-06 127.575p 1.7492229999999999e-06
+ 127.58750000000001p 1.858889e-06 127.60000000000001p 1.9667959999999998e-06 127.61250000000001p 2.0727850000000001e-06 127.62500000000001p 2.1766979999999998e-06 127.63749999999999p 2.2783810000000002e-06 127.64999999999999p 2.3776849999999999e-06 127.66249999999999p 2.474462e-06 127.675p 2.5685699999999999e-06 127.6875p 2.6598689999999999e-06 127.7p 2.7482260000000001e-06 127.71250000000001p 2.8335090000000001e-06 127.72499999999999p 2.9155930000000001e-06 127.7375p 2.994357e-06 127.75p 3.0696860000000001e-06 127.7625p 3.1414679999999999e-06 127.77500000000001p 3.2095989999999999e-06 127.78750000000001p 3.2739780000000001e-06 127.79999999999998p 3.3345110000000001e-06
+ 127.81249999999999p 3.3911079999999998e-06 127.82499999999999p 3.4436879999999998e-06 127.83750000000001p 3.4921730000000001e-06 127.85000000000001p 3.5364909999999999e-06 127.86250000000001p 3.576578e-06 127.87500000000001p 3.6123749999999999e-06 127.88749999999999p 3.6438300000000001e-06 127.89999999999999p 3.6708949999999999e-06 127.91249999999999p 3.6935310000000001e-06 127.925p 3.7117049999999999e-06 127.9375p 3.725388e-06 127.95p 3.7345590000000001e-06 127.96250000000001p 3.7392050000000001e-06 127.97499999999999p 3.7393170000000002e-06 127.9875p 3.7348919999999998e-06 128p 3.7259359999999999e-06 128.01249999999999p 3.712459e-06 128.02500000000001p 3.6944780000000002e-06
+ 128.03750000000002p 3.6720160000000002e-06 128.05000000000001p 3.6451029999999999e-06 128.0625p 3.6137729999999999e-06 128.07499999999999p 3.5780689999999999e-06 128.08750000000001p 3.5380369999999998e-06 128.09999999999999p 3.4937300000000001e-06 128.11250000000001p 3.4452079999999999e-06 128.125p 3.3925339999999998e-06 128.13749999999999p 3.3357789999999999e-06 128.15000000000001p 3.2750169999999998e-06 128.16249999999999p 3.21033e-06 128.17500000000001p 3.141801e-06 128.1875p 3.069523e-06 128.20000000000002p 2.9935900000000002e-06 128.21250000000001p 2.914101e-06 128.22499999999999p 2.8311619999999999e-06 128.23749999999998p 2.7448820000000001e-06 128.25p 2.6553709999999999e-06
+ 128.26249999999999p 2.5627489999999999e-06 128.27500000000001p 2.467135e-06 128.28749999999999p 2.3686530000000001e-06 128.30000000000001p 2.2674320000000001e-06 128.3125p 2.1636010000000002e-06 128.32499999999999p 2.0572949999999998e-06 128.33750000000001p 1.948652e-06 128.34999999999999p 1.837809e-06 128.36250000000001p 1.7249100000000001e-06 128.375p 1.610098e-06 128.38750000000002p 1.4935209999999999e-06 128.39999999999998p 1.375325e-06 128.41249999999999p 1.2556610000000001e-06 128.42500000000001p 1.134679e-06 128.4375p 1.0125339999999999e-06 128.45000000000002p 8.8937730000000004e-07 128.46250000000001p 7.6536419999999995e-07 128.47499999999999p 6.4064950000000005e-07
+ 128.48749999999998p 5.1538860000000001e-07 128.5p 3.897372e-07 128.51249999999999p 2.6385080000000001e-07 128.52500000000001p 1.378849e-07 128.53749999999999p 1.1994439999999999e-08 128.55000000000001p -1.136661e-07 128.5625p -2.3894320000000001e-07 128.57499999999999p -3.6368419999999997e-07 128.58750000000001p -4.8773780000000001e-07 128.59999999999999p -6.1095379999999997e-07 128.61250000000001p -7.3318389999999996e-07 128.625p -8.5428150000000004e-07 128.63750000000002p -9.7410169999999994e-07 128.64999999999998p -1.092502e-06 128.66249999999999p -1.2093419999999999e-06 128.67500000000001p -1.324484e-06 128.6875p -1.4377940000000001e-06 128.70000000000002p -1.5491370000000001e-06
+ 128.71250000000001p -1.6583859999999999e-06 128.72499999999999p -1.765414e-06 128.73749999999998p -1.870098e-06 128.75p -1.9723179999999998e-06 128.76249999999999p -2.0719590000000002e-06 128.77500000000001p -2.1689070000000001e-06 128.78749999999999p -2.263056e-06 128.80000000000001p -2.3543000000000001e-06 128.8125p -2.4425380000000001e-06 128.82499999999999p -2.5276749999999999e-06 128.83750000000001p -2.609618e-06 128.84999999999999p -2.6882809999999999e-06 128.86250000000001p -2.7635779999999999e-06 128.875p -2.8354340000000001e-06 128.88750000000002p -2.9037720000000001e-06 128.89999999999998p -2.9685239999999999e-06 128.91249999999999p -3.0296260000000001e-06 128.92499999999998p -3.0870179999999999e-06
+ 128.9375p -3.1406449999999998e-06 128.95000000000002p -3.1904579999999999e-06 128.96250000000001p -3.2364110000000001e-06 128.97500000000002p -3.2784659999999999e-06 128.98749999999998p -3.316587e-06 129p -3.3507439999999999e-06 129.01249999999999p -3.3809140000000001e-06 129.02500000000001p -3.4070760000000001e-06 129.03749999999999p -3.4292160000000002e-06 129.05000000000001p -3.4473250000000001e-06 129.0625p -3.4613990000000002e-06 129.07499999999999p -3.4714389999999999e-06 129.08750000000001p -3.4774489999999998e-06 129.09999999999999p -3.479442e-06 129.11250000000001p -3.477432e-06 129.125p -3.471441e-06 129.13750000000002p -3.4614929999999998e-06 129.14999999999998p -3.44762e-06
+ 129.16249999999999p -3.429856e-06 129.17499999999998p -3.4082400000000001e-06 129.1875p -3.3828180000000001e-06 129.20000000000002p -3.3536369999999999e-06 129.21250000000001p -3.320752e-06 129.22500000000002p -3.2842190000000001e-06 129.23749999999998p -3.2441e-06 129.25p -3.2004610000000001e-06 129.26249999999999p -3.1533719999999998e-06 129.27500000000001p -3.102907e-06 129.28749999999999p -3.0491429999999999e-06 129.30000000000001p -2.9921609999999999e-06 129.3125p -2.9320469999999999e-06 129.32499999999999p -2.8688890000000001e-06 129.33750000000001p -2.8027779999999999e-06 129.34999999999999p -2.7338080000000002e-06 129.36250000000001p -2.6620789999999999e-06 129.375p -2.5876890000000001e-06
+ 129.38750000000002p -2.5107439999999999e-06 129.39999999999998p -2.4313470000000002e-06 129.41249999999999p -2.349609e-06 129.42499999999998p -2.2656399999999998e-06 129.4375p -2.1795519999999998e-06 129.44999999999999p -2.0914610000000002e-06 129.46250000000001p -2.0014820000000002e-06 129.47500000000002p -1.909735e-06 129.48749999999998p -1.8163390000000001e-06 129.5p -1.721416e-06 129.51249999999999p -1.625087e-06 129.52500000000001p -1.527477e-06 129.53749999999999p -1.428709e-06 129.55000000000001p -1.3289089999999999e-06 129.5625p -1.228201e-06 129.57499999999999p -1.1267130000000001e-06 129.58750000000001p -1.0245690000000001e-06 129.59999999999999p -9.2189650000000003e-07
+ 129.61250000000001p -8.1882120000000003e-07 129.625p -7.1546890000000002e-07 129.63750000000002p -6.1196509999999995e-07 129.65000000000001p -5.0843449999999997e-07 129.66249999999999p -4.050012e-07 129.67499999999998p -3.0178840000000002e-07 129.6875p -1.989185e-07 129.69999999999999p -9.6512220000000002e-08 129.71250000000001p 5.310542e-09 129.72500000000002p 1.064316e-07 129.73749999999998p 2.0673430000000001e-07 129.75p 3.061036e-07 129.76249999999999p 4.0442670000000002e-07 129.77500000000001p 5.0159219999999997e-07 129.78749999999999p 5.9749140000000003e-07 129.80000000000001p 6.9201740000000002e-07 129.8125p 7.8506589999999998e-07 129.82499999999999p 8.7653500000000001e-07
+ 129.83750000000001p 9.6632530000000005e-07 129.84999999999999p 1.0543400000000001e-06 129.86250000000001p 1.140486e-06 129.875p 1.2246709999999999e-06 129.88750000000002p 1.3068079999999999e-06 129.90000000000001p 1.3868110000000001e-06 129.91249999999999p 1.4645990000000001e-06 129.92499999999998p 1.5400930000000001e-06 129.9375p 1.6132169999999999e-06 129.94999999999999p 1.6839000000000001e-06 129.96250000000001p 1.752073e-06 129.97500000000002p 1.817671e-06 129.98750000000001p 1.8806320000000001e-06 130p 1.9408979999999999e-06 130.01249999999999p 1.998415e-06 130.02500000000001p 2.0531310000000001e-06 130.03749999999999p 2.1050000000000002e-06 130.05000000000001p 2.1539779999999999e-06
+ 130.0625p 2.200026e-06 130.07499999999999p 2.243108e-06 130.08750000000001p 2.2831919999999998e-06 130.09999999999999p 2.3202490000000001e-06 130.11250000000001p 2.3542549999999999e-06 130.125p 2.385189e-06 130.13750000000002p 2.4130340000000001e-06 130.15000000000001p 2.4377770000000002e-06 130.16249999999999p 2.45941e-06 130.17499999999998p 2.4779259999999999e-06 130.1875p 2.4933229999999999e-06 130.19999999999999p 2.5056039999999999e-06 130.21250000000001p 2.5147740000000002e-06 130.22499999999999p 2.5208430000000002e-06 130.23750000000001p 2.5238229999999999e-06 130.25p 2.5237309999999999e-06 130.26249999999999p 2.5205869999999999e-06 130.27500000000001p 2.514416e-06
+ 130.28749999999999p 2.5052429999999999e-06 130.30000000000001p 2.4931010000000001e-06 130.3125p 2.4780210000000002e-06 130.32500000000002p 2.4600429999999999e-06 130.33749999999998p 2.439206e-06 130.34999999999999p 2.415555e-06 130.36250000000001p 2.389135e-06 130.375p 2.359997e-06 130.38750000000002p 2.3281950000000001e-06 130.40000000000001p 2.2937819999999999e-06 130.41249999999999p 2.256819e-06 130.42499999999998p 2.2173669999999999e-06 130.4375p 2.1754899999999999e-06 130.44999999999999p 2.1312539999999998e-06 130.46250000000001p 2.0847280000000001e-06 130.47499999999999p 2.0359849999999999e-06 130.48750000000001p 1.9850979999999998e-06 130.5p 1.9321429999999998e-06
+ 130.51249999999999p 1.877199e-06 130.52500000000001p 1.820346e-06 130.53749999999999p 1.7616650000000001e-06 130.55000000000001p 1.701242e-06 130.5625p 1.6391619999999999e-06 130.57500000000002p 1.5755119999999999e-06 130.58749999999998p 1.5103819999999999e-06 130.59999999999999p 1.443861e-06 130.61250000000001p 1.3760419999999999e-06 130.625p 1.307018e-06 130.63750000000002p 1.2368810000000001e-06 130.65000000000001p 1.165728e-06 130.66250000000002p 1.093654e-06 130.67499999999998p 1.0207550000000001e-06 130.6875p 9.4712870000000003e-07 130.69999999999999p 8.7287270000000001e-07 130.71250000000001p 7.9808479999999995e-07 130.72499999999999p 7.2286350000000005e-07
+ 130.73750000000001p 6.4730689999999997e-07 130.75p 5.7151369999999999e-07 130.76249999999999p 4.95582e-07 130.77500000000001p 4.1961009999999998e-07 130.78749999999999p 3.4369560000000001e-07 130.80000000000001p 2.6793590000000001e-07 130.8125p 1.924277e-07 130.82500000000002p 1.1726710000000001e-07 130.83749999999998p 4.2549269999999999e-08 130.84999999999999p -3.1631509999999998e-08 130.86249999999998p -1.05182e-07 130.875p -1.7801010000000001e-07 130.88750000000002p -2.5002509999999998e-07 130.90000000000001p -3.211376e-07 130.91250000000002p -3.912596e-07 130.92499999999998p -4.603049e-07 130.9375p -5.2818899999999999e-07 130.94999999999999p -5.9482920000000005e-07
+ 130.96250000000001p -6.6014460000000004e-07 130.97499999999999p -7.2405659999999999e-07 130.98750000000001p -7.8648859999999995e-07 131p -8.4736609999999998e-07 131.01249999999999p -9.0661710000000002e-07 131.02500000000001p -9.6417200000000009e-07 131.03749999999999p -1.019964e-06 131.05000000000001p -1.0739279999999999e-06 131.0625p -1.1260019999999999e-06 131.07500000000002p -1.176127e-06 131.08749999999998p -1.2242479999999999e-06 131.09999999999999p -1.27031e-06 131.11249999999998p -1.3142630000000001e-06 131.125p -1.35606e-06 131.13750000000002p -1.3956560000000001e-06 131.15000000000001p -1.4330099999999999e-06 131.16250000000002p -1.468084e-06 131.17499999999998p -1.500843e-06
+ 131.1875p -1.5312550000000001e-06 131.19999999999999p -1.5592930000000001e-06 131.21250000000001p -1.58493e-06 131.22499999999999p -1.6081459999999999e-06 131.23750000000001p -1.628923e-06 131.25p -1.6472450000000001e-06 131.26249999999999p -1.6631e-06 131.27500000000001p -1.6764820000000001e-06 131.28749999999999p -1.6873839999999999e-06 131.30000000000001p -1.6958060000000001e-06 131.3125p -1.7017500000000001e-06 131.32500000000002p -1.7052209999999999e-06 131.33749999999998p -1.706228e-06 131.34999999999999p -1.7047839999999999e-06 131.36249999999998p -1.700903e-06 131.375p -1.6946039999999999e-06 131.38749999999999p -1.6859100000000001e-06 131.40000000000001p -1.674845e-06
+ 131.41250000000002p -1.6614380000000001e-06 131.42499999999998p -1.6457200000000001e-06 131.4375p -1.6277249999999999e-06 131.44999999999999p -1.607491e-06 131.46250000000001p -1.585059e-06 131.47499999999999p -1.560471e-06 131.48750000000001p -1.5337729999999999e-06 131.5p -1.505014e-06 131.51249999999999p -1.474245e-06 131.52500000000001p -1.441521e-06 131.53749999999999p -1.4068959999999999e-06 131.55000000000001p -1.3704310000000001e-06 131.5625p -1.3321849999999999e-06 131.57500000000002p -1.2922230000000001e-06 131.58750000000001p -1.2506079999999999e-06 131.59999999999999p -1.2074089999999999e-06 131.61249999999998p -1.162695e-06 131.625p -1.1165349999999999e-06
+ 131.63749999999999p -1.0690029999999999e-06 131.65000000000001p -1.0201730000000001e-06 131.66250000000002p -9.7012099999999998e-07 131.67499999999998p -9.1892269999999997e-07 131.6875p -8.6665679999999999e-07 131.69999999999999p -8.1340260000000003e-07 131.71250000000001p -7.592402e-07 131.72499999999999p -7.0425069999999997e-07 131.73750000000001p -6.4851620000000002e-07 131.75p -5.9211909999999995e-07 131.76249999999999p -5.3514249999999998e-07 131.77500000000001p -4.7766989999999997e-07 131.78749999999999p -4.1978509999999999e-07 131.80000000000001p -3.6157210000000002e-07 131.8125p -3.0311490000000001e-07 131.82500000000002p -2.4449739999999999e-07 131.83750000000001p -1.8580340000000001e-07 131.84999999999999p -1.271165e-07
+ 131.86249999999998p -6.8519810000000006e-08 131.875p -1.0095810000000001e-08 131.88749999999999p 4.807351e-08 131.90000000000001p 1.05907e-07 131.91249999999999p 1.633242e-07 131.92500000000001p 2.2024590000000001e-07 131.9375p 2.7659369999999999e-07 131.94999999999999p 3.3229060000000003e-07 131.96250000000001p 3.8726059999999999e-07 131.97499999999999p 4.414293e-07 131.98750000000001p 4.947237e-07 132p 5.4707239999999996e-07 132.01249999999999p 5.9840569999999999e-07 132.02499999999998p 6.4865560000000001e-07 132.03749999999999p 6.9775599999999996e-07 132.05000000000001p 7.4564259999999995e-07 132.0625p 7.9225330000000002e-07 132.07500000000002p 8.3752790000000001e-07
+ 132.08750000000001p 8.8140860000000001e-07 132.09999999999999p 9.2383949999999998e-07 132.11249999999998p 9.6476739999999997e-07 132.125p 1.0041409999999999e-06 132.13749999999999p 1.041912e-06 132.15000000000001p 1.078034e-06 132.16249999999999p 1.112464e-06 132.17500000000001p 1.145161e-06 132.1875p 1.1760850000000001e-06 132.19999999999999p 1.205203e-06 132.21250000000001p 1.2324789999999999e-06 132.22499999999999p 1.2578860000000001e-06 132.23750000000001p 1.281394e-06 132.25p 1.3029789999999999e-06 132.26250000000002p 1.32262e-06 132.27499999999998p 1.3402980000000001e-06 132.28749999999999p 1.3559959999999999e-06 132.30000000000001p 1.369701e-06
+ 132.3125p 1.3814030000000001e-06 132.32500000000002p 1.3910939999999999e-06 132.33750000000001p 1.3987700000000001e-06 132.34999999999999p 1.404428e-06 132.36249999999998p 1.4080699999999999e-06 132.375p 1.4097e-06 132.38749999999999p 1.409324e-06 132.40000000000001p 1.406953e-06 132.41249999999999p 1.402597e-06 132.42500000000001p 1.3962719999999999e-06 132.4375p 1.387996e-06 132.44999999999999p 1.3777890000000001e-06 132.46250000000001p 1.365674e-06 132.47499999999999p 1.3516760000000001e-06 132.48750000000001p 1.335823e-06 132.5p 1.318147e-06 132.51250000000002p 1.298679e-06 132.52499999999998p 1.2774550000000001e-06
+ 132.53749999999999p 1.254513e-06 132.55000000000001p 1.2298920000000001e-06 132.5625p 1.2036340000000001e-06 132.57500000000002p 1.175783e-06 132.58750000000001p 1.146386e-06 132.60000000000002p 1.1154900000000001e-06 132.61249999999998p 1.083144e-06 132.625p 1.0494010000000001e-06 132.63749999999999p 1.0143139999999999e-06 132.65000000000001p 9.7793750000000007e-07 132.66249999999999p 9.4032820000000004e-07 132.67500000000001p 9.0154389999999997e-07 132.6875p 8.616438e-07 132.69999999999999p 8.2068830000000005e-07 132.71250000000001p 7.7873910000000001e-07 132.72499999999999p 7.3585890000000001e-07 132.73750000000001p 6.9211139999999996e-07 132.75p 6.4756109999999998e-07
+ 132.76250000000002p 6.0227329999999996e-07 132.77499999999998p 5.5631400000000004e-07 132.78749999999999p 5.0974979999999998e-07 132.79999999999998p 4.6264789999999998e-07 132.8125p 4.1507560000000001e-07 132.82500000000002p 3.671006e-07 132.83750000000001p 3.1879099999999999e-07 132.85000000000002p 2.7021469999999999e-07 132.86249999999998p 2.214397e-07 132.875p 1.7253390000000001e-07 132.88749999999999p 1.2356500000000001e-07 132.90000000000001p 7.4600299999999996e-08 132.91249999999999p 2.5706769999999999e-08 132.92500000000001p -2.3049119999999999e-08 132.9375p -7.1601510000000004e-08 132.94999999999999p -1.198852e-07 132.96250000000001p -1.678359e-07 132.97499999999999p -2.1538990000000001e-07
+ 132.98750000000001p -2.6248489999999999e-07 133p -3.0905910000000001e-07 133.01250000000002p -3.5505219999999998e-07 133.02499999999998p -4.0040519999999998e-07 133.03749999999999p -4.450599e-07 133.04999999999998p -4.8895999999999995e-07 133.0625p -5.3205029999999998e-07 133.07500000000002p -5.7427740000000002e-07 133.08750000000001p -6.1558910000000004e-07 133.10000000000002p -6.5593520000000004e-07 133.11249999999998p -6.9526699999999997e-07 133.125p -7.3353770000000001e-07 133.13749999999999p -7.7070229999999996e-07 133.15000000000001p -8.0671769999999998e-07 133.16249999999999p -8.4154259999999996e-07 133.17500000000001p -8.7513790000000005e-07 133.1875p -9.0746639999999998e-07 133.19999999999999p -9.3849300000000001e-07
+ 133.21250000000001p -9.6818459999999994e-07 133.22499999999999p -9.9651050000000009e-07 133.23750000000001p -1.0234419999999999e-06 133.25p -1.048952e-06 133.26250000000002p -1.073017e-06 133.27500000000001p -1.0956139999999999e-06 133.28749999999999p -1.1167250000000001e-06 133.29999999999998p -1.13633e-06 133.3125p -1.1544149999999999e-06 133.32499999999999p -1.170967e-06 133.33750000000001p -1.1859749999999999e-06 133.35000000000002p -1.1994300000000001e-06 133.36249999999998p -1.2113270000000001e-06 133.375p -1.22166e-06 133.38749999999999p -1.2304290000000001e-06 133.40000000000001p -1.2376330000000001e-06 133.41249999999999p -1.243275e-06 133.42500000000001p -1.247359e-06
+ 133.4375p -1.2498929999999999e-06 133.44999999999999p -1.250885e-06 133.46250000000001p -1.2503469999999999e-06 133.47499999999999p -1.2482899999999999e-06 133.48750000000001p -1.2447309999999999e-06 133.5p -1.239685e-06 133.51250000000002p -1.2331709999999999e-06 133.52500000000001p -1.225211e-06 133.53749999999999p -1.2158249999999999e-06 133.54999999999998p -1.2050389999999999e-06 133.5625p -1.1928780000000001e-06 133.57499999999999p -1.1793680000000001e-06 133.58750000000001p -1.1645400000000001e-06 133.60000000000002p -1.1484220000000001e-06 133.61249999999998p -1.1310479999999999e-06 133.625p -1.112449e-06 133.63749999999999p -1.0926600000000001e-06 133.65000000000001p -1.0717170000000001e-06
+ 133.66249999999999p -1.049657e-06 133.67500000000001p -1.0265170000000001e-06 133.6875p -1.002335e-06 133.69999999999999p -9.7715259999999994e-07 133.71250000000001p -9.5100909999999996e-07 133.72499999999999p -9.2394620000000004e-07 133.73750000000001p -8.9600609999999998e-07 133.75p -8.672316e-07 133.76250000000002p -8.3766579999999997e-07 133.77500000000001p -8.0735290000000002e-07 133.78749999999999p -7.7633690000000001e-07 133.79999999999998p -7.4466279999999999e-07 133.8125p -7.1237530000000003e-07 133.82499999999999p -6.7951979999999995e-07 133.83750000000001p -6.4614179999999995e-07 133.84999999999999p -6.1228660000000004e-07 133.86250000000001p -5.7799980000000003e-07 133.875p -5.4332699999999995e-07
+ 133.88749999999999p -5.0831370000000001e-07 133.90000000000001p -4.7300499999999999e-07 133.91249999999999p -4.3744609999999998e-07 133.92500000000001p -4.016818e-07 133.9375p -3.6575670000000001e-07 133.94999999999999p -3.2971470000000001e-07 133.96249999999998p -2.9359970000000001e-07 133.97499999999999p -2.5745470000000002e-07 133.98750000000001p -2.2132260000000001e-07 134p -1.852452e-07 134.01250000000002p -1.4926419999999999e-07 134.02500000000001p -1.134202e-07 134.03749999999999p -7.7753320000000004e-08 134.04999999999998p -4.230288e-08 134.0625p -7.1073520000000001e-09 134.07499999999999p 2.7795600000000001e-08 134.08750000000001p 6.2369200000000005e-08 134.09999999999999p 9.6577550000000002e-08
+ 134.11250000000001p 1.3038570000000001e-07 134.125p 1.637597e-07 134.13749999999999p 1.966666e-07 134.15000000000001p 2.290744e-07 134.16249999999999p 2.6095210000000001e-07 134.17500000000001p 2.9227000000000001e-07 134.1875p 3.2299930000000002e-07 134.20000000000002p 3.531123e-07 134.21249999999998p 3.8258259999999998e-07 134.22499999999999p 4.1138470000000002e-07 134.23750000000001p 4.3949449999999999e-07 134.25p 4.668889e-07 134.26250000000002p 4.9354589999999997e-07 134.27500000000001p 5.1944500000000003e-07 134.28749999999999p 5.4456660000000001e-07 134.29999999999998p 5.6889240000000003e-07 134.3125p 5.9240529999999999e-07 134.32499999999999p 6.1508940000000003e-07
+ 134.33750000000001p 6.3693010000000002e-07 134.34999999999999p 6.5791379999999996e-07 134.36250000000001p 6.7802829999999996e-07 134.375p 6.972625e-07 134.38749999999999p 7.1560650000000005e-07 134.40000000000001p 7.3305170000000004e-07 134.41249999999999p 7.495904e-07 134.42500000000001p 7.6521639999999998e-07 134.4375p 7.7992449999999998e-07 134.45000000000002p 7.9371060000000004e-07 134.46249999999998p 8.0657189999999996e-07 134.47499999999999p 8.1850650000000005e-07 134.48749999999998p 8.2951389999999998e-07 134.5p 8.3959450000000003e-07 134.51250000000002p 8.487497e-07 134.52500000000001p 8.5698209999999998e-07 134.53750000000002p 8.6429539999999997e-07 134.54999999999998p 8.7069420000000001e-07
+ 134.5625p 8.7618399999999995e-07 134.57499999999999p 8.807716e-07 134.58750000000001p 8.8446439999999999e-07 134.59999999999999p 8.8727089999999996e-07 134.61250000000001p 8.8920059999999995e-07 134.625p 8.9026370000000001e-07 134.63749999999999p 8.9047129999999996e-07 134.65000000000001p 8.8983540000000002e-07 134.66249999999999p 8.8836880000000005e-07 134.67500000000001p 8.8608490000000004e-07 134.6875p 8.82998e-07 134.70000000000002p 8.7912310000000002e-07 134.71249999999998p 8.7447600000000003e-07 134.72499999999999p 8.6907290000000002e-07 134.73749999999998p 8.6293079999999995e-07 134.75p 8.5606719999999997e-07 134.76250000000002p 8.4850030000000004e-07 134.77500000000001p 8.4024880000000001e-07
+ 134.78750000000002p 8.3133169999999999e-07 134.79999999999998p 8.2176869999999998e-07 134.8125p 8.1157979999999998e-07 134.82499999999999p 8.0078570000000003e-07 134.83750000000001p 7.89407e-07 134.84999999999999p 7.7746499999999995e-07 134.86250000000001p 7.6498119999999997e-07 134.875p 7.5197749999999997e-07 134.88749999999999p 7.3847570000000005e-07 134.90000000000001p 7.2449829999999998e-07 134.91249999999999p 7.1006759999999998e-07 134.92500000000001p 6.9520619999999997e-07 134.9375p 6.7993689999999996e-07 134.95000000000002p 6.6428249999999998e-07 134.96249999999998p 6.4826580000000003e-07 134.97499999999999p 6.3190980000000001e-07 134.98749999999998p 6.1523739999999999e-07 135p 5.9827159999999995e-07
+ 135.01250000000002p 5.8103500000000004e-07 135.02500000000001p 5.6355060000000005e-07 135.03750000000002p 5.45841e-07 135.04999999999998p 5.2792869999999999e-07 135.0625p 5.0983600000000001e-07 135.07499999999999p 4.9158530000000002e-07 135.08750000000001p 4.731983e-07 135.09999999999999p 4.5469689999999999e-07 135.11250000000001p 4.3610250000000001e-07 135.125p 4.1743639999999998e-07 135.13749999999999p 3.9871940000000001e-07 135.15000000000001p 3.7997199999999998e-07 135.16249999999999p 3.612146e-07 135.17500000000001p 3.424669e-07 135.1875p 3.2374839999999999e-07 135.20000000000002p 3.0507820000000001e-07 135.21250000000001p 2.8647489999999998e-07 135.22499999999999p 2.6795680000000001e-07
+ 135.23749999999998p 2.4954139999999999e-07 135.25p 2.3124619999999999e-07 135.26249999999999p 2.1308800000000001e-07 135.27500000000001p 1.9508290000000001e-07 135.28750000000002p 1.7724679999999999e-07 135.29999999999998p 1.5959499999999999e-07 135.3125p 1.4214219999999999e-07 135.32499999999999p 1.249026e-07 135.33750000000001p 1.0788970000000001e-07 135.34999999999999p 9.1116710000000001e-08 135.36250000000001p 7.4596080000000001e-08 135.375p 5.8339740000000001e-08 135.38749999999999p 4.2359040000000002e-08 135.40000000000001p 2.6664740000000001e-08 135.41249999999999p 1.1266989999999999e-08 135.42500000000001p -3.8246089999999998e-09 135.4375p -1.8601100000000001e-08 135.45000000000002p -3.3054090000000002e-08
+ 135.46250000000001p -4.7175800000000001e-08 135.47499999999999p -6.0959050000000006e-08 135.48749999999998p -7.4397249999999995e-08 135.5p -8.7484409999999996e-08 135.51249999999999p -1.0021510000000001e-07 135.52500000000001p -1.125846e-07 135.53750000000002p -1.245887e-07 135.55000000000001p -1.3622359999999999e-07 135.5625p -1.4748649999999999e-07 135.57499999999999p -1.5837470000000001e-07 135.58750000000001p -1.688863e-07 135.59999999999999p -1.7902009999999999e-07 135.61250000000001p -1.8877509999999999e-07 135.625p -1.981512e-07 135.63749999999999p -2.071486e-07 135.65000000000001p -2.157681e-07 135.66249999999999p -2.2401100000000001e-07 135.67500000000001p -2.318791e-07
+ 135.6875p -2.393748e-07 135.70000000000002p -2.4650069999999999e-07 135.71250000000001p -2.5326020000000002e-07 135.72499999999999p -2.5965700000000001e-07 135.73749999999998p -2.656953e-07 135.75p -2.7137960000000002e-07 135.76249999999999p -2.7671489999999998e-07 135.77500000000001p -2.8170669999999999e-07 135.78749999999999p -2.8636080000000002e-07 135.80000000000001p -2.9068330000000001e-07 135.8125p -2.9468079999999998e-07 135.82499999999999p -2.9836020000000002e-07 135.83750000000001p -3.0172869999999999e-07 135.84999999999999p -3.0479389999999998e-07 135.86250000000001p -3.0756360000000002e-07 135.875p -3.10046e-07 135.88750000000002p -3.122494e-07 135.89999999999998p -3.1418249999999999e-07
+ 135.91249999999999p -3.158542e-07 135.92500000000001p -3.1727370000000001e-07 135.9375p -3.1845019999999998e-07 135.95000000000002p -3.1939330000000001e-07 135.96250000000001p -3.2011259999999998e-07 135.97499999999999p -3.206182e-07 135.98749999999998p -3.2091980000000001e-07 136p -3.2102769999999998e-07 136.01249999999999p -3.2095210000000002e-07 136.02500000000001p -3.207034e-07 136.03749999999999p -3.2029189999999998e-07 136.05000000000001p -3.1972810000000001e-07 136.0625p -3.1902250000000002e-07 136.07499999999999p -3.1818569999999998e-07 136.08750000000001p -3.1722820000000002e-07 136.09999999999999p -3.161606e-07 136.11250000000001p -3.1499339999999999e-07 136.125p -3.1373710000000002e-07
+ 136.13750000000002p -3.1240210000000001e-07 136.14999999999998p -3.109989e-07 136.16249999999999p -3.0953759999999998e-07 136.17500000000001p -3.080285e-07 136.1875p -3.0648160000000001e-07 136.20000000000002p -3.0490679999999998e-07 136.21250000000001p -3.0331399999999999e-07 136.22499999999999p -3.0171280000000001e-07 136.23749999999998p -3.0011250000000002e-07 136.25p -2.9852240000000003e-07 136.26249999999999p -2.9695150000000001e-07 136.27500000000001p -2.9540860000000003e-07 136.28749999999999p -2.9390219999999999e-07 136.30000000000001p -2.924406e-07 136.3125p -2.9103170000000001e-07 136.32499999999999p -2.8968339999999998e-07 136.33750000000001p -2.884029e-07 136.34999999999999p -2.8719740000000002e-07
+ 136.36250000000001p -2.860736e-07 136.375p -2.8503790000000002e-07 136.38750000000002p -2.8409629999999998e-07 136.39999999999998p -2.8325440000000002e-07 136.41249999999999p -2.825175e-07 136.42499999999998p -2.8189050000000001e-07 136.4375p -2.8137770000000002e-07 136.45000000000002p -2.8098319999999998e-07 136.46250000000001p -2.8071059999999998e-07 136.47500000000002p -2.805629e-07 136.48749999999998p -2.8054279999999999e-07 136.5p -2.8065249999999998e-07 136.51249999999999p -2.808937e-07 136.52500000000001p -2.8126760000000001e-07 136.53749999999999p -2.8177480000000001e-07 136.55000000000001p -2.8241569999999998e-07 136.5625p -2.8318989999999999e-07 136.57499999999999p -2.840967e-07
+ 136.58750000000001p -2.8513460000000002e-07 136.59999999999999p -2.8630179999999998e-07 136.61250000000001p -2.87596e-07 136.625p -2.8901420000000001e-07 136.63750000000002p -2.9055309999999999e-07 136.64999999999998p -2.922086e-07 136.66249999999999p -2.9397620000000002e-07 136.67499999999998p -2.9585100000000002e-07 136.6875p -2.978275e-07 136.70000000000002p -2.9989950000000002e-07 136.71250000000001p -3.0206050000000001e-07 136.72500000000002p -3.0430349999999998e-07 136.73749999999998p -3.0662090000000001e-07 136.75p -3.0900469999999998e-07 136.76249999999999p -3.1144640000000002e-07 136.77500000000001p -3.139369e-07 136.78749999999999p -3.16467e-07 136.80000000000001p -3.1902660000000002e-07
+ 136.8125p -3.2160560000000001e-07 136.82499999999999p -3.2419320000000001e-07 136.83750000000001p -3.2677829999999999e-07 136.84999999999999p -3.293496e-07 136.86250000000001p -3.3189520000000001e-07 136.875p -3.3440300000000001e-07 136.88750000000002p -3.3686060000000002e-07 136.89999999999998p -3.3925519999999999e-07 136.91249999999999p -3.4157390000000002e-07 136.92499999999998p -3.4380349999999999e-07 136.9375p -3.4593049999999999e-07 136.94999999999999p -3.4794139999999997e-07 136.96250000000001p -3.4982230000000002e-07 136.97500000000002p -3.515594e-07 136.98749999999998p -3.531386e-07 137p -3.54546e-07 137.01249999999999p -3.5576730000000001e-07 137.02500000000001p -3.5678850000000002e-07
+ 137.03749999999999p -3.5759550000000001e-07 137.05000000000001p -3.5817409999999998e-07 137.0625p -3.5851050000000001e-07 137.07499999999999p -3.5859069999999998e-07 137.08750000000001p -3.584011e-07 137.09999999999999p -3.5792799999999997e-07 137.11250000000001p -3.5715819999999999e-07 137.125p -3.5607850000000001e-07 137.13750000000002p -3.5467609999999998e-07 137.15000000000001p -3.529384e-07 137.16249999999999p -3.508533e-07 137.17499999999998p -3.4840900000000001e-07 137.1875p -3.4559390000000003e-07 137.19999999999999p -3.4239700000000002e-07 137.21250000000001p -3.3880790000000001e-07 137.22500000000002p -3.348163e-07 137.23749999999998p -3.304128e-07 137.25p -3.2558819999999997e-07
+ 137.26249999999999p -3.2033410000000001e-07 137.27500000000001p -3.1464260000000003e-07 137.28749999999999p -3.0850640000000002e-07 137.30000000000001p -3.0191890000000003e-07 137.3125p -2.94874e-07 137.32499999999999p -2.8736650000000002e-07 137.33750000000001p -2.7939179999999998e-07 137.34999999999999p -2.7094589999999998e-07 137.36250000000001p -2.6202569999999999e-07 137.375p -2.5262879999999999e-07 137.38750000000002p -2.4275360000000001e-07 137.40000000000001p -2.3239910000000001e-07 137.41249999999999p -2.215655e-07 137.42499999999998p -2.102533e-07 137.4375p -1.984643e-07 137.44999999999999p -1.8620070000000001e-07 137.46250000000001p -1.734657e-07 137.47500000000002p -1.602635e-07
+ 137.48750000000001p -1.46599e-07 137.5p -1.3247779999999999e-07 137.51249999999999p -1.179065e-07 137.52500000000001p -1.028926e-07 137.53749999999999p -8.7444319999999995e-08 137.55000000000001p -7.1570769999999999e-08 137.5625p -5.5281870000000003e-08 137.57499999999999p -3.858837e-08 137.58749999999998p -2.1501850000000001e-08 137.59999999999999p -4.0346630000000003e-09 137.61250000000001p 1.3799999999999999e-08 137.625p 3.1988199999999999e-08 137.63750000000002p 5.0515199999999997e-08 137.65000000000001p 6.9365530000000003e-08 137.66249999999999p 8.8522970000000002e-08 137.67499999999998p 1.079706e-07 137.6875p 1.2769079999999999e-07 137.69999999999999p 1.476652e-07
+ 137.71250000000001p 1.678748e-07 137.72499999999999p 1.883002e-07 137.73750000000001p 2.089209e-07 137.75p 2.2971629999999999e-07 137.76249999999999p 2.5066489999999998e-07 137.77500000000001p 2.71745e-07 137.78749999999999p 2.9293389999999998e-07 137.80000000000001p 3.1420899999999998e-07 137.8125p 3.3554689999999999e-07 137.82500000000002p 3.5692380000000002e-07 137.83749999999998p 3.7831559999999999e-07 137.84999999999999p 3.9969790000000002e-07 137.86250000000001p 4.2104579999999999e-07 137.875p 4.4233439999999999e-07 137.88750000000002p 4.6353820000000002e-07 137.90000000000001p 4.8463189999999998e-07 137.91249999999999p 5.0558960000000005e-07 137.92499999999998p 5.2638560000000002e-07
+ 137.9375p 5.4699379999999997e-07 137.94999999999999p 5.6738840000000002e-07 137.96250000000001p 5.8754319999999999e-07 137.97499999999999p 6.0743209999999997e-07 137.98750000000001p 6.2702929999999997e-07 138p 6.4630880000000001e-07 138.01249999999999p 6.6524470000000005e-07 138.02500000000001p 6.8381159999999996e-07 138.03749999999999p 7.0198380000000001e-07 138.05000000000001p 7.1973630000000004e-07 138.0625p 7.3704400000000005e-07 138.07500000000002p 7.5388229999999995e-07 138.08749999999998p 7.7022699999999995e-07 138.09999999999999p 7.8605410000000002e-07 138.11250000000001p 8.0134010000000005e-07 138.125p 8.1606189999999997e-07 138.13750000000002p 8.3019709999999997e-07 138.15000000000001p 8.4372349999999998e-07
+ 138.16250000000002p 8.5661960000000003e-07 138.17499999999998p 8.6886450000000003e-07 138.1875p 8.8043799999999996e-07 138.19999999999999p 8.9132029999999999e-07 138.21250000000001p 9.0149260000000002e-07 138.22499999999999p 9.1093649999999999e-07 138.23750000000001p 9.1963459999999999e-07 138.25p 9.2757000000000004e-07 138.26249999999999p 9.3472689999999998e-07 138.27500000000001p 9.4109000000000002e-07 138.28749999999999p 9.4664509999999998e-07 138.30000000000001p 9.5137879999999997e-07 138.3125p 9.5527860000000007e-07 138.32500000000002p 9.5833270000000003e-07 138.33749999999998p 9.605303999999999e-07 138.34999999999999p 9.6186219999999995e-07 138.36249999999998p 9.6231909999999992e-07 138.375p 9.618933000000001e-07
+ 138.38750000000002p 9.6057820000000008e-07 138.40000000000001p 9.5836780000000009e-07 138.41250000000002p 9.5525740000000004e-07 138.42499999999998p 9.5124339999999999e-07 138.4375p 9.463229e-07 138.44999999999999p 9.4049440000000005e-07 138.46250000000001p 9.3375729999999996e-07 138.47499999999999p 9.2611209999999997e-07 138.48750000000001p 9.1756040000000004e-07 138.5p 9.0810470000000004e-07 138.51249999999999p 8.9774879999999999e-07 138.52500000000001p 8.864974e-07 138.53749999999999p 8.7435639999999997e-07 138.55000000000001p 8.6133260000000001e-07 138.5625p 8.4743400000000002e-07 138.57500000000002p 8.3266969999999997e-07 138.58749999999998p 8.1704949999999996e-07 138.59999999999999p 8.0058460000000005e-07
+ 138.61249999999998p 7.8328709999999998e-07 138.625p 7.6517009999999995e-07 138.63750000000002p 7.4624769999999997e-07 138.65000000000001p 7.2653490000000002e-07 138.66250000000002p 7.0604779999999996e-07 138.67499999999998p 6.8480340000000004e-07 138.6875p 6.6281950000000004e-07 138.69999999999999p 6.4011500000000001e-07 138.71250000000001p 6.1670950000000001e-07 138.72499999999999p 5.926236e-07 138.73750000000001p 5.6787879999999996e-07 138.75p 5.4249709999999996e-07 138.76249999999999p 5.1650149999999999e-07 138.77500000000001p 4.8991590000000004e-07 138.78749999999999p 4.6276460000000001e-07 138.80000000000001p 4.3507279999999998e-07 138.8125p 4.0686640000000001e-07 138.82500000000002p 3.7817169999999998e-07
+ 138.83749999999998p 3.4901589999999999e-07 138.84999999999999p 3.194265e-07 138.86249999999998p 2.8943179999999998e-07 138.875p 2.5906040000000001e-07 138.88749999999999p 2.2834150000000001e-07 138.90000000000001p 1.9730449999999999e-07 138.91250000000002p 1.6597949999999999e-07 138.92499999999998p 1.343968e-07 138.9375p 1.02587e-07 138.94999999999999p 7.0580920000000003e-08 138.96250000000001p 3.840984e-08 138.97499999999999p 6.105078e-09 138.98750000000001p -2.6301860000000001e-08 139p -5.8779309999999999e-08 139.01249999999999p -9.1295549999999995e-08 139.02500000000001p -1.2381879999999999e-07 139.03749999999999p -1.5631719999999999e-07 139.05000000000001p -1.887591e-07
+ 139.0625p -2.211127e-07 139.07500000000002p -2.5334649999999998e-07 139.08750000000001p -2.8542900000000001e-07 139.09999999999999p -3.1732889999999998e-07 139.11249999999998p -3.4901519999999999e-07 139.125p -3.8045710000000002e-07 139.13749999999999p -4.1162410000000003e-07 139.15000000000001p -4.4248599999999998e-07 139.16250000000002p -4.73013e-07 139.17499999999998p -5.0317569999999995e-07 139.1875p -5.3294510000000003e-07 139.19999999999999p -5.6229269999999999e-07 139.21250000000001p -5.911905e-07 139.22499999999999p -6.1961090000000001e-07 139.23750000000001p -6.4752700000000005e-07 139.25p -6.7491250000000002e-07 139.26249999999999p -7.0174169999999996e-07 139.27500000000001p -7.279893e-07
+ 139.28749999999999p -7.5363110000000003e-07 139.30000000000001p -7.7864310000000001e-07 139.3125p -8.0300250000000005e-07 139.32500000000002p -8.2668680000000004e-07 139.33750000000001p -8.4967470000000001e-07 139.34999999999999p -8.7194520000000003e-07 139.36249999999998p -8.9347850000000004e-07 139.375p -9.1425539999999997e-07 139.38749999999999p -9.3425749999999999e-07 139.40000000000001p -9.5346750000000001e-07 139.41249999999999p -9.7186869999999992e-07 139.42500000000001p -9.8944530000000001e-07 139.4375p -1.0061819999999999e-06 139.44999999999999p -1.022066e-06 139.46250000000001p -1.037084e-06 139.47499999999999p -1.051222e-06 139.48750000000001p -1.064471e-06 139.5p -1.0768199999999999e-06
+ 139.51249999999999p -1.088259e-06 139.52499999999998p -1.098779e-06 139.53749999999999p -1.108374e-06 139.55000000000001p -1.117037e-06 139.5625p -1.124761e-06 139.57500000000002p -1.131543e-06 139.58750000000001p -1.1373779999999999e-06 139.59999999999999p -1.1422630000000001e-06 139.61249999999998p -1.146196e-06 139.625p -1.1491750000000001e-06 139.63749999999999p -1.1512019999999999e-06 139.65000000000001p -1.1522749999999999e-06 139.66249999999999p -1.1523970000000001e-06 139.67500000000001p -1.1515699999999999e-06 139.6875p -1.1497969999999999e-06 139.69999999999999p -1.1470819999999999e-06 139.71250000000001p -1.1434299999999999e-06 139.72499999999999p -1.138846e-06
+ 139.73750000000001p -1.133337e-06 139.75p -1.12691e-06 139.76250000000002p -1.1195729999999999e-06 139.77499999999998p -1.111335e-06 139.78749999999999p -1.1022039999999999e-06 139.80000000000001p -1.0921920000000001e-06 139.8125p -1.08131e-06 139.82500000000002p -1.0695680000000001e-06 139.83750000000001p -1.056978e-06 139.84999999999999p -1.0435550000000001e-06 139.86249999999998p -1.0293109999999999e-06 139.875p -1.0142599999999999e-06 139.88749999999999p -9.9841770000000009e-07 139.90000000000001p -9.8179839999999998e-07 139.91249999999999p -9.6441819999999998e-07 139.92500000000001p -9.4629360000000002e-07 139.9375p -9.2744140000000005e-07 139.94999999999999p -9.0787899999999997e-07
+ 139.96250000000001p -8.8762430000000004e-07 139.97499999999999p -8.6669549999999998e-07 139.98750000000001p -8.4511149999999996e-07 140p -8.2289129999999998e-07 140.01250000000002p -8.0005469999999997e-07 140.02499999999998p -7.7662149999999996e-07 140.03749999999999p -7.526122e-07 140.05000000000001p -7.2804730000000001e-07 140.0625p -7.0294800000000003e-07 140.07500000000002p -6.7733549999999998e-07 140.08750000000001p -6.5123139999999999e-07 140.10000000000002p -6.246577e-07 140.11249999999998p -5.9763649999999995e-07 140.125p -5.7019019999999998e-07 140.13749999999999p -5.4234129999999998e-07 140.15000000000001p -5.1411269999999999e-07 140.16249999999999p -4.8552729999999998e-07 140.17500000000001p -4.5660829999999998e-07
+ 140.1875p -4.2737910000000002e-07 140.19999999999999p -3.9786300000000002e-07 140.21250000000001p -3.6808349999999999e-07 140.22499999999999p -3.3806440000000002e-07 140.23750000000001p -3.0782930000000003e-07 140.25p -2.7740209999999998e-07 140.26250000000002p -2.4680649999999998e-07 140.27499999999998p -2.1606639999999999e-07 140.28749999999999p -1.8520569999999999e-07 140.29999999999998p -1.542483e-07 140.3125p -1.232181e-07 140.32500000000002p -9.2138749999999995e-08 140.33750000000001p -6.1034139999999994e-08 140.35000000000002p -2.9927940000000002e-08 140.36249999999998p 1.15622e-09 140.375p 3.2194829999999997e-08 140.38749999999999p 6.3164470000000007e-08 140.40000000000001p 9.4041880000000004e-08
+ 140.41249999999999p 1.2480389999999999e-07 140.42500000000001p 1.5542760000000001e-07 140.4375p 1.858901e-07 140.44999999999999p 2.1616889999999999e-07 140.46250000000001p 2.462415e-07 140.47499999999999p 2.7608579999999999e-07 140.48750000000001p 3.0567979999999998e-07 140.5p 3.3500169999999999e-07 140.51250000000002p 3.640302e-07 140.52499999999998p 3.927441e-07 140.53749999999999p 4.2112260000000001e-07 140.54999999999998p 4.491449e-07 140.5625p 4.76791e-07 140.57500000000002p 5.0404080000000005e-07 140.58750000000001p 5.3087480000000004e-07 140.60000000000002p 5.5727370000000004e-07 140.61249999999998p 5.8321879999999999e-07 140.625p 6.0869149999999997e-07
+ 140.63749999999999p 6.3367369999999996e-07 140.65000000000001p 6.5814790000000001e-07 140.66249999999999p 6.8209669999999999e-07 140.67500000000001p 7.0550329999999996e-07 140.6875p 7.2835139999999998e-07 140.69999999999999p 7.5062500000000001e-07 140.71250000000001p 7.7230859999999996e-07 140.72499999999999p 7.9338740000000003e-07 140.73750000000001p 8.138466e-07 140.75p 8.3367250000000004e-07 140.76250000000002p 8.5285140000000001e-07 140.77500000000001p 8.7137029999999998e-07 140.78749999999999p 8.8921670000000001e-07 140.79999999999998p 9.0637879999999998e-07 140.8125p 9.2284509999999999e-07 140.82499999999999p 9.3860480000000005e-07 140.83750000000001p 9.5364739999999996e-07 140.85000000000002p 9.679634000000001e-07
+ 140.86249999999998p 9.8154339999999993e-07 140.875p 9.9437879999999992e-07 140.88749999999999p 1.006462e-06 140.90000000000001p 1.017785e-06 140.91249999999999p 1.028341e-06 140.92500000000001p 1.0381230000000001e-06 140.9375p 1.047127e-06 140.94999999999999p 1.0553469999999999e-06 140.96250000000001p 1.0627790000000001e-06 140.97499999999999p 1.0694179999999999e-06 140.98750000000001p 1.0752610000000001e-06 141p 1.080307e-06 141.01250000000002p 1.0845519999999999e-06 141.02500000000001p 1.0879950000000001e-06 141.03749999999999p 1.0906359999999999e-06 141.04999999999998p 1.092474e-06 141.0625p 1.0935100000000001e-06 141.07499999999999p 1.093745e-06
+ 141.08750000000001p 1.093179e-06 141.10000000000002p 1.0918169999999999e-06 141.11250000000001p 1.0896590000000001e-06 141.125p 1.08671e-06 141.13749999999999p 1.082975e-06 141.15000000000001p 1.078456e-06 141.16249999999999p 1.0731599999999999e-06 141.17500000000001p 1.0670929999999999e-06 141.1875p 1.060261e-06 141.19999999999999p 1.0526699999999999e-06 141.21250000000001p 1.0443290000000001e-06 141.22499999999999p 1.035245e-06 141.23750000000001p 1.0254270000000001e-06 141.25p 1.014884e-06 141.26250000000002p 1.0036260000000001e-06 141.27500000000001p 9.9166330000000003e-07 141.28749999999999p 9.7900660000000008e-07 141.29999999999998p 9.6566710000000001e-07
+ 141.3125p 9.5165660000000004e-07 141.32499999999999p 9.3698740000000002e-07 141.33750000000001p 9.216723e-07 141.34999999999999p 9.0572450000000001e-07 141.36250000000001p 8.8915760000000003e-07 141.375p 8.7198580000000003e-07 141.38749999999999p 8.5422370000000001e-07 141.40000000000001p 8.3588620000000004e-07 141.41249999999999p 8.169888e-07 141.42500000000001p 7.9754709999999995e-07 141.4375p 7.7757749999999999e-07 141.44999999999999p 7.5709639999999999e-07 141.46249999999998p 7.3612069999999995e-07 141.47499999999999p 7.1466769999999995e-07 141.48750000000001p 6.927548e-07 141.5p 6.7040010000000001e-07 141.51250000000002p 6.4762150000000001e-07 141.52500000000001p 6.2443749999999998e-07
+ 141.53749999999999p 6.0086690000000004e-07 141.54999999999998p 5.7692849999999998e-07 141.5625p 5.5264149999999999e-07 141.57499999999999p 5.2802530000000005e-07 141.58750000000001p 5.0309949999999998e-07 141.59999999999999p 4.7788369999999996e-07 141.61250000000001p 4.5239790000000001e-07 141.625p 4.2666209999999998e-07 141.63749999999999p 4.0069649999999999e-07 141.65000000000001p 3.7452139999999999e-07 141.66249999999999p 3.4815709999999998e-07 141.67500000000001p 3.2162409999999999e-07 141.6875p 2.949429e-07 141.70000000000002p 2.6813390000000002e-07 141.71249999999998p 2.412178e-07 141.72499999999999p 2.1421510000000001e-07 141.73750000000001p 1.871463e-07 141.75p 1.6003189999999999e-07
+ 141.76250000000002p 1.3289239999999999e-07 141.77500000000001p 1.0574809999999999e-07 141.78749999999999p 7.861934e-08 141.79999999999998p 5.1526270000000001e-08 141.8125p 2.4488939999999999e-08 141.82499999999999p -2.472721e-09 141.83750000000001p -2.9338949999999999e-08 141.84999999999999p -5.6090179999999999e-08 141.86250000000001p -8.2707000000000001e-08 141.875p -1.091702e-07 141.88749999999999p -1.3546090000000001e-07 141.90000000000001p -1.615603e-07 141.91249999999999p -1.8745e-07 141.92500000000001p -2.1311170000000001e-07 141.9375p -2.3852759999999998e-07 141.95000000000002p -2.6368009999999998e-07 141.96249999999998p -2.8855179999999999e-07 141.97499999999999p -3.1312580000000001e-07
+ 141.98749999999998p -3.3738550000000001e-07 142p -3.6131460000000001e-07 142.01250000000002p -3.8489720000000002e-07 142.02500000000001p -4.0811779999999999e-07 142.03750000000002p -4.3096139999999999e-07 142.04999999999998p -4.534131e-07 142.0625p -4.7545879999999999e-07 142.07499999999999p -4.9708449999999997e-07 142.08750000000001p -5.1827670000000005e-07 142.09999999999999p -5.3902259999999997e-07 142.11250000000001p -5.5930959999999998e-07 142.125p -5.791256e-07 142.13749999999999p -5.9845910000000004e-07 142.15000000000001p -6.1729879999999999e-07 142.16249999999999p -6.3563419999999997e-07 142.17500000000001p -6.5345519999999998e-07 142.1875p -6.7075209999999999e-07 142.20000000000002p -6.8751569999999997e-07
+ 142.21249999999998p -7.0373750000000001e-07 142.22499999999999p -7.1940919999999996e-07 142.23749999999998p -7.3452330000000005e-07 142.25p -7.4907259999999998e-07 142.26250000000002p -7.6305049999999995e-07 142.27500000000001p -7.7645100000000002e-07 142.28750000000002p -7.8926849999999998e-07 142.29999999999998p -8.0149789999999998e-07 142.3125p -8.1313460000000004e-07 142.32499999999999p -8.241747e-07 142.33750000000001p -8.346145e-07 142.34999999999999p -8.4445109999999999e-07 142.36250000000001p -8.5368189999999996e-07 142.375p -8.6230489999999997e-07 142.38749999999999p -8.7031850000000004e-07 142.40000000000001p -8.7772159999999998e-07 142.41249999999999p -8.8451359999999995e-07 142.42500000000001p -8.9069449999999996e-07
+ 142.4375p -8.9626449999999997e-07 142.45000000000002p -9.0122449999999998e-07 142.46249999999998p -9.0557559999999996e-07 142.47499999999999p -9.0931959999999997e-07 142.48749999999998p -9.1245840000000003e-07 142.5p -9.1499469999999997e-07 142.51250000000002p -9.1693140000000004e-07 142.52500000000001p -9.1827159999999996e-07 142.53750000000002p -9.1901930000000003e-07 142.54999999999998p -9.1917829999999998e-07 142.5625p -9.1875310000000001e-07 142.57499999999999p -9.1774849999999998e-07 142.58750000000001p -9.161697e-07 142.59999999999999p -9.1402189999999999e-07 142.61250000000001p -9.1131099999999995e-07 142.625p -9.0804299999999995e-07 142.63749999999999p -9.0422419999999997e-07 142.65000000000001p -8.9986120000000002e-07
+ 142.66249999999999p -8.9496080000000001e-07 142.67500000000001p -8.8953030000000003e-07 142.6875p -8.8357680000000001e-07 142.70000000000002p -8.771079e-07 142.71250000000001p -8.7013149999999996e-07 142.72499999999999p -8.6265549999999995e-07 142.73749999999998p -8.5468789999999999e-07 142.75p -8.4623709999999995e-07 142.76249999999999p -8.373117e-07 142.77500000000001p -8.2792010000000001e-07 142.78750000000002p -8.1807110000000004e-07 142.79999999999998p -8.0777370000000001e-07 142.8125p -7.9703680000000003e-07 142.82499999999999p -7.8586949999999997e-07 142.83750000000001p -7.742809e-07 142.84999999999999p -7.6228040000000004e-07 142.86250000000001p -7.4987730000000004e-07 142.875p -7.3708089999999996e-07
+ 142.88749999999999p -7.2390080000000001e-07 142.90000000000001p -7.1034639999999997e-07 142.91249999999999p -6.964272e-07 142.92500000000001p -6.8215290000000004e-07 142.9375p -6.6753309999999996e-07 142.95000000000002p -6.5257730000000004e-07 142.96250000000001p -6.3729530000000002e-07 142.97499999999999p -6.2169650000000002e-07 142.98749999999998p -6.0579079999999996e-07 143p -5.8958759999999995e-07 143.01249999999999p -5.730968e-07 143.02500000000001p -5.5632780000000002e-07 143.03750000000002p -5.3929019999999999e-07 143.05000000000001p -5.219938e-07 143.0625p -5.0444809999999998e-07 143.07499999999999p -4.8666249999999995e-07 143.08750000000001p -4.6864679999999999e-07 143.09999999999999p -4.504103e-07
+ 143.11250000000001p -4.3196270000000001e-07 143.125p -4.1331329999999999e-07 143.13749999999999p -3.9447159999999999e-07 143.15000000000001p -3.754472e-07 143.16249999999999p -3.5624929999999998e-07 143.17500000000001p -3.3688729999999999e-07 143.1875p -3.1737079999999998e-07 143.20000000000002p -2.9770890000000002e-07 143.21250000000001p -2.7791119999999999e-07 143.22499999999999p -2.5798679999999998e-07 143.23749999999998p -2.3794519999999999e-07 143.25p -2.1779560000000001e-07 143.26249999999999p -1.9754740000000001e-07 143.27500000000001p -1.7720989999999999e-07 143.28749999999999p -1.5679239999999999e-07 143.30000000000001p -1.3630420000000001e-07 143.3125p -1.157547e-07 143.32499999999999p -9.5153069999999994e-08
+ 143.33750000000001p -7.4508780000000005e-08 143.34999999999999p -5.3831159999999999e-08 143.36250000000001p -3.3129590000000001e-08 143.375p -1.2413459999999999e-08 143.38750000000002p 8.3078230000000005e-09 143.39999999999998p 2.9024799999999999e-08 143.41249999999999p 4.972802e-08 143.42500000000001p 7.0407970000000001e-08 143.4375p 9.1055120000000002e-08 143.45000000000002p 1.116599e-07 143.46250000000001p 1.3221280000000001e-07 143.47499999999999p 1.5270399999999999e-07 143.48749999999998p 1.7312400000000001e-07 143.5p 1.9346299999999999e-07 143.51249999999999p 2.137113e-07 143.52500000000001p 2.3385919999999999e-07 143.53749999999999p 2.5389670000000001e-07 143.55000000000001p 2.7381399999999999e-07
+ 143.5625p 2.9360119999999999e-07 143.57499999999999p 3.1324849999999999e-07 143.58750000000001p 3.3274569999999998e-07 143.59999999999999p 3.5208299999999999e-07 143.61250000000001p 3.7125030000000002e-07 143.625p 3.9023750000000002e-07 143.63750000000002p 4.0903450000000002e-07 143.64999999999998p 4.2763119999999998e-07 143.66249999999999p 4.460175e-07 143.67500000000001p 4.6418319999999998e-07 143.6875p 4.8211819999999996e-07 143.70000000000002p 4.9981230000000001e-07 143.71250000000001p 5.1725529999999996e-07 143.72500000000002p 5.3443710000000003e-07 143.73749999999998p 5.5134749999999995e-07 143.75p 5.6797619999999996e-07 143.76249999999999p 5.8431330000000003e-07 143.77500000000001p 6.003486e-07
+ 143.78749999999999p 6.1607210000000003e-07 143.80000000000001p 6.3147359999999996e-07 143.8125p 6.4654319999999998e-07 143.82499999999999p 6.6127099999999997e-07 143.83750000000001p 6.7564710000000001e-07 143.84999999999999p 6.8966170000000002e-07 143.86250000000001p 7.0330500000000004e-07 143.875p 7.165675e-07 143.88750000000002p 7.2943969999999997e-07 143.89999999999998p 7.4191190000000001e-07 143.91249999999999p 7.5397509999999999e-07 143.92499999999998p 7.656199e-07 143.9375p 7.7683730000000001e-07 143.95000000000002p 7.8761840000000003e-07 143.96250000000001p 7.9795439999999999e-07 143.97500000000002p 8.0783669999999995e-07 143.98749999999998p 8.1725699999999997e-07 144p 8.2620689999999996e-07
+ 144.01249999999999p 8.3467840000000003e-07 144.02500000000001p 8.4266370000000003e-07 144.03749999999999p 8.5015520000000004e-07 144.05000000000001p 8.5714539999999996e-07 144.0625p 8.6362719999999997e-07 144.07499999999999p 8.6959370000000002e-07 144.08750000000001p 8.7503819999999996e-07 144.09999999999999p 8.7995429999999997e-07 144.11250000000001p 8.8433590000000005e-07 144.125p 8.8817720000000001e-07 144.13750000000002p 8.9147270000000003e-07 144.14999999999998p 8.9421710000000004e-07 144.16249999999999p 8.9640550000000005e-07 144.17499999999998p 8.9803339999999995e-07 144.1875p 8.9909650000000001e-07 144.20000000000002p 8.99591e-07 144.21250000000001p 8.9951319999999995e-07 144.22500000000002p 8.9886009999999998e-07
+ 144.23749999999998p 8.9762879999999996e-07 144.25p 8.9581680000000002e-07 144.26249999999999p 8.9342229999999999e-07 144.27500000000001p 8.9044350000000002e-07 144.28749999999999p 8.8687919999999997e-07 144.30000000000001p 8.8272860000000002e-07 144.3125p 8.7799129999999999e-07 144.32499999999999p 8.7266729999999999e-07 144.33750000000001p 8.6675699999999998e-07 144.34999999999999p 8.602614e-07 144.36250000000001p 8.5318170000000005e-07 144.375p 8.4551980000000003e-07 144.38750000000002p 8.3727779999999995e-07 144.39999999999998p 8.2845839999999996e-07 144.41249999999999p 8.1906469999999998e-07 144.42499999999998p 8.0910039999999998e-07 144.4375p 7.9856940000000003e-07 144.44999999999999p 7.8747629999999998e-07
+ 144.46250000000001p 7.7582600000000003e-07 144.47500000000002p 7.6362389999999996e-07 144.48749999999998p 7.5087599999999995e-07 144.5p 7.3758859999999998e-07 144.51249999999999p 7.2376850000000004e-07 144.52500000000001p 7.0942300000000004e-07 144.53749999999999p 6.9455979999999996e-07 144.55000000000001p 6.7918720000000004e-07 144.5625p 6.633137e-07 144.57499999999999p 6.4694849999999996e-07 144.58750000000001p 6.3010109999999998e-07 144.59999999999999p 6.1278160000000005e-07 144.61250000000001p 5.9500030000000005e-07 144.625p 5.7676799999999999e-07 144.63750000000002p 5.5809619999999998e-07 144.65000000000001p 5.3899640000000001e-07 144.66249999999999p 5.1948070000000004e-07 144.67499999999998p 4.9956170000000003e-07
+ 144.6875p 4.7925220000000005e-07 144.69999999999999p 4.5856559999999998e-07 144.71250000000001p 4.375155e-07 144.72500000000002p 4.161159e-07 144.73749999999998p 3.9438109999999998e-07 144.75p 3.7232599999999999e-07 144.76249999999999p 3.4996549999999998e-07 144.77500000000001p 3.2731500000000002e-07 144.78749999999999p 3.0439009999999998e-07 144.80000000000001p 2.8120699999999998e-07 144.8125p 2.577816e-07 144.82499999999999p 2.3413069999999999e-07 144.83750000000001p 2.1027099999999999e-07 144.84999999999999p 1.862194e-07 144.86250000000001p 1.619932e-07 144.875p 1.3760990000000001e-07 144.88750000000002p 1.13087e-07 144.90000000000001p 8.8442350000000004e-08
+ 144.91249999999999p 6.3693960000000002e-08 144.92499999999998p 3.8859910000000003e-08 144.9375p 1.3958459999999999e-08 144.94999999999999p -1.0992049999999999e-08 144.96250000000001p -3.5973170000000002e-08 144.97500000000002p -6.0966379999999994e-08 144.98750000000001p -8.5953080000000001e-08 145p -1.1091469999999999e-07 145.01249999999999p -1.3583239999999999e-07 145.02500000000001p -1.6068780000000001e-07 145.03749999999999p -1.85462e-07 145.05000000000001p -2.1013650000000001e-07 145.0625p -2.3469269999999999e-07 145.07499999999999p -2.59112e-07 145.08749999999998p -2.8337609999999997e-07 145.09999999999999p -3.074665e-07 145.11250000000001p -3.313651e-07 145.125p -3.5505380000000001e-07
+ 145.13750000000002p -3.7851449999999998e-07 145.15000000000001p -4.0172950000000002e-07 145.16249999999999p -4.2468130000000002e-07 145.17499999999998p -4.4735240000000002e-07 145.1875p -4.6972549999999999e-07 145.19999999999999p -4.9178390000000004e-07 145.21250000000001p -5.1351059999999995e-07 145.22499999999999p -5.348893e-07 145.23750000000001p -5.5590390000000001e-07 145.25p -5.7653830000000003e-07 145.26249999999999p -5.9677709999999999e-07 145.27500000000001p -6.1660499999999998e-07 145.28749999999999p -6.3600700000000001e-07 145.30000000000001p -6.5496849999999995e-07 145.3125p -6.7347540000000001e-07 145.32500000000002p -6.915137e-07 145.33749999999998p -7.0907000000000004e-07 145.34999999999999p -7.2613109999999997e-07
+ 145.36250000000001p -7.426845e-07 145.375p -7.5871780000000002e-07 145.38750000000002p -7.7421909999999997e-07 145.40000000000001p -7.8917710000000004e-07 145.41249999999999p -8.035807e-07 145.42499999999998p -8.1741950000000001e-07 145.4375p -8.3068339999999997e-07 145.44999999999999p -8.4336260000000001e-07 145.46250000000001p -8.5544809999999999e-07 145.47499999999999p -8.6693120000000001e-07 145.48750000000001p -8.7780369999999996e-07 145.5p -8.8805789999999998e-07 145.51249999999999p -8.9768650000000005e-07 145.52500000000001p -9.0668280000000001e-07 145.53749999999999p -9.1504049999999998e-07 145.55000000000001p -9.2275399999999998e-07 145.5625p -9.2981779999999996e-07 145.57500000000002p -9.362274e-07
+ 145.58749999999998p -9.4197840000000004e-07 145.59999999999999p -9.4706709999999999e-07 145.61250000000001p -9.5149029999999998e-07 145.625p -9.552451000000001e-07 145.63750000000002p -9.5832929999999998e-07 145.65000000000001p -9.6074130000000007e-07 145.66250000000002p -9.624796e-07 145.67499999999998p -9.6354359999999994e-07 145.6875p -9.6393300000000006e-07 145.69999999999999p -9.6364800000000003e-07 145.71250000000001p -9.6268939999999999e-07 145.72499999999999p -9.6105819999999999e-07 145.73750000000001p -9.5875619999999997e-07 145.75p -9.5578549999999994e-07 145.76249999999999p -9.5214859999999996e-07 145.77500000000001p -9.4784880000000005e-07 145.78749999999999p -9.4288950000000003e-07 145.80000000000001p -9.3727459999999999e-07
+ 145.8125p -9.3100869999999997e-07 145.82500000000002p -9.2409649999999998e-07 145.83749999999998p -9.1654349999999996e-07 145.84999999999999p -9.0835530000000001e-07 145.86249999999998p -8.9953800000000002e-07 145.875p -8.9009839999999998e-07 145.88750000000002p -8.8004329999999999e-07 145.90000000000001p -8.6938010000000001e-07 145.91250000000002p -8.581167e-07 145.92499999999998p -8.4626109999999998e-07 145.9375p -8.3382200000000004e-07 145.94999999999999p -8.2080829999999998e-07 145.96250000000001p -8.0722929999999996e-07 145.97499999999999p -7.9309459999999997e-07 145.98750000000001p -7.7841419999999998e-07 146p -7.6319859999999996e-07 146.01249999999999p -7.4745820000000003e-07 146.02500000000001p -7.3120430000000002e-07
+ 146.03749999999999p -7.1444809999999999e-07 146.05000000000001p -6.9720119999999998e-07 146.0625p -6.7947560000000002e-07 146.07500000000002p -6.6128360000000004e-07 146.08749999999998p -6.4263769999999996e-07 146.09999999999999p -6.235506e-07 146.11249999999998p -6.0403560000000003e-07 146.125p -5.8410580000000002e-07 146.13750000000002p -5.6377499999999995e-07 146.15000000000001p -5.4305700000000002e-07 146.16250000000002p -5.2196590000000001e-07 146.17499999999998p -5.0051600000000003e-07 146.1875p -4.787219e-07 146.19999999999999p -4.5659830000000003e-07 146.21250000000001p -4.3416010000000001e-07 146.22499999999999p -4.1142270000000001e-07 146.23750000000001p -3.8840120000000002e-07 146.25p -3.6511130000000002e-07
+ 146.26249999999999p -3.4156860000000001e-07 146.27500000000001p -3.1778910000000001e-07 146.28749999999999p -2.9378869999999998e-07 146.30000000000001p -2.6958359999999999e-07 146.3125p -2.4519009999999998e-07 146.32500000000002p -2.206247e-07 146.33749999999998p -1.9590390000000001e-07 146.34999999999999p -1.710444e-07 146.36249999999998p -1.4606290000000001e-07 146.375p -1.209762e-07 146.38749999999999p -9.5801410000000004e-08 146.40000000000001p -7.0555389999999997e-08 146.41250000000002p -4.5255249999999998e-08 146.42499999999998p -1.9918099999999999e-08 146.4375p 5.4388959999999999e-09 146.44999999999999p 3.0798560000000002e-08 146.46250000000001p 5.6143669999999997e-08 146.47499999999999p 8.1456999999999999e-08
+ 146.48750000000001p 1.067213e-07 146.5p 1.3191949999999999e-07 146.51249999999999p 1.5703420000000001e-07 146.52500000000001p 1.8204829999999999e-07 146.53749999999999p 2.069447e-07 146.55000000000001p 2.317063e-07 146.5625p 2.563161e-07 146.57500000000002p 2.8075719999999999e-07 146.58750000000001p 3.050127e-07 146.59999999999999p 3.2906579999999998e-07 146.61249999999998p 3.5289999999999999e-07 146.625p 3.7649849999999997e-07 146.63749999999999p 3.9984509999999998e-07 146.65000000000001p 4.2292339999999998e-07 146.66250000000002p 4.4571739999999999e-07 146.67499999999998p 4.682111e-07 146.6875p 4.9038860000000004e-07 146.69999999999999p 5.122344e-07
+ 146.71250000000001p 5.3373309999999997e-07 146.72499999999999p 5.5486940000000004e-07 146.73750000000001p 5.7562849999999999e-07 146.75p 5.9599540000000003e-07 146.76249999999999p 6.1595579999999998e-07 146.77500000000001p 6.3549529999999999e-07 146.78749999999999p 6.5460000000000005e-07 146.80000000000001p 6.7325609999999997e-07 146.8125p 6.9145010000000001e-07 146.82500000000002p 7.0916900000000002e-07 146.83750000000001p 7.2639979999999996e-07 146.84999999999999p 7.4313000000000001e-07 146.86249999999998p 7.5934750000000002e-07 146.875p 7.7504029999999996e-07 146.88749999999999p 7.9019699999999999e-07 146.90000000000001p 8.0480629999999999e-07 146.91249999999999p 8.1885760000000004e-07 146.92500000000001p 8.3234019999999998e-07
+ 146.9375p 8.4524420000000001e-07 146.94999999999999p 8.5756000000000001e-07 146.96250000000001p 8.6927830000000004e-07 146.97499999999999p 8.8039019999999999e-07 146.98750000000001p 8.9088740000000005e-07 147p 9.0076180000000004e-07 147.01249999999999p 9.1000589999999998e-07 147.02499999999998p 9.1861260000000005e-07 147.03749999999999p 9.2657519999999998e-07 147.05000000000001p 9.3388750000000004e-07 147.0625p 9.405438e-07 147.07500000000002p 9.4653879999999999e-07 147.08750000000001p 9.5186769999999998e-07 147.09999999999999p 9.5652620000000004e-07 147.11249999999998p 9.6051039999999998e-07 147.125p 9.6381700000000003e-07 147.13749999999999p 9.6644319999999998e-07 147.15000000000001p 9.6838660000000001e-07
+ 147.16249999999999p 9.6964539999999994e-07 147.17500000000001p 9.702182e-07 147.1875p 9.7010420000000003e-07 147.19999999999999p 9.693031e-07 147.21250000000001p 9.6781510000000001e-07 147.22499999999999p 9.6564090000000005e-07 147.23750000000001p 9.6278170000000002e-07 147.25p 9.592392999999999e-07 147.26250000000002p 9.5501599999999998e-07 147.27499999999998p 9.5011449999999999e-07 147.28749999999999p 9.4453809999999995e-07 147.30000000000001p 9.3829070000000002e-07 147.3125p 9.3137660000000002e-07 147.32500000000002p 9.2380060000000001e-07 147.33750000000001p 9.1556800000000004e-07 147.34999999999999p 9.066849e-07 147.36249999999998p 8.9715740000000001e-07 147.375p 8.869924e-07
+ 147.38749999999999p 8.7619739999999996e-07 147.40000000000001p 8.6478020000000003e-07 147.41249999999999p 8.5274910000000003e-07 147.42500000000001p 8.4011290000000001e-07 147.4375p 8.2688099999999998e-07 147.44999999999999p 8.1306300000000003e-07 147.46250000000001p 7.9866910000000001e-07 147.47499999999999p 7.8371019999999995e-07 147.48750000000001p 7.6819720000000002e-07 147.5p 7.5214179999999998e-07 147.51250000000002p 7.3555579999999996e-07 147.52499999999998p 7.1845180000000005e-07 147.53749999999999p 7.0084239999999999e-07 147.54999999999998p 6.8274100000000001e-07 147.5625p 6.6416100000000001e-07 147.57500000000002p 6.4511660000000005e-07 147.58750000000001p 6.2562190000000002e-07 147.60000000000002p 6.0569170000000004e-07
+ 147.61249999999998p 5.8534110000000005e-07 147.625p 5.645853e-07 147.63749999999999p 5.4344010000000005e-07 147.65000000000001p 5.2192149999999999e-07 147.66249999999999p 5.0004569999999995e-07 147.67500000000001p 4.7782929999999999e-07 147.6875p 4.5528910000000001e-07 147.69999999999999p 4.3244210000000002e-07 147.71250000000001p 4.0930570000000002e-07 147.72499999999999p 3.8589740000000003e-07 147.73750000000001p 3.6223490000000002e-07 147.75p 3.3833609999999999e-07 147.76250000000002p 3.1421909999999998e-07 147.77499999999998p 2.8990220000000001e-07 147.78749999999999p 2.654038e-07 147.79999999999998p 2.407423e-07 147.8125p 2.159364e-07 147.82500000000002p 1.910048e-07
+ 147.83750000000001p 1.6596639999999999e-07 147.85000000000002p 1.4083989999999999e-07 147.86249999999998p 1.1564439999999999e-07 147.875p 9.0398699999999998e-08 147.88749999999999p 6.5121799999999995e-08 147.90000000000001p 3.9832640000000001e-08 147.91249999999999p 1.4550149999999999e-08 147.92500000000001p -1.0706780000000001e-08 147.9375p -3.5919309999999998e-08 147.94999999999999p -6.1068669999999996e-08 147.96250000000001p -8.6136189999999999e-08 147.97499999999999p -1.111033e-07 147.98750000000001p -1.3595150000000001e-07 148p -1.606625e-07 148.01250000000002p -1.852181e-07 148.02499999999998p -2.0960039999999999e-07 148.03749999999999p -2.337914e-07 148.04999999999998p -2.5777359999999999e-07
+ 148.0625p -2.8152959999999999e-07 148.07500000000002p -3.0504199999999999e-07 148.08750000000001p -3.2829409999999998e-07 148.10000000000002p -3.512692e-07 148.11249999999998p -3.7395069999999998e-07 148.125p -3.9632250000000001e-07 148.13749999999999p -4.1836889999999999e-07 148.15000000000001p -4.4007419999999998e-07 148.16249999999999p -4.6142330000000002e-07 148.17500000000001p -4.8240120000000004e-07 148.1875p -5.0299350000000002e-07 148.19999999999999p -5.2318599999999996e-07 148.21250000000001p -5.4296480000000003e-07 148.22499999999999p -5.6231650000000003e-07 148.23750000000001p -5.8122810000000001e-07 148.25p -5.9968689999999997e-07 148.26250000000002p -6.1768070000000001e-07 148.27500000000001p -6.3519769999999999e-07
+ 148.28749999999999p -6.5222640000000003e-07 148.29999999999998p -6.6875589999999996e-07 148.3125p -6.847756e-07 148.32499999999999p -7.0027549999999995e-07 148.33750000000001p -7.1524590000000001e-07 148.35000000000002p -7.2967760000000004e-07 148.36249999999998p -7.4356190000000003e-07 148.375p -7.5689049999999996e-07 148.38749999999999p -7.6965570000000004e-07 148.40000000000001p -7.8185010000000002e-07 148.41249999999999p -7.9346679999999996e-07 148.42500000000001p -8.0449960000000002e-07 148.4375p -8.1494239999999999e-07 148.44999999999999p -8.2478990000000002e-07 148.46250000000001p -8.3403720000000003e-07 148.47499999999999p -8.4267970000000005e-07 148.48750000000001p -8.5071359999999996e-07 148.5p -8.5813539999999997e-07
+ 148.51250000000002p -8.6494190000000002e-07 148.52500000000001p -8.7113080000000004e-07 148.53749999999999p -8.7669980000000002e-07 148.54999999999998p -8.8164749999999999e-07 148.5625p -8.8597270000000004e-07 148.57499999999999p -8.8967469999999995e-07 148.58750000000001p -8.9275329999999995e-07 148.60000000000002p -8.9520890000000001e-07 148.61250000000001p -8.9704200000000005e-07 148.625p -8.982539e-07 148.63749999999999p -8.9884610000000002e-07 148.65000000000001p -8.988207e-07 148.66249999999999p -8.981802e-07 148.67500000000001p -8.9692729999999997e-07 148.6875p -8.9506539999999997e-07 148.69999999999999p -8.9259830000000001e-07 148.71250000000001p -8.8952989999999995e-07 148.72499999999999p -8.8586479999999996e-07
+ 148.73750000000001p -8.8160790000000002e-07 148.75p -8.7676440000000005e-07 148.76250000000002p -8.7133999999999997e-07 148.77500000000001p -8.653406e-07 148.78749999999999p -8.5877259999999996e-07 148.79999999999998p -8.5164259999999998e-07 148.8125p -8.4395769999999996e-07 148.82499999999999p -8.3572520000000004e-07 148.83750000000001p -8.2695270000000003e-07 148.84999999999999p -8.1764819999999995e-07 148.86250000000001p -8.0782000000000004e-07 148.875p -7.9747669999999996e-07 148.88749999999999p -7.8662689999999997e-07 148.90000000000001p -7.7527999999999999e-07 148.91249999999999p -7.6344509999999998e-07 148.92500000000001p -7.5113189999999999e-07 148.9375p -7.3835039999999996e-07 148.94999999999999p -7.2511050000000003e-07
+ 148.96249999999998p -7.1142249999999996e-07 148.97499999999999p -6.9729710000000005e-07 148.98750000000001p -6.8274489999999997e-07 149p -6.6777699999999998e-07 149.01250000000002p -6.5240430000000003e-07 149.02500000000001p -6.3663820000000005e-07 149.03749999999999p -6.2049019999999995e-07 149.04999999999998p -6.0397200000000003e-07 149.0625p -5.8709529999999995e-07 149.07499999999999p -5.6987209999999995e-07 149.08750000000001p -5.5231449999999997e-07 149.09999999999999p -5.3443459999999996e-07 149.11250000000001p -5.1624489999999996e-07 149.125p -4.9775780000000004e-07 149.13749999999999p -4.7898580000000004e-07 149.15000000000001p -4.5994160000000001e-07 149.16249999999999p -4.40638e-07 149.17500000000001p -4.2108790000000003e-07
+ 149.1875p -4.0130410000000002e-07 149.20000000000002p -3.8129959999999998e-07 149.21249999999998p -3.6108759999999999e-07 149.22499999999999p -3.4068110000000002e-07 149.23750000000001p -3.200934e-07 149.25p -2.9933750000000002e-07 149.26250000000002p -2.7842690000000002e-07 149.27500000000001p -2.5737479999999998e-07 149.28749999999999p -2.3619449999999999e-07 149.29999999999998p -2.1489939999999999e-07 149.3125p -1.9350289999999999e-07 149.32499999999999p -1.7201820000000001e-07 149.33750000000001p -1.504588e-07 149.34999999999999p -1.288381e-07 149.36250000000001p -1.0716939999999999e-07 149.375p -8.5465989999999996e-08 149.38749999999999p -6.3741329999999994e-08 149.40000000000001p -4.200866e-08
+ 149.41249999999999p -2.0281270000000001e-08 149.42500000000001p 1.4275909999999999e-09 149.4375p 2.3104740000000001e-08 149.45000000000002p 4.4736999999999999e-08 149.46249999999998p 6.6311299999999994e-08 149.47499999999999p 8.7814560000000001e-08 149.48749999999998p 1.092338e-07 149.5p 1.3055620000000001e-07 149.51250000000002p 1.5176870000000001e-07 149.52500000000001p 1.728587e-07 149.53750000000002p 1.938136e-07 149.54999999999998p 2.146206e-07 149.5625p 2.3526729999999999e-07 149.57499999999999p 2.5574129999999999e-07 149.58750000000001p 2.7603029999999999e-07 149.59999999999999p 2.9612209999999998e-07 149.61250000000001p 3.1600469999999997e-07 149.625p 3.3566599999999998e-07
+ 149.63749999999999p 3.5509440000000001e-07 149.65000000000001p 3.7427799999999998e-07 149.66249999999999p 3.932054e-07 149.67500000000001p 4.1186510000000001e-07 149.6875p 4.3024589999999998e-07 149.70000000000002p 4.483367e-07 149.71249999999998p 4.6612650000000001e-07 149.72499999999999p 4.8360450000000003e-07 149.73749999999998p 5.0076019999999998e-07 149.75p 5.1758310000000003e-07 149.76250000000002p 5.3406289999999999e-07 149.77500000000001p 5.5018960000000001e-07 149.78750000000002p 5.6595340000000001e-07 149.79999999999998p 5.8134439999999996e-07 149.8125p 5.9635339999999996e-07 149.82499999999999p 6.10971e-07 149.83750000000001p 6.2518820000000004e-07 149.84999999999999p 6.3899609999999998e-07
+ 149.86250000000001p 6.5238620000000001e-07 149.875p 6.6535009999999995e-07 149.88749999999999p 6.7787969999999995e-07 149.90000000000001p 6.8996710000000005e-07 149.91249999999999p 7.0160469999999999e-07 149.92500000000001p 7.1278510000000003e-07 149.9375p 7.2350110000000001e-07 149.95000000000002p 7.3374599999999996e-07 149.96249999999998p 7.4351319999999998e-07 149.97499999999999p 7.5279630000000004e-07 149.98749999999998p 7.6158929999999998e-07 150p 7.6988649999999998e-07 150.01249999999999p 7.7768239999999998e-07 150.02500000000001p 7.8497190000000003e-07 150.03750000000002p 7.9175010000000002e-07 150.04999999999998p 7.9801240000000001e-07 150.0625p 8.0375459999999999e-07 150.07499999999999p 8.0897289999999996e-07
+ 150.08750000000001p 8.1366340000000005e-07 150.09999999999999p 8.1782309999999997e-07 150.11250000000001p 8.2144879999999998e-07 150.125p 8.2453789999999995e-07 150.13749999999999p 8.2708819999999996e-07 150.15000000000001p 8.2909760000000001e-07 150.16249999999999p 8.3056450000000001e-07 150.17500000000001p 8.3148760000000002e-07 150.1875p 8.3186600000000005e-07 150.20000000000002p 8.3169899999999999e-07 150.21250000000001p 8.3098639999999997e-07 150.22499999999999p 8.2972830000000003e-07 150.23749999999998p 8.27925e-07 150.25p 8.255775e-07 150.26249999999999p 8.2268679999999995e-07 150.27500000000001p 8.1925450000000005e-07 150.28750000000002p 8.1528230000000001e-07 150.29999999999998p 8.107727e-07
+ 150.3125p 8.0572810000000005e-07 150.32499999999999p 8.0015139999999997e-07 150.33750000000001p 7.9404600000000004e-07 150.34999999999999p 7.8741560000000002e-07 150.36250000000001p 7.8026409999999997e-07 150.375p 7.7259589999999997e-07 150.38749999999999p 7.6441579999999997e-07 150.40000000000001p 7.5572890000000004e-07 150.41249999999999p 7.4654050000000003e-07 150.42500000000001p 7.3685640000000001e-07 150.4375p 7.2668289999999998e-07 150.45000000000002p 7.1602639999999995e-07 150.46250000000001p 7.0489370000000004e-07 150.47499999999999p 6.9329190000000005e-07 150.48749999999998p 6.8122860000000002e-07 150.5p 6.6871159999999999e-07 150.51249999999999p 6.5574910000000005e-07 150.52500000000001p 6.4234949999999996e-07
+ 150.53750000000002p 6.285216e-07 150.55000000000001p 6.1427459999999996e-07 150.5625p 5.9961780000000003e-07 150.57499999999999p 5.8456110000000001e-07 150.58750000000001p 5.6911429999999997e-07 150.59999999999999p 5.5328790000000001e-07 150.61250000000001p 5.3709239999999997e-07 150.625p 5.2053859999999998e-07 150.63749999999999p 5.0363780000000004e-07 150.65000000000001p 4.8640120000000003e-07 150.66249999999999p 4.6884070000000001e-07 150.67500000000001p 4.5096800000000002e-07 150.6875p 4.3279530000000001e-07 150.70000000000002p 4.1433500000000001e-07 150.71250000000001p 3.955996e-07 150.72499999999999p 3.7660200000000003e-07 150.73749999999998p 3.5735520000000002e-07 150.75p 3.3787230000000003e-07
+ 150.76249999999999p 3.1816669999999999e-07 150.77500000000001p 2.9825210000000001e-07 150.78749999999999p 2.7814210000000002e-07 150.80000000000001p 2.5785050000000001e-07 150.8125p 2.373915e-07 150.82499999999999p 2.167791e-07 150.83750000000001p 1.9602759999999999e-07 150.84999999999999p 1.751514e-07 150.86250000000001p 1.54165e-07 150.875p 1.33083e-07 150.88750000000002p 1.1191989999999999e-07 150.89999999999998p 9.069054e-08 150.91249999999999p 6.9409659999999995e-08 150.92500000000001p 4.8092059999999997e-08 150.9375p 2.675258e-08 150.95000000000002p 5.4060870000000002e-09 150.96250000000001p -1.593256e-08 150.97499999999999p -3.7248490000000001e-08
+ 150.98749999999998p -5.852686e-08 151p -7.9752859999999995e-08 151.01249999999999p -1.0091169999999999e-07 151.02500000000001p -1.219886e-07 151.03749999999999p -1.4296899999999999e-07 151.05000000000001p -1.6383829999999999e-07 151.0625p -1.8458190000000001e-07 151.07499999999999p -2.0518550000000001e-07 151.08750000000001p -2.2563469999999999e-07 151.09999999999999p -2.4591540000000001e-07 151.11250000000001p -2.6601360000000002e-07 151.125p -2.8591530000000001e-07 151.13750000000002p -3.0560679999999998e-07 151.14999999999998p -3.250746e-07 151.16249999999999p -3.443052e-07 151.17500000000001p -3.6328530000000002e-07 151.1875p -3.820021e-07 151.20000000000002p -4.004427e-07
+ 151.21250000000001p -4.1859450000000001e-07 151.22500000000002p -4.3644509999999998e-07 151.23749999999998p -4.5398240000000002e-07 151.25p -4.7119449999999999e-07 151.26249999999999p -4.8806979999999996e-07 151.27500000000001p -5.0459689999999998e-07 151.28749999999999p -5.2076470000000002e-07 151.30000000000001p -5.3656239999999995e-07 151.3125p -5.5197950000000004e-07 151.32499999999999p -5.670058e-07 151.33750000000001p -5.8163119999999996e-07 151.34999999999999p -5.9584619999999996e-07 151.36250000000001p -6.0964150000000004e-07 151.375p -6.2300809999999996e-07 151.38750000000002p -6.3593719999999997e-07 151.39999999999998p -6.4842070000000003e-07 151.41249999999999p -6.6045040000000004e-07 151.42499999999998p -6.7201869999999995e-07
+ 151.4375p -6.8311840000000001e-07 151.45000000000002p -6.9374250000000003e-07 151.46250000000001p -7.038844e-07 151.47500000000002p -7.1353780000000004e-07 151.48749999999998p -7.2269680000000002e-07 151.5p -7.3135599999999995e-07 151.51249999999999p -7.3951020000000002e-07 151.52500000000001p -7.4715470000000002e-07 151.53749999999999p -7.5428489999999999e-07 151.55000000000001p -7.6089689999999997e-07 151.5625p -7.6698699999999998e-07 151.57499999999999p -7.7255190000000003e-07 151.58750000000001p -7.7758869999999996e-07 151.59999999999999p -7.8209490000000002e-07 151.61250000000001p -7.8606820000000003e-07 151.625p -7.8950689999999996e-07 151.63750000000002p -7.9240949999999997e-07 151.64999999999998p -7.9477500000000005e-07
+ 151.66249999999999p -7.9660280000000002e-07 151.67499999999998p -7.9789239999999998e-07 151.6875p -7.9864389999999997e-07 151.70000000000002p -7.9885769999999996e-07 151.71250000000001p -7.9853470000000005e-07 151.72500000000002p -7.9767579999999999e-07 151.73749999999998p -7.9628270000000003e-07 151.75p -7.9435709999999999e-07 151.76249999999999p -7.919012e-07 151.77500000000001p -7.8891750000000004e-07 151.78749999999999p -7.8540899999999996e-07 151.80000000000001p -7.8137869999999997e-07 151.8125p -7.7683030000000003e-07 151.82499999999999p -7.7176759999999996e-07 151.83750000000001p -7.6619489999999999e-07 151.84999999999999p -7.6011649999999996e-07 151.86250000000001p -7.5353729999999996e-07 151.875p -7.4646249999999999e-07
+ 151.88750000000002p -7.3889749999999996e-07 151.89999999999998p -7.3084800000000001e-07 151.91249999999999p -7.2232010000000002e-07 151.92499999999998p -7.1332009999999998e-07 151.9375p -7.0385449999999996e-07 151.94999999999999p -6.9393030000000005e-07 151.96250000000001p -6.8355459999999996e-07 151.97500000000002p -6.7273479999999996e-07 151.98749999999998p -6.6147860000000002e-07 152p -6.4979390000000001e-07 152.01249999999999p -6.3768899999999996e-07 152.02500000000001p -6.2517220000000002e-07 152.03749999999999p -6.1225219999999998e-07 152.05000000000001p -5.989378e-07 152.0625p -5.8523830000000005e-07 152.07499999999999p -5.7116290000000002e-07 152.08750000000001p -5.5672129999999998e-07 152.09999999999999p -5.4192299999999995e-07
+ 152.11250000000001p -5.2677819999999999e-07 152.125p -5.11297e-07 152.13750000000002p -4.9548960000000003e-07 152.15000000000001p -4.7936670000000003e-07 152.16249999999999p -4.6293890000000002e-07 152.17499999999998p -4.462171e-07 152.1875p -4.292123e-07 152.19999999999999p -4.1193569999999999e-07 152.21250000000001p -3.9439869999999998e-07 152.22500000000002p -3.7661279999999997e-07 152.23749999999998p -3.5858950000000002e-07 152.25p -3.4034059999999999e-07 152.26249999999999p -3.2187810000000001e-07 152.27500000000001p -3.0321379999999999e-07 152.28749999999999p -2.8435999999999999e-07 152.30000000000001p -2.653288e-07 152.3125p -2.461326e-07 152.32499999999999p -2.2678379999999999e-07
+ 152.33750000000001p -2.0729479999999999e-07 152.34999999999999p -1.876783e-07 152.36250000000001p -1.679469e-07 152.375p -1.4811339999999999e-07 152.38750000000002p -1.281905e-07 152.40000000000001p -1.081911e-07 152.41249999999999p -8.8128010000000003e-08 152.42499999999998p -6.8014209999999997e-08 152.4375p -4.7862649999999997e-08 152.44999999999999p -2.768631e-08 152.46250000000001p -7.4981949999999997e-09 152.47500000000002p 1.2688669999999999e-08 152.48750000000001p 3.2861260000000002e-08 152.5p 5.3006559999999998e-08 152.51249999999999p 7.3111539999999999e-08 152.52500000000001p 9.3163210000000006e-08 152.53749999999999p 1.1314859999999999e-07 152.55000000000001p 1.3305469999999999e-07
+ 152.5625p 1.5286869999999999e-07 152.57499999999999p 1.725777e-07 152.58749999999998p 1.9216890000000001e-07 152.59999999999999p 2.1162939999999999e-07 152.61250000000001p 2.3094670000000001e-07 152.625p 2.501081e-07 152.63750000000002p 2.6910110000000001e-07 152.65000000000001p 2.879132e-07 152.66249999999999p 3.0653209999999997e-07 152.67499999999998p 3.2494549999999999e-07 152.6875p 3.4314129999999999e-07 152.69999999999999p 3.6110750000000002e-07 152.71250000000001p 3.788322e-07 152.72499999999999p 3.963037e-07 152.73750000000001p 4.1351019999999999e-07 152.75p 4.304405e-07 152.76249999999999p 4.4708310000000003e-07 152.77500000000001p 4.6342699999999998e-07
+ 152.78749999999999p 4.7946110000000005e-07 152.80000000000001p 4.951748e-07 152.8125p 5.1055719999999999e-07 152.82500000000002p 5.2559820000000003e-07 152.83749999999998p 5.4028739999999997e-07 152.84999999999999p 5.546149e-07 152.86250000000001p 5.6857090000000005e-07 152.875p 5.8214580000000002e-07 152.88750000000002p 5.9533039999999999e-07 152.90000000000001p 6.0811549999999995e-07 152.91249999999999p 6.2049230000000005e-07 152.92499999999998p 6.3245220000000002e-07 152.9375p 6.4398690000000002e-07 152.94999999999999p 6.5508840000000004e-07 152.96250000000001p 6.6574880000000003e-07 152.97499999999999p 6.7596059999999998e-07 152.98750000000001p 6.8571660000000003e-07 153p 6.9500990000000004e-07
+ 153.01249999999999p 7.0383389999999998e-07 153.02500000000001p 7.1218210000000001e-07 153.03749999999999p 7.200486e-07 153.05000000000001p 7.2742770000000002e-07 153.0625p 7.3431399999999997e-07 153.07500000000002p 7.4070239999999998e-07 153.08749999999998p 7.4658820000000005e-07 153.09999999999999p 7.51967e-07 153.11250000000001p 7.5683469999999998e-07 153.125p 7.6118760000000003e-07 153.13750000000002p 7.6502240000000003e-07 153.15000000000001p 7.6833599999999995e-07 153.16250000000002p 7.7112569999999996e-07 153.17499999999998p 7.7338930000000002e-07 153.1875p 7.7512479999999996e-07 153.19999999999999p 7.7633069999999996e-07 153.21250000000001p 7.7700569999999996e-07 153.22499999999999p 7.7714889999999997e-07
+ 153.23750000000001p 7.7676010000000002e-07 153.25p 7.7583890000000002e-07 153.26249999999999p 7.743858e-07 153.27500000000001p 7.7240129999999996e-07 153.28749999999999p 7.6988660000000002e-07 153.30000000000001p 7.6684300000000003e-07 153.3125p 7.6327229999999996e-07 153.32500000000002p 7.5917679999999999e-07 153.33749999999998p 7.5455890000000003e-07 153.34999999999999p 7.4942150000000004e-07 153.36249999999998p 7.4376809999999999e-07 153.375p 7.3760230000000002e-07 153.38750000000002p 7.3092810000000004e-07 153.40000000000001p 7.237501e-07 153.41250000000002p 7.1607280000000002e-07 153.42499999999998p 7.0790169999999995e-07 153.4375p 6.9924219999999999e-07 153.44999999999999p 6.9010010000000001e-07
+ 153.46250000000001p 6.8048180000000003e-07 153.47499999999999p 6.7039389999999997e-07 153.48750000000001p 6.5984340000000001e-07 153.5p 6.4883750000000002e-07 153.51249999999999p 6.3738389999999997e-07 153.52500000000001p 6.2549059999999998e-07 153.53749999999999p 6.1316600000000003e-07 153.55000000000001p 6.0041869999999997e-07 153.5625p 5.8725760000000001e-07 153.57500000000002p 5.7369210000000004e-07 153.58749999999998p 5.5973179999999996e-07 153.59999999999999p 5.4538650000000005e-07 153.61249999999998p 5.3066649999999998e-07 153.625p 5.155822e-07 153.63750000000002p 5.0014429999999996e-07 153.65000000000001p 4.8436400000000004e-07 153.66250000000002p 4.6825249999999999e-07 153.67499999999998p 4.5182129999999998e-07
+ 153.6875p 4.3508219999999999e-07 153.69999999999999p 4.1804730000000001e-07 153.71250000000001p 4.007289e-07 153.72499999999999p 3.8313929999999998e-07 153.73750000000001p 3.6529120000000002e-07 153.75p 3.4719760000000001e-07 153.76249999999999p 3.2887149999999999e-07 153.77500000000001p 3.1032619999999998e-07 153.78749999999999p 2.9157499999999999e-07 153.80000000000001p 2.7263150000000002e-07 153.8125p 2.5350949999999998e-07 153.82500000000002p 2.3422269999999999e-07 153.83750000000001p 2.1478520000000001e-07 153.84999999999999p 1.9521099999999999e-07 153.86249999999998p 1.755143e-07 153.875p 1.557095e-07 153.88749999999999p 1.3581069999999999e-07 153.90000000000001p 1.158325e-07
+ 153.91250000000002p 9.5789290000000005e-08 153.92499999999998p 7.569563e-08 153.9375p 5.5566040000000002e-08 153.94999999999999p 3.5415080000000002e-08 153.96250000000001p 1.5257319999999998e-08 153.97499999999999p -4.8926689999999999e-09 153.98750000000001p -2.5020350000000001e-08 154p -4.511121e-08 154.01249999999999p -6.5150769999999998e-08 154.02500000000001p -8.5124599999999995e-08 154.03749999999999p -1.050184e-07 154.05000000000001p -1.2481779999999999e-07 154.0625p -1.4450859999999999e-07 154.07500000000002p -1.6407680000000001e-07 154.08750000000001p -1.8350830000000001e-07 154.09999999999999p -2.027894e-07 154.11249999999998p -2.219063e-07 154.125p -2.4084529999999999e-07
+ 154.13749999999999p -2.5959320000000002e-07 154.15000000000001p -2.7813649999999998e-07 154.16250000000002p -2.9646229999999997e-07 154.17499999999998p -3.145577e-07 154.1875p -3.3240980000000001e-07 154.19999999999999p -3.5000640000000001e-07 154.21250000000001p -3.6733499999999997e-07 154.22499999999999p -3.8438359999999999e-07 154.23750000000001p -4.0114050000000002e-07 154.25p -4.1759399999999997e-07 154.26249999999999p -4.3373289999999999e-07 154.27500000000001p -4.4954609999999999e-07 154.28749999999999p -4.6502280000000001e-07 154.30000000000001p -4.8015250000000004e-07 154.3125p -4.9492499999999997e-07 154.32500000000002p -5.0933039999999999e-07 154.33750000000001p -5.2335899999999997e-07 154.34999999999999p -5.3700159999999998e-07
+ 154.36249999999998p -5.5024909999999996e-07 154.375p -5.6309290000000003e-07 154.38749999999999p -5.7552449999999997e-07 154.40000000000001p -5.8753600000000003e-07 154.41249999999999p -5.991197e-07 154.42500000000001p -6.1026819999999995e-07 154.4375p -6.209745e-07 154.44999999999999p -6.3123200000000002e-07 154.46250000000001p -6.4103419999999995e-07 154.47499999999999p -6.5037530000000003e-07 154.48750000000001p -6.5924969999999995e-07 154.5p -6.6765209999999997e-07 154.51249999999999p -6.7557770000000004e-07 154.52499999999998p -6.8302179999999995e-07 154.53749999999999p -6.8998049999999995e-07 154.55000000000001p -6.9644989999999997e-07 154.5625p -7.0242650000000003e-07 154.57500000000002p -7.0790739999999998e-07
+ 154.58750000000001p -7.1288980000000004e-07 154.59999999999999p -7.1737149999999996e-07 154.61249999999998p -7.2135060000000004e-07 154.625p -7.2482530000000001e-07 154.63749999999999p -7.2779460000000004e-07 154.65000000000001p -7.3025759999999995e-07 154.66249999999999p -7.3221380000000004e-07 154.67500000000001p -7.33663e-07 154.6875p -7.3460569999999995e-07 154.69999999999999p -7.3504220000000004e-07 154.71250000000001p -7.3497360000000001e-07 154.72499999999999p -7.3440120000000002e-07 154.73750000000001p -7.3332659999999996e-07 154.75p -7.3175179999999999e-07 154.76250000000002p -7.2967909999999997e-07 154.77499999999998p -7.2711119999999996e-07 154.78749999999999p -7.2405119999999999e-07 154.80000000000001p -7.205023e-07
+ 154.8125p -7.1646810000000005e-07 154.82500000000002p -7.1195269999999997e-07 154.83750000000001p -7.0696029999999995e-07 154.84999999999999p -7.014956e-07 154.86249999999998p -6.9556330000000002e-07 154.875p -6.8916869999999997e-07 154.88749999999999p -6.8231720000000005e-07 154.90000000000001p -6.7501469999999996e-07 154.91249999999999p -6.6726719999999997e-07 154.92500000000001p -6.5908090000000003e-07 154.9375p -6.5046249999999998e-07 154.94999999999999p -6.4141880000000002e-07 154.96250000000001p -6.3195700000000003e-07 154.97499999999999p -6.2208429999999995e-07 154.98750000000001p -6.1180850000000004e-07 155p -6.011372e-07 155.01250000000002p -5.9007859999999995e-07 155.02499999999998p -5.7864089999999998e-07
+ 155.03749999999999p -5.6683279999999999e-07 155.04999999999998p -5.5466280000000001e-07 155.0625p -5.4213989999999996e-07 155.07500000000002p -5.2927320000000004e-07 155.08750000000001p -5.1607199999999999e-07 155.10000000000002p -5.0254579999999997e-07 155.11249999999998p -4.8870430000000001e-07 155.125p -4.7455729999999998e-07 155.13749999999999p -4.601148e-07 155.15000000000001p -4.4538690000000002e-07 155.16249999999999p -4.3038400000000002e-07 155.17500000000001p -4.1511639999999999e-07 155.1875p -3.9959479999999999e-07 155.19999999999999p -3.8382990000000002e-07 155.21250000000001p -3.678325e-07 155.22499999999999p -3.5161359999999999e-07 155.23750000000001p -3.3518410000000001e-07 155.25p -3.1855530000000001e-07
+ 155.26250000000002p -3.0173840000000002e-07 155.27499999999998p -2.8474479999999999e-07 155.28749999999999p -2.675857e-07 155.29999999999998p -2.5027280000000002e-07 155.3125p -2.3281759999999999e-07 155.32500000000002p -2.1523179999999999e-07 155.33750000000001p -1.975269e-07 155.35000000000002p -1.7971469999999999e-07 155.36249999999998p -1.618069e-07 155.375p -1.4381539999999999e-07 155.38749999999999p -1.25752e-07 155.40000000000001p -1.076286e-07 155.41249999999999p -8.945686e-08 155.42500000000001p -7.1248799999999994e-08 155.4375p -5.3016249999999997e-08 155.44999999999999p -3.4771070000000003e-08 155.46250000000001p -1.6525109999999999e-08 155.47499999999999p 1.709798e-09
+ 155.48750000000001p 1.992185e-08 155.5p 3.8099279999999999e-08 155.51250000000002p 5.6230330000000001e-08 155.52499999999998p 7.4303330000000006e-08 155.53749999999999p 9.2306620000000005e-08 155.54999999999998p 1.1022860000000001e-07 155.5625p 1.2805780000000001e-07 155.57500000000002p 1.457827e-07 155.58750000000001p 1.6339200000000001e-07 155.60000000000002p 1.8087430000000001e-07 155.61249999999998p 1.982185e-07 155.625p 2.1541350000000001e-07 155.63749999999999p 2.3244810000000001e-07 155.65000000000001p 2.4931159999999998e-07 155.66249999999999p 2.6599309999999998e-07 155.67500000000001p 2.8248199999999997e-07 155.6875p 2.987676e-07 155.69999999999999p 3.148397e-07
+ 155.71250000000001p 3.3068790000000001e-07 155.72499999999999p 3.4630200000000003e-07 155.73750000000001p 3.6167220000000002e-07 155.75p 3.7678849999999999e-07 155.76250000000002p 3.9164129999999998e-07 155.77500000000001p 4.0622110000000001e-07 155.78749999999999p 4.2051850000000002e-07 155.79999999999998p 4.3452439999999998e-07 155.8125p 4.4822989999999999e-07 155.82499999999999p 4.6162610000000003e-07 155.83750000000001p 4.747045e-07 155.85000000000002p 4.8745670000000005e-07 155.86249999999998p 4.9987439999999996e-07 155.875p 5.1194980000000004e-07 155.88749999999999p 5.2367509999999995e-07 155.90000000000001p 5.3504269999999995e-07 155.91249999999999p 5.4604539999999999e-07 155.92500000000001p 5.5667599999999997e-07
+ 155.9375p 5.6692779999999997e-07 155.94999999999999p 5.7679410000000002e-07 155.96250000000001p 5.8626860000000003e-07 155.97499999999999p 5.9534509999999995e-07 155.98750000000001p 6.0401789999999998e-07 156p 6.1228129999999998e-07 156.01250000000002p 6.2012999999999998e-07 156.02500000000001p 6.2755890000000002e-07 156.03749999999999p 6.3456329999999999e-07 156.04999999999998p 6.4113860000000004e-07 156.0625p 6.4728059999999996e-07 156.07499999999999p 6.5298540000000002e-07 156.08750000000001p 6.5824910000000003e-07 156.10000000000002p 6.6306859999999997e-07 156.11250000000001p 6.6744050000000001e-07 156.125p 6.7136229999999998e-07 156.13749999999999p 6.7483119999999997e-07 156.15000000000001p 6.7784519999999995e-07
+ 156.16249999999999p 6.8040229999999996e-07 156.17500000000001p 6.8250090000000001e-07 156.1875p 6.8413960000000002e-07 156.19999999999999p 6.8531749999999998e-07 156.21250000000001p 6.8603390000000002e-07 156.22499999999999p 6.8628839999999995e-07 156.23750000000001p 6.8608099999999999e-07 156.25p 6.8541170000000002e-07 156.26250000000002p 6.8428129999999999e-07 156.27500000000001p 6.8269039999999995e-07 156.28749999999999p 6.8064040000000001e-07 156.29999999999998p 6.7813260000000001e-07 156.3125p 6.75169e-07 156.32499999999999p 6.7175139999999996e-07 156.33750000000001p 6.6788250000000004e-07 156.34999999999999p 6.6356479999999999e-07 156.36250000000001p 6.5880140000000005e-07 156.375p 6.5359570000000005e-07
+ 156.38749999999999p 6.4795119999999999e-07 156.40000000000001p 6.4187200000000002e-07 156.41249999999999p 6.3536219999999998e-07 156.42500000000001p 6.2842640000000004e-07 156.4375p 6.2106940000000004e-07 156.45000000000002p 6.1329639999999998e-07 156.46249999999998p 6.0511279999999999e-07 156.47499999999999p 5.9652429999999998e-07 156.48750000000001p 5.8753679999999996e-07 156.5p 5.7815669999999998e-07 156.51250000000002p 5.6839049999999998e-07 156.52500000000001p 5.5824499999999998e-07 156.53749999999999p 5.4772740000000004e-07 156.54999999999998p 5.3684479999999998e-07 156.5625p 5.2560509999999997e-07 156.57499999999999p 5.1401590000000005e-07 156.58750000000001p 5.0208550000000005e-07 156.59999999999999p 4.8982220000000001e-07
+ 156.61250000000001p 4.772346e-07 156.625p 4.6433140000000003e-07 156.63749999999999p 4.511218e-07 156.65000000000001p 4.3761499999999999e-07 156.66249999999999p 4.2382050000000001e-07 156.67500000000001p 4.0974789999999998e-07 156.6875p 3.9540720000000003e-07 156.70000000000002p 3.808084e-07 156.71249999999998p 3.659617e-07 156.72499999999999p 3.5087750000000001e-07 156.73750000000001p 3.3556659999999998e-07 156.75p 3.2003959999999998e-07 156.76250000000002p 3.0430739999999999e-07 156.77500000000001p 2.8838110000000001e-07 156.78749999999999p 2.7227199999999999e-07 156.79999999999998p 2.5599120000000002e-07 156.8125p 2.3955019999999998e-07 156.82499999999999p 2.229607e-07
+ 156.83750000000001p 2.062342e-07 156.84999999999999p 1.8938250000000001e-07 156.86250000000001p 1.724174e-07 156.875p 1.5535090000000001e-07 156.88749999999999p 1.3819479999999999e-07 156.90000000000001p 1.209613e-07 156.91249999999999p 1.0366250000000001e-07 156.92500000000001p 8.6310349999999996e-08 156.9375p 6.8917109999999996e-08 156.95000000000002p 5.1494930000000003e-08 156.96249999999998p 3.4055990000000001e-08 156.97499999999999p 1.6612480000000001e-08 156.98749999999998p -8.234293e-10 157p -1.8239580000000002e-08 157.01250000000002p -3.5623830000000001e-08 157.02500000000001p -5.2964100000000002e-08 157.03750000000002p -7.0248309999999994e-08 157.04999999999998p -8.7464480000000002e-08
+ 157.0625p -1.046007e-07 157.07499999999999p -1.21645e-07 157.08750000000001p -1.3858569999999999e-07 157.09999999999999p -1.5541110000000001e-07 157.11250000000001p -1.721096e-07 157.125p -1.886697e-07 157.13749999999999p -2.0508000000000001e-07 157.15000000000001p -2.213294e-07 157.16249999999999p -2.3740660000000001e-07 157.17500000000001p -2.5330070000000002e-07 157.1875p -2.6900090000000002e-07 157.20000000000002p -2.844965e-07 157.21249999999998p -2.9977710000000002e-07 157.22499999999999p -3.148323e-07 157.23749999999998p -3.2965199999999999e-07 157.25p -3.4422619999999999e-07 157.26250000000002p -3.5854529999999999e-07 157.27500000000001p -3.7259949999999997e-07
+ 157.28750000000002p -3.8637959999999997e-07 157.29999999999998p -3.9987650000000001e-07 157.3125p -4.1308129999999999e-07 157.32499999999999p -4.2598530000000002e-07 157.33750000000001p -4.3858e-07 157.34999999999999p -4.5085720000000001e-07 157.36250000000001p -4.6280900000000003e-07 157.375p -4.7442780000000001e-07 157.38749999999999p -4.8570589999999998e-07 157.40000000000001p -4.9663640000000005e-07 157.41249999999999p -5.0721210000000005e-07 157.42500000000001p -5.174265e-07 157.4375p -5.272732e-07 157.45000000000002p -5.3674619999999997e-07 157.46249999999998p -5.4583940000000002e-07 157.47499999999999p -5.5454749999999998e-07 157.48749999999998p -5.6286520000000002e-07 157.5p -5.7078740000000004e-07
+ 157.51249999999999p -5.7830960000000003e-07 157.52500000000001p -5.8542729999999997e-07 157.53750000000002p -5.9213649999999996e-07 157.54999999999998p -5.9843330000000005e-07 157.5625p -6.0431440000000002e-07 157.57499999999999p -6.0977640000000002e-07 157.58750000000001p -6.1481640000000001e-07 157.59999999999999p -6.1943199999999998e-07 157.61250000000001p -6.2362080000000001e-07 157.625p -6.2738089999999998e-07 157.63749999999999p -6.3071039999999998e-07 157.65000000000001p -6.3360810000000001e-07 157.66249999999999p -6.3607289999999999e-07 157.67500000000001p -6.3810390000000004e-07 157.6875p -6.3970069999999999e-07 157.70000000000002p -6.408632e-07 157.71250000000001p -6.4159130000000002e-07 157.72499999999999p -6.4188549999999997e-07
+ 157.73749999999998p -6.4174650000000005e-07 157.75p -6.4117520000000003e-07 157.76249999999999p -6.4017309999999996e-07 157.77500000000001p -6.387415e-07 157.78750000000002p -6.3688229999999995e-07 157.79999999999998p -6.3459770000000005e-07 157.8125p -6.3188999999999998e-07 157.82499999999999p -6.2876189999999998e-07 157.83750000000001p -6.2521639999999995e-07 157.84999999999999p -6.2125659999999999e-07 157.86250000000001p -6.1688609999999995e-07 157.875p -6.1210849999999995e-07 157.88749999999999p -6.0692780000000001e-07 157.90000000000001p -6.0134830000000005e-07 157.91249999999999p -5.9537449999999998e-07 157.92500000000001p -5.8901110000000002e-07 157.9375p -5.8226299999999995e-07 157.95000000000002p -5.7513550000000003e-07
+ 157.96250000000001p -5.6763399999999996e-07 157.97499999999999p -5.5976419999999997e-07 157.98749999999998p -5.5153190000000003e-07 158p -5.4294329999999997e-07 158.01249999999999p -5.3400459999999995e-07 158.02500000000001p -5.2472239999999997e-07 158.03750000000002p -5.1510329999999995e-07 158.05000000000001p -5.0515440000000002e-07 158.0625p -4.9488270000000005e-07 158.07499999999999p -4.842954e-07 158.08750000000001p -4.7340019999999997e-07 158.09999999999999p -4.6220460000000001e-07 158.11250000000001p -4.5071650000000001e-07 158.125p -4.3894380000000001e-07 158.13749999999999p -4.2689469999999998e-07 158.15000000000001p -4.1457749999999998e-07 158.16249999999999p -4.0200059999999998e-07 158.17500000000001p -3.8917259999999999e-07
+ 158.1875p -3.7610240000000001e-07 158.20000000000002p -3.6279869999999999e-07 158.21250000000001p -3.4927050000000002e-07 158.22499999999999p -3.3552700000000001e-07 158.23749999999998p -3.215773e-07 158.25p -3.0743089999999998e-07 158.26249999999999p -2.9309710000000001e-07 158.27500000000001p -2.7858559999999998e-07 158.28749999999999p -2.6390589999999999e-07 158.30000000000001p -2.4906780000000001e-07 158.3125p -2.3408110000000001e-07 158.32499999999999p -2.189556e-07 158.33750000000001p -2.037014e-07 158.34999999999999p -1.883285e-07 158.36250000000001p -1.7284689999999999e-07 158.375p -1.5726679999999999e-07 158.38750000000002p -1.4159839999999999e-07 158.39999999999998p -1.258518e-07
+ 158.41249999999999p -1.100374e-07 158.42500000000001p -9.4165429999999995e-08 158.4375p -7.8246229999999999e-08 158.45000000000002p -6.2290140000000002e-08 158.46250000000001p -4.63075e-08 158.47499999999999p -3.0308680000000001e-08 158.48749999999998p -1.430403e-08 158.5p 1.696078e-09 158.51249999999999p 1.7681300000000001e-08 158.52500000000001p 3.3641310000000003e-08 158.53749999999999p 4.9565799999999998e-08 158.55000000000001p 6.5444460000000001e-08 158.5625p 8.1267069999999998e-08 158.57499999999999p 9.7023390000000007e-08 158.58750000000001p 1.127033e-07 158.59999999999999p 1.2829660000000001e-07 158.61250000000001p 1.4379320000000001e-07 158.625p 1.5918330000000001e-07
+ 158.63750000000002p 1.7445670000000001e-07 158.64999999999998p 1.896038e-07 158.66249999999999p 2.0461459999999999e-07 158.67500000000001p 2.1947949999999999e-07 158.6875p 2.3418889999999999e-07 158.70000000000002p 2.4873329999999998e-07 158.71250000000001p 2.6310319999999998e-07 158.72500000000002p 2.7728940000000001e-07 158.73749999999998p 2.912827e-07 158.75p 3.0507389999999998e-07 158.76249999999999p 3.1865429999999999e-07 158.77500000000001p 3.3201480000000001e-07 158.78749999999999p 3.4514690000000002e-07 158.80000000000001p 3.58042e-07 158.8125p 3.7069180000000001e-07 158.82499999999999p 3.8308789999999998e-07 158.83750000000001p 3.9522229999999999e-07 158.84999999999999p 4.0708709999999999e-07
+ 158.86250000000001p 4.1867449999999999e-07 158.875p 4.2997690000000002e-07 158.88750000000002p 4.4098690000000001e-07 158.89999999999998p 4.5169739999999999e-07 158.91249999999999p 4.621012e-07 158.92499999999998p 4.7219149999999998e-07 158.9375p 4.8196160000000004e-07 158.95000000000002p 4.9140519999999998e-07 158.96250000000001p 5.0051600000000003e-07 158.97500000000002p 5.0928800000000003e-07 158.98749999999998p 5.1771529999999995e-07 159p 5.2579230000000003e-07 159.01249999999999p 5.3351369999999999e-07 159.02500000000001p 5.4087439999999997e-07 159.03749999999999p 5.4786940000000004e-07 159.05000000000001p 5.5449410000000003e-07 159.0625p 5.6074389999999999e-07 159.07499999999999p 5.6661489999999995e-07
+ 159.08750000000001p 5.7210290000000003e-07 159.09999999999999p 5.7720429999999999e-07 159.11250000000001p 5.8191569999999998e-07 159.125p 5.862338e-07 159.13750000000002p 5.9015580000000005e-07 159.14999999999998p 5.9367890000000004e-07 159.16249999999999p 5.9680090000000003e-07 159.17499999999998p 5.995194e-07 159.1875p 6.0183279999999998e-07 159.20000000000002p 6.0373929999999998e-07 159.21250000000001p 6.0523770000000001e-07 159.22500000000002p 6.0632700000000003e-07 159.23749999999998p 6.0700620000000001e-07 159.25p 6.0727500000000004e-07 159.26249999999999p 6.0713320000000003e-07 159.27500000000001p 6.0658070000000002e-07 159.28749999999999p 6.0561800000000004e-07 159.30000000000001p 6.0424570000000005e-07
+ 159.3125p 6.0246459999999997e-07 159.32499999999999p 6.0027599999999997e-07 159.33750000000001p 5.976812e-07 159.34999999999999p 5.9468220000000002e-07 159.36250000000001p 5.9128090000000002e-07 159.375p 5.8747949999999995e-07 159.38750000000002p 5.8328080000000001e-07 159.39999999999998p 5.7868750000000004e-07 159.41249999999999p 5.737028e-07 159.42499999999998p 5.6833010000000005e-07 159.4375p 5.6257309999999996e-07 159.44999999999999p 5.5643580000000004e-07 159.46250000000001p 5.4992239999999996e-07 159.47500000000002p 5.4303730000000002e-07 159.48749999999998p 5.357854e-07 159.5p 5.2817159999999998e-07 159.51249999999999p 5.2020129999999996e-07 159.52500000000001p 5.1187989999999996e-07
+ 159.53749999999999p 5.0321329999999997e-07 159.55000000000001p 4.9420740000000002e-07 159.5625p 4.8486860000000003e-07 159.57499999999999p 4.7520330000000003e-07 159.58750000000001p 4.6521830000000001e-07 159.59999999999999p 4.5492060000000001e-07 159.61250000000001p 4.4431739999999999e-07 159.625p 4.3341610000000001e-07 159.63750000000002p 4.222244e-07 159.65000000000001p 4.1075e-07 159.66249999999999p 3.9900099999999999e-07 159.67499999999998p 3.8698580000000001e-07 159.6875p 3.747127e-07 159.69999999999999p 3.6219040000000001e-07 159.71250000000001p 3.494276e-07 159.72500000000002p 3.364334e-07 159.73749999999998p 3.2321699999999998e-07 159.75p 3.097876e-07
+ 159.76249999999999p 2.9615470000000002e-07 159.77500000000001p 2.8232800000000001e-07 159.78749999999999p 2.6831710000000003e-07 159.80000000000001p 2.5413200000000002e-07 159.8125p 2.3978279999999999e-07 159.82499999999999p 2.2527940000000001e-07 159.83750000000001p 2.1063230000000001e-07 159.84999999999999p 1.958516e-07 159.86250000000001p 1.8094799999999999e-07 159.875p 1.659318e-07 159.88750000000002p 1.5081369999999999e-07 159.90000000000001p 1.356044e-07 159.91249999999999p 1.203147e-07 159.92499999999998p 1.049552e-07 159.9375p 8.9536909999999994e-08 159.94999999999999p 7.4070640000000006e-08 159.96250000000001p 5.8567309999999997e-08 159.97499999999999p 4.3037850000000003e-08
+ 159.98750000000001p 2.7493190000000001e-08 160p 1.1944279999999999e-08 160.01249999999999p -3.5979469999999998e-09 160.02500000000001p -1.9122560000000001e-08 160.03749999999999p -3.4618650000000001e-08 160.05000000000001p -5.0075350000000002e-08 160.0625p -6.5481819999999999e-08 160.07499999999999p -8.082727e-08 160.08749999999998p -9.6100980000000002e-08 160.09999999999999p -1.112923e-07 160.11250000000001p -1.263905e-07 160.125p -1.413852e-07 160.13750000000002p -1.56266e-07 160.15000000000001p -1.710224e-07 160.16249999999999p -1.856442e-07 160.17499999999998p -2.0012139999999999e-07 160.1875p -2.1444400000000001e-07 160.19999999999999p -2.2860190000000001e-07
+ 160.21250000000001p -2.4258559999999998e-07 160.22499999999999p -2.5638540000000002e-07 160.23750000000001p -2.6999180000000002e-07 160.25p -2.8339559999999998e-07 160.26249999999999p -2.9658760000000001e-07 160.27500000000001p -3.0955880000000002e-07 160.28749999999999p -3.2230049999999998e-07 160.30000000000001p -3.3480400000000001e-07 160.3125p -3.4706090000000002e-07 160.32500000000002p -3.5906300000000002e-07 160.33749999999998p -3.708022e-07 160.34999999999999p -3.8227079999999998e-07 160.36250000000001p -3.934611e-07 160.375p -4.0436569999999998e-07 160.38750000000002p -4.1497740000000002e-07 160.40000000000001p -4.2528930000000002e-07 160.41249999999999p -4.3529469999999998e-07 160.42499999999998p -4.4498699999999999e-07
+ 160.4375p -4.5436009999999999e-07 160.44999999999999p -4.6340780000000001e-07 160.46250000000001p -4.7212449999999999e-07 160.47499999999999p -4.805047e-07 160.48750000000001p -4.8854299999999998e-07 160.5p -4.9623459999999995e-07 160.51249999999999p -5.0357449999999997e-07 160.52500000000001p -5.1055850000000005e-07 160.53749999999999p -5.1718220000000002e-07 160.55000000000001p -5.2344159999999996e-07 160.5625p -5.293332e-07 160.57500000000002p -5.3485350000000005e-07 160.58749999999998p -5.3999930000000002e-07 160.59999999999999p -5.4476780000000004e-07 160.61250000000001p -5.4915639999999999e-07 160.625p -5.5316269999999996e-07 160.63750000000002p -5.5678480000000003e-07 160.65000000000001p -5.600208e-07
+ 160.66250000000002p -5.6286920000000002e-07 160.67499999999998p -5.6532879999999998e-07 160.6875p -5.6739870000000001e-07 160.69999999999999p -5.6907809999999995e-07 160.71250000000001p -5.7036680000000003e-07 160.72499999999999p -5.7126439999999997e-07 160.73750000000001p -5.717712e-07 160.75p -5.718876e-07 160.76249999999999p -5.7161429999999995e-07 160.77500000000001p -5.7095210000000001e-07 160.78749999999999p -5.6990230000000002e-07 160.80000000000001p -5.6846640000000002e-07 160.8125p -5.6664610000000005e-07 160.82500000000002p -5.644433e-07 160.83749999999998p -5.6186029999999995e-07 160.84999999999999p -5.5889959999999999e-07 160.86249999999998p -5.5556399999999998e-07 160.875p -5.5185630000000004e-07
+ 160.88750000000002p -5.4777990000000001e-07 160.90000000000001p -5.4333820000000003e-07 160.91250000000002p -5.3853500000000002e-07 160.92499999999998p -5.3337399999999997e-07 160.9375p -5.2785960000000005e-07 160.94999999999999p -5.2199600000000004e-07 160.96250000000001p -5.1578799999999999e-07 160.97499999999999p -5.092403e-07 160.98750000000001p -5.0235799999999995e-07 161p -4.9514620000000002e-07 161.01249999999999p -4.8761060000000002e-07 161.02500000000001p -4.7975659999999995e-07 161.03749999999999p -4.7159029999999998e-07 161.05000000000001p -4.6311750000000002e-07 161.0625p -4.5434459999999999e-07 161.07500000000002p -4.4527779999999999e-07 161.08749999999998p -4.3592390000000001e-07 161.09999999999999p -4.2628960000000002e-07
+ 161.11249999999998p -4.163817e-07 161.125p -4.0620739999999997e-07 161.13750000000002p -3.9577380000000002e-07 161.15000000000001p -3.8508849999999997e-07 161.16250000000002p -3.741588e-07 161.17499999999998p -3.6299250000000001e-07 161.1875p -3.5159749999999998e-07 161.19999999999999p -3.3998149999999999e-07 161.21250000000001p -3.2815269999999998e-07 161.22499999999999p -3.161194e-07 161.23750000000001p -3.0388959999999998e-07 161.25p -2.91472e-07 161.26249999999999p -2.788749e-07 161.27500000000001p -2.6610710000000001e-07 161.28749999999999p -2.5317710000000001e-07 161.30000000000001p -2.4009389999999999e-07 161.3125p -2.268662e-07 161.32500000000002p -2.1350290000000001e-07
+ 161.33750000000001p -2.0001319999999999e-07 161.34999999999999p -1.864061e-07 161.36249999999998p -1.7269069999999999e-07 161.375p -1.588763e-07 161.38749999999999p -1.4497200000000001e-07 161.40000000000001p -1.309871e-07 161.41250000000002p -1.16931e-07 161.42499999999998p -1.028131e-07 161.4375p -8.8642609999999997e-08 161.44999999999999p -7.4429039999999997e-08 161.46250000000001p -6.0181770000000002e-08 161.47499999999999p -4.5910229999999999e-08 161.48750000000001p -3.1623829999999998e-08 161.5p -1.7332009999999999e-08 161.51249999999999p -3.0441750000000002e-09 161.52500000000001p 1.123028e-08 161.53749999999999p 2.548196e-08 161.55000000000001p 3.970152e-08
+ 161.5625p 5.3879620000000001e-08 161.57500000000002p 6.8006980000000002e-08 161.58750000000001p 8.2074349999999997e-08 161.59999999999999p 9.6072509999999999e-08 161.61249999999998p 1.099923e-07 161.625p 1.2382470000000001e-07 161.63749999999999p 1.375606e-07 161.65000000000001p 1.5119099999999999e-07 161.66250000000002p 1.6470710000000001e-07 161.67499999999998p 1.7810010000000001e-07 161.6875p 1.9136110000000001e-07 161.69999999999999p 2.0448169999999999e-07 161.71250000000001p 2.1745319999999999e-07 161.72499999999999p 2.3026719999999999e-07 161.73750000000001p 2.429153e-07 161.75p 2.5538940000000001e-07 161.76249999999999p 2.6768129999999998e-07 161.77500000000001p 2.7978300000000001e-07
+ 161.78749999999999p 2.9168669999999998e-07 161.80000000000001p 3.0338450000000003e-07 161.8125p 3.1486899999999999e-07 161.82500000000002p 3.2613259999999998e-07 161.83750000000001p 3.3716799999999999e-07 161.84999999999999p 3.4796800000000001e-07 161.86249999999998p 3.5852569999999999e-07 161.875p 3.6883419999999999e-07 161.88749999999999p 3.7888670000000002e-07 161.90000000000001p 3.886767e-07 161.91249999999999p 3.98198e-07 161.92500000000001p 4.0744419999999999e-07 161.9375p 4.164094e-07 161.94999999999999p 4.2508780000000002e-07 161.96250000000001p 4.334737e-07 161.97499999999999p 4.4156170000000002e-07 161.98750000000001p 4.4934649999999999e-07 162p 4.568232e-07
+ 162.01249999999999p 4.6398670000000001e-07 162.02499999999998p 4.708326e-07 162.03749999999999p 4.773564e-07 162.05000000000001p 4.8355380000000003e-07 162.0625p 4.8942090000000003e-07 162.07500000000002p 4.9495380000000004e-07 162.08750000000001p 5.0014899999999996e-07 162.09999999999999p 5.050032e-07 162.11249999999998p 5.0951319999999998e-07 162.125p 5.1367620000000001e-07 162.13749999999999p 5.1748950000000005e-07 162.15000000000001p 5.2095060000000002e-07 162.16249999999999p 5.2405749999999998e-07 162.17500000000001p 5.2680799999999999e-07 162.1875p 5.2920060000000001e-07 162.19999999999999p 5.3123379999999999e-07 162.21250000000001p 5.329063e-07 162.22499999999999p 5.3421720000000004e-07
+ 162.23750000000001p 5.3516560000000002e-07 162.25p 5.3575109999999998e-07 162.26250000000002p 5.3597350000000004e-07 162.27499999999998p 5.3583269999999995e-07 162.28749999999999p 5.3532909999999998e-07 162.30000000000001p 5.3446299999999996e-07 162.3125p 5.3323509999999999e-07 162.32500000000002p 5.3164659999999997e-07 162.33750000000001p 5.2969859999999999e-07 162.34999999999999p 5.2739259999999997e-07 162.36249999999998p 5.2473039999999998e-07 162.375p 5.2171369999999995e-07 162.38749999999999p 5.1834499999999995e-07 162.40000000000001p 5.1462660000000005e-07 162.41249999999999p 5.1056130000000004e-07 162.42500000000001p 5.0615190000000003e-07 162.4375p 5.014017e-07 162.44999999999999p 4.9631399999999998e-07
+ 162.46250000000001p 4.9089239999999999e-07 162.47499999999999p 4.8514099999999999e-07 162.48750000000001p 4.7906370000000003e-07 162.5p 4.7266489999999999e-07 162.51250000000002p 4.6594909999999998e-07 162.52499999999998p 4.589211e-07 162.53749999999999p 4.5158599999999998e-07 162.54999999999998p 4.4394879999999999e-07 162.5625p 4.3601510000000002e-07 162.57500000000002p 4.2779050000000001e-07 162.58750000000001p 4.1928069999999998e-07 162.60000000000002p 4.1049189999999998e-07 162.61249999999998p 4.014302e-07 162.625p 3.9210210000000002e-07 162.63749999999999p 3.825141e-07 162.65000000000001p 3.7267299999999999e-07 162.66249999999999p 3.6258590000000002e-07 162.67500000000001p 3.5225980000000002e-07
+ 162.6875p 3.4170209999999999e-07 162.69999999999999p 3.3092009999999999e-07 162.71250000000001p 3.199216e-07 162.72499999999999p 3.087142e-07 162.73750000000001p 2.97306e-07 162.75p 2.85705e-07 162.76250000000002p 2.7391930000000001e-07 162.77499999999998p 2.6195720000000001e-07 162.78749999999999p 2.4982730000000001e-07 162.79999999999998p 2.3753810000000001e-07 162.8125p 2.2509820000000001e-07 162.82500000000002p 2.1251639999999999e-07 162.83750000000001p 1.9980149999999999e-07 162.85000000000002p 1.8696260000000001e-07 162.86249999999998p 1.7400860000000001e-07 162.875p 1.6094880000000001e-07 162.88749999999999p 1.477921e-07 162.90000000000001p 1.3454799999999999e-07
+ 162.91249999999999p 1.2122560000000001e-07 162.92500000000001p 1.0783440000000001e-07 162.9375p 9.4383780000000003e-08 162.94999999999999p 8.0883090000000006e-08 162.96250000000001p 6.7341820000000004e-08 162.97499999999999p 5.3769450000000001e-08 162.98750000000001p 4.0175460000000002e-08 163p 2.656934e-08 163.01250000000002p 1.2960589999999999e-08 163.02499999999998p -6.4130120000000002e-10 163.03749999999999p -1.4226870000000001e-08 163.04999999999998p -2.778667e-08 163.0625p -4.1311280000000002e-08 163.07500000000002p -5.479132e-08 163.08750000000001p -6.8217459999999996e-08 163.10000000000002p -8.1580390000000005e-08 163.11249999999998p -9.4870909999999994e-08 163.125p -1.080798e-07
+ 163.13749999999999p -1.2119809999999999e-07 163.15000000000001p -1.3421659999999999e-07 163.16249999999999p -1.471265e-07 163.17500000000001p -1.599189e-07 163.1875p -1.725851e-07 163.19999999999999p -1.851164e-07 163.21250000000001p -1.9750439999999999e-07 163.22499999999999p -2.0974050000000001e-07 163.23750000000001p -2.2181649999999999e-07 163.25p -2.3372430000000001e-07 163.26250000000002p -2.4545579999999999e-07 163.27500000000001p -2.570032e-07 163.28749999999999p -2.6835860000000001e-07 163.29999999999998p -2.7951450000000001e-07 163.3125p -2.9046350000000001e-07 163.32499999999999p -3.0119820000000001e-07 163.33750000000001p -3.117117e-07 163.35000000000002p -3.2199689999999998e-07
+ 163.36249999999998p -3.3204699999999998e-07 163.375p -3.4185559999999999e-07 163.38749999999999p -3.5141619999999999e-07 163.40000000000001p -3.6072270000000002e-07 163.41249999999999p -3.6976889999999999e-07 163.42500000000001p -3.7854909999999998e-07 163.4375p -3.8705779999999999e-07 163.44999999999999p -3.9528939999999998e-07 163.46250000000001p -4.032387e-07 163.47499999999999p -4.1090089999999999e-07 163.48750000000001p -4.1827099999999997e-07 163.5p -4.2534459999999998e-07 163.51250000000002p -4.3211740000000003e-07 163.52500000000001p -4.3858510000000002e-07 163.53749999999999p -4.4474390000000001e-07 163.54999999999998p -4.5059010000000001e-07 163.5625p -4.5612030000000001e-07 163.57499999999999p -4.6133130000000002e-07
+ 163.58750000000001p -4.6622009999999999e-07 163.60000000000002p -4.707839e-07 163.61250000000001p -4.750203e-07 163.625p -4.789268e-07 163.63749999999999p -4.8250160000000002e-07 163.65000000000001p -4.8574269999999995e-07 163.66249999999999p -4.8864870000000002e-07 163.67500000000001p -4.9121800000000002e-07 163.6875p -4.9344980000000003e-07 163.69999999999999p -4.9534290000000002e-07 163.71250000000001p -4.9689690000000004e-07 163.72499999999999p -4.9811129999999996e-07 163.73750000000001p -4.9898600000000005e-07 163.75p -4.9952090000000005e-07 163.76250000000002p -4.9971649999999999e-07 163.77500000000001p -4.9957309999999999e-07 163.78749999999999p -4.9909169999999998e-07 163.79999999999998p -4.9827299999999995e-07
+ 163.8125p -4.9711849999999995e-07 163.82499999999999p -4.9562939999999999e-07 163.83750000000001p -4.9380739999999999e-07 163.84999999999999p -4.9165439999999996e-07 163.86250000000001p -4.891725e-07 163.875p -4.8636399999999997e-07 163.88749999999999p -4.8323139999999996e-07 163.90000000000001p -4.7977740000000002e-07 163.91249999999999p -4.7600490000000001e-07 163.92500000000001p -4.7191710000000002e-07 163.9375p -4.6751739999999999e-07 163.95000000000002p -4.6280920000000001e-07 163.96249999999998p -4.5779630000000001e-07 163.97499999999999p -4.5248269999999999e-07 163.98750000000001p -4.4687230000000001e-07 164p -4.4096959999999999e-07 164.01250000000002p -4.3477900000000001e-07 164.02500000000001p -4.2830510000000001e-07
+ 164.03749999999999p -4.215529e-07 164.04999999999998p -4.145272e-07 164.0625p -4.0723329999999998e-07 164.07499999999999p -3.996765e-07 164.08750000000001p -3.9186229999999999e-07 164.09999999999999p -3.8379620000000002e-07 164.11250000000001p -3.7548420000000001e-07 164.125p -3.669322e-07 164.13749999999999p -3.5814619999999999e-07 164.15000000000001p -3.4913250000000002e-07 164.16249999999999p -3.3989730000000002e-07 164.17500000000001p -3.304473e-07 164.1875p -3.2078889999999998e-07 164.20000000000002p -3.1092900000000002e-07 164.21249999999998p -3.0087439999999999e-07 164.22499999999999p -2.90632e-07 164.23750000000001p -2.8020879999999998e-07 164.25p -2.6961209999999998e-07
+ 164.26250000000002p -2.5884909999999998e-07 164.27500000000001p -2.4792709999999999e-07 164.28749999999999p -2.3685359999999999e-07 164.29999999999998p -2.2563609999999999e-07 164.3125p -2.1428229999999999e-07 164.32499999999999p -2.0279959999999999e-07 164.33750000000001p -1.9119599999999999e-07 164.34999999999999p -1.794792e-07 164.36250000000001p -1.676571e-07 164.375p -1.5573759999999999e-07 164.38749999999999p -1.437287e-07 164.40000000000001p -1.3163830000000001e-07 164.41249999999999p -1.1947449999999999e-07 164.42500000000001p -1.072454e-07 164.4375p -9.4959189999999998e-08 164.45000000000002p -8.2623899999999994e-08 164.46249999999998p -7.0247729999999995e-08 164.47499999999999p -5.7838849999999998e-08
+ 164.48749999999998p -4.5405440000000003e-08 164.5p -3.2955699999999998e-08 164.51250000000002p -2.0497810000000002e-08 164.52500000000001p -8.0399710000000002e-09 164.53750000000002p 4.409654e-09 164.54999999999998p 1.6842899999999999e-08 164.5625p 2.9251610000000001e-08 164.57499999999999p 4.1627679999999998e-08 164.58750000000001p 5.3963010000000001e-08 164.59999999999999p 6.624954e-08 164.61250000000001p 7.8479250000000004e-08 164.625p 9.0644169999999996e-08 164.63749999999999p 1.027364e-07 164.65000000000001p 1.147479e-07 164.66249999999999p 1.266711e-07 164.67500000000001p 1.3849809999999999e-07 164.6875p 1.5022119999999999e-07 164.70000000000002p 1.6183280000000001e-07
+ 164.71249999999998p 1.7332539999999999e-07 164.72499999999999p 1.8469139999999999e-07 164.73749999999998p 1.9592360000000001e-07 164.75p 2.0701449999999999e-07 164.76250000000002p 2.1795709999999999e-07 164.77500000000001p 2.2874420000000001e-07 164.78750000000002p 2.3936889999999999e-07 164.79999999999998p 2.4982409999999999e-07 164.8125p 2.6010330000000001e-07 164.82499999999999p 2.701996e-07 164.83750000000001p 2.8010649999999999e-07 164.84999999999999p 2.8981760000000001e-07 164.86250000000001p 2.9932670000000001e-07 164.875p 3.0862760000000001e-07 164.88749999999999p 3.1771419999999999e-07 164.90000000000001p 3.2658060000000001e-07 164.91249999999999p 3.3522110000000003e-07 164.92500000000001p 3.436302e-07
+ 164.9375p 3.5180229999999999e-07 164.95000000000002p 3.597321e-07 164.96249999999998p 3.6741469999999998e-07 164.97499999999999p 3.7484479999999998e-07 164.98749999999998p 3.8201789999999998e-07 165p 3.8892909999999999e-07 165.01249999999999p 3.9557409999999998e-07 165.02500000000001p 4.0194860000000003e-07 165.03750000000002p 4.0804840000000002e-07 165.04999999999998p 4.1386960000000002e-07 165.0625p 4.1940839999999999e-07 165.07499999999999p 4.246613e-07 165.08750000000001p 4.2962489999999999e-07 165.09999999999999p 4.3429610000000001e-07 165.11250000000001p 4.3867170000000002e-07 165.125p 4.4274899999999999e-07 165.13749999999999p 4.465255e-07 165.15000000000001p 4.4999859999999998e-07
+ 165.16249999999999p 4.5316620000000001e-07 165.17500000000001p 4.5602640000000001e-07 165.1875p 4.5857719999999998e-07 165.20000000000002p 4.6081709999999998e-07 165.21250000000001p 4.6274480000000002e-07 165.22499999999999p 4.6435899999999998e-07 165.23749999999998p 4.6565879999999999e-07 165.25p 4.6664349999999999e-07 165.26249999999999p 4.6731239999999999e-07 165.27500000000001p 4.6766539999999999e-07 165.28750000000002p 4.6770220000000003e-07 165.29999999999998p 4.6742290000000002e-07 165.3125p 4.6682790000000001e-07 165.32499999999999p 4.659177e-07 165.33750000000001p 4.6469309999999998e-07 165.34999999999999p 4.6315499999999999e-07 165.36250000000001p 4.613045e-07 165.375p 4.59143e-07
+ 165.38749999999999p 4.566723e-07 165.40000000000001p 4.5389390000000001e-07 165.41249999999999p 4.5081e-07 165.42500000000001p 4.4742280000000001e-07 165.4375p 4.4373470000000002e-07 165.45000000000002p 4.3974840000000002e-07 165.46250000000001p 4.3546670000000001e-07 165.47499999999999p 4.3089260000000002e-07 165.48749999999998p 4.260294e-07 165.5p 4.208806e-07 165.51249999999999p 4.1544979999999999e-07 165.52500000000001p 4.097409e-07 165.53750000000002p 4.0375780000000002e-07 165.55000000000001p 3.9750489999999999e-07 165.5625p 3.909864e-07 165.57499999999999p 3.8420709999999999e-07 165.58750000000001p 3.771718e-07 165.59999999999999p 3.6988519999999999e-07
+ 165.61250000000001p 3.6235270000000001e-07 165.625p 3.5457949999999998e-07 165.63749999999999p 3.4657099999999999e-07 165.65000000000001p 3.3833300000000002e-07 165.66249999999999p 3.2987119999999999e-07 165.67500000000001p 3.2119150000000002e-07 165.6875p 3.123001e-07 165.70000000000002p 3.0320330000000002e-07 165.71250000000001p 2.9390730000000002e-07 165.72499999999999p 2.8441879999999999e-07 165.73749999999998p 2.7474440000000001e-07 165.75p 2.6489090000000002e-07 165.76249999999999p 2.548653e-07 165.77500000000001p 2.446745e-07 165.78749999999999p 2.343257e-07 165.80000000000001p 2.2382630000000001e-07 165.8125p 2.1318340000000001e-07 165.82499999999999p 2.0240480000000001e-07
+ 165.83750000000001p 1.914978e-07 165.84999999999999p 1.8047009999999999e-07 165.86250000000001p 1.6932950000000001e-07 165.875p 1.580837e-07 165.88750000000002p 1.467407e-07 165.89999999999998p 1.3530830000000001e-07 165.91249999999999p 1.237947e-07 165.92500000000001p 1.122077e-07 165.9375p 1.005555e-07 165.95000000000002p 8.8846349999999999e-08 165.96250000000001p 7.7088290000000002e-08 165.97499999999999p 6.5289560000000003e-08 165.98749999999998p 5.345839e-08 166p 4.1603010000000002e-08 166.01249999999999p 2.9731669999999999e-08 166.02500000000001p 1.7852629999999999e-08 166.03749999999999p 5.9741530000000002e-09 166.05000000000001p -5.8955289999999999e-09
+ 166.0625p -1.7748179999999999e-08 166.07499999999999p -2.9575590000000001e-08 166.08750000000001p -4.1369570000000001e-08 166.09999999999999p -5.3121970000000001e-08 166.11250000000001p -6.4824680000000004e-08 166.125p -7.6469630000000004e-08 166.13750000000002p -8.8048799999999999e-08 166.14999999999998p -9.9554219999999997e-08 166.16249999999999p -1.10978e-07 166.17500000000001p -1.2231229999999999e-07 166.1875p -1.335494e-07 166.20000000000002p -1.4468150000000001e-07 166.21250000000001p -1.5570109999999999e-07 166.22500000000002p -1.6660080000000001e-07 166.23749999999998p -1.7737300000000001e-07 166.25p -1.880104e-07 166.26249999999999p -1.9850599999999999e-07 166.27500000000001p -2.0885250000000001e-07
+ 166.28749999999999p -2.1904300000000001e-07 166.30000000000001p -2.2907060000000001e-07 166.3125p -2.3892869999999998e-07 166.32499999999999p -2.486107e-07 166.33750000000001p -2.5811000000000003e-07 166.34999999999999p -2.6742040000000002e-07 166.36250000000001p -2.7653559999999999e-07 166.375p -2.8544980000000002e-07 166.38750000000002p -2.9415690000000001e-07 166.39999999999998p -3.0265129999999998e-07 166.41249999999999p -3.1092739999999998e-07 166.42499999999998p -3.1897990000000002e-07 166.4375p -3.2680339999999999e-07 166.45000000000002p -3.3439309999999999e-07 166.46250000000001p -3.417439e-07 166.47500000000002p -3.4885120000000002e-07 166.48749999999998p -3.5571040000000002e-07 166.5p -3.6231729999999998e-07
+ 166.51249999999999p -3.686677e-07 166.52500000000001p -3.7475749999999999e-07 166.53749999999999p -3.805832e-07 166.55000000000001p -3.8614100000000002e-07 166.5625p -3.9142759999999998e-07 166.57499999999999p -3.9643969999999999e-07 166.58750000000001p -4.011745e-07 166.59999999999999p -4.0562909999999998e-07 166.61250000000001p -4.0980090000000001e-07 166.625p -4.1368760000000002e-07 166.63750000000002p -4.1728689999999998e-07 166.64999999999998p -4.2059690000000003e-07 166.66249999999999p -4.2361579999999999e-07 166.67499999999998p -4.2634199999999999e-07 166.6875p -4.2877419999999998e-07 166.70000000000002p -4.309112e-07 166.71250000000001p -4.3275200000000001e-07 166.72500000000002p -4.3429590000000002e-07
+ 166.73749999999998p -4.3554250000000001e-07 166.75p -4.3649120000000002e-07 166.76249999999999p -4.3714200000000001e-07 166.77500000000001p -4.3749500000000001e-07 166.78749999999999p -4.3755050000000001e-07 166.80000000000001p -4.3730890000000002e-07 166.8125p -4.367708e-07 166.82499999999999p -4.3593730000000002e-07 166.83750000000001p -4.3480930000000002e-07 166.84999999999999p -4.3338819999999997e-07 166.86250000000001p -4.3167530000000001e-07 166.875p -4.2967239999999998e-07 166.88750000000002p -4.273814e-07 166.89999999999998p -4.2480419999999998e-07 166.91249999999999p -4.219431e-07 166.92499999999998p -4.1880060000000002e-07 166.9375p -4.1537920000000001e-07 166.94999999999999p -4.1168160000000002e-07
+ 166.96250000000001p -4.0771100000000002e-07 166.97500000000002p -4.0347040000000002e-07 166.98749999999998p -3.9896309999999999e-07 167p -3.9419260000000002e-07 167.01249999999999p -3.8916259999999998e-07 167.02500000000001p -3.838769e-07 167.03749999999999p -3.7833939999999998e-07 167.05000000000001p -3.7255430000000002e-07 167.0625p -3.665258e-07 167.07499999999999p -3.6025849999999998e-07 167.08750000000001p -3.537568e-07 167.09999999999999p -3.4702559999999998e-07 167.11250000000001p -3.4006970000000002e-07 167.125p -3.3289410000000001e-07 167.13750000000002p -3.25504e-07 167.15000000000001p -3.1790460000000002e-07 167.16249999999999p -3.101014e-07 167.17499999999998p -3.020998e-07
+ 167.1875p -2.939055e-07 167.19999999999999p -2.8552430000000001e-07 167.21250000000001p -2.7696210000000001e-07 167.22500000000002p -2.682247e-07 167.23749999999998p -2.5931839999999999e-07 167.25p -2.5024920000000002e-07 167.26249999999999p -2.4102350000000001e-07 167.27500000000001p -2.3164759999999999e-07 167.28749999999999p -2.2212799999999999e-07 167.30000000000001p -2.1247109999999999e-07 167.3125p -2.0268369999999999e-07 167.32499999999999p -1.927723e-07 167.33750000000001p -1.827438e-07 167.34999999999999p -1.72605e-07 167.36250000000001p -1.6236259999999999e-07 167.375p -1.520238e-07 167.38750000000002p -1.4159539999999999e-07 167.40000000000001p -1.310845e-07
+ 167.41249999999999p -1.2049809999999999e-07 167.42499999999998p -1.0984339999999999e-07 167.4375p -9.9127589999999994e-08 167.44999999999999p -8.8357730000000003e-08 167.46250000000001p -7.7541080000000005e-08 167.47499999999999p -6.668486e-08 167.48750000000001p -5.5796300000000002e-08 167.5p -4.4882660000000003e-08 167.51249999999999p -3.3951200000000002e-08 167.52500000000001p -2.3009179999999999e-08 167.53749999999999p -1.206385e-08 167.55000000000001p -1.122476e-09 167.5625p 9.8077049999999995e-09 167.57499999999999p 2.071946e-08 167.58749999999998p 3.160559e-08 167.59999999999999p 4.2458899999999998e-08 167.61250000000001p 5.3272239999999999e-08 167.625p 6.4038480000000002e-08
+ 167.63750000000002p 7.4750529999999995e-08 167.65000000000001p 8.5401359999999994e-08 167.66249999999999p 9.5983949999999998e-08 167.67499999999998p 1.0649140000000001e-07 167.6875p 1.169167e-07 167.69999999999999p 1.272531e-07 167.71250000000001p 1.3749379999999999e-07 167.72499999999999p 1.476321e-07 167.73750000000001p 1.5766139999999999e-07 167.75p 1.6757510000000001e-07 167.76249999999999p 1.773667e-07 167.77500000000001p 1.8702979999999999e-07 167.78749999999999p 1.965581e-07 167.80000000000001p 2.059454e-07 167.8125p 2.1518549999999999e-07 167.82500000000002p 2.242725e-07 167.83749999999998p 2.332003e-07 167.84999999999999p 2.4196329999999998e-07
+ 167.86250000000001p 2.5055560000000002e-07 167.875p 2.5897170000000002e-07 167.88750000000002p 2.6720600000000002e-07 167.90000000000001p 2.7525329999999999e-07 167.91249999999999p 2.8310840000000002e-07 167.92499999999998p 2.90766e-07 167.9375p 2.9822119999999999e-07 167.94999999999999p 3.054693e-07 167.96250000000001p 3.1250540000000003e-07 167.97499999999999p 3.1932500000000001e-07 167.98750000000001p 3.2592380000000002e-07 168p 3.3229740000000002e-07 168.01249999999999p 3.3844169999999998e-07 168.02500000000001p 3.4435279999999998e-07 168.03749999999999p 3.500268e-07 168.05000000000001p 3.5545999999999998e-07 168.0625p 3.6064910000000001e-07 168.07500000000002p 3.6559059999999999e-07
+ 168.08749999999998p 3.702814e-07 168.09999999999999p 3.7471850000000002e-07 168.11250000000001p 3.788991e-07 168.125p 3.828204e-07 168.13750000000002p 3.8648e-07 168.15000000000001p 3.8987570000000001e-07 168.16250000000002p 3.930052e-07 168.17499999999998p 3.9586650000000002e-07 168.1875p 3.9845810000000003e-07 168.19999999999999p 4.0077810000000001e-07 168.21250000000001p 4.0282530000000001e-07 168.22499999999999p 4.0459829999999998e-07 168.23750000000001p 4.0609629999999999e-07 168.25p 4.0731820000000001e-07 168.26249999999999p 4.0826339999999998e-07 168.27500000000001p 4.0893139999999999e-07 168.28749999999999p 4.0932200000000002e-07 168.30000000000001p 4.0943500000000001e-07
+ 168.3125p 4.0927050000000003e-07 168.32500000000002p 4.0882879999999998e-07 168.33749999999998p 4.081103e-07 168.34999999999999p 4.0711569999999997e-07 168.36249999999998p 4.0584570000000002e-07 168.375p 4.0430160000000002e-07 168.38750000000002p 4.0248430000000002e-07 168.40000000000001p 4.003954e-07 168.41250000000002p 3.980364e-07 168.42499999999998p 3.9540899999999999e-07 168.4375p 3.9251530000000002e-07 168.44999999999999p 3.8935729999999999e-07 168.46250000000001p 3.8593740000000002e-07 168.47499999999999p 3.8225799999999998e-07 168.48750000000001p 3.7832190000000003e-07 168.5p 3.7413189999999999e-07 168.51249999999999p 3.6969090000000001e-07 168.52500000000001p 3.6500229999999998e-07
+ 168.53749999999999p 3.6006930000000002e-07 168.55000000000001p 3.5489550000000002e-07 168.5625p 3.4948459999999999e-07 168.57500000000002p 3.438405e-07 168.58749999999998p 3.3796720000000001e-07 168.59999999999999p 3.3186880000000001e-07 168.61249999999998p 3.2554970000000002e-07 168.625p 3.1901450000000001e-07 168.63750000000002p 3.122677e-07 168.65000000000001p 3.0531410000000002e-07 168.66250000000002p 2.9815860000000002e-07 168.67499999999998p 2.9080640000000001e-07 168.6875p 2.8326270000000001e-07 168.69999999999999p 2.7553269999999998e-07 168.71250000000001p 2.6762190000000002e-07 168.72499999999999p 2.5953590000000001e-07 168.73750000000001p 2.5128050000000002e-07 168.75p 2.4286139999999999e-07
+ 168.76249999999999p 2.3428470000000001e-07 168.77500000000001p 2.255562e-07 168.78749999999999p 2.1668230000000001e-07 168.80000000000001p 2.07669e-07 168.8125p 1.9852289999999999e-07 168.82500000000002p 1.8925030000000001e-07 168.83750000000001p 1.7985769999999999e-07 168.84999999999999p 1.7035170000000001e-07 168.86249999999998p 1.6073899999999999e-07 168.875p 1.5102629999999999e-07 168.88749999999999p 1.412205e-07 168.90000000000001p 1.3132839999999999e-07 168.91250000000002p 1.2135699999999999e-07 168.92499999999998p 1.113132e-07 168.9375p 1.01204e-07 168.94999999999999p 9.1036560000000002e-08 168.96250000000001p 8.0817909999999994e-08 168.97499999999999p 7.055519e-08
+ 168.98750000000001p 6.0255550000000003e-08 169p 4.9926179999999998e-08 169.01249999999999p 3.9574250000000001e-08 169.02500000000001p 2.9206959999999999e-08 169.03749999999999p 1.8831519999999999e-08 169.05000000000001p 8.4551050000000007e-09 169.0625p -1.91508e-09 169.07500000000002p -1.2271860000000001e-08 169.08750000000001p -2.2608069999999999e-08 169.09999999999999p -3.2916580000000001e-08 169.11249999999998p -4.3190280000000002e-08 169.125p -5.3422099999999999e-08 169.13749999999999p -6.360498e-08 169.15000000000001p -7.3731939999999996e-08 169.16250000000002p -8.3796040000000004e-08 169.17500000000001p -9.3790379999999997e-08 169.1875p -1.037081e-07 169.19999999999999p -1.135425e-07
+ 169.21250000000001p -1.232868e-07 169.22499999999999p -1.329345e-07 169.23750000000001p -1.424789e-07 169.25p -1.5191350000000001e-07 169.26249999999999p -1.6123209999999999e-07 169.27500000000001p -1.704283e-07 169.28749999999999p -1.7949600000000001e-07 169.30000000000001p -1.88429e-07 169.3125p -1.9722129999999999e-07 169.32500000000002p -2.0586709999999999e-07 169.33750000000001p -2.1436069999999999e-07 169.34999999999999p -2.2269620000000001e-07 169.36249999999998p -2.3086839999999999e-07 169.375p -2.388716e-07 169.38749999999999p -2.467008e-07 169.40000000000001p -2.543506e-07 169.41249999999999p -2.6181619999999998e-07 169.42500000000001p -2.6909259999999999e-07
+ 169.4375p -2.7617519999999998e-07 169.44999999999999p -2.830593e-07 169.46250000000001p -2.8974050000000001e-07 169.47499999999999p -2.962145e-07 169.48750000000001p -3.024772e-07 169.5p -3.0852470000000002e-07 169.51249999999999p -3.1435299999999998e-07 169.52499999999998p -3.1995870000000001e-07 169.53749999999999p -3.2533810000000002e-07 169.55000000000001p -3.304879e-07 169.5625p -3.3540510000000002e-07 169.57500000000002p -3.4008649999999998e-07 169.58750000000001p -3.4452940000000002e-07 169.59999999999999p -3.4873109999999999e-07 169.61249999999998p -3.5268919999999997e-07 169.625p -3.5640129999999999e-07 169.63749999999999p -3.598653e-07 169.65000000000001p -3.6307929999999999e-07
+ 169.66249999999999p -3.660415e-07 169.67500000000001p -3.6875029999999999e-07 169.6875p -3.7120419999999998e-07 169.69999999999999p -3.7340209999999999e-07 169.71250000000001p -3.7534290000000001e-07 169.72499999999999p -3.770257e-07 169.73750000000001p -3.7844969999999997e-07 169.75p -3.7961460000000001e-07 169.76250000000002p -3.8051979999999998e-07 169.77499999999998p -3.8116530000000002e-07 169.78749999999999p -3.8155109999999999e-07 169.80000000000001p -3.8167740000000001e-07 169.8125p -3.8154439999999999e-07 169.82500000000002p -3.8115289999999998e-07 169.83750000000001p -3.805034e-07 169.84999999999999p -3.7959680000000002e-07 169.86249999999998p -3.7843430000000002e-07 169.875p -3.7701699999999999e-07
+ 169.88749999999999p -3.753464e-07 169.90000000000001p -3.7342400000000002e-07 169.91249999999999p -3.7125160000000003e-07 169.92500000000001p -3.6883099999999998e-07 169.9375p -3.6616430000000003e-07 169.94999999999999p -3.6325379999999999e-07 169.96250000000001p -3.6010180000000002e-07 169.97499999999999p -3.5671080000000001e-07 169.98750000000001p -3.5308360000000002e-07)
R_LOAD OUT 0 10
I_IBIAS 0 IBIAS pwl(0p 0 1p 24.5u 2p 24.5u 170p 24.5u)
.tran 0.0125p 170p
.print P(BJs|XBQ) V(BJs|XBQ) I(BJs|XBQ)
.print P(BJL1|XBQ) V(BJL1|XBQ) I(BJL1|XBQ)
.print P(BJL2|XBQ) V(BJL2|XBQ) I(BJL2|XBQ)
.print I(Lin|XBQ) I(L0|XBQ) I(L1|XBQ) I(L2|XBQ) I(RB|XBQ) I(RJ1|XBQ) I(RJ2|XBQ)
.print V(IN) I(V_REPLAY) V(OUT) I(R_LOAD)
.end
