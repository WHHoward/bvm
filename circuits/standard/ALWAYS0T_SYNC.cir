* ALWAYS0T_SYNC — ColdFlux RSFQ Standard Cell
* Source: IARPA SuperTools/ColdFlux Cell Library v3.0
* MIT-LL SFQ Process | JoSIM-compatible
* Ports: a q
* Junctions: 0 total
*
* Bias: 2.6mV DC bias line (resistors calculated per ColdFlux methodology)
* Usage: .include circuits/standard/ALWAYS0T_SYNC.cir
*        .model jjmit jj(rtype=1, vg=2.8m, cap=0.07p, r0=160, rn=16, icrit=0.1m)
*
.subckt THmitll_ALWAYS0T_SYNC a q
.param Lptl=2p
.param L1=Lptl
.param L2=Lptl
.param L3=Lptl
.param R1=2
.param R2=2
.param R3=2
L1 a 1 1.282E-012
L2 clk 2 1.401E-012
L3 3 q 1.428E-012
R1 1 0 R1
R2 2 0 R2
R3 3 0 R3
.ends
