* BVM_LOAD_QB_MATRIX_V1: ideal replay 13ps 8x500 logical0_read
* exact I(B_LD1)(t) from raw/source/13ps/8x500/logical0_read/run-01.csv; no reshape/hold/scale/resample
.include ../../../jjmit.cir
.include ../../../bq_cell.cir
XBQ IN OUT IBIAS BQ
I_REPLAY 0 IN pwl(0p 0 0.012500000000000001p 0 0.025000000000000001p 0 0.037499999999999999p 0 0.050000000000000003p 0 0.0625p 0 0.074999999999999997p 0 0.087500000000000008p 0 0.10000000000000001p 0 0.1125p 0 0.125p 0 0.13749999999999998p 0 0.14999999999999999p 0 0.16249999999999998p 0 0.17500000000000002p 0 0.1875p 0 0.20000000000000001p 0 0.21249999999999999p 0
+ 0.22500000000000001p 0 0.23749999999999999p 0 0.25p 0 0.26250000000000001p 0 0.27499999999999997p 0 0.28749999999999998p 0 0.29999999999999999p 0 0.3125p 0 0.32499999999999996p 0 0.33749999999999997p 0 0.35000000000000003p 0 0.36250000000000004p 0 0.375p 0 0.38750000000000001p 0 0.40000000000000002p 0 0.41250000000000003p 0 0.42499999999999999p 0 0.4375p 0
+ 0.45000000000000001p 0 0.46250000000000002p 0 0.47499999999999998p 0 0.48749999999999999p 0 0.5p 0 0.51249999999999996p 0 0.52500000000000002p 0 0.53749999999999998p 0 0.54999999999999993p 0 0.5625p 0 0.57499999999999996p 0 0.58750000000000002p 0 0.59999999999999998p 0 0.61249999999999993p 0 0.625p 0 0.63749999999999996p 0 0.64999999999999991p 0 0.66249999999999998p 0
+ 0.67499999999999993p 0 0.6875p 0 0.70000000000000007p 0 0.71250000000000002p 0 0.72500000000000009p 0 0.73750000000000004p 0 0.75p 0 0.76250000000000007p 0 0.77500000000000002p 0 0.78749999999999998p 0 0.80000000000000004p 0 0.8125p 0 0.82500000000000007p 0 0.83750000000000002p 0 0.84999999999999998p 0 0.86250000000000004p 0 0.875p 0 0.88749999999999996p 0
+ 0.90000000000000002p 0 0.91249999999999998p 0 0.92500000000000004p 0 0.9375p 0 0.94999999999999996p 0 0.96250000000000002p 0 0.97499999999999998p 0 0.98749999999999993p 0 1p 0 1.0125p 0 1.0249999999999999p 0 1.0374999999999999p 0 1.05p 0 1.0625p 0 1.075p 0 1.0874999999999999p 0 1.0999999999999999p 0 1.1125p 0
+ 1.125p 0 1.1375p 0 1.1499999999999999p 0 1.1624999999999999p 0 1.175p 0 1.1875p 0 1.2p 0 1.2124999999999999p 0 1.2249999999999999p 0 1.2374999999999998p 0 1.25p 0 1.2625p 0 1.2749999999999999p 0 1.2874999999999999p 0 1.2999999999999998p 0 1.3125p 0 1.325p 0 1.3374999999999999p 0
+ 1.3499999999999999p 0 1.3624999999999998p 0 1.375p 0 1.3875000000000002p 0 1.4000000000000001p 0 1.4125000000000001p 0 1.425p 0 1.4375p 0 1.4500000000000002p 0 1.4625000000000001p 0 1.4750000000000001p 0 1.4875p 0 1.5p 0 1.5125000000000002p 0 1.5250000000000001p 0 1.5375000000000001p 0 1.55p 0 1.5625p 0
+ 1.575p 0 1.5875000000000001p 0 1.6000000000000001p 0 1.6125p 0 1.625p 0 1.6375p 0 1.6500000000000001p 0 1.6625000000000001p 0 1.675p 0 1.6875p 0 1.7p 0 1.7125000000000001p 0 1.7250000000000001p 0 1.7375p 0 1.75p 0 1.7625p 0 1.7749999999999999p 0 1.7875000000000001p 0
+ 1.8p 0 1.8125p 0 1.825p 0 1.8375000000000001p 0 1.8625000000000003p 0 1.875p 0 1.8875000000000002p 0 1.8999999999999999p 0 1.9125000000000001p 0 1.925p 0 1.9375000000000002p 0 1.95p 0 1.9625000000000001p 0 1.9749999999999999p 0 1.9875000000000003p 0 2p 0 2.0125000000000002p 0 2.0249999999999999p 0
+ 2.0375000000000001p 0 2.0499999999999998p 0 2.0625p 0 2.0749999999999997p 0 2.0875000000000004p 0 2.1000000000000001p 0 2.1125000000000003p 0 2.125p 0 2.1375000000000002p 0 2.1499999999999999p 0 2.1625000000000001p 0 2.1749999999999998p 0 2.1875p 0 2.1999999999999997p 0 2.2124999999999999p 0 2.2250000000000001p 0 2.2375000000000003p 0 2.25p 0
+ 2.2625000000000002p 0 2.2749999999999999p 0 2.2875000000000001p 0 2.2999999999999998p 0 2.3125p 0 2.3249999999999997p 0 2.3374999999999999p 0 2.3500000000000001p 0 2.3625000000000003p 0 2.375p 0 2.3875000000000002p 0 2.3999999999999999p 0 2.4125000000000001p 0 2.4249999999999998p 0 2.4375p 0 2.4499999999999997p 0 2.4624999999999999p 0 2.4749999999999996p 0
+ 2.4875000000000003p 0 2.5p 0 2.5125000000000002p 0 2.5249999999999999p 0 2.5375000000000001p 0 2.5499999999999998p 0 2.5625p 0 2.5749999999999997p 0 2.5874999999999999p 0 2.5999999999999996p 0 2.6124999999999998p 0 2.625p 0 2.6375000000000002p 0 2.6499999999999999p 0 2.6625000000000001p 0 2.6749999999999998p 0 2.6875p 0 2.6999999999999997p 0
+ 2.7124999999999999p 0 2.7249999999999996p 0 2.7374999999999998p 0 2.75p 0 2.7625000000000002p 0 2.7750000000000004p 0 2.7875000000000001p 0 2.8000000000000003p 0 2.8125p 0 2.8250000000000002p 0 2.8374999999999999p 0 2.8500000000000001p 0 2.8624999999999998p 0 2.875p 0 2.8875000000000002p 0 2.9000000000000004p 0 2.9125000000000001p 0 2.9250000000000003p 0
+ 2.9375p 0 2.9500000000000002p 0 2.9624999999999999p 0 2.9750000000000001p 0 2.9874999999999998p 0 3p 0 3.0124999999999997p 0 3.0250000000000004p 0 3.0375000000000001p 0 3.0500000000000003p 0 3.0625p 0 3.0750000000000002p 0 3.0874999999999999p 0 3.1000000000000001p 0 3.1124999999999998p 0 3.125p 0 3.1374999999999997p 0 3.1499999999999999p 0
+ 3.1625000000000001p 0 3.1750000000000003p 0 3.1875p 0 3.2000000000000002p 0 3.2124999999999999p 0 3.2250000000000001p 0 3.2374999999999998p 0 3.25p 0 3.2624999999999997p 0 3.2749999999999999p 0 3.2875000000000001p 0 3.3000000000000003p 0 3.3125p 0 3.3250000000000002p 0 3.3374999999999999p 0 3.3500000000000001p 0 3.3624999999999998p 0 3.375p 0
+ 3.3874999999999997p 0 3.3999999999999999p 0 3.4124999999999996p 0 3.4250000000000003p 0 3.4375p 0 3.4500000000000002p 0 3.4624999999999999p 0 3.4750000000000001p 0 3.4874999999999998p 0 3.5p 0 3.5124999999999997p 0 3.5249999999999999p 0 3.5374999999999996p 0 3.5499999999999998p 0 3.5625p 0 3.5750000000000002p 0 3.5874999999999999p 0 3.6000000000000001p 0
+ 3.6124999999999998p 0 3.625p 0 3.6374999999999997p 0 3.6499999999999999p 0 3.6624999999999996p 0 3.6750000000000003p 0 3.6875p 0 3.7000000000000002p 0 3.7124999999999999p 0 3.7250000000000005p 0 3.7375000000000003p 0 3.75p 0 3.7624999999999997p 0 3.7750000000000004p 0 3.7875000000000001p 0 3.7999999999999998p 0 3.8124999999999996p 0 3.8250000000000002p 0
+ 3.8375000000000004p 0 3.8500000000000001p 0 3.8624999999999998p 0 3.8750000000000004p 0 3.8875000000000002p 0 3.8999999999999999p 0 3.9124999999999996p 0 3.9250000000000003p 0 3.9375p 0 3.9499999999999997p 0 3.9624999999999999p 0 3.9750000000000005p 0 3.9875000000000003p 0 4p 0 4.0124999999999993p 0 4.0250000000000004p 0 4.0375000000000005p 0 4.0499999999999998p 0
+ 4.0625p 0 4.0750000000000002p 0 4.0875000000000004p 0 4.0999999999999996p 0 4.1124999999999998p 0 4.125p 0 4.1375000000000002p 0 4.1499999999999995p 0 4.1624999999999996p 0 4.1750000000000007p 0 4.1875p 0 4.2000000000000002p 0 4.2124999999999995p 0 4.2250000000000005p 0 4.2374999999999998p 0 4.25p 0 4.2624999999999993p 0 4.2750000000000004p 0
+ 4.2874999999999996p 0 4.2999999999999998p 0 4.3125p 0 4.3250000000000002p 0 4.3375000000000004p 0 4.3499999999999996p 0 4.3624999999999998p 0 4.375p 0 4.3875000000000002p 0 4.3999999999999995p 0 4.4124999999999996p 0 4.4249999999999998p 0 4.4375p 0 4.4500000000000002p 0 4.4624999999999995p 0 4.4750000000000005p 0 4.4874999999999998p 0 4.5p 0
+ 4.5124999999999993p 0 4.5250000000000004p 0 4.5374999999999996p 0 4.5499999999999998p 0 4.5625p 0 4.5750000000000002p 0 4.5875000000000004p 0 4.5999999999999996p 0 4.6125000000000007p 0 4.625p 0 4.6375000000000002p 0 4.6499999999999995p 0 4.6625000000000005p 0 4.6749999999999998p 0 4.6875p 0 4.7000000000000002p 0 4.7125000000000004p 0 4.7250000000000005p 0
+ 4.7374999999999998p 0 4.75p 0 4.7625000000000002p 0 4.7750000000000004p 0 4.7874999999999996p 0 4.7999999999999998p 0 4.8125p 0 4.8250000000000002p 0 4.8375000000000004p 0 4.8499999999999996p 0 4.8625000000000007p 0 4.875p 0 4.8875000000000002p 0 4.8999999999999995p 0 4.9125000000000005p 0 4.9249999999999998p 0 4.9375p 0 4.9499999999999993p 0
+ 4.9625000000000004p 0 4.9750000000000005p 0 4.9874999999999998p 0 5p 0 5.0125000000000002p 0 5.0250000000000004p 0 5.0374999999999996p 0 5.0499999999999998p 0 5.0625p 0 5.0750000000000002p 0 5.0874999999999995p 0 5.0999999999999996p 0 5.1125000000000007p 0 5.125p 0 5.1375000000000002p 0 5.1499999999999995p 0 5.1625000000000005p 0 5.1749999999999998p 0
+ 5.1875p 0 5.1999999999999993p 0 5.2125000000000004p 0 5.2249999999999996p 0 5.2374999999999998p 0 5.25p 0 5.2625000000000002p 0 5.2750000000000004p 0 5.2874999999999996p 0 5.2999999999999998p 0 5.3125p 0 5.3250000000000002p 0 5.3374999999999995p 0 5.3499999999999996p 0 5.3624999999999998p 0 5.375p 0 5.3875000000000002p 0 5.3999999999999995p 0
+ 5.4125000000000005p 0 5.4249999999999998p 0 5.4375p 0 5.4499999999999993p 0 5.4625000000000004p 0 5.4749999999999996p 0 5.4874999999999998p 0 5.5p 0 5.5125000000000002p 0 5.5250000000000004p 0 5.5374999999999996p 0 5.5500000000000007p 0 5.5625p 0 5.5750000000000002p 0 5.5874999999999995p 0 5.6000000000000005p 0 5.6124999999999998p 0 5.625p 0
+ 5.6375000000000002p 0 5.6500000000000004p 0 5.6625000000000005p 0 5.6749999999999998p 0 5.6875p 0 5.7000000000000002p 0 5.7125000000000004p 0 5.7249999999999996p 0 5.7374999999999998p 0 5.75p 0 5.7625000000000002p 0 5.7750000000000004p 0 5.7874999999999996p 0 5.8000000000000007p 0 5.8125p 0 5.8250000000000002p 0 5.8374999999999995p 0 5.8500000000000005p 0
+ 5.8624999999999998p 0 5.875p 0 5.8874999999999993p 0 5.9000000000000004p 0 5.9125000000000005p 0 5.9249999999999998p 0 5.9375p 0 5.9500000000000002p 0 5.9625000000000004p 0 5.9749999999999996p 0 5.9874999999999998p 0 6p 0 6.0125000000000002p 0 6.0249999999999995p 0 6.0374999999999996p 0 6.0500000000000007p 0 6.0625p 0 6.0750000000000002p 0
+ 6.0874999999999995p 0 6.1000000000000005p 0 6.1124999999999998p 0 6.125p 0 6.1374999999999993p 0 6.1500000000000004p 0 6.1624999999999996p 0 6.1749999999999998p 0 6.1875p 0 6.2000000000000002p 0 6.2125000000000004p 0 6.2249999999999996p 0 6.2374999999999998p 0 6.25p 0 6.2625000000000002p 0 6.2749999999999995p 0 6.2874999999999996p 0 6.2999999999999998p 0
+ 6.3125p 0 6.3250000000000002p 0 6.3374999999999995p 0 6.3500000000000005p 0 6.3624999999999998p 0 6.375p 0 6.3875000000000002p 0 6.4000000000000004p 0 6.4124999999999996p 0 6.4249999999999998p 0 6.4375p 0 6.4500000000000002p 0 6.4625000000000004p 0 6.4749999999999996p 0 6.4875000000000007p 0 6.5p 0 6.5125000000000002p 0 6.5249999999999995p 0
+ 6.5375000000000005p 0 6.5499999999999998p 0 6.5625p 0 6.5750000000000002p 0 6.5875000000000004p 0 6.6000000000000005p 0 6.6124999999999998p 0 6.625p 0 6.6375000000000002p 0 6.6500000000000004p 0 6.6624999999999996p 0 6.6749999999999998p 0 6.6875p 0 6.7000000000000002p 0 6.7125000000000004p 0 6.7249999999999996p 0 6.7375000000000007p 0 6.75p 0
+ 6.7625000000000002p 0 6.7749999999999995p 0 6.7875000000000005p 0 6.7999999999999998p 0 6.8125p 0 6.8249999999999993p 0 6.8375000000000004p 0 6.8500000000000005p 0 6.8624999999999998p 0 6.875p 0 6.8875000000000002p 0 6.9000000000000004p 0 6.9124999999999996p 0 6.9249999999999998p 0 6.9375p 0 6.9500000000000002p 0 6.9624999999999995p 0 6.9749999999999996p 0
+ 6.9874999999999998p 0 7p 0 7.0125000000000002p 0 7.0249999999999995p 0 7.0375000000000005p 0 7.0499999999999998p 0 7.0625p 0 7.0749999999999993p 0 7.0875000000000004p 0 7.0999999999999996p 0 7.1124999999999998p 0 7.125p 0 7.1375000000000002p 0 7.1500000000000004p 0 7.1624999999999996p 0 7.1749999999999998p 0 7.1875p 0 7.2000000000000002p 0
+ 7.2124999999999995p 0 7.2249999999999996p 0 7.2374999999999998p 0 7.25p 0 7.2625000000000002p 0 7.2749999999999995p 0 7.2874999999999996p 0 7.2999999999999998p 0 7.3125000000000009p 0 7.3249999999999993p 0 7.3375000000000004p 0 7.3500000000000005p 0 7.3624999999999998p 0 7.375p 0 7.3874999999999993p 0 7.4000000000000004p 0 7.4125000000000005p 0 7.4249999999999998p 0
+ 7.4375p 0 7.4500000000000011p 0 7.4624999999999995p 0 7.4750000000000005p 0 7.4874999999999989p 0 7.5p 0 7.5125000000000002p 0 7.5249999999999995p 0 7.5375000000000005p 0 7.5500000000000007p 0 7.5625p 0 7.5750000000000002p 0 7.5874999999999995p 0 7.5999999999999996p 0 7.6125000000000007p 0 7.6249999999999991p 0 7.6375000000000002p 0 7.6500000000000004p 0
+ 7.6624999999999996p 0 7.6750000000000007p 0 7.6874999999999991p 0 7.7000000000000002p 0 7.7125000000000004p 0 7.7249999999999996p 0 7.7374999999999998p 0 7.7500000000000009p 0 7.7624999999999993p 0 7.7750000000000004p 0 7.7874999999999996p 0 7.7999999999999998p 0 7.8125000000000009p 0 7.8249999999999993p 0 7.8375000000000004p 0 7.8500000000000005p 0 7.8624999999999998p 0 7.875p 0
+ 7.8874999999999993p 0 7.8999999999999995p 0 7.9125000000000005p 0 7.9249999999999998p 0 7.9375p 0 7.9500000000000011p 0 7.9624999999999995p 0 7.9750000000000005p 0 7.9874999999999989p 0 8p 0 8.0125000000000011p 0 8.0249999999999986p 0 8.0374999999999996p 0 8.0500000000000007p 0 8.0625p 0 8.0750000000000011p 0 8.0874999999999986p 0 8.0999999999999996p 0
+ 8.1125000000000007p 0 8.125p 0 8.1374999999999993p 0 8.1500000000000004p 0 8.1624999999999996p 0 8.1750000000000007p 0 8.1875p 0 8.1999999999999993p 0 8.2125000000000004p 0 8.2249999999999996p 0 8.2375000000000007p 0 8.25p 0 8.2624999999999993p 0 8.2750000000000004p 0 8.2875000000000014p 0 8.2999999999999989p 0 8.3125p 0 8.3249999999999993p 0
+ 8.3375000000000004p 0 8.3500000000000014p 0 8.3624999999999989p 0 8.375p 0 8.3875000000000011p 0 8.4000000000000004p 0 8.4124999999999996p 0 8.4249999999999989p 0 8.4375p 0 8.4500000000000011p 0 8.4625000000000004p 0 8.4749999999999996p 0 8.4875000000000007p 0 8.5p 0 8.5125000000000011p 0 8.5249999999999986p 0 8.5374999999999996p 0 8.5500000000000007p 0
+ 8.5625p 0 8.5749999999999993p 0 8.5875000000000004p 0 8.5999999999999996p 0 8.6125000000000007p 0 8.625p 0 8.6374999999999993p 0 8.6500000000000004p 0 8.6624999999999996p 0 8.6750000000000007p 0 8.6875p 0 8.6999999999999993p 0 8.7125000000000004p 0 8.7249999999999996p 0 8.7375000000000007p 0 8.75p 0 8.7624999999999993p 0 8.7750000000000004p 0
+ 8.7875000000000014p 0 8.7999999999999989p 0 8.8125p 0 8.8249999999999993p 0 8.8375000000000004p 0 8.8499999999999996p 0 8.8624999999999989p 0 8.875p 0 8.8875000000000011p 0 8.9000000000000004p 0 8.9124999999999996p 0 8.9249999999999989p 0 8.9375p 0 8.9500000000000011p 0 8.9624999999999986p 0 8.9749999999999996p 0 8.9875000000000007p 0 9p 0
+ 9.0125000000000011p 0 9.0249999999999986p 0 9.0374999999999996p 0 9.0500000000000007p 0 9.0625p 0 9.0749999999999993p 0 9.0875000000000004p 0 9.0999999999999996p 0 9.1125000000000007p 0 9.125p 0 9.1374999999999993p 0 9.1500000000000004p 0 9.1624999999999996p 0 9.1750000000000007p 0 9.1875p 0 9.1999999999999993p 0 9.2125000000000004p 0 9.2250000000000014p 0
+ 9.2374999999999989p 0 9.25p 0 9.2624999999999993p 0 9.2750000000000004p 0 9.2875000000000014p 0 9.2999999999999989p 0 9.3125p 0 9.3250000000000011p 0 9.3375000000000004p 0 9.3499999999999996p 0 9.3624999999999989p 0 9.375p 0 9.3875000000000011p 0 9.4000000000000004p 0 9.4124999999999996p 0 9.4250000000000007p 0 9.4375p 0 9.4500000000000011p 0
+ 9.4624999999999986p 0 9.4749999999999996p 0 9.4875000000000007p 0 9.5p 0 9.5124999999999993p 0 9.5250000000000004p 0 9.5374999999999996p 0 9.5500000000000007p 0 9.5625p 0 9.5749999999999993p 0 9.5875000000000004p 0 9.5999999999999996p 0 9.6125000000000007p 0 9.625p 0 9.6374999999999993p 0 9.6500000000000004p 0 9.6624999999999996p 0 9.6750000000000007p 0
+ 9.6875p 0 9.6999999999999993p 0 9.7125000000000004p 0 9.7250000000000014p 0 9.7374999999999989p 0 9.75p 0 9.7624999999999993p 0 9.7750000000000004p 0 9.7874999999999996p 0 9.7999999999999989p 0 9.8125p 0 9.8250000000000011p 0 9.8375000000000004p 0 9.8499999999999996p 0 9.8624999999999989p 0 9.875p 0 9.8875000000000011p 0 9.8999999999999986p 0
+ 9.9124999999999996p 0 9.9250000000000007p 0 9.9375p 0 9.9500000000000011p 0 9.9624999999999986p 0 9.9749999999999996p 0 9.9875000000000007p 0 10p -5.0994619999999998e-20 10.012499999999999p -3.9455170000000002e-07 10.025p -7.6097619999999996e-07 10.0375p -1.0987970000000001e-06 10.050000000000001p -1.40934e-06 10.0625p -1.6944790000000001e-06 10.074999999999999p -1.9562079999999998e-06 10.0875p -2.1964970000000002e-06 10.1p -2.417243e-06 10.112500000000001p -2.6202560000000002e-06 10.125p -2.8072500000000001e-06
+ 10.137499999999999p -2.9798499999999999e-06 10.15p -3.1395850000000002e-06 10.162500000000001p -3.2878979999999998e-06 10.174999999999999p -3.4261410000000002e-06 10.1875p -3.5555789999999999e-06 10.199999999999999p -3.6773949999999998e-06 10.2125p -3.7926899999999999e-06 10.225000000000001p -3.9024839999999999e-06 10.237499999999999p -4.0077200000000003e-06 10.25p -4.1092679999999997e-06 10.262500000000001p -4.2079239999999998e-06 10.275p -4.3044139999999998e-06 10.2875p -4.3993969999999999e-06 10.299999999999999p -4.4934699999999999e-06 10.3125p -4.5871630000000003e-06 10.325000000000001p -4.6809499999999996e-06 10.3375p -4.7752480000000001e-06 10.35p -4.8704190000000003e-06
+ 10.362500000000001p -4.9667719999999997e-06 10.375p -5.0645700000000002e-06 10.387500000000001p -5.1640260000000003e-06 10.399999999999999p -5.2653129999999999e-06 10.4125p -5.3685600000000003e-06 10.425000000000001p -5.4738570000000001e-06 10.4375p -5.5812580000000004e-06 10.449999999999999p -5.6907859999999998e-06 10.4625p -5.8024270000000002e-06 10.475p -5.9161419999999999e-06 10.487500000000001p -6.0318630000000003e-06 10.5p -6.1494989999999999e-06 10.512499999999999p -6.2689360000000004e-06 10.525p -6.3900370000000002e-06 10.5375p -6.5126509999999996e-06 10.550000000000001p -6.6366070000000001e-06 10.5625p -6.7617220000000002e-06 10.574999999999999p -6.8878000000000004e-06
+ 10.5875p -7.014633e-06 10.6p -7.1420049999999999e-06 10.612500000000001p -7.2696940000000003e-06 10.625p -7.3974700000000003e-06 10.637499999999999p -7.5251000000000002e-06 10.65p -7.6523490000000003e-06 10.662500000000001p -7.7789790000000005e-06 10.674999999999999p -7.9047540000000001e-06 10.6875p -8.0294359999999999e-06 10.699999999999999p -8.1527939999999995e-06 10.7125p -8.2745959999999994e-06 10.725p -8.3946170000000007e-06 10.737499999999999p -8.5126379999999994e-06 10.75p -8.628445e-06 10.762500000000001p -8.7418320000000008e-06 10.775p -8.8526000000000006e-06 10.7875p -8.9605589999999997e-06 10.799999999999999p -9.0655300000000003e-06
+ 10.8125p -9.1673419999999993e-06 10.825000000000001p -9.265834e-06 10.837499999999999p -9.360859e-06 10.85p -9.4522769999999997e-06 10.862500000000001p -9.5399630000000006e-06 10.875p -9.6238019999999997e-06 10.887500000000001p -9.7036919999999997e-06 10.899999999999999p -9.779542e-06 10.9125p -9.851275e-06 10.925000000000001p -9.9188250000000007e-06 10.9375p -9.9821399999999999e-06 10.949999999999999p -1.004118e-05 10.9625p -1.0095920000000001e-05 10.975p -1.014633e-05 10.987500000000001p -1.019243e-05 11p -1.023421e-05 11.012499999999999p -9.8771500000000008e-06 11.025p -9.5439550000000007e-06
+ 11.0375p -9.2351480000000004e-06 11.050000000000001p -8.9494559999999992e-06 11.0625p -8.6850719999999993e-06 11.074999999999999p -8.4400769999999995e-06 11.0875p -8.212586e-06 11.100000000000001p -8.0007990000000003e-06 11.112499999999999p -7.8030100000000004e-06 11.125p -7.6176160000000001e-06 11.137499999999999p -7.4431160000000004e-06 11.15p -7.2781069999999998e-06 11.162500000000001p -7.1212849999999997e-06 11.174999999999999p -6.9714400000000001e-06 11.1875p -6.8274559999999999e-06 11.200000000000001p -6.6883029999999999e-06 11.2125p -6.5530440000000001e-06 11.225p -6.4208200000000001e-06 11.237499999999999p -6.2908580000000003e-06 11.25p -6.1624609999999998e-06
+ 11.262500000000001p -6.0350090000000003e-06 11.275p -5.9079510000000001e-06 11.2875p -5.7808099999999996e-06 11.300000000000001p -5.6531719999999996e-06 11.3125p -5.5246870000000001e-06 11.325000000000001p -5.3950640000000001e-06 11.337499999999999p -5.264071e-06 11.35p -5.1315290000000001e-06 11.362500000000001p -4.9973100000000003e-06 11.375p -4.8613320000000004e-06 11.387499999999999p -4.7235599999999997e-06 11.4p -4.5839999999999996e-06 11.4125p -4.4426980000000002e-06 11.425000000000001p -4.2997340000000002e-06 11.4375p -4.155223e-06 11.449999999999999p -4.009311e-06 11.4625p -3.8621699999999996e-06 11.475p -3.7139999999999999e-06
+ 11.487500000000001p -3.5650199999999999e-06 11.5p -3.4154719999999998e-06 11.512499999999999p -3.265617e-06 11.525p -3.115728e-06 11.5375p -2.9660949999999999e-06 11.550000000000001p -2.8170170000000001e-06 11.5625p -2.6688030000000001e-06 11.574999999999999p -2.5217700000000002e-06 11.5875p -2.376238e-06 11.600000000000001p -2.2325330000000001e-06 11.612499999999999p -2.0909830000000001e-06 11.625p -1.9519139999999999e-06 11.637499999999999p -1.815652e-06 11.65p -1.6825199999999999e-06 11.6625p -1.552839e-06 11.674999999999999p -1.42692e-06 11.6875p -1.3050720000000001e-06 11.700000000000001p -1.1875939999999999e-06
+ 11.7125p -1.074776e-06 11.725p -9.6689799999999995e-07 11.737499999999999p -8.642314e-07 11.75p -7.670342e-07 11.762500000000001p -6.7555280000000003e-07 11.774999999999999p -5.9002039999999995e-07 11.7875p -5.1065700000000002e-07 11.800000000000001p -4.3766820000000001e-07 11.8125p -3.7124510000000001e-07 11.825000000000001p -3.1156379999999999e-07 11.8375p -2.5878510000000002e-07 11.85p -2.1305380000000001e-07 11.862500000000001p -1.7449900000000001e-07 11.875p -1.4323350000000001e-07 11.887499999999999p -1.1935369999999999e-07 11.9p -1.029397e-07 11.9125p -9.4054810000000003e-08 11.925000000000001p -9.2746089999999998e-08
+ 11.9375p -9.9043870000000002e-08 11.949999999999999p -1.1296209999999999e-07 11.9625p -1.344982e-07 11.975p -1.636336e-07 11.987500000000001p -2.0033339999999999e-07 12p -2.4454700000000003e-07 12.012499999999999p -2.9620799999999997e-07 12.025p -3.5523469999999999e-07 12.037500000000001p -4.2153019999999997e-07 12.049999999999999p -4.9498299999999998e-07 12.0625p -5.7546710000000002e-07 12.074999999999999p -6.6284220000000001e-07 12.0875p -7.5695450000000003e-07 12.100000000000001p -8.5763689999999997e-07 12.112499999999999p -9.6470929999999991e-07 12.125p -1.0779789999999999e-06 12.137500000000001p -1.1972430000000001e-06 12.15p -1.322284e-06
+ 12.1625p -1.452875e-06 12.174999999999999p -1.58878e-06 12.1875p -1.7297510000000001e-06 12.200000000000001p -1.8755319999999999e-06 12.2125p -2.025856e-06 12.225p -2.1804509999999998e-06 12.237500000000001p -2.3390340000000001e-06 12.25p -2.5013169999999999e-06 12.262500000000001p -2.6670040000000002e-06 12.274999999999999p -2.8357939999999999e-06 12.2875p -3.0073800000000001e-06 12.300000000000001p -3.1814499999999998e-06 12.3125p -3.357689e-06 12.324999999999999p -3.5357759999999999e-06 12.3375p -3.7153900000000002e-06 12.35p -3.8962040000000002e-06 12.362500000000001p -4.0778920000000002e-06 12.375p -4.2601250000000001e-06
+ 12.387499999999999p -4.4425750000000004e-06 12.4p -4.6249119999999999e-06 12.4125p -4.8068079999999997e-06 12.425000000000001p -4.9879339999999998e-06 12.4375p -5.1679650000000004e-06 12.449999999999999p -5.346576e-06 12.4625p -5.5234469999999997e-06 12.475p -5.6982589999999996e-06 12.487500000000001p -5.8706979999999999e-06 12.5p -6.040454e-06 12.512499999999999p -6.2072219999999998e-06 12.525p -6.3707010000000001e-06 12.537500000000001p -6.5305980000000001e-06 12.549999999999999p -6.6866249999999997e-06 12.5625p -6.8384999999999998e-06 12.574999999999999p -6.9859499999999996e-06 12.5875p -7.128707e-06 12.6p -7.2665130000000004e-06
+ 12.612499999999999p -7.3991169999999999e-06 12.625p -7.5262790000000003e-06 12.637500000000001p -7.6477639999999997e-06 12.65p -7.7633519999999996e-06 12.6625p -7.8728270000000008e-06 12.674999999999999p -7.9759859999999996e-06 12.6875p -8.0726370000000008e-06 12.700000000000001p -8.1625970000000005e-06 12.712499999999999p -8.2456949999999993e-06 12.725p -8.3217690000000007e-06 12.737500000000001p -8.3906719999999992e-06 12.75p -8.4522640000000002e-06 12.762500000000001p -8.5064200000000001e-06 12.775p -8.5530260000000004e-06 12.7875p -8.5919779999999999e-06 12.800000000000001p -8.6231879999999995e-06 12.8125p -8.6465760000000005e-06 12.824999999999999p -8.6620760000000006e-06
+ 12.8375p -8.6696349999999999e-06 12.85p -8.669211e-06 12.862500000000001p -8.6607759999999995e-06 12.875p -8.6443120000000007e-06 12.887499999999999p -8.619814e-06 12.9p -8.5872910000000003e-06 12.9125p -8.5467609999999992e-06 12.925000000000001p -8.4982579999999997e-06 12.9375p -8.4418249999999994e-06 12.949999999999999p -8.3775170000000005e-06 12.9625p -8.305403e-06 12.975000000000001p -8.2255609999999996e-06 12.987499999999999p -8.1380810000000006e-06 13p -8.0430659999999996e-06 13.012499999999999p -7.9406279999999998e-06 13.025p -7.8308900000000008e-06 13.037500000000001p -7.7139870000000005e-06 13.049999999999999p -7.5900619999999998e-06
+ 13.0625p -7.4592700000000003e-06 13.075000000000001p -7.3217749999999999e-06 13.0875p -7.1777510000000003e-06 13.1p -7.0273789999999999e-06 13.112499999999999p -6.8708509999999999e-06 13.125p -6.7083660000000003e-06 13.137500000000001p -6.5401329999999997e-06 13.15p -6.3663670000000003e-06 13.1625p -6.1872889999999999e-06 13.175000000000001p -6.003131e-06 13.1875p -5.8141290000000001e-06 13.200000000000001p -5.6205230000000002e-06 13.212499999999999p -5.4225640000000002e-06 13.225p -5.2205030000000001e-06 13.237500000000001p -5.014599e-06 13.25p -4.8051150000000002e-06 13.262499999999999p -4.5923180000000001e-06 13.275p -4.3764769999999999e-06
+ 13.2875p -4.1578659999999999e-06 13.300000000000001p -3.9367610000000001e-06 13.3125p -3.7134400000000001e-06 13.324999999999999p -3.4881839999999999e-06 13.3375p -3.2612729999999999e-06 13.35p -3.0329900000000002e-06 13.362500000000001p -2.803617e-06 13.375p -2.573438e-06 13.387499999999999p -2.3427349999999999e-06 13.4p -2.1117879999999999e-06 13.4125p -1.8808799999999999e-06 13.425000000000001p -1.650288e-06 13.4375p -1.4202890000000001e-06 13.449999999999999p -1.191157e-06 13.4625p -9.6316299999999998e-07 13.475000000000001p -7.3657600000000004e-07 13.487499999999999p -5.1166029999999999e-07 13.5p -2.8867650000000002e-07
+ 13.512499999999999p -6.7881130000000006e-08 13.525p 1.5047409999999999e-07 13.5375p 3.6614210000000002e-07 13.549999999999999p 5.7888110000000003e-07 13.5625p 7.8845479999999999e-07 13.575000000000001p 9.9463260000000007e-07 13.5875p 1.1971900000000001e-06 13.6p 1.3959090000000001e-06 13.612499999999999p 1.5905770000000001e-06 13.625p 1.7809890000000001e-06 13.637500000000001p 1.966947e-06 13.649999999999999p 2.14826e-06 13.6625p 2.3247439999999999e-06 13.675000000000001p 2.4962220000000001e-06 13.6875p 2.6625240000000002e-06 13.700000000000001p 2.8234910000000001e-06 13.7125p 2.9789669999999999e-06 13.725p 3.128807e-06
+ 13.737500000000001p 3.2728729999999999e-06 13.75p 3.4110360000000002e-06 13.762499999999999p 3.5431719999999999e-06 13.775p 3.6691690000000002e-06 13.7875p 3.7889210000000002e-06 13.800000000000001p 3.9023290000000001e-06 13.8125p 4.0093050000000002e-06 13.824999999999999p 4.109768e-06 13.8375p 4.2036440000000002e-06 13.85p 4.2908669999999996e-06 13.862500000000001p 4.3713820000000001e-06 13.875p 4.445139e-06 13.887499999999999p 4.5120960000000003e-06 13.9p 4.572221e-06 13.912500000000001p 4.6254879999999997e-06 13.924999999999999p 4.6718790000000002e-06 13.9375p 4.7113850000000001e-06 13.949999999999999p 4.7440039999999999e-06
+ 13.9625p 4.7697390000000003e-06 13.975p 4.7886049999999997e-06 13.987499999999999p 4.80062e-06 14p 4.8058120000000001e-06 14.012500000000001p 4.8042149999999999e-06 14.025p 4.7958690000000003e-06 14.0375p 4.7808229999999996e-06 14.049999999999999p 4.7591319999999999e-06 14.0625p 4.7308569999999998e-06 14.075000000000001p 4.6960649999999999e-06 14.0875p 4.6548309999999997e-06 14.1p 4.6072359999999998e-06 14.112500000000001p 4.5533659999999998e-06 14.125p 4.4933130000000004e-06 14.137500000000001p 4.4271770000000002e-06 14.149999999999999p 4.355061e-06 14.1625p 4.2770760000000003e-06 14.175000000000001p 4.1933369999999997e-06
+ 14.1875p 4.1039650000000001e-06 14.199999999999999p 4.0090850000000001e-06 14.2125p 3.9088300000000001e-06 14.225p 3.803335e-06 14.237500000000001p 3.6927420000000001e-06 14.25p 3.5771960000000001e-06 14.262499999999999p 3.4568469999999999e-06 14.275p 3.3318509999999999e-06 14.2875p 3.2023659999999999e-06 14.300000000000001p 3.068555e-06 14.3125p 2.9305869999999998e-06 14.324999999999999p 2.7886310000000001e-06 14.3375p 2.6428630000000002e-06 14.35p 2.4934600000000001e-06 14.362500000000001p 2.3406059999999998e-06 14.375p 2.184484e-06 14.387499999999999p 2.0252830000000001e-06 14.4p 1.863193e-06
+ 14.412500000000001p 1.6984089999999999e-06 14.424999999999999p 1.5311269999999999e-06 14.4375p 1.361545e-06 14.449999999999999p 1.1898640000000001e-06 14.4625p 1.016287e-06 14.475p 8.4101809999999999e-07 14.487499999999999p 6.6426450000000001e-07 14.5p 4.8623340000000003e-07 14.512500000000001p 3.0713389999999998e-07 14.525p 1.2717590000000001e-07 14.5375p -5.3429799999999998e-08 14.549999999999999p -2.3447189999999999e-07 14.562500000000002p -4.1573879999999998e-07 14.574999999999999p -5.9701850000000005e-07 14.587499999999999p -7.7809930000000001e-07 14.6p -9.5876970000000003e-07 14.612500000000001p -1.1388189999999999e-06 14.625000000000002p -1.3180370000000001e-06
+ 14.637499999999999p -1.4962139999999999e-06 14.649999999999999p -1.6731440000000001e-06 14.6625p -1.8486190000000001e-06 14.675000000000001p -2.022434e-06 14.687500000000002p -2.194389e-06 14.700000000000001p -2.3642810000000001e-06 14.712499999999999p -2.5319150000000001e-06 14.725p -2.697093e-06 14.737500000000001p -2.8596250000000002e-06 14.75p -3.0193219999999998e-06 14.762500000000001p -3.1759980000000001e-06 14.774999999999999p -3.3294720000000001e-06 14.7875p -3.4795669999999998e-06 14.800000000000001p -3.6261080000000001e-06 14.8125p -3.768928e-06 14.825000000000001p -3.9078610000000003e-06 14.837499999999999p -4.0427490000000001e-06 14.85p -4.1734380000000003e-06
+ 14.862499999999999p -4.2997770000000003e-06 14.875p -4.4216250000000002e-06 14.887500000000001p -4.538844e-06 14.900000000000002p -4.6513020000000003e-06 14.9125p -4.7588729999999998e-06 14.924999999999999p -4.8614389999999998e-06 14.9375p -4.9588870000000004e-06 14.950000000000001p -5.0511109999999999e-06 14.962500000000002p -5.1380120000000001e-06 14.974999999999998p -5.2194980000000001e-06 14.987499999999999p -5.2954839999999999e-06 15p -5.3658929999999998e-06 15.012500000000001p -5.4306530000000001e-06 15.025p -5.4897040000000003e-06 15.037499999999998p -5.542989e-06 15.049999999999999p -5.5904599999999998e-06 15.0625p -5.6320789999999999e-06 15.075000000000001p -5.6678140000000001e-06
+ 15.0875p -5.6976399999999997e-06 15.100000000000001p -5.7215420000000001e-06 15.112499999999999p -5.7395120000000002e-06 15.125p -5.7515489999999998e-06 15.137499999999999p -5.7576630000000004e-06 15.15p -5.7578689999999997e-06 15.162500000000001p -5.7521910000000001e-06 15.174999999999999p -5.7406609999999999e-06 15.1875p -5.7233199999999996e-06 15.199999999999999p -5.7002150000000003e-06 15.2125p -5.6714030000000003e-06 15.225000000000001p -5.6369469999999996e-06 15.237499999999999p -5.5969179999999998e-06 15.249999999999998p -5.5513950000000004e-06 15.262499999999999p -5.5004650000000002e-06 15.275p -5.4442210000000003e-06 15.287500000000001p -5.3827649999999996e-06 15.300000000000001p -5.3162040000000001e-06
+ 15.312499999999998p -5.2446529999999997e-06 15.324999999999999p -5.1682349999999998e-06 15.3375p -5.0870770000000004e-06 15.350000000000001p -5.0013139999999998e-06 15.362500000000001p -4.911088e-06 15.374999999999998p -4.8165460000000004e-06 15.387499999999999p -4.717839e-06 15.4p -4.6151269999999998e-06 15.4125p -4.508574e-06 15.425000000000001p -4.3983480000000004e-06 15.437499999999998p -4.2846219999999998e-06 15.449999999999999p -4.1675759999999999e-06 15.4625p -4.0473920000000002e-06 15.475p -3.9242560000000003e-06 15.487500000000001p -3.7983589999999998e-06 15.500000000000002p -3.6698949999999999e-06 15.512499999999999p -3.5390610000000001e-06 15.524999999999999p -3.4060570000000002e-06
+ 15.5375p -3.2710859999999999e-06 15.550000000000001p -3.1343530000000002e-06 15.562500000000002p -2.9960659999999999e-06 15.574999999999999p -2.8564319999999999e-06 15.587499999999999p -2.7156630000000001e-06 15.6p -2.573969e-06 15.612500000000001p -2.4315630000000002e-06 15.625000000000002p -2.2886579999999999e-06 15.637500000000001p -2.1454659999999999e-06 15.649999999999999p -2.0022009999999999e-06 15.6625p -1.859074e-06 15.675000000000001p -1.7162969999999999e-06 15.6875p -1.574081e-06 15.700000000000001p -1.432635e-06 15.712499999999999p -1.292166e-06 15.725p -1.1528809999999999e-06 15.737500000000001p -1.014983e-06 15.75p -8.7867239999999999e-07
+ 15.762500000000001p -7.4414779999999996e-07 15.774999999999999p -6.1160450000000002e-07 15.7875p -4.8123429999999996e-07 15.799999999999999p -3.5322549999999998e-07 15.8125p -2.277626e-07 15.825000000000001p -1.05026e-07 15.837500000000002p 1.4808160000000001e-08 15.85p 1.3156830000000001e-07 15.862499999999999p 2.4508750000000002e-07 15.875p 3.552041e-07 15.887500000000001p 4.6176140000000002e-07 15.900000000000002p 5.6460799999999997e-07 15.912499999999998p 6.6359840000000001e-07 15.924999999999999p 7.5859250000000003e-07 15.9375p 8.494564e-07 15.950000000000001p 9.3606200000000003e-07 15.9625p 1.0182879999999999e-06 15.974999999999998p 1.0960190000000001e-06
+ 15.987499999999999p 1.1691449999999999e-06 16p 1.2375659999999999e-06 16.012499999999999p 1.3011849999999999e-06 16.025000000000002p 1.3599150000000001e-06 16.037500000000001p 1.413673e-06 16.049999999999997p 1.462385e-06 16.0625p 1.5059850000000001e-06 16.074999999999999p 1.5444110000000001e-06 16.087500000000002p 1.577611e-06 16.100000000000001p 1.6055389999999999e-06 16.112499999999997p 1.628158e-06 16.125p 1.6454369999999999e-06 16.137499999999999p 1.657352e-06 16.150000000000002p 1.6638869999999999e-06 16.162500000000001p 1.665034e-06 16.174999999999997p 1.660792e-06 16.1875p 1.6511669999999999e-06 16.199999999999999p 1.636173e-06
+ 16.212499999999999p 1.6158310000000001e-06 16.225000000000001p 1.590169e-06 16.237500000000001p 1.5592240000000001e-06 16.25p 1.523037e-06 16.262499999999999p 1.4816590000000001e-06 16.274999999999999p 1.435146e-06 16.287500000000001p 1.383562e-06 16.300000000000001p 1.326979e-06 16.3125p 1.2654730000000001e-06 16.324999999999999p 1.199127e-06 16.337499999999999p 1.1280339999999999e-06 16.350000000000001p 1.052288e-06 16.362500000000001p 9.7199269999999996e-07 16.375p 8.8725679999999995e-07 16.387499999999999p 7.9819460000000004e-07 16.399999999999999p 7.0492610000000004e-07 16.412500000000001p 6.0757669999999999e-07 16.425000000000001p 5.0627680000000004e-07
+ 16.4375p 4.0116199999999998e-07 16.449999999999999p 2.9237260000000002e-07 16.462499999999999p 1.8005330000000001e-07 16.475000000000001p 6.435302e-08 16.487500000000001p -5.4575100000000003e-08 16.5p -1.7657430000000001e-07 16.512499999999999p -3.014843e-07 16.524999999999999p -4.2914149999999998e-07 16.537500000000001p -5.5937940000000002e-07 16.550000000000001p -6.9202870000000003e-07 16.5625p -8.2691779999999996e-07 16.575000000000003p -9.6387289999999995e-07 16.587499999999999p -1.1027179999999999e-06 16.599999999999998p -1.243276e-06 16.612500000000001p -1.3853680000000001e-06 16.625p -1.5288150000000001e-06 16.637500000000003p -1.6734350000000001e-06 16.649999999999999p -1.8190470000000001e-06
+ 16.662499999999998p -1.9654700000000001e-06 16.675000000000001p -2.1125230000000001e-06 16.6875p -2.2600240000000002e-06 16.700000000000003p -2.407791e-06 16.712499999999999p -2.5556449999999999e-06 16.724999999999998p -2.703406e-06 16.737500000000001p -2.8508950000000002e-06 16.75p -2.9979359999999999e-06 16.762499999999999p -3.1443530000000001e-06 16.775000000000002p -3.2899710000000001e-06 16.787499999999998p -3.434619e-06 16.800000000000001p -3.578126e-06 16.8125p -3.720324e-06 16.824999999999999p -3.8610479999999996e-06 16.837500000000002p -4.0001339999999997e-06 16.849999999999998p -4.1374210000000003e-06 16.862500000000001p -4.2727520000000004e-06 16.875p -4.4059730000000001e-06
+ 16.887499999999999p -4.5369289999999999e-06 16.900000000000002p -4.6654740000000002e-06 16.912499999999998p -4.7914609999999998e-06 16.925000000000001p -4.9147480000000002e-06 16.9375p -5.0351960000000004e-06 16.949999999999999p -5.1526700000000003e-06 16.962500000000002p -5.2670389999999997e-06 16.975000000000001p -5.3781740000000002e-06 16.987499999999997p -5.485952e-06 17p -5.5902530000000003e-06 17.012499999999999p -5.6909610000000002e-06 17.025000000000002p -5.7879650000000004e-06 17.037500000000001p -5.8811570000000004e-06 17.049999999999997p -5.9704340000000001e-06 17.0625p -6.0556990000000001e-06 17.074999999999999p -6.1368570000000004e-06 17.087500000000002p -6.213819e-06 17.100000000000001p -6.2864999999999999e-06
+ 17.112499999999997p -6.3548230000000001e-06 17.125p -6.4187110000000001e-06 17.137499999999999p -6.478097e-06 17.149999999999999p -6.5329139999999997e-06 17.162500000000001p -6.5831060000000003e-06 17.175000000000001p -6.6286179999999996e-06 17.1875p -6.6694010000000003e-06 17.199999999999999p -6.7054140000000002e-06 17.212499999999999p -6.7366180000000001e-06 17.225000000000001p -6.7629839999999999e-06 17.237500000000001p -6.7844840000000004e-06 17.25p -6.8010989999999997e-06 17.262499999999999p -6.8128140000000002e-06 17.274999999999999p -6.8196209999999998e-06 17.287500000000001p -6.8215169999999997e-06 17.300000000000001p -6.8185059999999998e-06 17.3125p -6.8105960000000004e-06 17.324999999999999p -6.7978039999999996e-06
+ 17.337499999999999p -6.7801480000000002e-06 17.350000000000001p -6.7576570000000004e-06 17.362500000000001p -6.7303639999999998e-06 17.375p -6.6983050000000002e-06 17.387499999999999p -6.6615270000000002e-06 17.399999999999999p -6.6200780000000002e-06 17.412500000000001p -6.5740150000000003e-06 17.425000000000001p -6.5233979999999996e-06 17.4375p -6.4682939999999998e-06 17.449999999999999p -6.4087769999999999e-06 17.462499999999999p -6.3449220000000002e-06 17.475000000000001p -6.2768130000000003e-06 17.487500000000001p -6.2045380000000003e-06 17.5p -6.128189e-06 17.512500000000003p -6.047864e-06 17.524999999999999p -5.9636650000000003e-06 17.537499999999998p -5.8756990000000001e-06 17.550000000000001p -5.7840769999999998e-06
+ 17.5625p -5.6889139999999998e-06 17.575000000000003p -5.5903300000000001e-06 17.587499999999999p -5.4884480000000003e-06 17.599999999999998p -5.3833940000000002e-06 17.612500000000001p -5.2752989999999999e-06 17.625p -5.1642959999999997e-06 17.637500000000003p -5.0505220000000004e-06 17.649999999999999p -4.9341150000000001e-06 17.662499999999998p -4.8152180000000002e-06 17.675000000000001p -4.6939750000000002e-06 17.6875p -4.570533e-06 17.699999999999999p -4.4450389999999998e-06 17.712500000000002p -4.3176440000000003e-06 17.724999999999998p -4.1884990000000004e-06 17.737500000000001p -4.0577570000000002e-06 17.75p -3.9255720000000002e-06 17.762499999999999p -3.7920989999999998e-06 17.775000000000002p -3.6574919999999999e-06
+ 17.787499999999998p -3.5219079999999999e-06 17.800000000000001p -3.3855029999999999e-06 17.8125p -3.2484309999999999e-06 17.824999999999999p -3.110848e-06 17.837500000000002p -2.9729099999999998e-06 17.849999999999998p -2.83477e-06 17.862500000000001p -2.6965809999999998e-06 17.875p -2.558496e-06 17.887499999999999p -2.4206650000000001e-06 17.900000000000002p -2.2832379999999998e-06 17.912500000000001p -2.1463620000000001e-06 17.924999999999997p -2.010183e-06 17.9375p -1.8748429999999999e-06 17.949999999999999p -1.7404859999999999e-06 17.962500000000002p -1.6072489999999999e-06 17.975000000000001p -1.4752680000000001e-06 17.987499999999997p -1.3446790000000001e-06 18p -1.2156099999999999e-06
+ 18.012499999999999p -1.08819e-06 18.025000000000002p -9.6254349999999993e-07 18.037500000000001p -8.3879180000000003e-07 18.049999999999997p -7.1705279999999997e-07 18.0625p -5.9744079999999997e-07 18.074999999999999p -4.8006669999999998e-07 18.087499999999999p -3.6503760000000002e-07 18.100000000000001p -2.5245670000000002e-07 18.112500000000001p -1.4242349999999999e-07 18.125p -3.5033420000000002e-08 18.137499999999999p 6.9622190000000001e-08 18.149999999999999p 1.71456e-07 18.162500000000001p 2.703849e-07 18.175000000000001p 3.6632989999999998e-07 18.1875p 4.5921650000000001e-07 18.199999999999999p 5.4897410000000002e-07 18.212499999999999p 6.3553690000000002e-07 18.225000000000001p 7.1884309999999997e-07
+ 18.237500000000001p 7.9883550000000001e-07 18.25p 8.7546119999999999e-07 18.262499999999999p 9.4867160000000002e-07 18.274999999999999p 1.0184230000000001e-06 18.287500000000001p 1.0846749999999999e-06 18.300000000000001p 1.147393e-06 18.3125p 1.206546e-06 18.324999999999999p 1.262108e-06 18.337499999999999p 1.3140560000000001e-06 18.350000000000001p 1.362373e-06 18.362500000000001p 1.407044e-06 18.375p 1.448062e-06 18.387499999999999p 1.4854209999999999e-06 18.399999999999999p 1.5191199999999999e-06 18.412500000000001p 1.549163e-06 18.425000000000001p 1.5755570000000001e-06 18.4375p 1.598314e-06 18.450000000000003p 1.6174500000000001e-06
+ 18.462499999999999p 1.632983e-06 18.474999999999998p 1.6449370000000001e-06 18.487500000000001p 1.653341e-06 18.5p 1.6582230000000001e-06 18.512500000000003p 1.6596200000000001e-06 18.524999999999999p 1.657569e-06 18.537499999999998p 1.652113e-06 18.550000000000001p 1.6432969999999999e-06 18.5625p 1.6311679999999999e-06 18.575000000000003p 1.6157799999999999e-06 18.587499999999999p 1.597188e-06 18.599999999999998p 1.5754500000000001e-06 18.612500000000001p 1.550628e-06 18.625p 1.5227850000000001e-06 18.637499999999999p 1.491989e-06 18.650000000000002p 1.458312e-06 18.662499999999998p 1.4218239999999999e-06 18.675000000000001p 1.382602e-06
+ 18.6875p 1.3407229999999999e-06 18.699999999999999p 1.296269e-06 18.712500000000002p 1.249321e-06 18.724999999999998p 1.199965e-06 18.737500000000001p 1.1482869999999999e-06 18.75p 1.0943770000000001e-06 18.762499999999999p 1.0383259999999999e-06 18.775000000000002p 9.8022619999999991e-07 18.787499999999998p 9.2017229999999999e-07 18.800000000000001p 8.5826040000000003e-07 18.8125p 7.9458799999999997e-07 18.824999999999999p 7.2925409999999999e-07 18.837500000000002p 6.6235889999999999e-07 18.850000000000001p 5.9400370000000003e-07 18.862499999999997p 5.2429099999999997e-07 18.875p 4.5332409999999998e-07 18.887499999999999p 3.8120720000000002e-07 18.900000000000002p 3.0804520000000001e-07
+ 18.912500000000001p 2.3394339999999999e-07 18.924999999999997p 1.590079e-07 18.9375p 8.3344970000000007e-08 18.949999999999999p 7.0610629999999997e-09 18.962500000000002p -6.9737119999999996e-08 18.975000000000001p -1.469429e-07 18.987499999999997p -2.2444979999999999e-07 19p -3.0215129999999999e-07 19.012499999999999p -3.7994170000000003e-07 19.024999999999999p -4.577152e-07 19.037500000000001p -5.3536700000000003e-07 19.050000000000001p -6.1279289999999996e-07 19.0625p -6.8988929999999999e-07 19.074999999999999p -7.6655380000000001e-07 19.087499999999999p -8.4268480000000002e-07 19.100000000000001p -9.1818210000000003e-07 19.112500000000001p -9.9294670000000005e-07 19.125p -1.066881e-06
+ 19.137499999999999p -1.139888e-06 19.149999999999999p -1.2118739999999999e-06 19.162500000000001p -1.282746e-06 19.175000000000001p -1.3524120000000001e-06 19.1875p -1.420784e-06 19.199999999999999p -1.4877749999999999e-06 19.212499999999999p -1.553298e-06 19.225000000000001p -1.617272e-06 19.237500000000001p -1.679616e-06 19.25p -1.740252e-06 19.262499999999999p -1.7991029999999999e-06 19.274999999999999p -1.8560980000000001e-06 19.287500000000001p -1.9111650000000001e-06 19.300000000000001p -1.9642359999999999e-06 19.3125p -2.0152479999999998e-06 19.324999999999999p -2.064136e-06 19.337499999999999p -2.1108440000000001e-06 19.350000000000001p -2.1553139999999999e-06
+ 19.362500000000001p -2.1974930000000002e-06 19.375p -2.2373320000000002e-06 19.387500000000003p -2.2747840000000002e-06 19.399999999999999p -2.3098049999999998e-06 19.412499999999998p -2.342355e-06 19.425000000000001p -2.3723970000000001e-06 19.4375p -2.399898e-06 19.450000000000003p -2.424828e-06 19.462499999999999p -2.447159e-06 19.474999999999998p -2.4668689999999998e-06 19.487500000000001p -2.4839379999999998e-06 19.5p -2.4983490000000002e-06 19.512500000000003p -2.5100900000000001e-06 19.524999999999999p -2.5191499999999998e-06 19.537499999999998p -2.5255249999999998e-06 19.550000000000001p -2.5292120000000002e-06 19.5625p -2.530211e-06 19.574999999999999p -2.5285270000000001e-06
+ 19.587500000000002p -2.5241679999999999e-06 19.599999999999998p -2.5171450000000002e-06 19.612500000000001p -2.507473e-06 19.625p -2.495169e-06 19.637499999999999p -2.4802559999999998e-06 19.650000000000002p -2.4627569999999998e-06 19.662499999999998p -2.4426999999999999e-06 19.675000000000001p -2.4201159999999999e-06 19.6875p -2.395039e-06 19.699999999999999p -2.3675059999999999e-06 19.712500000000002p -2.3375559999999999e-06 19.724999999999998p -2.3052329999999998e-06 19.737500000000001p -2.2705819999999998e-06 19.75p -2.233651e-06 19.762499999999999p -2.1944920000000001e-06 19.775000000000002p -2.1531580000000001e-06 19.787500000000001p -2.109704e-06 19.799999999999997p -2.0641899999999998e-06
+ 19.8125p -2.0166770000000001e-06 19.824999999999999p -1.9672259999999999e-06 19.837500000000002p -1.915903e-06 19.850000000000001p -1.862776e-06 19.862499999999997p -1.807913e-06 19.875p -1.7513840000000001e-06 19.887499999999999p -1.693263e-06 19.900000000000002p -1.6336229999999999e-06 19.912500000000001p -1.57254e-06 19.924999999999997p -1.5100900000000001e-06 19.9375p -1.446351e-06 19.949999999999999p -1.3814030000000001e-06 19.962499999999999p -1.315326e-06 19.975000000000001p -1.248201e-06 19.987500000000001p -1.18011e-06 20p -1.1111339999999999e-06 20.012499999999999p -6.4680640000000002e-07 20.024999999999999p -2.098884e-07
+ 20.037500000000001p 1.990598e-07 20.050000000000001p 5.8128009999999997e-07 20.0625p 9.3856259999999996e-07 20.074999999999999p 1.272819e-06 20.087499999999999p 1.585935e-06 20.100000000000001p 1.8797279999999999e-06 20.112500000000001p 2.155925e-06 20.125p 2.4161609999999998e-06 20.137499999999999p 2.6619810000000002e-06 20.149999999999999p 2.894838e-06 20.162500000000001p 3.1160980000000001e-06 20.175000000000001p 3.3270379999999999e-06 20.1875p 3.528853e-06 20.199999999999999p 3.7226530000000001e-06 20.212499999999999p 3.9094710000000003e-06 20.225000000000001p 4.0902609999999996e-06 20.237500000000001p 4.2659010000000003e-06 20.25p 4.4371990000000002e-06
+ 20.262499999999999p 4.6048899999999999e-06 20.274999999999999p 4.7696440000000004e-06 20.287500000000001p 4.9320649999999998e-06 20.300000000000001p 5.092695e-06 20.3125p 5.2520150000000001e-06 20.325000000000003p 5.4104519999999996e-06 20.337499999999999p 5.5683760000000001e-06 20.349999999999998p 5.7261049999999996e-06 20.362500000000001p 5.8839090000000001e-06 20.375p 6.0420099999999998e-06 20.387500000000003p 6.2005859999999996e-06 20.399999999999999p 6.3597740000000002e-06 20.412499999999998p 6.5196710000000003e-06 20.425000000000001p 6.6803360000000004e-06 20.4375p 6.8417960000000002e-06 20.450000000000003p 7.0040430000000003e-06 20.462499999999999p 7.1670409999999998e-06 20.474999999999998p 7.330725e-06
+ 20.487500000000001p 7.4950049999999997e-06 20.5p 7.6597679999999999e-06 20.512499999999999p 7.8248780000000001e-06 20.525000000000002p 7.9901809999999999e-06 20.537499999999998p 8.1555050000000004e-06 20.550000000000001p 8.3206619999999992e-06 20.5625p 8.4854509999999996e-06 20.574999999999999p 8.6496590000000007e-06 20.587500000000002p 8.8130610000000004e-06 20.599999999999998p 8.9754250000000006e-06 20.612500000000001p 9.1365100000000004e-06 20.625p 9.2960720000000007e-06 20.637499999999999p 9.45386e-06 20.650000000000002p 9.60962e-06 20.662499999999998p 9.7630999999999997e-06 20.675000000000001p 9.9140429999999996e-06 20.6875p 1.00622e-05 20.699999999999999p 1.02073e-05
+ 20.712500000000002p 1.034912e-05 20.725000000000001p 1.0487400000000001e-05 20.737499999999997p 1.0621900000000001e-05 20.75p 1.075239e-05 20.762499999999999p 1.0878640000000001e-05 20.775000000000002p 1.1000429999999999e-05 20.787500000000001p 1.1117539999999999e-05 20.799999999999997p 1.1229780000000001e-05 20.8125p 1.133695e-05 20.824999999999999p 1.143886e-05 20.837500000000002p 1.153535e-05 20.850000000000001p 1.1626250000000001e-05 20.862499999999997p 1.171141e-05 20.875p 1.17907e-05 20.887499999999999p 1.1863980000000001e-05 20.899999999999999p 1.193115e-05 20.912500000000001p 1.1992110000000001e-05 20.925000000000001p 1.2046769999999999e-05
+ 20.9375p 1.209505e-05 20.949999999999999p 1.2136900000000001e-05 20.962499999999999p 1.2172280000000001e-05 20.975000000000001p 1.2201149999999999e-05 20.987500000000001p 1.222349e-05 21p 1.2239310000000001e-05 21.012499999999999p 1.1854059999999999e-05 21.024999999999999p 1.149044e-05 21.037500000000001p 1.114898e-05 21.050000000000001p 1.08284e-05 21.0625p 1.052689e-05 21.074999999999999p 1.024254e-05 21.087499999999999p 9.9734750000000003e-06 21.100000000000001p 9.7179030000000005e-06 21.112500000000001p 9.4741350000000004e-06 21.125p 9.2405879999999998e-06 21.137499999999999p 9.0157849999999999e-06 21.149999999999999p 8.7983509999999996e-06
+ 21.162500000000001p 8.5870139999999992e-06 21.175000000000001p 8.3806030000000006e-06 21.1875p 8.1780420000000002e-06 21.199999999999999p 7.9783520000000001e-06 21.212499999999999p 7.7806430000000006e-06 21.225000000000001p 7.584118e-06 21.237500000000001p 7.3880630000000001e-06 21.25p 7.1918499999999996e-06 21.262500000000003p 6.9949310000000004e-06 21.274999999999999p 6.7968349999999998e-06 21.287499999999998p 6.5971669999999999e-06 21.300000000000001p 6.3956000000000002e-06 21.3125p 6.1918800000000003e-06 21.325000000000003p 5.9858130000000001e-06 21.337499999999999p 5.7772710000000004e-06 21.349999999999998p 5.5661830000000003e-06 21.362500000000001p 5.3525309999999998e-06 21.375p 5.1363539999999996e-06
+ 21.387500000000003p 4.9177350000000003e-06 21.399999999999999p 4.6968069999999996e-06 21.412499999999998p 4.4737409999999997e-06 21.425000000000001p 4.2487529999999996e-06 21.4375p 4.0220900000000001e-06 21.449999999999999p 3.7940349999999999e-06 21.462500000000002p 3.5649010000000002e-06 21.474999999999998p 3.3350280000000002e-06 21.487500000000001p 3.1047800000000002e-06 21.5p 2.8745440000000001e-06 21.512499999999999p 2.6447229999999999e-06 21.525000000000002p 2.415739e-06 21.537499999999998p 2.1880250000000001e-06 21.550000000000001p 1.9620270000000001e-06 21.5625p 1.7381989999999999e-06 21.574999999999999p 1.516998e-06 21.587500000000002p 1.2988890000000001e-06 21.599999999999998p 1.0843369999999999e-06
+ 21.612500000000001p 8.7380389999999996e-07 21.625p 6.6775270000000003e-07 21.637499999999999p 4.6663949999999999e-07 21.650000000000002p 2.7091479999999998e-07 21.662500000000001p 8.1020459999999995e-08 21.674999999999997p -1.026112e-07 21.6875p -2.795593e-07 21.699999999999999p -4.494161e-07 21.712500000000002p -6.1178780000000001e-07 21.725000000000001p -7.6629640000000004e-07 21.737499999999997p -9.125804e-07 21.75p -1.050296e-06 21.762499999999999p -1.179119e-06 21.775000000000002p -1.2987449999999999e-06 21.787500000000001p -1.4088880000000001e-06 21.799999999999997p -1.5092849999999999e-06 21.8125p -1.599697e-06 21.824999999999999p -1.6799030000000001e-06
+ 21.837499999999999p -1.749709e-06 21.850000000000001p -1.8089420000000001e-06 21.862500000000001p -1.857455e-06 21.875p -1.895122e-06 21.887499999999999p -1.9218450000000001e-06 21.899999999999999p -1.9375460000000001e-06 21.912500000000001p -1.942176e-06 21.925000000000001p -1.9357069999999999e-06 21.9375p -1.918136e-06 21.949999999999999p -1.8894840000000001e-06 21.962499999999999p -1.849798e-06 21.975000000000001p -1.7991460000000001e-06 21.987500000000001p -1.737619e-06 22p -1.6653340000000001e-06 22.012499999999999p -1.582428e-06 22.024999999999999p -1.48906e-06 22.037500000000001p -1.385412e-06 22.050000000000001p -1.271684e-06
+ 22.0625p -1.1481000000000001e-06 22.074999999999999p -1.014901e-06 22.087499999999999p -8.7234820000000003e-07 22.100000000000001p -7.2071920000000002e-07 22.112500000000001p -5.603109e-07 22.125p -3.9143590000000002e-07 22.137499999999999p -2.1442289999999999e-07 22.149999999999999p -2.9615409999999999e-08 22.162500000000001p 1.626289e-07 22.175000000000001p 3.6193930000000003e-07 22.1875p 5.6793250000000005e-07 22.200000000000003p 7.8021409999999997e-07 22.212499999999999p 9.9837889999999995e-07 22.224999999999998p 1.222012e-06 22.237500000000001p 1.4506919999999999e-06 22.25p 1.6839859999999999e-06 22.262500000000003p 1.921457e-06 22.274999999999999p 2.1626619999999999e-06
+ 22.287499999999998p 2.407154e-06 22.300000000000001p 2.6544789999999998e-06 22.3125p 2.9041840000000001e-06 22.325000000000003p 3.155811e-06 22.337499999999999p 3.4089020000000001e-06 22.349999999999998p 3.6629990000000001e-06 22.362500000000001p 3.9176450000000002e-06 22.375p 4.1723839999999996e-06 22.387499999999999p 4.4267609999999997e-06 22.400000000000002p 4.6803260000000002e-06 22.412499999999998p 4.9326339999999997e-06 22.425000000000001p 5.1832410000000003e-06 22.4375p 5.4317120000000004e-06 22.449999999999999p 5.6776170000000003e-06 22.462500000000002p 5.9205320000000004e-06 22.474999999999998p 6.1600420000000002e-06 22.487500000000001p 6.3957410000000001e-06 22.5p 6.6272279999999998e-06
+ 22.512499999999999p 6.8541159999999998e-06 22.525000000000002p 7.0760240000000003e-06 22.537499999999998p 7.2925850000000001e-06 22.550000000000001p 7.5034409999999997e-06 22.5625p 7.7082449999999999e-06 22.574999999999999p 7.9066619999999994e-06 22.587500000000002p 8.0983709999999992e-06 22.600000000000001p 8.2830619999999997e-06 22.612499999999997p 8.4604370000000007e-06 22.625p 8.6302129999999997e-06 22.637499999999999p 8.7921199999999998e-06 22.650000000000002p 8.9459000000000002e-06 22.662500000000001p 9.091312e-06 22.674999999999997p 9.2281260000000001e-06 22.6875p 9.356128e-06 22.699999999999999p 9.475117e-06 22.712500000000002p 9.5849069999999995e-06 22.725000000000001p 9.6853280000000002e-06
+ 22.737500000000001p 9.7762219999999999e-06 22.75p 9.8574470000000001e-06 22.762499999999999p 9.9288750000000007e-06 22.774999999999999p 9.9903940000000004e-06 22.787500000000001p 1.00419e-05 22.800000000000001p 1.008332e-05 22.8125p 1.011458e-05 22.824999999999999p 1.0135610000000001e-05 22.837499999999999p 1.0146389999999999e-05 22.850000000000001p 1.014688e-05 22.862500000000001p 1.0137069999999999e-05 22.875p 1.011696e-05 22.887499999999999p 1.008656e-05 22.899999999999999p 1.0045910000000001e-05 22.912500000000001p 9.9950440000000004e-06 22.925000000000001p 9.9340130000000007e-06 22.9375p 9.8628869999999995e-06 22.949999999999999p 9.7817449999999996e-06
+ 22.962499999999999p 9.6906800000000005e-06 22.975000000000001p 9.5897969999999994e-06 22.987500000000001p 9.4792129999999995e-06 23p 9.3590559999999995e-06 23.012499999999999p 9.2294660000000006e-06 23.024999999999999p 9.0905959999999997e-06 23.037500000000001p 8.9426079999999999e-06 23.050000000000001p 8.7856760000000006e-06 23.0625p 8.6199849999999994e-06 23.074999999999999p 8.4457299999999999e-06 23.087499999999999p 8.2631149999999999e-06 23.100000000000001p 8.0723560000000005e-06 23.112500000000001p 7.8736769999999993e-06 23.125p 7.6673110000000004e-06 23.137500000000003p 7.4535020000000004e-06 23.149999999999999p 7.2325020000000003e-06 23.162499999999998p 7.004569e-06 23.175000000000001p 6.7699729999999999e-06
+ 23.1875p 6.5289880000000002e-06 23.200000000000003p 6.2818989999999997e-06 23.212499999999999p 6.0289949999999999e-06 23.224999999999998p 5.7705750000000002e-06 23.237500000000001p 5.5069410000000002e-06 23.25p 5.2384039999999998e-06 23.262500000000003p 4.9652789999999998e-06 23.274999999999999p 4.6878890000000004e-06 23.287499999999998p 4.4065570000000002e-06 23.300000000000001p 4.1216170000000003e-06 23.3125p 3.8334020000000001e-06 23.324999999999999p 3.5422530000000001e-06 23.337500000000002p 3.248511e-06 23.349999999999998p 2.9525210000000001e-06 23.362500000000001p 2.6546340000000001e-06 23.375p 2.3551990000000001e-06 23.387499999999999p 2.0545680000000002e-06 23.400000000000002p 1.7530969999999999e-06
+ 23.412499999999998p 1.451139e-06 23.425000000000001p 1.1490510000000001e-06 23.4375p 8.4718819999999999e-07 23.449999999999999p 5.4590599999999999e-07 23.462500000000002p 2.455591e-07 23.474999999999998p -5.3498960000000002e-08 23.487500000000001p -3.509162e-07 23.5p -6.4634290000000004e-07 23.512499999999999p -9.3943169999999996e-07 23.525000000000002p -1.2298380000000001e-06 23.537500000000001p -1.517222e-06 23.549999999999997p -1.801246e-06 23.5625p -2.0815770000000001e-06 23.574999999999999p -2.3578870000000002e-06 23.587500000000002p -2.629854e-06 23.600000000000001p -2.8971600000000001e-06 23.612499999999997p -3.1594939999999998e-06 23.625p -3.4165510000000002e-06
+ 23.637499999999999p -3.668034e-06 23.650000000000002p -3.9136509999999996e-06 23.662500000000001p -4.1531199999999998e-06 23.675000000000001p -4.3861659999999999e-06 23.6875p -4.6125210000000003e-06 23.699999999999999p -4.8319280000000002e-06 23.712499999999999p -5.0441370000000001e-06 23.725000000000001p -5.2489099999999997e-06 23.737500000000001p -5.4460150000000002e-06 23.75p -5.6352340000000004e-06 23.762499999999999p -5.8163560000000004e-06 23.774999999999999p -5.9891830000000004e-06 23.787500000000001p -6.1535259999999999e-06 23.800000000000001p -6.3092079999999999e-06 23.8125p -6.4560630000000004e-06 23.824999999999999p -6.5939370000000001e-06 23.837499999999999p -6.7226870000000003e-06 23.850000000000001p -6.8421829999999996e-06
+ 23.862500000000001p -6.9523049999999998e-06 23.875p -7.0529470000000001e-06 23.887499999999999p -7.1440160000000001e-06 23.899999999999999p -7.2254289999999996e-06 23.912500000000001p -7.2971180000000001e-06 23.925000000000001p -7.3590250000000002e-06 23.9375p -7.4111070000000001e-06 23.949999999999999p -7.4533329999999997e-06 23.962499999999999p -7.4856839999999997e-06 23.975000000000001p -7.5081549999999998e-06 23.987500000000001p -7.5207529999999998e-06 24p -7.5234970000000002e-06 24.012499999999999p -7.5164209999999997e-06 24.024999999999999p -7.4995690000000004e-06 24.037500000000001p -7.4729979999999998e-06 24.050000000000001p -7.43678e-06 24.0625p -7.3909970000000002e-06 24.075000000000003p -7.3357419999999998e-06
+ 24.087499999999999p -7.2711230000000001e-06 24.099999999999998p -7.1972579999999998e-06 24.112500000000001p -7.1142770000000002e-06 24.125p -7.0223230000000001e-06 24.137500000000003p -6.921547e-06 24.149999999999999p -6.8121130000000001e-06 24.162499999999998p -6.6941979999999997e-06 24.175000000000001p -6.5679850000000003e-06 24.1875p -6.4336709999999997e-06 24.200000000000003p -6.2914600000000004e-06 24.212499999999999p -6.141569e-06 24.224999999999998p -5.9842210000000002e-06 24.237500000000001p -5.8196509999999997e-06 24.25p -5.6481000000000002e-06 24.262499999999999p -5.469819e-06 24.275000000000002p -5.2850659999999999e-06 24.287499999999998p -5.0941080000000003e-06 24.300000000000001p -4.8972180000000004e-06
+ 24.3125p -4.6946750000000001e-06 24.324999999999999p -4.4867669999999997e-06 24.337500000000002p -4.2737850000000003e-06 24.349999999999998p -4.0560270000000003e-06 24.362500000000001p -3.8337969999999997e-06 24.375p -3.6074010000000002e-06 24.387499999999999p -3.377152e-06 24.400000000000002p -3.1433649999999999e-06 24.412499999999998p -2.9063579999999999e-06 24.425000000000001p -2.666455e-06 24.4375p -2.4239779999999998e-06 24.449999999999999p -2.179254e-06 24.462500000000002p -1.932609e-06 24.475000000000001p -1.684373e-06 24.487499999999997p -1.434875e-06 24.5p -1.184443e-06 24.512499999999999p -9.3340560000000002e-07 24.525000000000002p -6.8209119999999995e-07
+ 24.537500000000001p -4.308259e-07 24.549999999999997p -1.7993460000000001e-07 24.5625p 7.0260269999999995e-08 24.574999999999999p 3.194387e-07 24.587500000000002p 5.6728379999999995e-07 24.600000000000001p 8.134821e-07 24.612500000000001p 1.0577240000000001e-06 24.625p 1.2997039999999999e-06 24.637499999999999p 1.539122e-06 24.649999999999999p 1.7756819999999999e-06 24.662500000000001p 2.009093e-06 24.675000000000001p 2.2390719999999999e-06 24.6875p 2.4653389999999999e-06 24.699999999999999p 2.6876229999999999e-06 24.712499999999999p 2.9056580000000001e-06 24.725000000000001p 3.1191860000000002e-06 24.737500000000001p 3.3279560000000002e-06 24.75p 3.5317250000000001e-06
+ 24.762499999999999p 3.730257e-06 24.774999999999999p 3.9233250000000003e-06 24.787500000000001p 4.1107089999999999e-06 24.800000000000001p 4.2922000000000002e-06 24.8125p 4.4675939999999996e-06 24.824999999999999p 4.6367e-06 24.837499999999999p 4.7993330000000002e-06 24.850000000000001p 4.9553190000000001e-06 24.862500000000001p 5.1044919999999998e-06 24.875p 5.2466979999999996e-06 24.887499999999999p 5.3817889999999998e-06 24.899999999999999p 5.5096289999999999e-06 24.912500000000001p 5.6300929999999997e-06 24.925000000000001p 5.7430629999999997e-06 24.9375p 5.8484319999999998e-06 24.949999999999999p 5.9461050000000001e-06 24.962499999999999p 6.0359930000000003e-06 24.975000000000001p 6.1180209999999996e-06
+ 24.987500000000001p 6.1921219999999997e-06 25p 6.2582380000000003e-06 25.012500000000003p 6.3163239999999998e-06 25.024999999999999p 6.3663439999999999e-06 25.037499999999998p 6.4082690000000003e-06 25.050000000000001p 6.4420840000000001e-06 25.0625p 6.4677809999999998e-06 25.075000000000003p 6.4853639999999996e-06 25.087499999999999p 6.4948449999999998e-06 25.099999999999998p 6.496247e-06 25.112500000000001p 6.4895999999999997e-06 25.125p 6.4749469999999999e-06 25.137500000000003p 6.4523369999999996e-06 25.149999999999999p 6.4218309999999999e-06 25.162499999999998p 6.3834970000000001e-06 25.175000000000001p 6.3374130000000002e-06 25.1875p 6.283666e-06 25.199999999999999p 6.2223499999999998e-06
+ 25.212500000000002p 6.1535700000000003e-06 25.224999999999998p 6.077437e-06 25.237500000000001p 5.9940730000000002e-06 25.25p 5.903605e-06 25.262499999999999p 5.8061689999999998e-06 25.275000000000002p 5.701909e-06 25.287499999999998p 5.5909769999999999e-06 25.300000000000001p 5.4735320000000002e-06 25.3125p 5.3497380000000004e-06 25.324999999999999p 5.2197680000000004e-06 25.337500000000002p 5.0838030000000002e-06 25.349999999999998p 4.942027e-06 25.362500000000001p 4.7946319999999998e-06 25.375p 4.6418180000000003e-06 25.387499999999999p 4.4837860000000002e-06 25.400000000000002p 4.3207470000000002e-06 25.412500000000001p 4.1529149999999999e-06 25.424999999999997p 3.9805110000000004e-06
+ 25.4375p 3.803758e-06 25.449999999999999p 3.6228860000000001e-06 25.462500000000002p 3.4381269999999999e-06 25.475000000000001p 3.2497209999999999e-06 25.487499999999997p 3.0579060000000001e-06 25.5p 2.8629289999999999e-06 25.512499999999999p 2.6650380000000001e-06 25.525000000000002p 2.4644819999999998e-06 25.537500000000001p 2.2615150000000001e-06 25.550000000000001p 2.0563940000000002e-06 25.5625p 1.849376e-06 25.574999999999999p 1.6407199999999999e-06 25.587499999999999p 1.430687e-06 25.600000000000001p 1.219541e-06 25.612500000000001p 1.007543e-06 25.625p 7.9495649999999998e-07 25.637499999999999p 5.8204630000000003e-07 25.649999999999999p 3.690755e-07
+ 25.662500000000001p 1.563073e-07 25.675000000000001p -5.599575e-08 25.6875p -2.6757229999999999e-07 25.699999999999999p -4.7816229999999997e-07 25.712499999999999p -6.8750729999999999e-07 25.725000000000001p -8.9535099999999996e-07 25.737500000000001p -1.101439e-06 25.75p -1.305521e-06 25.762499999999999p -1.507347e-06 25.774999999999999p -1.706672e-06 25.787500000000001p -1.9032550000000001e-06 25.800000000000001p -2.0968570000000001e-06 25.8125p -2.2872450000000001e-06 25.824999999999999p -2.4741889999999999e-06 25.837499999999999p -2.6574659999999999e-06 25.850000000000001p -2.8368539999999999e-06 25.862500000000001p -3.0121400000000002e-06 25.875p -3.183114e-06
+ 25.887499999999999p -3.3495739999999998e-06 25.899999999999999p -3.5113230000000002e-06 25.912500000000001p -3.6681699999999999e-06 25.925000000000001p -3.8199310000000003e-06 25.9375p -3.9664279999999998e-06 25.950000000000003p -4.1074909999999996e-06 25.962499999999999p -4.2429569999999997e-06 25.974999999999998p -4.3726700000000001e-06 25.987500000000001p -4.4964809999999998e-06 26p -4.6142510000000001e-06 26.012500000000003p -4.7258480000000002e-06 26.024999999999999p -4.8311460000000002e-06 26.037499999999998p -4.9300290000000004e-06 26.050000000000001p -5.0223909999999999e-06 26.0625p -5.1081320000000003e-06 26.075000000000003p -5.1871620000000003e-06 26.087499999999999p -5.2594e-06 26.099999999999998p -5.3247720000000003e-06
+ 26.112500000000001p -5.3832149999999998e-06 26.125p -5.4346749999999998e-06 26.137499999999999p -5.4791050000000001e-06 26.150000000000002p -5.5164700000000001e-06 26.162499999999998p -5.5467410000000003e-06 26.175000000000001p -5.5699020000000003e-06 26.1875p -5.5859430000000003e-06 26.199999999999999p -5.5948649999999997e-06 26.212500000000002p -5.5966769999999997e-06 26.224999999999998p -5.5913969999999997e-06 26.237500000000001p -5.5790549999999999e-06 26.25p -5.5596860000000004e-06 26.262499999999999p -5.5333360000000002e-06 26.275000000000002p -5.5000610000000001e-06 26.287499999999998p -5.4599239999999998e-06 26.300000000000001p -5.4129969999999998e-06 26.3125p -5.3593609999999999e-06 26.324999999999999p -5.2991060000000004e-06
+ 26.337500000000002p -5.2323300000000003e-06 26.350000000000001p -5.1591390000000003e-06 26.362499999999997p -5.0796459999999996e-06 26.375p -4.9939749999999999e-06 26.387499999999999p -4.9022530000000002e-06 26.400000000000002p -4.804619e-06 26.412500000000001p -4.7012169999999998e-06 26.424999999999997p -4.5921980000000002e-06 26.4375p -4.4777210000000003e-06 26.449999999999999p -4.3579509999999997e-06 26.462500000000002p -4.2330580000000003e-06 26.475000000000001p -4.1032209999999999e-06 26.487500000000001p -3.9686219999999998e-06 26.5p -3.8294509999999996e-06 26.512499999999999p -3.685901e-06 26.524999999999999p -3.5381719999999999e-06 26.537500000000001p -3.3864680000000001e-06 26.550000000000001p -3.230998e-06
+ 26.5625p -3.0719729999999999e-06 26.574999999999999p -2.9096099999999999e-06 26.587499999999999p -2.7441300000000001e-06 26.600000000000001p -2.575756e-06 26.612500000000001p -2.4047130000000002e-06 26.625p -2.2312299999999999e-06 26.637499999999999p -2.0555390000000001e-06 26.649999999999999p -1.8778719999999999e-06 26.662500000000001p -1.698464e-06 26.675000000000001p -1.517551e-06 26.6875p -1.3353689999999999e-06 26.699999999999999p -1.152156e-06 26.712499999999999p -9.6815020000000009e-07 26.725000000000001p -7.8358889999999997e-07 26.737500000000001p -5.9870970000000002e-07 26.75p -4.1374930000000001e-07 26.762499999999999p -2.2894370000000001e-07 26.774999999999999p -4.4527470000000003e-08
+ 26.787500000000001p 1.3926650000000001e-07 26.800000000000001p 3.222069e-07 26.8125p 5.0406490000000002e-07 26.824999999999999p 6.8461400000000004e-07 26.837499999999999p 8.6363049999999997e-07 26.850000000000001p 1.0408939999999999e-06 26.862500000000001p 1.2161859999999999e-06 26.875p 1.389294e-06 26.887500000000003p 1.5600079999999999e-06 26.899999999999999p 1.728122e-06 26.912499999999998p 1.893434e-06 26.925000000000001p 2.0557469999999999e-06 26.9375p 2.214869e-06 26.950000000000003p 2.3706129999999999e-06 26.962499999999999p 2.5227980000000002e-06 26.974999999999998p 2.6712459999999999e-06 26.987500000000001p 2.8157870000000001e-06 27p 2.9562550000000002e-06
+ 27.012500000000003p 3.0924919999999998e-06 27.024999999999999p 3.224345e-06 27.037499999999998p 3.3516659999999999e-06 27.050000000000001p 3.4743159999999999e-06 27.0625p 3.5921599999999998e-06 27.074999999999999p 3.705072e-06 27.087500000000002p 3.8129310000000002e-06 27.099999999999998p 3.9156240000000001e-06 27.112500000000001p 4.0130439999999999e-06 27.125p 4.1050919999999997e-06 27.137499999999999p 4.191675e-06 27.150000000000002p 4.2727090000000002e-06 27.162499999999998p 4.3481160000000004e-06 27.175000000000001p 4.4178250000000003e-06 27.1875p 4.4817720000000001e-06 27.199999999999999p 4.5399030000000002e-06 27.212500000000002p 4.5921679999999998e-06 27.224999999999998p 4.638526e-06
+ 27.237500000000001p 4.678945e-06 27.25p 4.7133960000000004e-06 27.262499999999999p 4.7418619999999997e-06 27.275000000000002p 4.7643310000000001e-06 27.287500000000001p 4.7807989999999998e-06 27.299999999999997p 4.7912680000000002e-06 27.3125p 4.7957490000000004e-06 27.324999999999999p 4.7942599999999997e-06 27.337500000000002p 4.7868240000000003e-06 27.350000000000001p 4.7734729999999996e-06 27.362499999999997p 4.7542470000000004e-06 27.375p 4.7291899999999997e-06 27.387499999999999p 4.6983560000000003e-06 27.400000000000002p 4.6618019999999996e-06 27.412500000000001p 4.6195950000000003e-06 27.425000000000001p 4.571807e-06 27.4375p 4.5185159999999996e-06 27.449999999999999p 4.4598080000000003e-06
+ 27.462499999999999p 4.395774e-06 27.475000000000001p 4.3265110000000001e-06 27.487500000000001p 4.2521210000000003e-06 27.5p 4.1727150000000001e-06 27.512499999999999p 4.0884060000000003e-06 27.524999999999999p 3.9993150000000002e-06 27.537500000000001p 3.9055659999999998e-06 27.550000000000001p 3.8072909999999999e-06 27.5625p 3.7046250000000001e-06 27.574999999999999p 3.5977089999999999e-06 27.587499999999999p 3.486686e-06 27.600000000000001p 3.3717089999999999e-06 27.612500000000001p 3.252929e-06 27.625p 3.1305049999999999e-06 27.637499999999999p 3.0045990000000002e-06 27.649999999999999p 2.875377e-06 27.662500000000001p 2.7430089999999999e-06 27.675000000000001p 2.6076659999999999e-06
+ 27.6875p 2.4695240000000001e-06 27.699999999999999p 2.3287630000000001e-06 27.712499999999999p 2.1855629999999999e-06 27.725000000000001p 2.0401090000000002e-06 27.737500000000001p 1.8925859999999999e-06 27.75p 1.7431830000000001e-06 27.762499999999999p 1.5920899999999999e-06 27.774999999999999p 1.4394989999999999e-06 27.787500000000001p 1.2856029999999999e-06 27.800000000000001p 1.1305950000000001e-06 27.8125p 9.7467130000000004e-07 27.825000000000003p 8.1802729999999997e-07 27.837499999999999p 6.6085929999999995e-07 27.849999999999998p 5.0336369999999995e-07 27.862500000000001p 3.4573670000000002e-07 27.875p 1.8817460000000001e-07 27.887500000000003p 3.0872909999999999e-08 27.899999999999999p -1.259735e-07
+ 27.912499999999998p -2.8217089999999997e-07 27.925000000000001p -4.3752659999999998e-07 27.9375p -5.9184949999999998e-07 27.949999999999999p -7.449501e-07 27.962499999999999p -8.966408e-07 27.974999999999998p -1.046736e-06 27.987500000000001p -1.195054e-06 28p -1.3414129999999999e-06 28.012499999999999p -1.4856359999999999e-06 28.025000000000002p -1.6275479999999999e-06 28.037499999999998p -1.766979e-06 28.050000000000001p -1.9037610000000001e-06 28.0625p -2.0377290000000002e-06 28.074999999999999p -2.1687239999999999e-06 28.087500000000002p -2.2965899999999999e-06 28.099999999999998p -2.4211739999999999e-06 28.112500000000001p -2.542331e-06 28.125p -2.6599160000000002e-06
+ 28.137499999999999p -2.7737919999999998e-06 28.150000000000002p -2.8838280000000002e-06 28.162499999999998p -2.9898940000000002e-06 28.175000000000001p -3.0918690000000002e-06 28.1875p -3.1896360000000001e-06 28.199999999999999p -3.2830839999999999e-06 28.212500000000002p -3.3721069999999998e-06 28.225000000000001p -3.4566059999999998e-06 28.237499999999997p -3.536488e-06 28.25p -3.6116650000000002e-06 28.262499999999999p -3.6820550000000001e-06 28.275000000000002p -3.7475839999999999e-06 28.287500000000001p -3.8081839999999998e-06 28.299999999999997p -3.863792e-06 28.3125p -3.9143519999999997e-06 28.324999999999999p -3.9598169999999996e-06 28.337500000000002p -4.0001419999999999e-06 28.350000000000001p -4.0352940000000004e-06
+ 28.362500000000001p -4.0652429999999998e-06 28.375p -4.0899679999999998e-06 28.387499999999999p -4.1094510000000003e-06 28.399999999999999p -4.123686e-06 28.412500000000001p -4.1326710000000001e-06 28.425000000000001p -4.1364090000000004e-06 28.4375p -4.134914e-06 28.449999999999999p -4.1282039999999998e-06 28.462499999999999p -4.1163020000000004e-06 28.475000000000001p -4.0992420000000004e-06 28.487500000000001p -4.0770619999999997e-06 28.5p -4.0498060000000003e-06 28.512499999999999p -4.0175250000000001e-06 28.524999999999999p -3.9802770000000002e-06 28.537500000000001p -3.9381249999999997e-06 28.550000000000001p -3.8911410000000004e-06 28.5625p -3.8393980000000004e-06 28.574999999999999p -3.7829799999999999e-06
+ 28.587499999999999p -3.7219739999999998e-06 28.600000000000001p -3.6564720000000001e-06 28.612500000000001p -3.586575e-06 28.625p -3.5123860000000001e-06 28.637499999999999p -3.434014e-06 28.649999999999999p -3.3515750000000002e-06 28.662500000000001p -3.2651860000000001e-06 28.675000000000001p -3.174973e-06 28.6875p -3.0810639999999999e-06 28.699999999999999p -2.9835910000000001e-06 28.712499999999999p -2.8826920000000001e-06 28.725000000000001p -2.778508e-06 28.737500000000001p -2.6711830000000001e-06 28.75p -2.5608659999999998e-06 28.762500000000003p -2.4477080000000001e-06 28.774999999999999p -2.3318650000000002e-06 28.787499999999998p -2.2134930000000001e-06 28.800000000000001p -2.0927529999999999e-06
+ 28.8125p -1.9698089999999998e-06 28.825000000000003p -1.8448239999999999e-06 28.837499999999999p -1.717965e-06 28.849999999999998p -1.589402e-06 28.862500000000001p -1.4593050000000001e-06 28.875p -1.327846e-06 28.887499999999999p -1.1951959999999999e-06 28.899999999999999p -1.0615290000000001e-06 28.912499999999998p -9.2701969999999997e-07 28.925000000000001p -7.9184210000000002e-07 28.9375p -6.5617060000000004e-07 28.949999999999999p -5.2017969999999996e-07 28.962500000000002p -3.840433e-07 28.974999999999998p -2.4793490000000001e-07 28.987500000000001p -1.120272e-07 29p 2.3508139999999999e-08 29.012499999999999p 1.5850079999999999e-07 29.025000000000002p 2.9278190000000002e-07
+ 29.037499999999998p 4.2618400000000003e-07 29.050000000000001p 5.5854189999999998e-07 29.0625p 6.8969229999999996e-07 29.074999999999999p 8.1947419999999995e-07 29.087500000000002p 9.4772919999999999e-07 29.099999999999998p 1.0743010000000001e-06 29.112500000000001p 1.1990380000000001e-06 29.125000000000004p 1.3217889999999999e-06 29.137499999999999p 1.4424069999999999e-06 29.149999999999999p 1.56075e-06 29.162500000000001p 1.676678e-06 29.174999999999997p 1.7900550000000001e-06 29.187500000000004p 1.9007479999999999e-06 29.199999999999999p 2.0086300000000001e-06 29.212499999999999p 2.113577e-06 29.225000000000001p 2.215469e-06 29.237499999999997p 2.3141899999999999e-06 29.250000000000004p 2.409631e-06
+ 29.262499999999999p 2.5016849999999999e-06 29.274999999999999p 2.5902499999999999e-06 29.287500000000001p 2.675231e-06 29.299999999999997p 2.7565350000000001e-06 29.312500000000004p 2.8340759999999999e-06 29.324999999999999p 2.907772e-06 29.337499999999999p 2.9775490000000002e-06 29.350000000000001p 3.043333e-06 29.362499999999997p 3.1050590000000001e-06 29.375000000000004p 3.1626680000000002e-06 29.387499999999999p 3.2161029999999999e-06 29.400000000000002p 3.2653159999999999e-06 29.412500000000001p 3.3102609999999999e-06 29.424999999999997p 3.3509e-06 29.4375p 3.3871999999999999e-06 29.449999999999999p 3.4191329999999999e-06 29.462500000000002p 3.4466760000000002e-06 29.475000000000001p 3.4698120000000001e-06
+ 29.487499999999997p 3.4885300000000001e-06 29.5p 3.5028249999999998e-06 29.512499999999999p 3.5126940000000001e-06 29.525000000000002p 3.518143e-06 29.537500000000001p 3.5191829999999999e-06 29.549999999999997p 3.515829e-06 29.5625p 3.5080999999999999e-06 29.574999999999999p 3.4960250000000001e-06 29.587500000000002p 3.479633e-06 29.600000000000001p 3.4589609999999998e-06 29.612499999999997p 3.4340500000000002e-06 29.625p 3.404947e-06 29.637499999999999p 3.3717019999999999e-06 29.650000000000002p 3.3343730000000001e-06 29.662500000000001p 3.293019e-06 29.674999999999997p 3.247706e-06 29.6875p 3.1985029999999998e-06 29.699999999999999p 3.1454870000000001e-06
+ 29.712500000000002p 3.0887339999999998e-06 29.724999999999998p 3.028329e-06 29.737499999999997p 2.9643580000000001e-06 29.75p 2.8969129999999999e-06 29.762499999999999p 2.826088e-06 29.775000000000002p 2.7519829999999998e-06 29.787499999999998p 2.6746990000000002e-06 29.800000000000004p 2.5943439999999998e-06 29.8125p 2.5110260000000001e-06 29.824999999999999p 2.4248590000000002e-06 29.837500000000002p 2.335957e-06 29.849999999999998p 2.2444390000000001e-06 29.862500000000004p 2.1504280000000001e-06 29.875p 2.0540480000000002e-06 29.887499999999999p 1.955425e-06 29.900000000000002p 1.8546880000000001e-06 29.912499999999998p 1.7519680000000001e-06 29.925000000000004p 1.6474000000000001e-06
+ 29.9375p 1.5411190000000001e-06 29.949999999999996p 1.4332600000000001e-06 29.962500000000002p 1.323964e-06 29.974999999999998p 1.2133699999999999e-06 29.987500000000001p 1.101618e-06 30p 9.8885229999999994e-07 30.012499999999996p 8.7521480000000001e-07 30.025000000000002p 7.6084960000000002e-07 30.037499999999998p 6.4590099999999995e-07 30.050000000000001p 5.3051369999999998e-07 30.0625p 4.1483270000000002e-07 30.074999999999996p 2.9900270000000002e-07 30.087500000000002p 1.831686e-07 30.099999999999998p 6.7474739999999997e-08 30.112500000000001p -4.7935099999999998e-08 30.125p -1.629177e-07 30.137500000000003p -2.773308e-07 30.150000000000002p -3.9103319999999999e-07
+ 30.162499999999998p -5.0388490000000002e-07 30.175000000000001p -6.1574709999999995e-07 30.1875p -7.2648300000000001e-07 30.200000000000003p -8.35957e-07 30.212500000000002p -9.4403580000000004e-07 30.224999999999998p -1.050588e-06 30.237500000000001p -1.155484e-06 30.25p -1.2585980000000001e-06 30.262500000000003p -1.359805e-06 30.274999999999999p -1.4589839999999999e-06 30.287499999999998p -1.556015e-06 30.300000000000001p -1.6507830000000001e-06 30.3125p -1.7431760000000001e-06 30.325000000000003p -1.8330840000000001e-06 30.337499999999999p -1.9204010000000001e-06 30.349999999999998p -2.0050249999999999e-06 30.362500000000001p -2.0868559999999999e-06 30.375p -2.1658000000000001e-06
+ 30.387500000000003p -2.2417660000000002e-06 30.399999999999999p -2.314666e-06 30.412499999999998p -2.3844169999999998e-06 30.425000000000001p -2.4509410000000002e-06 30.4375p -2.5141619999999998e-06 30.450000000000003p -2.5740109999999999e-06 30.462499999999999p -2.6304229999999998e-06 30.474999999999998p -2.6833339999999999e-06 30.487500000000001p -2.7326899999999998e-06 30.499999999999996p -2.778439e-06 30.512500000000003p -2.820532e-06 30.524999999999999p -2.858927e-06 30.537500000000001p -2.8935879999999998e-06 30.550000000000001p -2.9244809999999998e-06 30.562499999999996p -2.9515789999999999e-06 30.575000000000003p -2.9748580000000002e-06 30.587499999999999p -2.9943010000000001e-06 30.600000000000001p -3.009894e-06
+ 30.612500000000001p -3.0216309999999998e-06 30.624999999999996p -3.0295069999999999e-06 30.637500000000003p -3.0335249999999999e-06 30.649999999999999p -3.0336909999999998e-06 30.662500000000001p -3.030017e-06 30.675000000000001p -3.02252e-06 30.687499999999996p -3.0112219999999998e-06 30.700000000000003p -2.9961489999999999e-06 30.712499999999999p -2.9773310000000001e-06 30.725000000000001p -2.9548059999999998e-06 30.737500000000001p -2.9286129999999999e-06 30.749999999999996p -2.8987969999999998e-06 30.762499999999999p -2.8654079999999999e-06 30.774999999999999p -2.8285009999999999e-06 30.787500000000001p -2.7881329999999999e-06 30.800000000000001p -2.7443679999999999e-06 30.812499999999996p -2.6972720000000001e-06 30.824999999999999p -2.646916e-06
+ 30.837499999999999p -2.5933760000000002e-06 30.850000000000001p -2.5367300000000002e-06 30.862500000000001p -2.4770600000000001e-06 30.874999999999996p -2.4144539999999999e-06 30.887499999999999p -2.3489999999999999e-06 30.899999999999999p -2.280792e-06 30.912500000000001p -2.2099260000000001e-06 30.925000000000001p -2.136501e-06 30.937500000000004p -2.0606210000000002e-06 30.949999999999999p -1.9823890000000002e-06 30.962499999999999p -1.9019139999999999e-06 30.975000000000001p -1.8193070000000001e-06 30.987500000000001p -1.73468e-06 31.000000000000004p -1.648147e-06 31.012499999999999p -1.559827e-06 31.024999999999999p -1.4698370000000001e-06 31.037500000000001p -1.378299e-06 31.049999999999997p -1.2853340000000001e-06
+ 31.062500000000004p -1.191066e-06 31.074999999999999p -1.0956200000000001e-06 31.087499999999999p -9.9912109999999998e-07 31.100000000000001p -9.0169630000000001e-07 31.112499999999997p -8.0347289999999997e-07 31.125000000000004p -7.0457870000000002e-07 31.137499999999999p -6.0514189999999999e-07 31.149999999999999p -5.0529100000000002e-07 31.162500000000001p -4.0515440000000002e-07 31.174999999999997p -3.0486030000000002e-07 31.187500000000004p -2.0453679999999999e-07 31.199999999999999p -1.043113e-07 31.212499999999999p -4.3107799999999999e-09 31.225000000000001p 9.5338850000000003e-08 31.237499999999997p 1.945125e-07 31.250000000000004p 2.9308609999999997e-07 31.262499999999999p 3.9093719999999999e-07 31.275000000000002p 4.8794440000000004e-07
+ 31.287500000000001p 5.8398809999999997e-07 31.299999999999997p 6.7895040000000005e-07 31.3125p 7.7271520000000001e-07 31.324999999999999p 8.6516860000000001e-07 31.337500000000002p 9.561987e-07 31.350000000000001p 1.0456960000000001e-06 31.362499999999997p 1.133553e-06 31.375p 1.2196660000000001e-06 31.387499999999999p 1.3039309999999999e-06 31.400000000000002p 1.3862519999999999e-06 31.412500000000001p 1.46653e-06 31.424999999999997p 1.5446720000000001e-06 31.4375p 1.6205899999999999e-06 31.449999999999999p 1.6941940000000001e-06 31.462500000000002p 1.7654029999999999e-06 31.475000000000001p 1.8341350000000001e-06 31.487499999999997p 1.900314e-06 31.5p 1.9638659999999999e-06
+ 31.512499999999999p 2.024722e-06 31.525000000000002p 2.082815e-06 31.537500000000001p 2.1380839999999999e-06 31.549999999999997p 2.1904700000000001e-06 31.5625p 2.239918e-06 31.574999999999999p 2.2863789999999999e-06 31.587500000000002p 2.3298039999999998e-06 31.599999999999998p 2.3701509999999999e-06 31.612499999999997p 2.407382e-06 31.625p 2.4414620000000001e-06 31.637499999999999p 2.47236e-06 31.650000000000002p 2.5000499999999999e-06 31.662499999999998p 2.5245079999999999e-06 31.675000000000004p 2.5457180000000001e-06 31.6875p 2.563664e-06 31.699999999999999p 2.5783369999999999e-06 31.712500000000002p 2.5897299999999999e-06 31.724999999999998p 2.5978419999999998e-06
+ 31.737500000000004p 2.602673e-06 31.75p 2.604232e-06 31.762499999999999p 2.6025270000000002e-06 31.775000000000002p 2.5975729999999998e-06 31.787499999999998p 2.5893879999999998e-06 31.800000000000004p 2.5779930000000002e-06 31.8125p 2.5634150000000001e-06 31.824999999999996p 2.545684e-06 31.837500000000002p 2.524832e-06 31.849999999999998p 2.5008959999999999e-06 31.862500000000001p 2.4739179999999998e-06 31.875p 2.4439419999999999e-06 31.887499999999996p 2.4110159999999999e-06 31.900000000000002p 2.3751899999999999e-06 31.912499999999998p 2.3365200000000001e-06 31.925000000000001p 2.2950629999999999e-06 31.9375p 2.2508800000000002e-06 31.949999999999996p 2.204037e-06
+ 31.962500000000002p 2.1546000000000001e-06 31.974999999999998p 2.102639e-06 31.987500000000001p 2.0482269999999998e-06 32p 1.9914410000000002e-06 32.012500000000003p 1.932358e-06 32.024999999999999p 1.8710599999999999e-06 32.037500000000001p 1.80763e-06 32.050000000000004p 1.7421550000000001e-06 32.0625p 1.674721e-06 32.075000000000003p 1.60542e-06 32.087499999999999p 1.534344e-06 32.099999999999994p 1.4615849999999999e-06 32.112500000000004p 1.3872409999999999e-06 32.125p 1.3114090000000001e-06 32.137500000000003p 1.2341880000000001e-06 32.149999999999999p 1.155678e-06 32.162499999999994p 1.0759810000000001e-06 32.175000000000004p 9.9519890000000005e-07
+ 32.1875p 9.1343679999999999e-07 32.200000000000003p 8.3079900000000003e-07 32.212499999999999p 7.4739110000000004e-07 32.224999999999994p 6.633191e-07 32.237500000000004p 5.7868989999999996e-07 32.25p 4.9361039999999995e-07 32.262500000000003p 4.08188e-07 32.274999999999999p 3.225302e-07 32.287499999999994p 2.367443e-07 32.300000000000004p 1.509376e-07 32.3125p 6.5217200000000005e-08 32.325000000000003p -2.031034e-08 32.337499999999999p -1.055389e-07 32.349999999999994p -1.9036309999999999e-07 32.362499999999997p -2.746783e-07 32.375p -3.583808e-07 32.387500000000003p -4.4136789999999999e-07 32.399999999999999p -5.2353809999999998e-07
+ 32.412500000000001p -6.0479110000000002e-07 32.424999999999997p -6.8502820000000002e-07 32.4375p -7.6415199999999997e-07 32.450000000000003p -8.4206699999999999e-07 32.462499999999999p -9.1867929999999997e-07 32.475000000000001p -9.9389679999999996e-07 32.487499999999997p -1.0676289999999999e-06 32.5p -1.13979e-06 32.512500000000003p -1.210291e-06 32.524999999999999p -1.2790510000000001e-06 32.537500000000001p -1.345988e-06 32.549999999999997p -1.4110239999999999e-06 32.5625p -1.474083e-06 32.575000000000003p -1.5350910000000001e-06 32.587499999999999p -1.5939779999999999e-06 32.600000000000001p -1.6506759999999999e-06 32.612499999999997p -1.705122e-06 32.625p -1.757252e-06
+ 32.637500000000003p -1.8070090000000001e-06 32.649999999999999p -1.854338e-06 32.662500000000001p -1.899185e-06 32.674999999999997p -1.941502e-06 32.6875p -1.9812429999999999e-06 32.700000000000003p -2.0183670000000002e-06 32.712499999999999p -2.0528340000000002e-06 32.725000000000001p -2.0846080000000001e-06 32.737499999999997p -2.1136590000000001e-06 32.75p -2.139958e-06 32.762500000000003p -2.1634790000000002e-06 32.774999999999999p -2.1842030000000001e-06 32.787500000000001p -2.2021110000000002e-06 32.799999999999997p -2.217189e-06 32.8125p -2.2294269999999999e-06 32.825000000000003p -2.238819e-06 32.837499999999999p -2.2453619999999999e-06 32.850000000000001p -2.249055e-06
+ 32.862499999999997p -2.2499039999999999e-06 32.875p -2.2479149999999999e-06 32.887500000000003p -2.2431019999999998e-06 32.899999999999999p -2.235477e-06 32.912500000000001p -2.2250610000000001e-06 32.924999999999997p -2.2118749999999999e-06 32.9375p -2.1959450000000002e-06 32.950000000000003p -2.1772979999999998e-06 32.962499999999999p -2.155969e-06 32.975000000000001p -2.1319919999999999e-06 32.987499999999997p -2.1054059999999999e-06 33p -2.0762530000000001e-06 33.012500000000003p -2.0445789999999999e-06 33.024999999999999p -2.0104310000000001e-06 33.037500000000001p -1.9738620000000001e-06 33.049999999999997p -1.9349249999999999e-06 33.0625p -1.893677e-06 33.075000000000003p -1.8501779999999999e-06
+ 33.087499999999999p -1.804491e-06 33.100000000000001p -1.7566799999999999e-06 33.112499999999997p -1.7068140000000001e-06 33.125p -1.654962e-06 33.137500000000003p -1.6011969999999999e-06 33.150000000000006p -1.5455930000000001e-06 33.162500000000001p -1.4882269999999999e-06 33.174999999999997p -1.429177e-06 33.1875p -1.3685239999999999e-06 33.199999999999996p -1.30635e-06 33.212500000000006p -1.242739e-06 33.225000000000001p -1.1777759999999999e-06 33.237499999999997p -1.1115479999999999e-06 33.25p -1.044144e-06 33.262499999999996p -9.7565199999999998e-07 33.275000000000006p -9.0616329999999996e-07 33.287500000000001p -8.3576910000000004e-07 33.299999999999997p -7.6456149999999995e-07
+ 33.3125p -6.9263339999999997e-07 33.324999999999996p -6.2007820000000001e-07 33.337500000000006p -5.4698999999999995e-07 33.350000000000001p -4.734628e-07 33.362499999999997p -3.9959110000000001e-07 33.375p -3.2546959999999999e-07 33.387499999999996p -2.5119260000000002e-07 33.400000000000006p -1.7685460000000001e-07 33.412500000000001p -1.0254960000000001e-07 33.424999999999997p -2.8371140000000001e-08 33.4375p 4.5587499999999997e-08 33.449999999999996p 1.192339e-07 33.462499999999999p 1.9247619999999999e-07 33.475000000000001p 2.6522370000000002e-07 33.487499999999997p 3.373863e-07 33.5p 4.0887529999999999e-07 33.512499999999996p 4.7960309999999995e-07 33.524999999999999p 5.4948340000000002e-07
+ 33.537500000000001p 6.1843119999999997e-07 33.550000000000004p 6.8636329999999997e-07 33.5625p 7.5319769999999996e-07 33.574999999999996p 8.1885459999999996e-07 33.587499999999999p 8.8325550000000002e-07 33.600000000000001p 9.4632419999999996e-07 33.612500000000004p 1.007986e-06 33.625p 1.068169e-06 33.637499999999996p 1.126803e-06 33.649999999999999p 1.1838199999999999e-06 33.662500000000001p 1.239155e-06 33.675000000000004p 1.2927430000000001e-06 33.6875p 1.3445250000000001e-06 33.699999999999996p 1.394441e-06 33.712499999999999p 1.4424369999999999e-06 33.725000000000001p 1.4884589999999999e-06 33.737500000000004p 1.532456e-06 33.75p 1.574381e-06
+ 33.762499999999996p 1.6141900000000001e-06 33.774999999999999p 1.6518400000000001e-06 33.787500000000001p 1.6872910000000001e-06 33.800000000000004p 1.7205070000000001e-06 33.8125p 1.7514559999999999e-06 33.824999999999996p 1.7801070000000001e-06 33.837499999999999p 1.806431e-06 33.850000000000001p 1.830405e-06 33.862500000000004p 1.852008e-06 33.875p 1.8712200000000001e-06 33.887500000000003p 1.8880270000000001e-06 33.899999999999999p 1.902416e-06 33.912500000000001p 1.9143780000000001e-06 33.925000000000004p 1.9239069999999999e-06 33.9375p 1.930999e-06 33.950000000000003p 1.9356550000000002e-06 33.962499999999999p 1.9378779999999999e-06 33.974999999999994p 1.9376720000000002e-06
+ 33.987500000000004p 1.9350480000000002e-06 34p 1.930017e-06 34.012500000000003p 1.922593e-06 34.024999999999999p 1.9127950000000002e-06 34.037499999999994p 1.900643e-06 34.050000000000004p 1.886161e-06 34.0625p 1.869374e-06 34.075000000000003p 1.850311e-06 34.087499999999999p 1.8290049999999999e-06 34.099999999999994p 1.805489e-06 34.112500000000004p 1.7798009999999999e-06 34.125p 1.75198e-06 34.137500000000003p 1.7220669999999999e-06 34.149999999999999p 1.6901079999999999e-06 34.162499999999994p 1.656149e-06 34.175000000000004p 1.620239e-06 34.1875p 1.5824300000000001e-06 34.200000000000003p 1.542774e-06
+ 34.212499999999999p 1.5013280000000001e-06 34.224999999999994p 1.4581489999999999e-06 34.237499999999997p 1.413297e-06 34.25p 1.366833e-06 34.262500000000003p 1.3188209999999999e-06 34.274999999999999p 1.2693249999999999e-06 34.287500000000001p 1.2184109999999999e-06 34.299999999999997p 1.166149e-06 34.3125p 1.1126059999999999e-06 34.325000000000003p 1.0578559999999999e-06 34.337499999999999p 1.0019680000000001e-06 34.350000000000001p 9.4501739999999997e-07 34.362499999999997p 8.8707779999999999e-07 34.375p 8.2822480000000004e-07 34.387500000000003p 7.6853450000000003e-07 34.399999999999999p 7.0808420000000001e-07 34.412500000000001p 6.4695150000000005e-07 34.424999999999997p 5.8521480000000003e-07
+ 34.4375p 5.2295310000000003e-07 34.450000000000003p 4.6024559999999998e-07 34.462499999999999p 3.9717180000000002e-07 34.475000000000001p 3.3381180000000001e-07 34.487499999999997p 2.7024519999999998e-07 34.5p 2.0655219999999999e-07 34.512500000000003p 1.4281250000000001e-07 34.524999999999999p 7.9105860000000002e-08 34.537500000000001p 1.5511599999999998e-08 34.549999999999997p -4.7891259999999999e-08 34.5625p -1.110242e-07 34.575000000000003p -1.738092e-07 34.587499999999999p -2.36169e-07 34.600000000000001p -2.98027e-07 34.612499999999997p -3.5930759999999998e-07 34.625p -4.1993609999999997e-07 34.637500000000003p -4.7983870000000004e-07 34.649999999999999p -5.3894290000000002e-07
+ 34.662500000000001p -5.9717719999999996e-07 34.674999999999997p -6.5447169999999998e-07 34.6875p -7.1075770000000001e-07 34.700000000000003p -7.6596780000000004e-07 34.712499999999999p -8.2003650000000004e-07 34.725000000000001p -8.7289979999999995e-07 34.737499999999997p -9.2449519999999995e-07 34.75p -9.7476209999999992e-07 34.762500000000003p -1.0236419999999999e-06 34.774999999999999p -1.071078e-06 34.787500000000001p -1.1170150000000001e-06 34.799999999999997p -1.1614e-06 34.8125p -1.204184e-06 34.825000000000003p -1.245316e-06 34.837499999999999p -1.2847510000000001e-06 34.850000000000001p -1.322446e-06 34.862499999999997p -1.3583570000000001e-06 34.875p -1.392446e-06
+ 34.887500000000003p -1.4246770000000001e-06 34.899999999999999p -1.455014e-06 34.912500000000001p -1.4834249999999999e-06 34.924999999999997p -1.509881e-06 34.9375p -1.5343559999999999e-06 34.950000000000003p -1.5568240000000001e-06 34.962499999999999p -1.577265e-06 34.975000000000001p -1.5956579999999999e-06 34.987499999999997p -1.6119890000000001e-06 35p -1.6262420000000001e-06 35.012500000000003p -1.638407e-06 35.025000000000006p -1.6484749999999999e-06 35.037500000000001p -1.656441e-06 35.049999999999997p -1.662302e-06 35.0625p -1.6660560000000001e-06 35.074999999999996p -1.6677079999999999e-06 35.087500000000006p -1.6672600000000001e-06 35.100000000000001p -1.6647210000000001e-06
+ 35.112499999999997p -1.6601020000000001e-06 35.125p -1.6534140000000001e-06 35.137499999999996p -1.644674e-06 35.150000000000006p -1.6338989999999999e-06 35.162500000000001p -1.6211100000000001e-06 35.174999999999997p -1.6063289999999999e-06 35.1875p -1.5895829999999999e-06 35.199999999999996p -1.570898e-06 35.212500000000006p -1.5503049999999999e-06 35.225000000000001p -1.527837e-06 35.237499999999997p -1.503528e-06 35.25p -1.477415e-06 35.262499999999996p -1.449537e-06 35.275000000000006p -1.4199360000000001e-06 35.287500000000001p -1.388655e-06 35.299999999999997p -1.35574e-06 35.3125p -1.3212360000000001e-06 35.324999999999996p -1.285194e-06
+ 35.337499999999999p -1.247665e-06 35.350000000000001p -1.2087e-06 35.362499999999997p -1.1683539999999999e-06 35.375p -1.1266829999999999e-06 35.387499999999996p -1.083744e-06 35.399999999999999p -1.0395960000000001e-06 35.412500000000001p -9.9429789999999996e-07 35.425000000000004p -9.4791179999999999e-07 35.4375p -9.0049989999999995e-07 35.449999999999996p -8.5212550000000003e-07 35.462499999999999p -8.0285300000000005e-07 35.475000000000001p -7.5274790000000002e-07 35.487500000000004p -7.0187630000000001e-07 35.5p -6.5030490000000003e-07 35.512499999999996p -5.9810140000000004e-07 35.524999999999999p -5.4533369999999995e-07 35.537500000000001p -4.9207040000000001e-07 35.550000000000004p -4.3838040000000001e-07
+ 35.5625p -3.8433289999999999e-07 35.574999999999996p -3.2999709999999998e-07 35.587499999999999p -2.7544259999999999e-07 35.600000000000001p -2.2073890000000001e-07 35.612500000000004p -1.6595530000000001e-07 35.625p -1.11161e-07 35.637499999999996p -5.6425100000000003e-08 35.649999999999999p -1.816176e-09 35.662500000000001p 5.2597550000000001e-08 35.675000000000004p 1.0674840000000001e-07 35.6875p 1.605692e-07 35.699999999999996p 2.1399349999999999e-07 35.712499999999999p 2.6695580000000001e-07 35.725000000000001p 3.1939099999999998e-07 35.737500000000004p 3.7123540000000002e-07 35.75p 4.22426e-07 35.762500000000003p 4.7290089999999999e-07 35.774999999999999p 5.2259940000000003e-07
+ 35.787500000000001p 5.714621e-07 35.800000000000004p 6.1943059999999999e-07 35.8125p 6.6644820000000002e-07 35.825000000000003p 7.1245939999999996e-07 35.837499999999999p 7.5741019999999999e-07 35.849999999999994p 8.0124819999999999e-07 35.862500000000004p 8.4392260000000001e-07 35.875p 8.8538419999999999e-07 35.887500000000003p 9.2558560000000005e-07 35.899999999999999p 9.6448110000000009e-07 35.912499999999994p 1.002027e-06 35.925000000000004p 1.038181e-06 35.9375p 1.072903e-06 35.950000000000003p 1.1061549999999999e-06 35.962499999999999p 1.1378999999999999e-06 35.974999999999994p 1.168106e-06 35.987500000000004p 1.1967389999999999e-06 36p 1.223769e-06
+ 36.012500000000003p 1.249169e-06 36.024999999999999p 1.2729130000000001e-06 36.037499999999994p 1.2949770000000001e-06 36.050000000000004p 1.31534e-06 36.0625p 1.333983e-06 36.075000000000003p 1.350889e-06 36.087499999999999p 1.366042e-06 36.099999999999994p 1.3794310000000001e-06 36.112499999999997p 1.3910450000000001e-06 36.125p 1.400876e-06 36.137500000000003p 1.408918e-06 36.149999999999999p 1.415168e-06 36.162500000000001p 1.419624e-06 36.174999999999997p 1.422288e-06 36.1875p 1.423162e-06 36.200000000000003p 1.4222520000000001e-06 36.212499999999999p 1.419565e-06 36.225000000000001p 1.4151119999999999e-06
+ 36.237499999999997p 1.4089030000000001e-06 36.25p 1.400954e-06 36.262500000000003p 1.391279e-06 36.274999999999999p 1.3798980000000001e-06 36.287500000000001p 1.36683e-06 36.299999999999997p 1.3520980000000001e-06 36.3125p 1.3357270000000001e-06 36.325000000000003p 1.317741e-06 36.337499999999999p 1.2981699999999999e-06 36.350000000000001p 1.277044e-06 36.362499999999997p 1.254393e-06 36.375p 1.2302520000000001e-06 36.387500000000003p 1.204657e-06 36.399999999999999p 1.1776430000000001e-06 36.412500000000001p 1.1492500000000001e-06 36.424999999999997p 1.1195179999999999e-06 36.4375p 1.0884879999999999e-06 36.450000000000003p 1.0562050000000001e-06
+ 36.462499999999999p 1.0227110000000001e-06 36.475000000000001p 9.880542e-07 36.487499999999997p 9.5228079999999999e-07 36.5p 9.1543960000000003e-07 36.512500000000003p 8.7757999999999995e-07 36.524999999999999p 8.3875289999999995e-07 36.537500000000001p 7.990101e-07 36.549999999999997p 7.584042e-07 36.5625p 7.1698910000000003e-07 36.575000000000003p 6.7481899999999998e-07 36.587499999999999p 6.3194939999999998e-07 36.600000000000001p 5.8843599999999999e-07 36.612499999999997p 5.4433559999999999e-07 36.625p 4.9970519999999997e-07 36.637500000000003p 4.5460229999999999e-07 36.649999999999999p 4.0908509999999998e-07 36.662500000000001p 3.632118e-07 36.674999999999997p 3.1704100000000001e-07
+ 36.6875p 2.7063150000000002e-07 36.700000000000003p 2.240422e-07 36.712499999999999p 1.7733199999999999e-07 36.725000000000001p 1.3055990000000001e-07 36.737499999999997p 8.3784580000000004e-08 36.75p 3.7064710000000002e-08 36.762500000000003p -9.5413460000000003e-09 36.774999999999999p -5.5975539999999997e-08 36.787500000000001p -1.021802e-07 36.799999999999997p -1.4809819999999999e-07 36.8125p -1.936729e-07 36.825000000000003p -2.3884809999999999e-07 36.837499999999999p -2.8356859999999999e-07 36.850000000000001p -3.2777960000000002e-07 36.862499999999997p -3.7142750000000002e-07 36.875p -4.1445909999999998e-07 36.887499999999996p -4.568225e-07 36.900000000000006p -4.9846669999999998e-07
+ 36.912500000000001p -5.3934159999999999e-07 36.924999999999997p -5.7939849999999997e-07 36.9375p -6.1858970000000001e-07 36.949999999999996p -6.5686869999999997e-07 36.962500000000006p -6.9419050000000001e-07 36.975000000000001p -7.3051109999999996e-07 36.987499999999997p -7.6578820000000001e-07 37p -7.9998090000000003e-07 37.012499999999996p -8.3304969999999998e-07 37.025000000000006p -8.6495659999999999e-07 37.037500000000001p -8.9566540000000002e-07 37.049999999999997p -9.251412e-07 37.0625p -9.5335110000000002e-07 37.074999999999996p -9.8026360000000005e-07 37.087500000000006p -1.005849e-06 37.100000000000001p -1.03008e-06 37.112499999999997p -1.0529300000000001e-06 37.125p -1.074375e-06
+ 37.137499999999996p -1.0943930000000001e-06 37.150000000000006p -1.112962e-06 37.162500000000001p -1.1300650000000001e-06 37.174999999999997p -1.1456849999999999e-06 37.1875p -1.1598070000000001e-06 37.199999999999996p -1.1724180000000001e-06 37.212499999999999p -1.183508e-06 37.225000000000001p -1.193067e-06 37.237499999999997p -1.2010889999999999e-06 37.25p -1.2075680000000001e-06 37.262499999999996p -1.2125020000000001e-06 37.274999999999999p -1.21589e-06 37.287500000000001p -1.2177330000000001e-06 37.300000000000004p -1.2180330000000001e-06 37.3125p -1.216795e-06 37.324999999999996p -1.214027e-06 37.337499999999999p -1.209737e-06 37.350000000000001p -1.2039349999999999e-06
+ 37.362500000000004p -1.196635e-06 37.375p -1.18785e-06 37.387499999999996p -1.1775970000000001e-06 37.399999999999999p -1.165894e-06 37.412500000000001p -1.15276e-06 37.425000000000004p -1.138218e-06 37.4375p -1.12229e-06 37.449999999999996p -1.105001e-06 37.462499999999999p -1.0863789999999999e-06 37.475000000000001p -1.066451e-06 37.487500000000004p -1.045247e-06 37.5p -1.0227979999999999e-06 37.512499999999996p -9.9913800000000009e-07 37.524999999999999p -9.7429989999999999e-07 37.537500000000001p -9.4831989999999997e-07 37.550000000000004p -9.2123469999999995e-07 37.5625p -8.9308259999999996e-07 37.574999999999996p -8.6390299999999998e-07
+ 37.587499999999999p -8.3373639999999996e-07 37.600000000000001p -8.0262469999999997e-07 37.612500000000004p -7.7061040000000001e-07 37.625p -7.3773739999999998e-07 37.637500000000003p -7.0405020000000005e-07 37.649999999999999p -6.6959460000000001e-07 37.662500000000001p -6.3441670000000003e-07 37.675000000000004p -5.9856379999999995e-07 37.6875p -5.620836e-07 37.700000000000003p -5.2502449999999999e-07 37.712499999999999p -4.8743559999999995e-07 37.724999999999994p -4.4936619999999999e-07 37.737500000000004p -4.1086620000000001e-07 37.75p -3.7198599999999998e-07 37.762500000000003p -3.3277599999999999e-07 37.774999999999999p -2.9328710000000002e-07 37.787499999999994p -2.5357010000000001e-07 37.800000000000004p -2.136762e-07
+ 37.8125p -1.7365630000000001e-07 37.825000000000003p -1.3356159999999999e-07 37.837499999999999p -9.3442959999999999e-08 37.849999999999994p -5.335117e-08 37.862500000000004p -1.333677e-08 37.875p 2.654996e-08 37.887500000000003p 6.6259130000000006e-08 37.899999999999999p 1.057412e-07 37.912499999999994p 1.4494730000000001e-07 37.925000000000004p 1.8382879999999999e-07 37.9375p 2.223379e-07 37.950000000000003p 2.6042730000000001e-07 37.962499999999999p 2.9805050000000001e-07 37.974999999999994p 3.351619e-07 37.987499999999997p 3.7171640000000001e-07 38p 4.0767009999999999e-07 38.012500000000003p 4.4297969999999998e-07 38.024999999999999p 4.7760329999999999e-07
+ 38.037500000000001p 5.1149960000000003e-07 38.049999999999997p 5.4462869999999997e-07 38.0625p 5.7695160000000002e-07 38.075000000000003p 6.0843060000000001e-07 38.087499999999999p 6.3902919999999998e-07 38.100000000000001p 6.6871199999999996e-07 38.112499999999997p 6.974451e-07 38.125p 7.2519579999999997e-07 38.137500000000003p 7.5193280000000003e-07 38.149999999999999p 7.7762620000000004e-07 38.162500000000001p 8.0224749999999996e-07 38.174999999999997p 8.2576960000000005e-07 38.1875p 8.4816709999999997e-07 38.200000000000003p 8.6941589999999996e-07 38.212499999999999p 8.894934e-07 38.225000000000001p 9.0837869999999998e-07 38.237499999999997p 9.2605249999999997e-07 38.25p 9.42497e-07
+ 38.262500000000003p 9.576958999999999e-07 38.274999999999999p 9.7163479999999997e-07 38.287500000000001p 9.8430070000000004e-07 38.299999999999997p 9.9568230000000001e-07 38.3125p 1.00577e-06 38.325000000000003p 1.014556e-06 38.337499999999999p 1.022033e-06 38.350000000000001p 1.0281979999999999e-06 38.362499999999997p 1.0330469999999999e-06 38.375p 1.036578e-06 38.387500000000003p 1.0387929999999999e-06 38.399999999999999p 1.039693e-06 38.412500000000001p 1.0392810000000001e-06 38.424999999999997p 1.0375630000000001e-06 38.4375p 1.034545e-06 38.450000000000003p 1.0302370000000001e-06 38.462499999999999p 1.0246469999999999e-06 38.475000000000001p 1.0177879999999999e-06
+ 38.487499999999997p 1.0096719999999999e-06 38.5p 1.000315e-06 38.512500000000003p 9.8973130000000007e-07 38.524999999999999p 9.7793990000000009e-07 38.537500000000001p 9.649592000000001e-07 38.549999999999997p 9.508097e-07 38.5625p 9.3551330000000005e-07 38.575000000000003p 9.1909300000000004e-07 38.587499999999999p 9.0157340000000004e-07 38.600000000000001p 8.8298009999999998e-07 38.612499999999997p 8.6334030000000003e-07 38.625p 8.4268200000000003e-07 38.637500000000003p 8.210346e-07 38.649999999999999p 7.9842880000000002e-07 38.662500000000001p 7.7489599999999998e-07 38.674999999999997p 7.5046900000000005e-07 38.6875p 7.2518129999999999e-07 38.700000000000003p 6.990676e-07
+ 38.712499999999999p 6.721634e-07 38.725000000000001p 6.4450510000000001e-07 38.737499999999997p 6.1612989999999995e-07 38.75p 5.8707570000000001e-07 38.762499999999996p 5.5738120000000004e-07 38.775000000000006p 5.2708589999999999e-07 38.787500000000001p 4.9622969999999996e-07 38.799999999999997p 4.6485310000000001e-07 38.8125p 4.3299719999999998e-07 38.824999999999996p 4.0070360000000002e-07 38.837500000000006p 3.6801420000000001e-07 38.850000000000001p 3.349712e-07 38.862499999999997p 3.0161740000000002e-07 38.875p 2.679955e-07 38.887499999999996p 2.3414870000000001e-07 38.900000000000006p 2.0012009999999999e-07 38.912500000000001p 1.65953e-07 38.924999999999997p 1.3169070000000001e-07
+ 38.9375p 9.7376659999999997e-08 38.949999999999996p 6.3054000000000003e-08 38.962500000000006p 2.8765859999999999e-08 38.975000000000001p -5.4448089999999996e-09 38.987499999999997p -3.9535299999999999e-08 39p -7.3463190000000002e-08 39.012499999999996p -1.071864e-07 39.025000000000006p -1.406632e-07 39.037500000000001p -1.7385229999999999e-07 39.049999999999997p -2.0671300000000001e-07 39.0625p -2.39205e-07 39.074999999999996p -2.7128859999999999e-07 39.087499999999999p -3.029249e-07 39.100000000000001p -3.3407539999999997e-07 39.112500000000004p -3.6470259999999999e-07 39.125p -3.9476960000000001e-07 39.137499999999996p -4.2424040000000001e-07 39.149999999999999p -4.5307979999999999e-07
+ 39.162500000000001p -4.8125359999999998e-07 39.175000000000004p -5.0872829999999995e-07 39.1875p -5.3547170000000004e-07 39.199999999999996p -5.614525e-07 39.212499999999999p -5.8664029999999999e-07 39.225000000000001p -6.1100600000000001e-07 39.237500000000004p -6.3452140000000004e-07 39.25p -6.5715980000000001e-07 39.262499999999996p -6.7889529999999997e-07 39.274999999999999p -6.9970350000000004e-07 39.287500000000001p -7.1956109999999999e-07 39.300000000000004p -7.3844610000000004e-07 39.3125p -7.5633779999999997e-07 39.324999999999996p -7.7321680000000002e-07 39.337499999999999p -7.8906510000000002e-07 39.350000000000001p -8.0386599999999995e-07 39.362500000000004p -8.1760409999999996e-07 39.375p -8.3026559999999996e-07
+ 39.387499999999996p -8.4183789999999998e-07 39.399999999999999p -8.5230989999999999e-07 39.412500000000001p -8.6167180000000003e-07 39.425000000000004p -8.6991559999999997e-07 39.4375p -8.7703430000000005e-07 39.449999999999996p -8.8302250000000004e-07 39.462499999999999p -8.8787640000000005e-07 39.475000000000001p -8.9159339999999995e-07 39.487500000000004p -8.9417259999999997e-07 39.5p -8.9561430000000004e-07 39.512500000000003p -8.9592039999999996e-07 39.524999999999999p -8.9509420000000005e-07 39.537500000000001p -8.9314030000000005e-07 39.550000000000004p -8.900649e-07 39.5625p -8.8587550000000002e-07 39.575000000000003p -8.8058099999999999e-07 39.587499999999999p -8.7419169999999999e-07 39.599999999999994p -8.6671919999999998e-07
+ 39.612500000000004p -8.5817649999999998e-07 39.625p -8.485779e-07 39.637500000000003p -8.3793890000000003e-07 39.649999999999999p -8.2627630000000004e-07 39.662499999999994p -8.1360840000000001e-07 39.675000000000004p -7.9995429999999999e-07 39.6875p -7.8533450000000002e-07 39.700000000000003p -7.6977079999999998e-07 39.712499999999999p -7.532858e-07 39.724999999999994p -7.3590339999999996e-07 39.737500000000004p -7.1764860000000003e-07 39.75p -6.9854739999999996e-07 39.762500000000003p -6.7862650000000004e-07 39.774999999999999p -6.5791409999999999e-07 39.787499999999994p -6.3643870000000005e-07 39.800000000000004p -6.1423010000000001e-07 39.8125p -5.9131890000000001e-07 39.825000000000003p -5.6773630000000005e-07
+ 39.837499999999999p -5.4351420000000002e-07 39.849999999999994p -5.1868559999999997e-07 39.862499999999997p -4.9328369999999996e-07 39.875p -4.6734260000000001e-07 39.887500000000003p -4.4089680000000002e-07 39.899999999999999p -4.1398149999999999e-07 39.912500000000001p -3.8663229999999999e-07 39.924999999999997p -3.5888499999999997e-07 39.9375p -3.3077619999999998e-07 39.950000000000003p -3.023426e-07 39.962499999999999p -2.7362100000000001e-07 39.975000000000001p -2.4464889999999999e-07 39.987499999999997p -2.1546349999999999e-07 40p -1.861025e-07 40.012500000000003p -1.566036e-07 40.024999999999999p -1.2700440000000001e-07 40.037500000000001p -9.7342629999999995e-08 40.049999999999997p -6.7655940000000001e-08
+ 40.0625p -3.798187e-08 40.075000000000003p -8.3578239999999996e-09 40.087499999999999p 2.1179000000000001e-08 40.100000000000001p 5.0591639999999998e-08 40.112499999999997p 7.9843419999999997e-08 40.125p 1.08898e-07 40.137500000000003p 1.3771940000000001e-07 40.149999999999999p 1.6627220000000001e-07 40.162500000000001p 1.9452109999999999e-07 40.174999999999997p 2.2243170000000001e-07 40.1875p 2.4997000000000001e-07 40.200000000000003p 2.7710239999999998e-07 40.212499999999999p 3.0379629999999998e-07 40.225000000000001p 3.3001950000000003e-07 40.237499999999997p 3.5574059999999999e-07 40.25p 3.8092889999999999e-07 40.262500000000003p 4.0555449999999999e-07 40.274999999999999p 4.2958839999999999e-07
+ 40.287500000000001p 4.5300230000000002e-07 40.299999999999997p 4.7576890000000001e-07 40.3125p 4.9786179999999995e-07 40.325000000000003p 5.1925540000000005e-07 40.337499999999999p 5.3992529999999999e-07 40.350000000000001p 5.5984790000000003e-07 40.362499999999997p 5.7900080000000003e-07 40.375p 5.9736239999999997e-07 40.387500000000003p 6.1491249999999996e-07 40.399999999999999p 6.3163179999999996e-07 40.412500000000001p 6.47502e-07 40.424999999999997p 6.6250619999999995e-07 40.4375p 6.7662840000000001e-07 40.450000000000003p 6.8985390000000001e-07 40.462499999999999p 7.021692e-07 40.475000000000001p 7.1356200000000005e-07 40.487499999999997p 7.2402100000000002e-07 40.5p 7.3353630000000001e-07
+ 40.512500000000003p 7.4209920000000002e-07 40.524999999999999p 7.4970220000000004e-07 40.537500000000001p 7.5633899999999998e-07 40.549999999999997p 7.6200460000000003e-07 40.5625p 7.6669510000000002e-07 40.575000000000003p 7.7040799999999997e-07 40.587499999999999p 7.7314199999999995e-07 40.600000000000001p 7.7489680000000002e-07 40.612499999999997p 7.7567370000000004e-07 40.625p 7.7547499999999997e-07 40.637499999999996p 7.7430420000000003e-07 40.650000000000006p 7.7216600000000001e-07 40.662500000000001p 7.690665e-07 40.674999999999997p 7.6501259999999995e-07 40.6875p 7.6001279999999998e-07 40.699999999999996p 7.5407639999999995e-07 40.712500000000006p 7.4721410000000003e-07 40.725000000000001p 7.394374e-07
+ 40.737499999999997p 7.3075930000000002e-07 40.75p 7.2119360000000005e-07 40.762499999999996p 7.1075520000000005e-07 40.775000000000006p 6.9946019999999998e-07 40.787500000000001p 6.8732539999999999e-07 40.799999999999997p 6.7436900000000005e-07 40.8125p 6.6060980000000005e-07 40.824999999999996p 6.4606769999999998e-07 40.837500000000006p 6.3076359999999995e-07 40.850000000000001p 6.1471909999999995e-07 40.862499999999997p 5.9795669999999998e-07 40.875p 5.8049980000000001e-07 40.887499999999996p 5.6237260000000003e-07 40.900000000000006p 5.4359979999999999e-07 40.912500000000001p 5.2420710000000002e-07 40.924999999999997p 5.0422089999999998e-07 40.9375p 4.8366810000000003e-07 40.949999999999996p 4.6257619999999998e-07
+ 40.962499999999999p 4.4097330000000002e-07 40.975000000000001p 4.1888829999999999e-07 40.987500000000004p 3.963503e-07 41p 3.7338900000000001e-07 41.012499999999996p 3.5003449999999998e-07 41.024999999999999p 3.2631719999999998e-07 41.037500000000001p 3.0226800000000002e-07 41.050000000000004p 2.7791820000000002e-07 41.0625p 2.5329909999999999e-07 41.074999999999996p 2.284424e-07 41.087499999999999p 2.0337989999999999e-07 41.100000000000001p 1.781438e-07 41.112500000000004p 1.5276600000000001e-07 41.125p 1.2727889999999999e-07 41.137499999999996p 1.017147e-07 41.149999999999999p 7.6105569999999995e-08 41.162500000000001p 5.048374e-08 41.175000000000004p 2.4881299999999999e-08
+ 41.1875p -6.6976890000000002e-10 41.199999999999996p -2.613767e-08 41.212499999999999p -5.1490799999999997e-08 41.225000000000001p -7.6697800000000005e-08 41.237500000000004p -1.017276e-07 41.25p -1.265494e-07 41.262499999999996p -1.5113289999999999e-07 41.274999999999999p -1.75448e-07 41.287500000000001p -1.994652e-07 41.300000000000004p -2.2315529999999999e-07 41.3125p -2.4648979999999999e-07 41.324999999999996p -2.6944060000000002e-07 41.337499999999999p -2.9198009999999999e-07 41.350000000000001p -3.140816e-07 41.362500000000004p -3.3571859999999999e-07 41.375p -3.5686570000000001e-07 41.387500000000003p -3.774978e-07 41.399999999999999p -3.9759089999999998e-07
+ 41.412500000000001p -4.1712150000000001e-07 41.425000000000004p -4.360668e-07 41.4375p -4.5440520000000001e-07 41.450000000000003p -4.721155e-07 41.462499999999999p -4.8917770000000001e-07 41.474999999999994p -5.0557229999999997e-07 41.487500000000004p -5.2128099999999999e-07 41.5p -5.3628639999999996e-07 41.512500000000003p -5.505719e-07 41.524999999999999p -5.6412189999999996e-07 41.537499999999994p -5.7692180000000002e-07 41.550000000000004p -5.88958e-07 41.5625p -6.0021779999999997e-07 41.575000000000003p -6.1068970000000005e-07 41.587499999999999p -6.2036320000000004e-07 41.599999999999994p -6.2922849999999999e-07 41.612500000000004p -6.3727730000000005e-07 41.625p -6.4450210000000003e-07
+ 41.637500000000003p -6.5089660000000004e-07 41.649999999999999p -6.5645530000000004e-07 41.662499999999994p -6.6117400000000004e-07 41.675000000000004p -6.6504969999999996e-07 41.6875p -6.6807999999999998e-07 41.700000000000003p -6.7026409999999996e-07 41.712499999999999p -6.7160189999999996e-07 41.724999999999994p -6.720944e-07 41.737499999999997p -6.7174400000000001e-07 41.75p -6.7055360000000002e-07 41.762500000000003p -6.6852770000000004e-07 41.774999999999999p -6.6567139999999995e-07 41.787500000000001p -6.6199120000000003e-07 41.799999999999997p -6.5749419999999998e-07 41.8125p -6.5218880000000001e-07 41.825000000000003p -6.460844e-07 41.837499999999999p -6.3919130000000005e-07 41.850000000000001p -6.3152059999999999e-07
+ 41.862499999999997p -6.2308459999999995e-07 41.875p -6.1389640000000003e-07 41.887500000000003p -6.0397010000000002e-07 41.899999999999999p -5.9332039999999999e-07 41.912500000000001p -5.8196329999999996e-07 41.924999999999997p -5.6991520000000002e-07 41.9375p -5.5719360000000001e-07 41.950000000000003p -5.438167e-07 41.962499999999999p -5.2980349999999998e-07 41.975000000000001p -5.1517360000000001e-07 41.987499999999997p -4.9994759999999995e-07 42p -4.8414640000000002e-07 42.012500000000003p -4.677918e-07 42.024999999999999p -4.5090619999999999e-07 42.037500000000001p -4.3351259999999998e-07 42.049999999999997p -4.1563449999999999e-07 42.0625p -3.9729589999999999e-07 42.075000000000003p -3.7852139999999997e-07
+ 42.087499999999999p -3.5933609999999997e-07 42.100000000000001p -3.3976519999999998e-07 42.112499999999997p -3.1983480000000002e-07 42.125p -2.99571e-07 42.137500000000003p -2.7900030000000003e-07 42.149999999999999p -2.581496e-07 42.162500000000001p -2.3704599999999999e-07 42.174999999999997p -2.1571679999999999e-07 42.1875p -1.9418939999999999e-07 42.200000000000003p -1.7249160000000001e-07 42.212499999999999p -1.5065110000000001e-07 42.225000000000001p -1.2869579999999999e-07 42.237499999999997p -1.066536e-07 42.25p -8.455239e-08 42.262500000000003p -6.2420070000000002e-08 42.274999999999999p -4.0284479999999999e-08 42.287500000000001p -1.8173359999999999e-08 42.299999999999997p 3.8856649999999999e-09
+ 42.3125p 2.5865159999999998e-08 42.325000000000003p 4.7737860000000002e-08 42.337499999999999p 6.9476740000000004e-08 42.350000000000001p 9.105505e-08 42.362499999999997p 1.124463e-07 42.375p 1.336244e-07 42.387500000000003p 1.5456349999999999e-07 42.399999999999999p 1.752383e-07 42.412500000000001p 1.9562379999999999e-07 42.424999999999997p 2.1569549999999999e-07 42.4375p 2.3542940000000001e-07 42.450000000000003p 2.548018e-07 42.462499999999999p 2.7378990000000003e-07 42.475000000000001p 2.9237119999999998e-07 42.487499999999997p 3.1052390000000002e-07 42.5p 3.2822680000000001e-07 42.512499999999996p 3.4545930000000003e-07 42.525000000000006p 3.622014e-07
+ 42.537500000000001p 3.7843399999999999e-07 42.549999999999997p 3.9413839999999997e-07 42.5625p 4.0929700000000002e-07 42.574999999999996p 4.2389259999999997e-07 42.587500000000006p 4.3790900000000001e-07 42.600000000000001p 4.513307e-07 42.612499999999997p 4.6414290000000001e-07 42.625p 4.763317e-07 42.637499999999996p 4.8788419999999999e-07 42.650000000000006p 4.9878799999999998e-07 42.662500000000001p 5.0903190000000001e-07 42.674999999999997p 5.1860520000000001e-07 42.6875p 5.2749840000000005e-07 42.699999999999996p 5.3570280000000001e-07 42.712500000000006p 5.4321039999999997e-07 42.725000000000001p 5.5001439999999996e-07 42.737499999999997p 5.5610860000000002e-07 42.75p 5.6148800000000003e-07
+ 42.762499999999996p 5.6614830000000005e-07 42.775000000000006p 5.7008619999999997e-07 42.787500000000001p 5.7329920000000004e-07 42.799999999999997p 5.7578599999999999e-07 42.8125p 5.7754590000000004e-07 42.824999999999996p 5.7857919999999999e-07 42.837499999999999p 5.7888720000000002e-07 42.850000000000001p 5.7847200000000002e-07 42.862500000000004p 5.7733659999999996e-07 42.875p 5.7548500000000005e-07 42.887499999999996p 5.7292200000000003e-07 42.899999999999999p 5.6965319999999998e-07 42.912500000000001p 5.6568509999999999e-07 42.925000000000004p 5.6102520000000005e-07 42.9375p 5.5568170000000004e-07 42.949999999999996p 5.4966349999999995e-07 42.962499999999999p 5.4298059999999996e-07 42.975000000000001p 5.3564350000000004e-07
+ 42.987500000000004p 5.2766380000000002e-07 43p 5.1905359999999996e-07 43.012499999999996p 5.0982579999999996e-07 43.024999999999999p 4.9999400000000002e-07 43.037500000000001p 4.8957270000000001e-07 43.050000000000004p 4.7857690000000002e-07 43.0625p 4.6702229999999999e-07 43.074999999999996p 4.5492530000000001e-07 43.087499999999999p 4.4230279999999998e-07 43.100000000000001p 4.291724e-07 43.112500000000004p 4.1555220000000003e-07 43.125p 4.0146100000000002e-07 43.137499999999996p 3.8691789999999998e-07 43.149999999999999p 3.7194269999999998e-07 43.162500000000001p 3.5655559999999998e-07 43.175000000000004p 3.4077709999999997e-07 43.1875p 3.2462839999999998e-07 43.199999999999996p 3.0813089999999998e-07
+ 43.212499999999999p 2.913064e-07 43.225000000000001p 2.7417700000000001e-07 43.237500000000004p 2.5676519999999999e-07 43.25p 2.3909359999999999e-07 43.262500000000003p 2.2118530000000001e-07 43.274999999999999p 2.0306350000000001e-07 43.287499999999994p 1.847515e-07 43.300000000000004p 1.6627280000000001e-07 43.3125p 1.476511e-07 43.325000000000003p 1.2891019999999999e-07 43.337499999999999p 1.100738e-07 43.349999999999994p 9.1165950000000001e-08 43.362500000000004p 7.2210410000000001e-08 43.375p 5.3231049999999998e-08 43.387500000000003p 3.4251690000000002e-08 43.399999999999999p 1.529604e-08 43.412499999999994p -3.6122770000000001e-09 43.425000000000004p -2.2449789999999998e-08
+ 43.4375p -4.1193189999999998e-08 43.450000000000003p -5.9819359999999997e-08 43.462499999999999p -7.8305429999999997e-08 43.474999999999994p -9.6628739999999994e-08 43.487500000000004p -1.1476690000000001e-07 43.5p -1.3269799999999999e-07 43.512500000000003p -1.5040020000000001e-07 43.524999999999999p -1.6785210000000001e-07 43.537499999999994p -1.8503289999999999e-07 43.550000000000004p -2.0192190000000001e-07 43.5625p -2.184991e-07 43.575000000000003p -2.347447e-07 43.587499999999999p -2.5063950000000001e-07 43.599999999999994p -2.6616499999999997e-07 43.612499999999997p -2.813029e-07 43.625p -2.9603560000000002e-07 43.637500000000003p -3.1034610000000001e-07 43.649999999999999p -3.2421789999999998e-07
+ 43.662500000000001p -3.376352e-07 43.674999999999997p -3.505828e-07 43.6875p -3.630461e-07 43.700000000000003p -3.7501109999999999e-07 43.712499999999999p -3.8646459999999999e-07 43.725000000000001p -3.9739409999999998e-07 43.737499999999997p -4.077876e-07 43.75p -4.1763410000000001e-07 43.762500000000003p -4.2692309999999998e-07 43.774999999999999p -4.3564489999999999e-07 43.787500000000001p -4.4379049999999999e-07 43.799999999999997p -4.5135179999999999e-07 43.8125p -4.5832139999999999e-07 43.825000000000003p -4.6469249999999998e-07 43.837499999999999p -4.7045939999999999e-07 43.850000000000001p -4.7561680000000001e-07 43.862499999999997p -4.8016059999999999e-07 43.875p -4.8408700000000001e-07
+ 43.887500000000003p -4.8739350000000002e-07 43.899999999999999p -4.90078e-07 43.912500000000001p -4.9213940000000001e-07 43.924999999999997p -4.9357729999999995e-07 43.9375p -4.9439210000000002e-07 43.950000000000003p -4.94585e-07 43.962499999999999p -4.9415790000000003e-07 43.975000000000001p -4.9311370000000003e-07 43.987499999999997p -4.914557e-07 44p -4.8918830000000003e-07 44.012500000000003p -4.8631650000000004e-07 44.024999999999999p -4.828461e-07 44.037500000000001p -4.7878350000000005e-07 44.049999999999997p -4.7413599999999998e-07 44.0625p -4.6891150000000002e-07 44.075000000000003p -4.6311859999999998e-07 44.087499999999999p -4.5676659999999998e-07 44.100000000000001p -4.4986560000000002e-07
+ 44.112499999999997p -4.4242610000000001e-07 44.125p -4.3445939999999998e-07 44.137500000000003p -4.2597749999999999e-07 44.149999999999999p -4.1699290000000001e-07 44.162500000000001p -4.0751859999999999e-07 44.174999999999997p -3.9756830000000001e-07 44.1875p -3.8715630000000001e-07 44.200000000000003p -3.7629720000000001e-07 44.212499999999999p -3.6500639999999997e-07 44.225000000000001p -3.532996e-07 44.237499999999997p -3.4119299999999998e-07 44.25p -3.2870319999999999e-07 44.262500000000003p -3.158474e-07 44.274999999999999p -3.0264299999999999e-07 44.287500000000001p -2.8910779999999999e-07 44.299999999999997p -2.7526019999999998e-07 44.3125p -2.611186e-07 44.325000000000003p -2.4670180000000002e-07
+ 44.337499999999999p -2.3202899999999999e-07 44.350000000000001p -2.1711949999999999e-07 44.362499999999997p -2.01993e-07 44.375p -1.866692e-07 44.387499999999996p -1.7116810000000001e-07 44.400000000000006p -1.5550980000000001e-07 44.412500000000001p -1.3971449999999999e-07 44.424999999999997p -1.2380270000000001e-07 44.4375p -1.077947e-07 44.449999999999996p -9.1710930000000004e-08 44.462500000000006p -7.5571940000000004e-08 44.475000000000001p -5.9398179999999998e-08 44.487499999999997p -4.32101e-08 44.5p -2.7028080000000001e-08 44.512499999999996p -1.087241e-08 44.525000000000006p 5.236699e-09 44.537500000000001p 2.1279199999999999e-08 44.549999999999997p 3.7235190000000003e-08
+ 44.5625p 5.3084949999999999e-08 44.574999999999996p 6.8808960000000005e-08 44.587500000000006p 8.4387939999999995e-08 44.600000000000001p 9.9802879999999999e-08 44.612499999999997p 1.15035e-07 44.625p 1.300659e-07 44.637499999999996p 1.448774e-07 44.650000000000006p 1.5945169999999999e-07 44.662500000000001p 1.737714e-07 44.674999999999997p 1.8781939999999999e-07 44.6875p 2.0157919999999999e-07 44.699999999999996p 2.1503450000000001e-07 44.712499999999999p 2.2816959999999999e-07 44.725000000000001p 2.4096909999999998e-07 44.737500000000004p 2.5341819999999998e-07 44.75p 2.655025e-07 44.762499999999996p 2.7720830000000001e-07 44.774999999999999p 2.8852230000000002e-07
+ 44.787500000000001p 2.994317e-07 44.800000000000004p 3.099242e-07 44.8125p 3.1998830000000002e-07 44.824999999999996p 3.2961289999999998e-07 44.837499999999999p 3.3878750000000002e-07 44.850000000000001p 3.4750229999999999e-07 44.862500000000004p 3.5574809999999998e-07 44.875p 3.635161e-07 44.887499999999996p 3.7079839999999998e-07 44.899999999999999p 3.775877e-07 44.912500000000001p 3.8387730000000002e-07 44.925000000000004p 3.8966099999999998e-07 44.9375p 3.9493349999999999e-07 44.949999999999996p 3.9969e-07 44.962499999999999p 4.0392640000000001e-07 44.975000000000001p 4.0763940000000001e-07 44.987500000000004p 4.1082620000000001e-07 45p 4.1348470000000002e-07
+ 45.012499999999996p 4.1561349999999999e-07 45.024999999999999p 4.1721190000000003e-07 45.037500000000001p 4.1827980000000003e-07 45.050000000000004p 4.1881770000000001e-07 45.0625p 4.1882700000000002e-07 45.074999999999996p 4.1830960000000002e-07 45.087499999999999p 4.1726789999999998e-07 45.100000000000001p 4.1570530000000001e-07 45.112500000000004p 4.1362560000000001e-07 45.125p 4.1103320000000001e-07 45.137500000000003p 4.0793329999999998e-07 45.149999999999999p 4.043316e-07 45.162499999999994p 4.002344e-07 45.175000000000004p 3.9564880000000001e-07 45.1875p 3.9058209999999999e-07 45.200000000000003p 3.8504249999999998e-07 45.212499999999999p 3.7903869999999998e-07 45.224999999999994p 3.7257979999999998e-07
+ 45.237500000000004p 3.656756e-07 45.25p 3.5833649999999997e-07 45.262500000000003p 3.5057310000000002e-07 45.274999999999999p 3.4239669999999999e-07 45.287499999999994p 3.3381910000000002e-07 45.300000000000004p 3.2485260000000001e-07 45.3125p 3.1550959999999998e-07 45.325000000000003p 3.0580349999999999e-07 45.337499999999999p 2.9574760000000001e-07 45.349999999999994p 2.8535580000000002e-07 45.362500000000004p 2.746424e-07 45.375p 2.6362199999999998e-07 45.387500000000003p 2.523095e-07 45.399999999999999p 2.4072019999999999e-07 45.412499999999994p 2.2886970000000001e-07 45.425000000000004p 2.167738e-07 45.4375p 2.0444860000000001e-07 45.450000000000003p 1.9191030000000001e-07
+ 45.462499999999999p 1.7917559999999999e-07 45.475000000000001p 1.6626100000000001e-07 45.487499999999997p 1.5318360000000001e-07 45.5p 1.3996029999999999e-07 45.512500000000003p 1.2660829999999999e-07 45.524999999999999p 1.1314490000000001e-07 45.537500000000001p 9.9587310000000003e-08 45.549999999999997p 8.5953040000000002e-08 45.5625p 7.2259499999999999e-08 45.575000000000003p 5.8524129999999997e-08 45.587499999999999p 4.4764379999999998e-08 45.600000000000001p 3.0997660000000002e-08 45.612499999999997p 1.7241340000000001e-08 45.625p 3.5127149999999999e-09 45.637500000000003p -1.017102e-08 45.649999999999999p -2.379277e-08 45.662500000000001p -3.7335589999999999e-08 45.674999999999997p -5.0782689999999999e-08
+ 45.6875p -6.4117449999999996e-08 45.700000000000003p -7.7323450000000001e-08 45.712499999999999p -9.0384480000000005e-08 45.725000000000001p -1.0328460000000001e-07 45.737499999999997p -1.1600809999999999e-07 45.75p -1.285395e-07 45.762500000000003p -1.4086370000000001e-07 45.774999999999999p -1.5296580000000001e-07 45.787500000000001p -1.648314e-07 45.799999999999997p -1.7644640000000001e-07 45.8125p -1.8779680000000001e-07 45.825000000000003p -1.988694e-07 45.837499999999999p -2.09651e-07 45.850000000000001p -2.2012920000000001e-07 45.862499999999997p -2.3029170000000001e-07 45.875p -2.4012670000000001e-07 45.887500000000003p -2.496231e-07 45.899999999999999p -2.5876989999999999e-07
+ 45.912500000000001p -2.6755690000000003e-07 45.924999999999997p -2.759741e-07 45.9375p -2.840122e-07 45.950000000000003p -2.9166239999999998e-07 45.962499999999999p -2.989164e-07 45.975000000000001p -3.0576629999999999e-07 45.987499999999997p -3.1220489999999999e-07 46p -3.1822549999999999e-07 46.012500000000003p -3.2382180000000002e-07 46.024999999999999p -3.289884e-07 46.037500000000001p -3.3372009999999999e-07 46.049999999999997p -3.3801250000000001e-07 46.0625p -3.4186169999999999e-07 46.075000000000003p -3.4526429999999999e-07 46.087499999999999p -3.4821760000000001e-07 46.100000000000001p -3.5071930000000001e-07 46.112499999999997p -3.52768e-07 46.125p -3.5436250000000002e-07
+ 46.137500000000003p -3.555024e-07 46.149999999999999p -3.5618790000000002e-07 46.162500000000001p -3.5641959999999999e-07 46.174999999999997p -3.5619880000000001e-07 46.1875p -3.5552749999999999e-07 46.200000000000003p -3.5440790000000001e-07 46.212499999999999p -3.528431e-07 46.225000000000001p -3.5083649999999999e-07 46.237499999999997p -3.4839229999999999e-07 46.25p -3.455151e-07 46.262499999999996p -3.4220999999999999e-07 46.275000000000006p -3.384827e-07 46.287500000000001p -3.3433930000000002e-07 46.299999999999997p -3.2978659999999999e-07 46.3125p -3.248317e-07 46.324999999999996p -3.1948229999999998e-07 46.337500000000006p -3.1374660000000002e-07 46.350000000000001p -3.0763309999999998e-07
+ 46.362499999999997p -3.0115099999999999e-07 46.375p -2.9430970000000002e-07 46.387499999999996p -2.8711900000000002e-07 46.400000000000006p -2.7958950000000002e-07 46.412500000000001p -2.7173159999999999e-07 46.424999999999997p -2.6355670000000001e-07 46.4375p -2.5507599999999997e-07 46.449999999999996p -2.4630150000000002e-07 46.462500000000006p -2.3724519999999999e-07 46.475000000000001p -2.279196e-07 46.487499999999997p -2.1833749999999999e-07 46.5p -2.0851189999999999e-07 46.512499999999996p -1.9845599999999999e-07 46.525000000000006p -1.881835e-07 46.537500000000001p -1.7770810000000001e-07 46.549999999999997p -1.6704369999999999e-07 46.5625p -1.5620459999999999e-07 46.574999999999996p -1.452051e-07
+ 46.587499999999999p -1.340596e-07 46.600000000000001p -1.2278280000000001e-07 46.612500000000004p -1.1138950000000001e-07 46.625p -9.9894449999999999e-08 46.637499999999996p -8.8312580000000003e-08 46.649999999999999p -7.665888e-08 46.662500000000001p -6.4948350000000006e-08 46.675000000000004p -5.3196020000000002e-08 46.6875p -4.1416920000000001e-08 46.699999999999996p -2.9626069999999999e-08 46.712499999999999p -1.7838429999999999e-08 46.725000000000001p -6.0689279999999998e-09 46.737500000000004p 5.6676020000000004e-09 46.75p 1.7356409999999998e-08 46.762499999999996p 2.898287e-08 46.774999999999999p 4.0532460000000003e-08 46.787500000000001p 5.1990840000000001e-08 46.800000000000004p 6.3343819999999997e-08
+ 46.8125p 7.4577400000000002e-08 46.824999999999996p 8.5677750000000001e-08 46.837499999999999p 9.663131e-08 46.850000000000001p 1.0742469999999999e-07 46.862500000000004p 1.180448e-07 46.875p 1.284789e-07 46.887499999999996p 1.3871419999999999e-07 46.899999999999999p 1.4873869999999999e-07 46.912500000000001p 1.5854029999999999e-07 46.925000000000004p 1.6810729999999999e-07 46.9375p 1.774286e-07 46.949999999999996p 1.8649309999999999e-07 46.962499999999999p 1.952903e-07 46.975000000000001p 2.0381e-07 46.987500000000004p 2.1204240000000001e-07 47p 2.1997789999999999e-07 47.012500000000003p 2.2760770000000001e-07 47.024999999999999p 2.349232e-07
+ 47.037499999999994p 2.4191599999999998e-07 47.050000000000004p 2.4857870000000002e-07 47.0625p 2.5490370000000001e-07 47.075000000000003p 2.6088440000000002e-07 47.087499999999999p 2.665143e-07 47.099999999999994p 2.7178750000000001e-07 47.112500000000004p 2.7669859999999999e-07 47.125p 2.812426e-07 47.137500000000003p 2.8541499999999999e-07 47.149999999999999p 2.892118e-07 47.162499999999994p 2.9262949999999998e-07 47.175000000000004p 2.9566510000000001e-07 47.1875p 2.9831599999999998e-07 47.200000000000003p 3.0058019999999999e-07 47.212499999999999p 3.024562e-07 47.224999999999994p 3.039428e-07 47.237500000000004p 3.0503960000000002e-07 47.25p 3.057465e-07
+ 47.262500000000003p 3.0606389999999999e-07 47.274999999999999p 3.0599279999999999e-07 47.287499999999994p 3.0553439999999998e-07 47.300000000000004p 3.046908e-07 47.3125p 3.0346419999999998e-07 47.325000000000003p 3.0185760000000001e-07 47.337499999999999p 2.9987409999999999e-07 47.350000000000001p 2.9751760000000001e-07 47.362499999999997p 2.9479239999999998e-07 47.375p 2.9170299999999998e-07 47.387500000000003p 2.8825460000000001e-07 47.399999999999999p 2.8445279999999998e-07 47.412500000000001p 2.8030349999999998e-07 47.424999999999997p 2.758131e-07 47.4375p 2.7098839999999999e-07 47.450000000000003p 2.658367e-07 47.462499999999999p 2.6036539999999998e-07 47.475000000000001p 2.545826e-07
+ 47.487499999999997p 2.4849649999999999e-07 47.5p 2.42116e-07 47.512500000000003p 2.3544989999999999e-07 47.524999999999999p 2.285076e-07 47.537500000000001p 2.2129890000000001e-07 47.549999999999997p 2.1383360000000001e-07 47.5625p 2.06122e-07 47.575000000000003p 1.9817470000000001e-07 47.587499999999999p 1.900024e-07 47.600000000000001p 1.8161619999999999e-07 47.612499999999997p 1.7302730000000001e-07 47.625p 1.642473e-07 47.637500000000003p 1.552878e-07 47.649999999999999p 1.461608e-07 47.662500000000001p 1.368782e-07 47.674999999999997p 1.2745220000000001e-07 47.6875p 1.178953e-07 47.700000000000003p 1.0821989999999999e-07
+ 47.712499999999999p 9.8438490000000002e-08 47.725000000000001p 8.8563849999999997e-08 47.737499999999997p 7.8608680000000003e-08 47.75p 6.8585800000000005e-08 47.762500000000003p 5.8508060000000003e-08 47.774999999999999p 4.8388319999999999e-08 47.787500000000001p 3.8239480000000003e-08 47.799999999999997p 2.8074419999999999e-08 47.8125p 1.7906010000000002e-08 47.825000000000003p 7.7470490000000006e-09 47.837499999999999p -2.3896740000000001e-09 47.850000000000001p -1.249146e-08 47.862499999999997p -2.2545699999999999e-08 47.875p -3.2539869999999997e-08 47.887500000000003p -4.2461570000000002e-08 47.899999999999999p -5.2298540000000003e-08 47.912500000000001p -6.2038650000000005e-08 47.924999999999997p -7.166994e-08
+ 47.9375p -8.1180610000000006e-08 47.950000000000003p -9.0559079999999996e-08 47.962499999999999p -9.9793950000000004e-08 47.975000000000001p -1.08874e-07 47.987499999999997p -1.177884e-07 48p -1.2652630000000001e-07 48.012500000000003p -1.3507729999999999e-07 48.024999999999999p -1.4343130000000001e-07 48.037500000000001p -1.5157830000000001e-07 48.049999999999997p -1.5950879999999999e-07 48.0625p -1.6721330000000001e-07 48.075000000000003p -1.74683e-07 48.087499999999999p -1.8190910000000001e-07 48.100000000000001p -1.8888340000000001e-07 48.112499999999997p -1.9559779999999999e-07 48.125p -2.020447e-07 48.137499999999996p -2.0821680000000001e-07 48.150000000000006p -2.141073e-07
+ 48.162500000000001p -2.1970950000000001e-07 48.174999999999997p -2.2501730000000001e-07 48.1875p -2.30025e-07 48.199999999999996p -2.3472719999999999e-07 48.212500000000006p -2.3911900000000001e-07 48.225000000000001p -2.4319570000000003e-07 48.237499999999997p -2.4695319999999999e-07 48.25p -2.5038790000000001e-07 48.262499999999996p -2.534964e-07 48.275000000000006p -2.5627569999999998e-07 48.287500000000001p -2.5872350000000002e-07 48.299999999999997p -2.6083770000000002e-07 48.3125p -2.6261660000000001e-07 48.324999999999996p -2.6405910000000001e-07 48.337500000000006p -2.6516449999999999e-07 48.350000000000001p -2.6593229999999998e-07 48.362499999999997p -2.6636270000000001e-07 48.375p -2.664562e-07
+ 48.387499999999996p -2.6621369999999997e-07 48.400000000000006p -2.6563659999999999e-07 48.412500000000001p -2.6472670000000001e-07 48.424999999999997p -2.6348610000000003e-07 48.4375p -2.619174e-07 48.449999999999996p -2.600237e-07 48.462499999999999p -2.5780829999999998e-07 48.475000000000001p -2.5527500000000001e-07 48.487500000000004p -2.5242809999999998e-07 48.5p -2.4927200000000001e-07 48.512499999999996p -2.4581180000000002e-07 48.524999999999999p -2.4205269999999997e-07 48.537500000000001p -2.3800040000000001e-07 48.550000000000004p -2.336609e-07 48.5625p -2.2904050000000001e-07 48.574999999999996p -2.2414609999999999e-07 48.587499999999999p -2.1898450000000001e-07 48.600000000000001p -2.1356310000000001e-07
+ 48.612500000000004p -2.078896e-07 48.625p -2.0197179999999999e-07 48.637499999999996p -1.9581799999999999e-07 48.649999999999999p -1.8943660000000001e-07 48.662500000000001p -1.828365e-07 48.675000000000004p -1.760265e-07 48.6875p -1.6901589999999999e-07 48.699999999999996p -1.6181420000000001e-07 48.712499999999999p -1.544309e-07 48.725000000000001p -1.46876e-07 48.737500000000004p -1.391595e-07 48.75p -1.3129149999999999e-07 48.762499999999996p -1.2328249999999999e-07 48.774999999999999p -1.15143e-07 48.787500000000001p -1.0688350000000001e-07 48.800000000000004p -9.851494e-08 48.8125p -9.004804e-08 48.824999999999996p -8.1493789999999994e-08
+ 48.837499999999999p -7.2863200000000006e-08 48.850000000000001p -6.416737e-08 48.862500000000004p -5.5417400000000001e-08 48.875p -4.6624469999999999e-08 48.887500000000003p -3.7799739999999998e-08 48.899999999999999p -2.8954400000000001e-08 48.912499999999994p -2.0099609999999999e-08 48.925000000000004p -1.1246520000000001e-08 48.9375p -2.4062310000000002e-09 48.950000000000003p 6.4101969999999999e-09 48.962499999999999p 1.5191780000000001e-08 48.974999999999994p 2.3927609999999999e-08 48.987500000000004p 3.260687e-08 49p 4.1218849999999999e-08 49.012500000000003p 4.9752960000000003e-08 49.024999999999999p 5.8198749999999997e-08 49.037499999999994p 6.6545909999999997e-08 49.050000000000004p 7.4784270000000003e-08
+ 49.0625p 8.2903859999999994e-08 49.075000000000003p 9.0894869999999999e-08 49.087499999999999p 9.8747690000000006e-08 49.099999999999994p 1.064529e-07 49.112500000000004p 1.140014e-07 49.125p 1.2138409999999999e-07 49.137500000000003p 1.2859229999999999e-07 49.149999999999999p 1.356176e-07 49.162499999999994p 1.4245170000000001e-07 49.175000000000004p 1.4908669999999999e-07 49.1875p 1.5551490000000001e-07 49.200000000000003p 1.6172900000000001e-07 49.212499999999999p 1.6772169999999999e-07 49.225000000000001p 1.734863e-07 49.237499999999997p 1.7901639999999999e-07 49.25p 1.8430570000000001e-07 49.262500000000003p 1.8934830000000001e-07 49.274999999999999p 1.941389e-07
+ 49.287500000000001p 1.9867210000000001e-07 49.299999999999997p 2.0294310000000001e-07 49.3125p 2.069474e-07 49.325000000000003p 2.1068089999999999e-07 49.337499999999999p 2.1413970000000001e-07 49.350000000000001p 2.1732040000000001e-07 49.362499999999997p 2.202199e-07 49.375p 2.2283539999999999e-07 49.387500000000003p 2.2516469999999999e-07 49.399999999999999p 2.2720560000000001e-07 49.412500000000001p 2.2895660000000001e-07 49.424999999999997p 2.3041640000000001e-07 49.4375p 2.315842e-07 49.450000000000003p 2.3245930000000001e-07 49.462499999999999p 2.3304160000000001e-07 49.475000000000001p 2.3333140000000001e-07 49.487499999999997p 2.333292e-07 49.5p 2.330359e-07
+ 49.512500000000003p 2.3245280000000001e-07 49.524999999999999p 2.3158170000000001e-07 49.537500000000001p 2.3042439999999999e-07 49.549999999999997p 2.289834e-07 49.5625p 2.2726140000000001e-07 49.575000000000003p 2.2526139999999999e-07 49.587499999999999p 2.229868e-07 49.600000000000001p 2.2044130000000001e-07 49.612499999999997p 2.17629e-07 49.625p 2.1455419999999999e-07 49.637500000000003p 2.1122159999999999e-07 49.649999999999999p 2.076362e-07 49.662500000000001p 2.0380329999999999e-07 49.674999999999997p 1.9972849999999999e-07 49.6875p 1.9541759999999999e-07 49.700000000000003p 1.9087669999999999e-07 49.712499999999999p 1.861123e-07 49.725000000000001p 1.8113100000000001e-07
+ 49.737499999999997p 1.7593979999999999e-07 49.75p 1.7054569999999999e-07 49.762500000000003p 1.649562e-07 49.774999999999999p 1.5917890000000001e-07 49.787500000000001p 1.5322150000000001e-07 49.799999999999997p 1.4709219999999999e-07 49.8125p 1.4079899999999999e-07 49.825000000000003p 1.3435030000000001e-07 49.837499999999999p 1.2775480000000001e-07 49.850000000000001p 1.2102100000000001e-07 49.862499999999997p 1.141579e-07 49.875p 1.071744e-07 49.887500000000003p 1.000796e-07 49.899999999999999p 9.288265e-08 49.912500000000001p 8.5592949999999995e-08 49.924999999999997p 7.8219849999999994e-08 49.9375p 7.0772799999999997e-08 49.950000000000003p 6.3261319999999996e-08
+ 49.962499999999999p 5.569499e-08 49.975000000000001p 4.8083420000000003e-08 49.987499999999997p 4.0436229999999999e-08 50p 3.2763079999999999e-08 50.012499999999996p 2.5073600000000002e-08 50.025000000000006p 1.7377439999999999e-08 50.037500000000001p 9.6842060000000004e-09 50.049999999999997p 2.0034760000000002e-09 50.0625p -5.6552210000000002e-09 50.074999999999996p -1.3282409999999999e-08 50.087500000000006p -2.08687e-08 50.100000000000001p -2.8404760000000001e-08 50.112499999999997p -3.5881370000000001e-08 50.125p -4.32894e-08 50.137499999999996p -5.0619860000000001e-08 50.150000000000006p -5.7863860000000003e-08 50.162500000000001p -6.5012650000000002e-08 50.174999999999997p -7.2057660000000007e-08
+ 50.1875p -7.8990430000000006e-08 50.199999999999996p -8.5802700000000001e-08 50.212500000000006p -9.2486370000000004e-08 50.225000000000001p -9.9033549999999994e-08 50.237499999999997p -1.0543650000000001e-07 50.25p -1.116878e-07 50.262499999999996p -1.1778e-07 50.275000000000006p -1.2370619999999999e-07 50.287500000000001p -1.294596e-07 50.299999999999997p -1.3503340000000001e-07 50.3125p -1.4042129999999999e-07 50.324999999999996p -1.456173e-07 50.337499999999999p -1.5061560000000001e-07 50.350000000000001p -1.554105e-07 50.362500000000004p -1.599967e-07 50.375p -1.6436919999999999e-07 50.387499999999996p -1.685234e-07 50.399999999999999p -1.724546e-07
+ 50.412500000000001p -1.7615889999999999e-07 50.425000000000004p -1.7963230000000001e-07 50.4375p -1.8287120000000001e-07 50.449999999999996p -1.858725e-07 50.462499999999999p -1.8863310000000001e-07 50.475000000000001p -1.9115040000000001e-07 50.487500000000004p -1.9342220000000001e-07 50.5p -1.9544629999999999e-07 50.512499999999996p -1.972212e-07 50.524999999999999p -1.9874539999999999e-07 50.537500000000001p -2.0001789999999999e-07 50.550000000000004p -2.0103790000000001e-07 50.5625p -2.01805e-07 50.574999999999996p -2.0231909999999999e-07 50.587499999999999p -2.025804e-07 50.600000000000001p -2.025895e-07 50.612500000000004p -2.0234719999999999e-07 50.625p -2.0185460000000001e-07
+ 50.637499999999996p -2.0111319999999999e-07 50.649999999999999p -2.0012479999999999e-07 50.662500000000001p -1.988914e-07 50.675000000000004p -1.9741539999999999e-07 50.6875p -1.956995e-07 50.699999999999996p -1.9374650000000001e-07 50.712499999999999p -1.9155990000000001e-07 50.725000000000001p -1.8914299999999999e-07 50.737500000000004p -1.8649970000000001e-07 50.75p -1.8363399999999999e-07 50.762500000000003p -1.805502e-07 50.774999999999999p -1.772531e-07 50.787499999999994p -1.737473e-07 50.800000000000004p -1.7003790000000001e-07 50.8125p -1.6613039999999999e-07 50.825000000000003p -1.6203020000000001e-07 50.837499999999999p -1.577431e-07 50.849999999999994p -1.5327509999999999e-07
+ 50.862500000000004p -1.486324e-07 50.875p -1.438213e-07 50.887500000000003p -1.388484e-07 50.899999999999999p -1.3372059999999999e-07 50.912499999999994p -1.2844459999999999e-07 50.925000000000004p -1.2302760000000001e-07 50.9375p -1.1747689999999999e-07 50.950000000000003p -1.1179970000000001e-07 50.962499999999999p -1.060037e-07 50.974999999999994p -1.0009639999999999e-07 50.987500000000004p -9.4085560000000005e-08 51p -8.7979079999999996e-08 51.012500000000003p -8.1784849999999999e-08 51.024999999999999p -7.5510919999999995e-08 51.037499999999994p -6.9165360000000007e-08 51.050000000000004p -6.2756330000000002e-08 51.0625p -5.6292039999999998e-08 51.075000000000003p -4.9780710000000001e-08
+ 51.087499999999999p -4.3230640000000003e-08 51.100000000000001p -3.6650099999999999e-08 51.112499999999997p -3.0047410000000003e-08 51.125p -2.3430849999999998e-08 51.137500000000003p -1.6808719999999999e-08 51.149999999999999p -1.0189269999999999e-08 51.162500000000001p -3.5807530000000002e-09 51.174999999999997p 3.0086560000000002e-09 51.1875p 9.5708159999999994e-09 51.200000000000003p 1.6097650000000001e-08 51.212499999999999p 2.258117e-08 51.225000000000001p 2.9013450000000001e-08 51.237499999999997p 3.5386649999999999e-08 51.25p 4.1693069999999997e-08 51.262500000000003p 4.7925070000000003e-08 51.274999999999999p 5.4075179999999997e-08 51.287500000000001p 6.0136019999999996e-08 51.299999999999997p 6.6100369999999995e-08
+ 51.3125p 7.1961150000000006e-08 51.325000000000003p 7.7711420000000002e-08 51.337499999999999p 8.3344430000000006e-08 51.350000000000001p 8.8853579999999995e-08 51.362499999999997p 9.4232459999999994e-08 51.375p 9.9474830000000001e-08 51.387500000000003p 1.0457470000000001e-07 51.399999999999999p 1.095261e-07 51.412500000000001p 1.143235e-07 51.424999999999997p 1.189616e-07 51.4375p 1.234349e-07 51.450000000000003p 1.277387e-07 51.462499999999999p 1.3186809999999999e-07 51.475000000000001p 1.358187e-07 51.487499999999997p 1.3958610000000001e-07 51.5p 1.431663e-07 51.512500000000003p 1.4655560000000001e-07 51.524999999999999p 1.497504e-07
+ 51.537500000000001p 1.5274740000000001e-07 51.549999999999997p 1.555437e-07 51.5625p 1.581364e-07 51.575000000000003p 1.6052310000000001e-07 51.587499999999999p 1.627016e-07 51.600000000000001p 1.6466990000000001e-07 51.612499999999997p 1.6642629999999999e-07 51.625p 1.6796940000000001e-07 51.637500000000003p 1.692981e-07 51.649999999999999p 1.704114e-07 51.662500000000001p 1.713088e-07 51.674999999999997p 1.719899e-07 51.6875p 1.7245480000000001e-07 51.700000000000003p 1.727035e-07 51.712499999999999p 1.727366e-07 51.725000000000001p 1.7255490000000001e-07 51.737499999999997p 1.721593e-07 51.75p 1.7155109999999999e-07
+ 51.762500000000003p 1.7073180000000001e-07 51.774999999999999p 1.697033e-07 51.787500000000001p 1.684676e-07 51.799999999999997p 1.67027e-07 51.8125p 1.6538410000000001e-07 51.825000000000003p 1.635416e-07 51.837500000000006p 1.615025e-07 51.850000000000001p 1.5927020000000001e-07 51.862499999999997p 1.5684819999999999e-07 51.875p 1.542401e-07 51.887499999999996p 1.5144980000000001e-07 51.900000000000006p 1.4848169999999999e-07 51.912500000000001p 1.4533990000000001e-07 51.924999999999997p 1.420291e-07 51.9375p 1.3855400000000001e-07 51.949999999999996p 1.349196e-07 51.962500000000006p 1.3113100000000001e-07 51.975000000000001p 1.2719339999999999e-07
+ 51.987499999999997p 1.2311250000000001e-07 52p 1.188936e-07 52.012499999999996p 1.145428e-07 52.025000000000006p 1.100658e-07 52.037500000000001p 1.0546880000000001e-07 52.049999999999997p 1.007579e-07 52.0625p 9.5939379999999998e-08 52.074999999999996p 9.101974e-08 52.087500000000006p 8.6005470000000006e-08 52.100000000000001p 8.0903179999999998e-08 52.112499999999997p 7.5719569999999994e-08 52.125p 7.0461429999999996e-08 52.137499999999996p 6.5135609999999997e-08 52.150000000000006p 5.9749009999999998e-08 52.162500000000001p 5.4308590000000002e-08 52.174999999999997p 4.882136e-08 52.1875p 4.3294350000000003e-08 52.199999999999996p 3.7734610000000001e-08
+ 52.212499999999999p 3.2149229999999999e-08 52.225000000000001p 2.654529e-08 52.237500000000004p 2.0929850000000001e-08 52.25p 1.5309999999999999e-08 52.262499999999996p 9.6927769999999996e-09 52.274999999999999p 4.0852010000000002e-09 52.287500000000001p -1.5057460000000001e-09 52.300000000000004p -7.0731310000000003e-09 52.3125p -1.2610069999999999e-08 52.324999999999996p -1.8109750000000001e-08 52.337499999999999p -2.3565420000000001e-08 52.350000000000001p -2.8970429999999999e-08 52.362500000000004p -3.4318180000000001e-08 52.375p -3.9602190000000001e-08 52.387499999999996p -4.4816100000000001e-08 52.399999999999999p -4.9953620000000003e-08 52.412500000000001p -5.5008619999999998e-08 52.425000000000004p -5.9975059999999999e-08
+ 52.4375p -6.4847060000000004e-08 52.449999999999996p -6.9618870000000001e-08 52.462499999999999p -7.4284879999999995e-08 52.475000000000001p -7.8839640000000001e-08 52.487500000000004p -8.3277870000000005e-08 52.5p -8.7594429999999995e-08 52.512499999999996p -9.1784379999999999e-08 52.524999999999999p -9.5842930000000004e-08 52.537500000000001p -9.9765499999999994e-08 52.550000000000004p -1.0354770000000001e-07 52.5625p -1.071852e-07 52.574999999999996p -1.106742e-07 52.587499999999999p -1.140107e-07 52.600000000000001p -1.171911e-07 52.612500000000004p -1.2021210000000001e-07 52.625p -1.2307049999999999e-07 52.637500000000003p -1.2576329999999999e-07 52.649999999999999p -1.2828769999999999e-07
+ 52.662499999999994p -1.306412e-07 52.675000000000004p -1.3282150000000001e-07 52.6875p -1.3482650000000001e-07 52.700000000000003p -1.366544e-07 52.712499999999999p -1.383036e-07 52.724999999999994p -1.397726e-07 52.737500000000004p -1.410603e-07 52.75p -1.4216579999999999e-07 52.762500000000003p -1.4308829999999999e-07 52.774999999999999p -1.438275e-07 52.787499999999994p -1.443831e-07 52.800000000000004p -1.44755e-07 52.8125p -1.4494360000000001e-07 52.825000000000003p -1.4494919999999999e-07 52.837499999999999p -1.4477269999999999e-07 52.849999999999994p -1.444148e-07 52.862500000000004p -1.438768e-07 52.875p -1.4315999999999999e-07
+ 52.887500000000003p -1.4226600000000001e-07 52.899999999999999p -1.411966e-07 52.912499999999994p -1.3995389999999999e-07 52.925000000000004p -1.385399e-07 52.9375p -1.369573e-07 52.950000000000003p -1.3520860000000001e-07 52.962499999999999p -1.332967e-07 52.975000000000001p -1.3122459999999999e-07 52.987499999999997p -1.2899550000000001e-07 53p -1.2661280000000001e-07 53.012500000000003p -1.2408019999999999e-07 53.024999999999999p -1.2140140000000001e-07 53.037500000000001p -1.185803e-07 53.049999999999997p -1.1562110000000001e-07 53.0625p -1.12528e-07 53.075000000000003p -1.0930539999999999e-07 53.087499999999999p -1.059579e-07 53.100000000000001p -1.0249010000000001e-07
+ 53.112499999999997p -9.8907e-08 53.125p -9.5213449999999998e-08 53.137500000000003p -9.1414570000000004e-08 53.149999999999999p -8.7515549999999996e-08 53.162500000000001p -8.3521689999999999e-08 53.174999999999997p -7.9438399999999995e-08 53.1875p -7.5271180000000004e-08 53.200000000000003p -7.1025599999999995e-08 53.212499999999999p -6.6707319999999999e-08 53.225000000000001p -6.2322069999999996e-08 53.237499999999997p -5.7875659999999999e-08 53.25p -5.3373910000000003e-08 53.262500000000003p -4.882273e-08 53.274999999999999p -4.4228060000000003e-08 53.287500000000001p -3.9595860000000001e-08 53.299999999999997p -3.493213e-08 53.3125p -3.024287e-08 53.325000000000003p -2.5534110000000001e-08
+ 53.337499999999999p -2.081186e-08 53.350000000000001p -1.608215e-08 53.362499999999997p -1.135098e-08 53.375p -6.6243190000000002e-09 53.387500000000003p -1.9081340000000001e-09 53.399999999999999p 2.7916599999999998e-09 53.412500000000001p 7.4691899999999999e-09 53.424999999999997p 1.211863e-08 53.4375p 1.673421e-08 53.450000000000003p 2.1310230000000001e-08 53.462499999999999p 2.5841059999999999e-08 53.475000000000001p 3.0321149999999999e-08 53.487499999999997p 3.4745019999999998e-08 53.5p 3.9107299999999997e-08 53.512500000000003p 4.3402710000000002e-08 53.524999999999999p 4.7626070000000002e-08 53.537500000000001p 5.1772330000000001e-08 53.549999999999997p 5.5836530000000001e-08
+ 53.5625p 5.9813849999999994e-08 53.575000000000003p 6.3699590000000003e-08 53.587499999999999p 6.7489179999999994e-08 53.600000000000001p 7.1178209999999998e-08 53.612499999999997p 7.4762379999999993e-08 53.625p 7.8237559999999994e-08 53.637500000000003p 8.1599770000000002e-08 53.649999999999999p 8.4845190000000004e-08 53.662500000000001p 8.7970150000000001e-08 53.674999999999997p 9.0971159999999999e-08 53.6875p 9.3844899999999999e-08 53.700000000000003p 9.6588200000000002e-08 53.712500000000006p 9.9198089999999995e-08 53.725000000000001p 1.016718e-07 53.737499999999997p 1.040066e-07 53.75p 1.062003e-07 53.762499999999996p 1.082504e-07 53.775000000000006p 1.101549e-07
+ 53.787500000000001p 1.119121e-07 53.799999999999997p 1.135202e-07 53.8125p 1.149777e-07 53.824999999999996p 1.162834e-07 53.837500000000006p 1.174361e-07 53.850000000000001p 1.1843509999999999e-07 53.862499999999997p 1.192796e-07 53.875p 1.199691e-07 53.887499999999996p 1.2050330000000001e-07 53.900000000000006p 1.208821e-07 53.912500000000001p 1.211057e-07 53.924999999999997p 1.211743e-07 53.9375p 1.210884e-07 53.949999999999996p 1.208487e-07 53.962500000000006p 1.204561e-07 53.975000000000001p 1.199116e-07 53.987499999999997p 1.1921660000000001e-07 54p 1.183723e-07
+ 54.012499999999996p 1.173806e-07 54.025000000000006p 1.16243e-07 54.037500000000001p 1.149618e-07 54.049999999999997p 1.135389e-07 54.0625p 1.1197669999999999e-07 54.074999999999996p 1.1027780000000001e-07 54.087499999999999p 1.084447e-07 54.100000000000001p 1.0648040000000001e-07 54.112500000000004p 1.0438770000000001e-07 54.125p 1.021698e-07 54.137499999999996p 9.9829910000000006e-08 54.149999999999999p 9.7371540000000006e-08 54.162500000000001p 9.4798190000000001e-08 54.175000000000004p 9.2113549999999996e-08 54.1875p 8.9321440000000004e-08 54.199999999999996p 8.6425790000000002e-08 54.212499999999999p 8.3430650000000002e-08 54.225000000000001p 8.0340169999999998e-08
+ 54.237500000000004p 7.7158640000000001e-08 54.25p 7.389041e-08 54.262499999999996p 7.0539959999999996e-08 54.274999999999999p 6.7111819999999995e-08 54.287500000000001p 6.3610640000000004e-08 54.300000000000004p 6.004112e-08 54.3125p 5.6408050000000001e-08 54.324999999999996p 5.2716250000000001e-08 54.337499999999999p 4.897064e-08 54.350000000000001p 4.5176170000000002e-08 54.362500000000004p 4.1337819999999998e-08 54.375p 3.7460630000000002e-08 54.387499999999996p 3.3549680000000003e-08 54.399999999999999p 2.9610030000000001e-08 54.412500000000001p 2.564682e-08 54.425000000000004p 2.1665150000000001e-08 54.4375p 1.767015e-08 54.449999999999996p 1.366696e-08
+ 54.462499999999999p 9.6606739999999999e-09 54.475000000000001p 5.6564129999999996e-09 54.487500000000004p 1.6592560000000001e-09 54.5p -2.3257370000000002e-09 54.512500000000003p -6.2935429999999999e-09 54.524999999999999p -1.0239179999999999e-08 54.537499999999994p -1.4157690000000001e-08 54.550000000000004p -1.804421e-08 54.5625p -2.1893879999999999e-08 54.575000000000003p -2.5701960000000001e-08 54.587499999999999p -2.9463719999999998e-08 54.599999999999994p -3.317455e-08 54.612500000000004p -3.6829909999999997e-08 54.625p -4.0425329999999999e-08 54.637500000000003p -4.3956449999999998e-08 54.649999999999999p -4.7418980000000003e-08 54.662499999999994p -5.0808770000000001e-08 54.675000000000004p -5.412175e-08
+ 54.6875p -5.7353959999999999e-08 54.700000000000003p -6.050156e-08 54.712499999999999p -6.3560839999999998e-08 54.724999999999994p -6.6528210000000006e-08 54.737500000000004p -6.940019e-08 54.75p -7.2173470000000005e-08 54.762500000000003p -7.4844829999999998e-08 54.774999999999999p -7.7411230000000005e-08 54.787499999999994p -7.9869760000000003e-08 54.800000000000004p -8.2217640000000006e-08 54.8125p -8.4452259999999998e-08 54.825000000000003p -8.6571159999999999e-08 54.837499999999999p -8.8572029999999997e-08 54.850000000000001p -9.0452710000000003e-08 54.862499999999997p -9.2211219999999995e-08 54.875p -9.3845719999999996e-08 54.887500000000003p -9.5354550000000005e-08 54.899999999999999p -9.6736209999999994e-08
+ 54.912500000000001p -9.7989350000000004e-08 54.924999999999997p -9.9112820000000004e-08 54.9375p -1.001056e-07 54.950000000000003p -1.009669e-07 54.962499999999999p -1.01696e-07 54.975000000000001p -1.022924e-07 54.987499999999997p -1.027559e-07 55p -1.030862e-07 55.012500000000003p -1.032835e-07 55.024999999999999p -1.033478e-07 55.037500000000001p -1.032795e-07 55.049999999999997p -1.030792e-07 55.0625p -1.027475e-07 55.075000000000003p -1.022853e-07 55.087499999999999p -1.016936e-07 55.100000000000001p -1.0097360000000001e-07 55.112499999999997p -1.001266e-07 55.125p -9.9154129999999997e-08
+ 55.137500000000003p -9.8057819999999999e-08 55.149999999999999p -9.6839480000000005e-08 55.162500000000001p -9.5501040000000002e-08 55.174999999999997p -9.4044609999999994e-08 55.1875p -9.2472419999999997e-08 55.200000000000003p -9.0786850000000003e-08 55.212499999999999p -8.8990409999999996e-08 55.225000000000001p -8.7085749999999996e-08 55.237499999999997p -8.5075640000000005e-08 55.25p -8.2962979999999993e-08 55.262500000000003p -8.0750799999999995e-08 55.274999999999999p -7.8442219999999999e-08 55.287500000000001p -7.6040509999999995e-08 55.299999999999997p -7.3549010000000002e-08 55.3125p -7.0971179999999999e-08 55.325000000000003p -6.8310590000000004e-08 55.337499999999999p -6.5570889999999997e-08 55.350000000000001p -6.2755820000000005e-08
+ 55.362499999999997p -5.9869200000000002e-08 55.375p -5.6914930000000001e-08 55.387500000000003p -5.389699e-08 55.399999999999999p -5.0819429999999998e-08 55.412500000000001p -4.7686360000000003e-08 55.424999999999997p -4.4501919999999998e-08 55.4375p -4.1270349999999997e-08 55.450000000000003p -3.7995910000000003e-08 55.462499999999999p -3.4682889999999998e-08 55.475000000000001p -3.1335629999999998e-08 55.487499999999997p -2.7958509999999998e-08 55.5p -2.4555909999999999e-08 55.512500000000003p -2.1132240000000001e-08 55.524999999999999p -1.7691930000000001e-08 55.537500000000001p -1.4239399999999999e-08 55.549999999999997p -1.0779090000000001e-08 55.5625p -7.3154120000000003e-09 55.575000000000003p -3.8527949999999998e-09
+ 55.587500000000006p -3.95635e-10 55.600000000000001p 3.051688e-09 55.612499999999997p 6.4848220000000002e-09 55.625p 9.8994440000000007e-09 55.637499999999996p 1.329127e-08 55.650000000000006p 1.665606e-08 55.662500000000001p 1.998962e-08 55.674999999999997p 2.3287809999999999e-08 55.6875p 2.6546539999999998e-08 55.699999999999996p 2.9761800000000001e-08 55.712500000000006p 3.2929640000000002e-08 55.725000000000001p 3.6046169999999999e-08 55.737499999999997p 3.9107589999999997e-08 55.75p 4.2110189999999999e-08 55.762499999999996p 4.5050330000000002e-08 55.775000000000006p 4.7924469999999997e-08 55.787500000000001p 5.0729149999999999e-08 55.799999999999997p 5.3461039999999998e-08
+ 55.8125p 5.6116869999999997e-08 55.824999999999996p 5.8693529999999998e-08 55.837500000000006p 6.1187960000000005e-08 55.850000000000001p 6.3597269999999997e-08 55.862499999999997p 6.5918640000000001e-08 55.875p 6.8149400000000005e-08 55.887499999999996p 7.0286999999999999e-08 55.899999999999999p 7.2328999999999999e-08 55.912500000000001p 7.4273099999999998e-08 55.924999999999997p 7.6117139999999998e-08 55.9375p 7.7859079999999995e-08 55.949999999999996p 7.9497009999999997e-08 55.962499999999999p 8.1029169999999998e-08 55.975000000000001p 8.2453930000000003e-08 55.987500000000004p 8.3769829999999994e-08 56p 8.4975500000000005e-08 56.012499999999996p 8.6069760000000005e-08 56.024999999999999p 8.705155e-08
+ 56.037500000000001p 8.7919970000000006e-08 56.050000000000004p 8.8674249999999997e-08 56.0625p 8.9313779999999998e-08 56.074999999999996p 8.9838079999999999e-08 56.087499999999999p 9.0246849999999999e-08 56.100000000000001p 9.0539899999999997e-08 56.112500000000004p 9.0717209999999998e-08 56.125p 9.0778900000000003e-08 56.137499999999996p 9.0725220000000004e-08 56.149999999999999p 9.05566e-08 56.162500000000001p 9.0273580000000003e-08 56.175000000000004p 8.9876869999999996e-08 56.1875p 8.9367280000000005e-08 56.199999999999996p 8.8745820000000002e-08 56.212499999999999p 8.8013579999999995e-08 56.225000000000001p 8.7171820000000003e-08 56.237500000000004p 8.622193e-08 56.25p 8.5165419999999997e-08
+ 56.262499999999996p 8.4003950000000006e-08 56.274999999999999p 8.2739279999999994e-08 56.287500000000001p 8.1373320000000006e-08 56.300000000000004p 7.9908089999999999e-08 56.3125p 7.8345719999999996e-08 56.324999999999996p 7.6688479999999999e-08 56.337499999999999p 7.4938740000000003e-08 56.350000000000001p 7.3098959999999999e-08 56.362500000000004p 7.1171739999999994e-08 56.375p 6.9159770000000005e-08 56.387500000000003p 6.7065819999999995e-08 56.399999999999999p 6.4892769999999997e-08 56.412499999999994p 6.2643600000000006e-08 56.425000000000004p 6.0321369999999993e-08 56.4375p 5.79292e-08 56.450000000000003p 5.5470329999999999e-08 56.462499999999999p 5.2948039999999998e-08 56.474999999999994p 5.0365699999999999e-08
+ 56.487500000000004p 4.7726730000000001e-08 56.5p 4.5034619999999997e-08 56.512500000000003p 4.2292920000000001e-08 56.524999999999999p 3.9505210000000003e-08 56.537499999999994p 3.6675160000000001e-08 56.550000000000004p 3.3806430000000003e-08 56.5625p 3.0902750000000002e-08 56.575000000000003p 2.7967880000000001e-08 56.587499999999999p 2.5005600000000001e-08 56.599999999999994p 2.2019720000000001e-08 56.612500000000004p 1.901406e-08 56.625p 1.599246e-08 56.637500000000003p 1.295876e-08 56.649999999999999p 9.9168149999999993e-09 56.662499999999994p 6.8704729999999999e-09 56.675000000000004p 3.8235750000000002e-09 56.6875p 7.7995240000000002e-10 56.700000000000003p -2.2565790000000002e-09
+ 56.712499999999999p -5.2822250000000003e-09 56.725000000000001p -8.2932140000000006e-09 56.737499999999997p -1.128581e-08 56.75p -1.42563e-08 56.762500000000003p -1.7201019999999999e-08 56.774999999999999p -2.0116349999999999e-08 56.787500000000001p -2.299871e-08 56.799999999999997p -2.5844579999999999e-08 56.8125p -2.8650489999999999e-08 56.825000000000003p -3.1413039999999998e-08 56.837499999999999p -3.4128869999999999e-08 56.850000000000001p -3.679473e-08 56.862499999999997p -3.9407399999999999e-08 56.875p -4.1963769999999997e-08 56.887500000000003p -4.4460790000000003e-08 56.899999999999999p -4.6895490000000001e-08 56.912500000000001p -4.9265010000000001e-08 56.924999999999997p -5.1566570000000003e-08
+ 56.9375p -5.3797460000000003e-08 56.950000000000003p -5.5955099999999999e-08 56.962499999999999p -5.8036990000000002e-08 56.975000000000001p -6.0040749999999995e-08 56.987499999999997p -6.1964079999999997e-08 57p -6.3804820000000003e-08 57.012500000000003p -6.5560880000000002e-08 57.024999999999999p -6.723031e-08 57.037500000000001p -6.8811280000000003e-08 57.049999999999997p -7.0302059999999996e-08 57.0625p -7.1701030000000004e-08 57.075000000000003p -7.3006709999999993e-08 57.087499999999999p -7.4217740000000006e-08 57.100000000000001p -7.5332869999999995e-08 57.112499999999997p -7.6350970000000004e-08 57.125p -7.7271069999999993e-08 57.137500000000003p -7.8092280000000005e-08 57.149999999999999p -7.8813860000000002e-08
+ 57.162500000000001p -7.9435199999999994e-08 57.174999999999997p -7.9955810000000004e-08 57.1875p -8.0375329999999996e-08 57.200000000000003p -8.0693510000000004e-08 57.212499999999999p -8.0910270000000001e-08 57.225000000000001p -8.1025600000000005e-08 57.237499999999997p -8.1039679999999994e-08 57.25p -8.0952750000000003e-08 57.262500000000003p -8.0765240000000006e-08 57.274999999999999p -8.0477650000000002e-08 57.287500000000001p -8.0090640000000003e-08 57.299999999999997p -7.9604979999999997e-08 57.3125p -7.902155e-08 57.325000000000003p -7.8341370000000005e-08 57.337499999999999p -7.756556e-08 57.350000000000001p -7.6695359999999995e-08 57.362499999999997p -7.5732149999999994e-08 57.375p -7.4677370000000006e-08
+ 57.387500000000003p -7.3532619999999999e-08 57.399999999999999p -7.2299580000000004e-08 57.412500000000001p -7.0980040000000004e-08 57.424999999999997p -6.9575899999999995e-08 57.4375p -6.8089149999999997e-08 57.450000000000003p -6.6521880000000006e-08 57.462500000000006p -6.4876280000000001e-08 57.475000000000001p -6.3154630000000007e-08 57.487499999999997p -6.1359289999999994e-08 57.5p -5.9492719999999999e-08 57.512499999999996p -5.7557430000000002e-08 57.525000000000006p -5.5556039999999998e-08 57.537500000000001p -5.349123e-08 57.549999999999997p -5.1365769999999998e-08 57.5625p -4.9182459999999998e-08 57.574999999999996p -4.6944190000000001e-08 57.587500000000006p -4.4653910000000002e-08 57.600000000000001p -4.2314619999999997e-08
+ 57.612499999999997p -3.9929369999999999e-08 57.625p -3.7501260000000003e-08 57.637499999999996p -3.5033429999999998e-08 57.650000000000006p -3.2529070000000002e-08 57.662500000000001p -2.9991389999999999e-08 57.674999999999997p -2.7423649999999999e-08 57.6875p -2.4829129999999999e-08 57.699999999999996p -2.2211120000000001e-08 57.712500000000006p -1.957294e-08 57.725000000000001p -1.691794e-08 57.737499999999997p -1.424945e-08 57.75p -1.157084e-08 57.762499999999996p -8.8854459999999997e-09 57.774999999999999p -6.1966279999999997e-09 57.787500000000001p -3.5077320000000001e-09 57.799999999999997p -8.220929e-10 57.8125p 1.856968e-09 57.824999999999996p 4.526147e-09
+ 57.837499999999999p 7.1821660000000002e-09 57.850000000000001p 9.8217699999999997e-09 57.862500000000004p 1.244174e-08 57.875p 1.5038880000000001e-08 57.887499999999996p 1.761005e-08 57.899999999999999p 2.0152129999999999e-08 57.912500000000001p 2.2662070000000001e-08 57.925000000000004p 2.513686e-08 57.9375p 2.7573529999999998e-08 57.949999999999996p 2.996918e-08 57.962499999999999p 3.2320980000000002e-08 57.975000000000001p 3.4626129999999997e-08 57.987500000000004p 3.688194e-08 58p 3.908576e-08 58.012499999999996p 4.1235019999999998e-08 58.024999999999999p 4.3327230000000002e-08 58.037500000000001p 4.5359970000000001e-08 58.050000000000004p 4.733091e-08
+ 58.0625p 4.923781e-08 58.074999999999996p 5.1078500000000003e-08 58.087499999999999p 5.2850909999999999e-08 58.100000000000001p 5.4553050000000002e-08 58.112500000000004p 5.6183049999999997e-08 58.125p 5.773911e-08 58.137499999999996p 5.9219540000000002e-08 58.149999999999999p 6.062273e-08 58.162500000000001p 6.1947200000000003e-08 58.175000000000004p 6.3191560000000006e-08 58.1875p 6.4354510000000005e-08 58.199999999999996p 6.5434880000000005e-08 58.212499999999991p 6.6431590000000004e-08 58.225000000000001p 6.7343680000000001e-08 58.237500000000004p 6.8170269999999994e-08 58.250000000000007p 6.8910619999999999e-08 58.262499999999996p 6.9564079999999999e-08 58.274999999999999p 7.0130130000000002e-08
+ 58.287500000000001p 7.0608339999999995e-08 58.299999999999997p 7.0998399999999993e-08 58.3125p 7.1300109999999999e-08 58.325000000000003p 7.1513370000000005e-08 58.337499999999991p 7.1638210000000003e-08 58.349999999999994p 7.1674750000000005e-08 58.362500000000004p 7.1623240000000003e-08 58.375000000000007p 7.1483999999999993e-08 58.387499999999996p 7.1257509999999998e-08 58.399999999999999p 7.0944310000000003e-08 58.412500000000001p 7.054508e-08 58.424999999999997p 7.0060590000000003e-08 58.4375p 6.9491699999999995e-08 58.450000000000003p 6.8839389999999997e-08 58.462500000000006p 6.8104739999999997e-08 58.474999999999994p 6.7288929999999999e-08 58.487500000000004p 6.6393209999999998e-08 58.500000000000007p 6.5418959999999999e-08
+ 58.512499999999996p 6.4367630000000006e-08 58.524999999999999p 6.324078e-08 58.537500000000001p 6.2040029999999995e-08 58.549999999999997p 6.0767120000000003e-08 58.5625p 5.9423839999999999e-08 58.575000000000003p 5.8012100000000002e-08 58.587500000000006p 5.6533839999999997e-08 58.599999999999994p 5.4991130000000001e-08 58.612499999999997p 5.3386059999999998e-08 58.625000000000007p 5.1720830000000002e-08 58.637499999999996p 4.9997690000000003e-08 58.649999999999999p 4.8218959999999997e-08 58.662500000000001p 4.6386999999999997e-08 58.674999999999997p 4.4504269999999999e-08 58.6875p 4.257325e-08 58.700000000000003p 4.0596480000000002e-08 58.712500000000006p 3.8576549999999997e-08 58.724999999999994p 3.65161e-08
+ 58.737499999999997p 3.44178e-08 58.750000000000007p 3.2284369999999999e-08 58.762499999999996p 3.0118550000000002e-08 58.774999999999999p 2.792312e-08 58.787500000000001p 2.5700900000000001e-08 58.800000000000004p 2.3454700000000001e-08 58.8125p 2.1187379999999998e-08 58.825000000000003p 1.8901799999999999e-08 58.837500000000006p 1.6600849999999999e-08 58.849999999999994p 1.4287410000000001e-08 58.862499999999997p 1.1964380000000001e-08 58.875p 9.6346440000000006e-09 58.887499999999996p 7.3011049999999999e-09 58.899999999999999p 4.9666489999999997e-09 58.912500000000001p 2.6341569999999998e-09 58.925000000000004p 3.0649590000000001e-10 58.9375p -2.0134830000000001e-09 58.950000000000003p -4.3229469999999997e-09
+ 58.962500000000006p -6.619087e-09 58.974999999999994p -8.8991199999999994e-09 58.987499999999997p -1.116029e-08 59p -1.3399880000000001e-08 59.012499999999996p -1.5615209999999999e-08 59.024999999999999p -1.780362e-08 59.037500000000001p -1.9962530000000001e-08 59.050000000000004p -2.2089359999999999e-08 59.062499999999993p -2.4181619999999999e-08 59.075000000000003p -2.6236840000000001e-08 59.087500000000006p -2.8252629999999999e-08 59.099999999999994p -3.0226629999999998e-08 59.112499999999997p -3.215658e-08 59.125p -3.404023e-08 59.13750000000001p -3.587545e-08 59.149999999999999p -3.7660130000000003e-08 59.162500000000001p -3.9392260000000003e-08 59.175000000000004p -4.1069899999999998e-08
+ 59.187499999999993p -4.269116e-08 59.200000000000003p -4.4254259999999997e-08 59.212500000000006p -4.5757479999999998e-08 59.224999999999994p -4.7199180000000002e-08 59.237499999999997p -4.8577809999999999e-08 59.25p -4.9891889999999999e-08 59.262500000000003p -5.114004e-08 59.274999999999999p -5.2320960000000003e-08 59.287500000000001p -5.3433440000000001e-08 59.300000000000004p -5.4476350000000003e-08 59.312499999999993p -5.544868e-08 59.325000000000003p -5.6349470000000001e-08 59.337500000000006p -5.7177870000000002e-08 59.349999999999994p -5.7933139999999998e-08 59.362499999999997p -5.8614610000000001e-08 59.375p -5.9221709999999999e-08 59.387500000000003p -5.9753970000000004e-08 59.399999999999999p -6.0211010000000005e-08
+ 59.412500000000001p -6.0592540000000004e-08 59.425000000000004p -6.0898379999999996e-08 59.437499999999993p -6.1128430000000001e-08 59.449999999999996p -6.1282679999999997e-08 59.462500000000006p -6.136124e-08 59.474999999999994p -6.1364280000000003e-08 59.487499999999997p -6.1292089999999999e-08 59.5p -6.1145039999999995e-08 59.512500000000003p -6.0923600000000002e-08 59.524999999999999p -6.0628310000000005e-08 59.537500000000001p -6.0259819999999994e-08 59.550000000000004p -5.9818859999999996e-08 59.562499999999993p -5.9306259999999999e-08 59.574999999999996p -5.872291e-08 59.587500000000006p -5.8069810000000002e-08 59.600000000000009p -5.7348030000000001e-08 59.612499999999997p -5.655872e-08 59.625p -5.5703119999999998e-08
+ 59.637500000000003p -5.4782529999999997e-08 59.649999999999999p -5.3798350000000002e-08 59.662500000000001p -5.2752029999999998e-08 59.675000000000004p -5.1645100000000002e-08 59.687499999999993p -5.0479180000000003e-08 59.699999999999996p -4.9255920000000002e-08 59.712499999999999p -4.7977070000000003e-08 59.725000000000009p -4.6644410000000002e-08 59.737499999999997p -4.5259799999999999e-08 59.75p -4.3825160000000002e-08 59.762500000000003p -4.2342459999999997e-08 59.774999999999999p -4.0813709999999998e-08 59.787500000000001p -3.9241e-08 59.800000000000004p -3.762643e-08 59.812499999999993p -3.5972159999999998e-08 59.824999999999996p -3.4280409999999998e-08 59.837499999999999p -3.2553400000000002e-08 59.850000000000009p -3.0793419999999998e-08
+ 59.862499999999997p -2.9002780000000001e-08 59.875p -2.7183809999999999e-08 59.887500000000003p -2.5338870000000001e-08 59.899999999999991p -2.347036e-08 59.912500000000001p -2.1580670000000001e-08 59.925000000000004p -1.9672239999999999e-08 59.937500000000007p -1.774751e-08 59.949999999999996p -1.5808910000000001e-08 59.962499999999999p -1.385892e-08 59.975000000000001p -1.1899990000000001e-08 59.987499999999997p -9.9345780000000004e-09 60p -7.9651550000000003e-09 60.012500000000003p -5.9941769999999999e-09 60.024999999999991p -4.0240919999999997e-09 60.037500000000001p -2.0573410000000002e-09 60.050000000000004p -9.6347919999999997e-11 60.062500000000007p 1.8564770000000001e-09 60.074999999999996p 3.7987450000000004e-09
+ 60.087499999999999p 5.728088e-09 60.100000000000001p 7.6421639999999992e-09 60.112499999999997p 9.5386609999999997e-09 60.125p 1.141529e-08 60.137500000000003p 1.326981e-08 60.149999999999991p 1.5100009999999999e-08 60.162499999999994p 1.6903710000000001e-08 60.175000000000004p 1.8678770000000001e-08 60.187500000000007p 2.0423119999999999e-08 60.199999999999996p 2.21347e-08 60.212499999999999p 2.3811530000000001e-08 60.225000000000001p 2.5451659999999999e-08 60.237499999999997p 2.7053210000000002e-08 60.25p 2.861433e-08 60.262500000000003p 3.0133270000000003e-08 60.275000000000006p 3.1608290000000001e-08 60.287499999999994p 3.3037750000000001e-08 60.300000000000004p 3.4420050000000003e-08
+ 60.312500000000007p 3.5753669999999998e-08 60.324999999999996p 3.7037149999999998e-08 60.337499999999999p 3.8269089999999999e-08 60.350000000000001p 3.9448189999999998e-08 60.362499999999997p 4.057318e-08 60.375p 4.1642890000000002e-08 60.387500000000003p 4.2656210000000002e-08 60.400000000000006p 4.3612130000000002e-08 60.412499999999994p 4.450967e-08 60.425000000000004p 4.5347979999999997e-08 60.437500000000007p 4.6126240000000003e-08 60.449999999999996p 4.6843729999999999e-08 60.462499999999999p 4.7499830000000001e-08 60.475000000000001p 4.8093949999999998e-08 60.487499999999997p 4.8625619999999999e-08 60.5p 4.9094439999999997e-08 60.512500000000003p 4.9500079999999999e-08 60.525000000000006p 4.98423e-08
+ 60.537499999999994p 5.0120939999999997e-08 60.549999999999997p 5.0335909999999999e-08 60.562500000000007p 5.0487210000000001e-08 60.574999999999996p 5.0574929999999999e-08 60.587499999999999p 5.0599210000000003e-08 60.600000000000001p 5.0560289999999997e-08 60.612499999999997p 5.0458489999999998e-08 60.625p 5.0294190000000001e-08 60.637500000000003p 5.006787e-08 60.650000000000006p 4.9780070000000002e-08 60.662499999999994p 4.9431409999999999e-08 60.674999999999997p 4.9022569999999997e-08 60.687500000000007p 4.8554329999999999e-08 60.699999999999996p 4.8027519999999998e-08 60.712499999999999p 4.7443040000000003e-08 60.725000000000001p 4.6801879999999999e-08 60.737500000000004p 4.6105069999999997e-08 60.75p 4.535372e-08
+ 60.762500000000003p 4.4549010000000001e-08 60.775000000000006p 4.3692160000000003e-08 60.787499999999994p 4.2784480000000002e-08 60.799999999999997p 4.1827319999999997e-08 60.8125p 4.0822079999999999e-08 60.824999999999996p 3.9770229999999999e-08 60.837499999999999p 3.8673289999999998e-08 60.850000000000001p 3.7532830000000001e-08 60.862500000000004p 3.6350459999999999e-08 60.875p 3.512785e-08 60.887500000000003p 3.3866699999999998e-08 60.900000000000006p 3.2568769999999998e-08 60.912499999999994p 3.1235830000000001e-08 60.924999999999997p 2.9869710000000002e-08 60.9375p 2.8472279999999998e-08 60.949999999999996p 2.704542e-08 60.962499999999999p 2.559106e-08 60.975000000000001p 2.4111129999999998e-08
+ 60.987500000000004p 2.2607620000000001e-08 60.999999999999993p 2.108252e-08 61.012500000000003p 1.9537830000000001e-08 61.025000000000006p 1.797559e-08 61.037499999999994p 1.6397850000000001e-08 61.049999999999997p 1.4806650000000001e-08 61.0625p 1.320406e-08 61.075000000000003p 1.159216e-08 61.087499999999999p 9.9730009999999997e-09 61.100000000000001p 8.3486739999999995e-09 61.112500000000004p 6.7212460000000001e-09 61.124999999999993p 5.0927860000000001e-09 61.137500000000003p 3.4653550000000002e-09 61.150000000000006p 1.8410030000000001e-09 61.162499999999994p 2.2177159999999999e-10 61.174999999999997p -1.390316e-09 61.1875p -2.993252e-09 61.200000000000003p -4.5850470000000003e-09
+ 61.212499999999999p -6.163736e-09 61.225000000000001p -7.7273769999999997e-09 61.237500000000004p -9.2740550000000002e-09 61.249999999999993p -1.080188e-08 61.262499999999996p -1.2309009999999999e-08 61.275000000000006p -1.3793610000000001e-08 61.287499999999994p -1.52539e-08 61.299999999999997p -1.6688139999999999e-08 61.3125p -1.8094609999999999e-08 61.325000000000003p -1.9471650000000002e-08 61.337499999999999p -2.0817629999999999e-08 61.350000000000001p -2.2131000000000001e-08 61.362500000000004p -2.34102e-08 61.374999999999993p -2.465377e-08 61.387499999999996p -2.5860280000000001e-08 61.400000000000006p -2.7028350000000001e-08 61.412500000000009p -2.8156659999999999e-08 61.424999999999997p -2.9243940000000001e-08
+ 61.4375p -3.0289000000000001e-08 61.450000000000003p -3.1290669999999999e-08 61.462499999999999p -3.224786e-08 61.475000000000001p -3.3159559999999999e-08 61.487500000000004p -3.4024779999999998e-08 61.499999999999993p -3.4842629999999998e-08 61.512499999999996p -3.5612259999999998e-08 61.524999999999999p -3.63329e-08 61.537500000000009p -3.7003829999999997e-08 61.549999999999997p -3.7624409999999998e-08 61.5625p -3.8194059999999997e-08 61.575000000000003p -3.8712270000000003e-08 61.587499999999999p -3.9178589999999998e-08 61.600000000000001p -3.9592649999999997e-08 61.612500000000004p -3.995414e-08 61.624999999999993p -4.026281e-08 61.637499999999996p -4.05185e-08 61.649999999999999p -4.0721100000000003e-08
+ 61.662500000000009p -4.0870569999999998e-08 61.674999999999997p -4.0966950000000003e-08 61.6875p -4.1010319999999997e-08 61.700000000000003p -4.1000870000000003e-08 61.712499999999991p -4.0938809999999999e-08 61.725000000000001p -4.0824460000000003e-08 61.737500000000004p -4.0658159999999997e-08 61.749999999999993p -4.0440359999999999e-08 61.762499999999996p -4.017153e-08 61.774999999999999p -3.9852249999999999e-08 61.787500000000009p -3.9483120000000002e-08 61.799999999999997p -3.9064820000000002e-08 61.8125p -3.8598099999999998e-08 61.825000000000003p -3.8083740000000002e-08 61.837499999999991p -3.7522609999999999e-08 61.850000000000001p -3.6915620000000002e-08 61.862500000000004p -3.626373e-08 61.875000000000007p -3.5567959999999998e-08
+ 61.887499999999996p -3.4829380000000002e-08 61.899999999999999p -3.4049120000000001e-08 61.912500000000001p -3.3228349999999997e-08 61.924999999999997p -3.2368279999999999e-08 61.9375p -3.1470189999999998e-08 61.950000000000003p -3.0535359999999997e-08 61.962499999999991p -2.9565170000000002e-08 61.975000000000001p -2.856099e-08 61.987500000000004p -2.7524239999999999e-08 62.000000000000007p -2.645641e-08 62.012499999999996p -2.5358969999999999e-08 62.024999999999999p -2.423347e-08 62.037500000000001p -2.3081450000000001e-08 62.049999999999997p -2.1904509999999999e-08 62.0625p -2.0704260000000001e-08 62.075000000000003p -1.9482340000000001e-08 62.087499999999991p -1.8240399999999998e-08 62.099999999999994p -1.6980119999999999e-08
+ 62.112500000000004p -1.5703189999999999e-08 62.125000000000007p -1.441133e-08 62.137499999999996p -1.310625e-08 62.149999999999999p -1.1789680000000001e-08 62.162500000000001p -1.046337e-08 62.174999999999997p -9.1290649999999994e-09 62.1875p -7.7885069999999995e-09 62.200000000000003p -6.4434490000000002e-09 62.212500000000006p -5.09564e-09 62.224999999999994p -3.7468280000000002e-09 62.237500000000004p -2.398752e-09 62.250000000000007p -1.0531469999999999e-09 62.262499999999996p 2.8826330000000001e-10 62.274999999999999p 1.6237680000000001e-09 62.287500000000001p 2.9516680000000002e-09 62.299999999999997p 4.2702830000000004e-09 62.3125p 5.5779480000000004e-09 62.325000000000003p 6.8730209999999998e-09
+ 62.337500000000006p 8.1538809999999999e-09 62.349999999999994p 9.4189300000000007e-09 62.362499999999997p 1.06666e-08 62.375000000000007p 1.1895340000000001e-08 62.387499999999996p 1.310366e-08 62.399999999999999p 1.429005e-08 62.412500000000001p 1.5453079999999999e-08 62.424999999999997p 1.6591339999999999e-08 62.4375p 1.7703450000000001e-08 62.450000000000003p 1.8788069999999998e-08 62.462500000000006p 1.984392e-08 62.474999999999994p 2.0869720000000001e-08 62.487499999999997p 2.186429e-08 62.500000000000007p 2.282643e-08 62.512499999999996p 2.3755049999999999e-08 62.524999999999999p 2.4649050000000001e-08 62.537500000000001p 2.5507429999999999e-08 62.550000000000004p 2.6329190000000001e-08
+ 62.5625p 2.7113410000000001e-08 62.575000000000003p 2.7859229999999999e-08 62.587500000000006p 2.8565820000000001e-08 62.599999999999994p 2.9232399999999998e-08 62.612499999999997p 2.9858279999999998e-08 62.625p 3.0442770000000003e-08 62.637499999999996p 3.0985290000000002e-08 62.649999999999999p 3.148529e-08 62.662500000000001p 3.1942259999999999e-08 62.675000000000004p 3.2355779999999998e-08 62.6875p 3.2725470000000001e-08 62.700000000000003p 3.3051009999999999e-08 62.712500000000006p 3.3332129999999999e-08 62.724999999999994p 3.3568630000000002e-08 62.737499999999997p 3.3760369999999998e-08 62.75p 3.3907259999999997e-08 62.762499999999996p 3.400926e-08 62.774999999999999p 3.4066399999999997e-08
+ 62.787500000000001p 3.407876e-08 62.800000000000004p 3.40465e-08 62.812499999999993p 3.3969800000000002e-08 62.825000000000003p 3.3848909999999999e-08 62.837500000000006p 3.3684159999999997e-08 62.849999999999994p 3.3475900000000003e-08 62.862499999999997p 3.3224549999999997e-08 62.875p 3.2930590000000001e-08 62.88750000000001p 3.2594540000000001e-08 62.899999999999999p 3.221699e-08 62.912500000000001p 3.1798550000000001e-08 62.925000000000004p 3.1339920000000002e-08 62.937499999999993p 3.0841820000000001e-08 62.950000000000003p 3.0305030000000002e-08 62.962500000000006p 2.9730360000000001e-08 62.974999999999994p 2.9118700000000001e-08 62.987499999999997p 2.8470960000000001e-08 63p 2.7788089999999999e-08
+ 63.012500000000003p 2.70711e-08 63.024999999999999p 2.6321010000000001e-08 63.037500000000001p 2.5538919999999999e-08 63.050000000000004p 2.472594e-08 63.062499999999993p 2.388322e-08 63.075000000000003p 2.3011949999999998e-08 63.087500000000006p 2.211334e-08 63.099999999999994p 2.118865e-08 63.112499999999997p 2.0239150000000002e-08 63.125p 1.926615e-08 63.137500000000003p 1.8270989999999999e-08 63.149999999999999p 1.7255020000000001e-08 63.162500000000001p 1.621962e-08 63.175000000000004p 1.5166199999999999e-08 63.187499999999993p 1.4096150000000001e-08 63.199999999999996p 1.3010940000000001e-08 63.212500000000006p 1.191199e-08 63.224999999999994p 1.080078e-08
+ 63.237499999999997p 9.6787780000000006e-09 63.25p 8.547466e-09 63.262500000000003p 7.4083359999999996e-09 63.274999999999999p 6.2628809999999997e-09 63.287500000000001p 5.1125999999999999e-09 63.300000000000004p 3.9589939999999998e-09 63.312499999999993p 2.8035610000000001e-09 63.324999999999996p 1.6477989999999999e-09 63.337500000000006p 4.9320140000000005e-10 63.350000000000009p -6.5874610000000002e-10 63.362499999999997p -1.806565e-09 63.375p -2.9487850000000002e-09 63.387500000000003p -4.0839509999999996e-09 63.399999999999999p -5.2106169999999998e-09 63.412500000000001p -6.3273569999999998e-09 63.425000000000004p -7.4327590000000004e-09 63.437499999999993p -8.52543e-09 63.449999999999996p -9.6039989999999992e-09
+ 63.462499999999999p -1.0667120000000001e-08 63.475000000000009p -1.171345e-08 63.487499999999997p -1.2741719999999999e-08 63.5p -1.375062e-08 63.512500000000003p -1.473894e-08 63.524999999999999p -1.5705439999999999e-08 63.537500000000001p -1.664895e-08 63.550000000000004p -1.7568309999999998e-08 63.562499999999993p -1.8462419999999998e-08 63.574999999999996p -1.933018e-08 63.587499999999999p -2.0170560000000001e-08 63.600000000000009p -2.0982549999999999e-08 63.612499999999997p -2.1765180000000001e-08 63.625p -2.2517539999999999e-08 63.637500000000003p -2.3238720000000001e-08 63.649999999999991p -2.3927899999999999e-08 63.662500000000001p -2.458427e-08 63.675000000000004p -2.5207080000000001e-08
+ 63.687500000000007p -2.5795619999999999e-08 63.699999999999996p -2.6349220000000001e-08 63.712499999999999p -2.6867269999999998e-08 63.725000000000001p -2.73492e-08 63.737499999999997p -2.7794480000000001e-08 63.75p -2.8202649999999999e-08 63.762500000000003p -2.8573270000000001e-08 63.774999999999991p -2.8905970000000001e-08 63.787500000000001p -2.9200420000000002e-08 63.800000000000004p -2.9456339999999998e-08 63.812500000000007p -2.9673520000000001e-08 63.824999999999996p -2.9851759999999998e-08 63.837499999999999p -2.9990949999999998e-08 63.850000000000001p -3.0091000000000001e-08 63.862499999999997p -3.0151899999999999e-08 63.875p -3.0173649999999997e-08 63.887500000000003p -3.0156339999999998e-08 63.899999999999991p -3.010009e-08
+ 63.912499999999994p -3.0005060000000002e-08 63.925000000000004p -2.9871490000000001e-08 63.937500000000007p -2.9699629999999999e-08 63.949999999999996p -2.948981e-08 63.962499999999999p -2.924238e-08 63.975000000000001p -2.895777e-08 63.987499999999997p -2.8636430000000001e-08 64p -2.827885e-08 64.012500000000003p -2.7885600000000001e-08 64.025000000000006p -2.7457249999999999e-08 64.037499999999994p -2.6994450000000001e-08 64.049999999999997p -2.6497869999999998e-08 64.0625p -2.5968229999999999e-08 64.075000000000003p -2.5406289999999999e-08 64.087500000000006p -2.4812830000000001e-08 64.100000000000009p -2.4188709999999999e-08 64.112499999999997p -2.3534780000000001e-08 64.125p -2.2851959999999999e-08
+ 64.137500000000003p -2.2141190000000001e-08 64.150000000000006p -2.1403440000000001e-08 64.162499999999994p -2.0639709999999998e-08 64.174999999999997p -1.985105e-08 64.1875p -1.9038509999999999e-08 64.199999999999989p -1.8203189999999999e-08 64.212500000000006p -1.7346209999999999e-08 64.225000000000009p -1.646871e-08 64.237499999999997p -1.557186e-08 64.25p -1.465684e-08 64.262500000000003p -1.3724860000000001e-08 64.275000000000006p -1.2777150000000001e-08 64.287499999999994p -1.1814939999999999e-08 64.299999999999997p -1.0839499999999999e-08 64.3125p -9.8520970000000006e-09 64.324999999999989p -8.8540119999999999e-09 64.337500000000006p -7.8465370000000004e-09 64.350000000000009p -6.8309750000000004e-09
+ 64.362499999999997p -5.8086329999999997e-09 64.375p -4.7808240000000001e-09 64.387500000000003p -3.7488659999999997e-09 64.400000000000006p -2.7140760000000002e-09 64.412499999999994p -1.677773e-09 64.424999999999997p -6.4127409999999996e-10 64.4375p 3.9410650000000002e-10 64.449999999999989p 1.42706e-09 64.462499999999991p 2.4562829999999998e-09 64.475000000000009p 3.4804820000000002e-09 64.487500000000011p 4.498371e-09 64.5p 5.5086779999999998e-09 64.512500000000003p 6.51014e-09 64.525000000000006p 7.5015130000000002e-09 64.537499999999994p 8.4815649999999998e-09 64.549999999999997p 9.4490830000000008e-09 64.5625p 1.040287e-08 64.574999999999989p 1.134176e-08
+ 64.587499999999991p 1.2264599999999999e-08 64.600000000000009p 1.317026e-08 64.612500000000011p 1.405763e-08 64.625p 1.4925629999999999e-08 64.637500000000003p 1.5773219999999999e-08 64.650000000000006p 1.6599380000000001e-08 64.662499999999994p 1.7403099999999999e-08 64.674999999999997p 1.818343e-08 64.6875p 1.893943e-08 64.699999999999989p 1.9670220000000001e-08 64.712499999999991p 2.037492e-08 64.724999999999994p 2.105271e-08 64.737500000000011p 2.1702789999999998e-08 64.75p 2.232441e-08 64.762500000000003p 2.2916850000000001e-08 64.775000000000006p 2.3479439999999999e-08 64.787499999999994p 2.4011519999999999e-08 64.799999999999997p 2.4512509999999999e-08
+ 64.8125p 2.498184e-08 64.825000000000003p 2.5419000000000001e-08 64.837499999999991p 2.58235e-08 64.849999999999994p 2.6194909999999998e-08 64.862500000000011p 2.6532839999999999e-08 64.875p 2.6836940000000001e-08 64.887500000000003p 2.710691e-08 64.900000000000006p 2.7342479999999998e-08 64.912499999999994p 2.7543439999999999e-08 64.924999999999997p 2.77096e-08 64.9375p 2.7840849999999999e-08 64.950000000000003p 2.793709e-08 64.962499999999991p 2.799828e-08 64.974999999999994p 2.8024420000000002e-08 64.987500000000011p 2.8015569999999999e-08 65p 2.79718e-08 65.012500000000003p 2.7893250000000001e-08 65.025000000000006p 2.778009e-08
+ 65.037499999999994p 2.7632559999999999e-08 65.049999999999997p 2.745089e-08 65.0625p 2.723541e-08 65.075000000000003p 2.6986449999999999e-08 65.087499999999991p 2.6704400000000001e-08 65.099999999999994p 2.6389680000000001e-08 65.112499999999997p 2.604277e-08 65.125p 2.5664159999999999e-08 65.137500000000003p 2.5254390000000001e-08 65.150000000000006p 2.4814059999999999e-08 65.162500000000009p 2.4343769999999999e-08 65.174999999999997p 2.3844179999999999e-08 65.1875p 2.3315969999999999e-08 65.200000000000003p 2.2759870000000002e-08 65.212499999999991p 2.2176619999999999e-08 65.224999999999994p 2.156703e-08 65.237499999999997p 2.09319e-08 65.25p 2.027208e-08
+ 65.262500000000003p 1.9588440000000001e-08 65.275000000000006p 1.8881900000000001e-08 65.287500000000009p 1.8153369999999999e-08 65.299999999999997p 1.7403810000000001e-08 65.3125p 1.6634199999999999e-08 65.325000000000003p 1.5845530000000001e-08 65.337499999999991p 1.5038839999999998e-08 65.349999999999994p 1.421516e-08 65.362499999999997p 1.3375540000000001e-08 65.375p 1.2521069999999999e-08 65.387500000000003p 1.1652830000000001e-08 65.400000000000006p 1.077194e-08 65.412500000000009p 9.8795050000000008e-09 65.424999999999997p 8.976663e-09 65.4375p 8.0645529999999995e-09 65.450000000000003p 7.1443220000000002e-09 65.462499999999991p 6.2171270000000003e-09 65.474999999999994p 5.2841279999999998e-09
+ 65.487499999999997p 4.3464909999999999e-09 65.5p 3.4053840000000001e-09 65.512500000000003p 2.4619760000000002e-09 65.525000000000006p 1.517437e-09 65.537500000000009p 5.7293260000000001e-10 65.549999999999997p -3.70372e-10 65.5625p -1.311318e-09 65.575000000000003p -2.248751e-09 65.587499999999991p -3.1815249999999999e-09 65.599999999999994p -4.1085030000000002e-09 65.612499999999997p -5.0285589999999999e-09 65.625p -5.9405770000000001e-09 65.637500000000003p -6.8434539999999996e-09 65.650000000000006p -7.736102e-09 65.662500000000009p -8.6174489999999995e-09 65.674999999999997p -9.4864380000000004e-09 65.6875p -1.0342030000000001e-08 65.700000000000003p -1.1183220000000001e-08
+ 65.712499999999991p -1.200899e-08 65.724999999999994p -1.281837e-08 65.737499999999997p -1.3610420000000001e-08 65.75p -1.4384199999999999e-08 65.762500000000003p -1.513881e-08 65.775000000000006p -1.5873360000000002e-08 65.787500000000009p -1.6587020000000001e-08 65.799999999999997p -1.7278959999999999e-08 65.8125p -1.7948379999999998e-08 65.825000000000003p -1.8594520000000001e-08 65.837499999999991p -1.921665e-08 65.849999999999994p -1.9814060000000001e-08 65.862499999999997p -2.03861e-08 65.875p -2.093212e-08 65.887500000000003p -2.1451530000000002e-08 65.900000000000006p -2.1943750000000001e-08 65.912500000000009p -2.2408250000000001e-08 65.924999999999997p -2.2844539999999999e-08
+ 65.9375p -2.325217e-08 65.950000000000003p -2.3630689999999999e-08 65.962500000000006p -2.397973e-08 65.974999999999994p -2.4298949999999999e-08 65.987499999999997p -2.4588010000000001e-08 66p -2.4846670000000001e-08 66.012499999999989p -2.5074669999999999e-08 66.025000000000006p -2.5271830000000002e-08 66.037500000000009p -2.5437979999999999e-08 66.049999999999997p -2.5573e-08 66.0625p -2.5676820000000001e-08 66.075000000000003p -2.574939e-08 66.087500000000006p -2.5790709999999999e-08 66.099999999999994p -2.58008e-08 66.112499999999997p -2.5779759999999999e-08 66.125p -2.5727670000000001e-08 66.137499999999989p -2.5644709999999999e-08 66.150000000000006p -2.5531040000000002e-08
+ 66.162500000000009p -2.5386889999999999e-08 66.174999999999997p -2.5212530000000001e-08 66.1875p -2.5008239999999998e-08 66.200000000000003p -2.477437e-08 66.212500000000006p -2.451128e-08 66.224999999999994p -2.4219369999999999e-08 66.237499999999997p -2.389907e-08 66.25p -2.3550869999999999e-08 66.262499999999989p -2.3175250000000001e-08 66.275000000000006p -2.2772760000000001e-08 66.287500000000009p -2.2343959999999999e-08 66.300000000000011p -2.188945e-08 66.3125p -2.140986e-08 66.325000000000003p -2.0905830000000001e-08 66.337500000000006p -2.0378060000000001e-08 66.349999999999994p -1.982725e-08 66.362499999999997p -1.925414e-08 66.375p -1.8659489999999999e-08
+ 66.387499999999989p -1.8044090000000002e-08 66.399999999999991p -1.740875e-08 66.412500000000009p -1.6754279999999999e-08 66.425000000000011p -1.608156e-08 66.4375p -1.539144e-08 66.450000000000003p -1.4684819999999999e-08 66.462500000000006p -1.3962600000000001e-08 66.474999999999994p -1.3225710000000001e-08 66.487499999999997p -1.247508e-08 66.5p -1.171167e-08 66.512499999999989p -1.0936440000000001e-08 66.524999999999991p -1.015037e-08 66.537500000000009p -9.3544429999999995e-09 66.550000000000011p -8.5496539999999994e-09 66.5625p -7.7370060000000003e-09 66.575000000000003p -6.9175079999999998e-09 66.587500000000006p -6.0921759999999999e-09 66.599999999999994p -5.2620260000000003e-09
+ 66.612499999999997p -4.4280799999999999e-09 66.625p -3.591359e-09 66.637500000000003p -2.7528869999999999e-09 66.649999999999991p -1.913684e-09 66.662499999999994p -1.0747670000000001e-09 66.675000000000011p -2.3715349999999998e-10 66.6875p 5.9814830000000002e-10 66.700000000000003p 1.4301339999999999e-09 66.712500000000006p 2.2578079999999999e-09 66.724999999999994p 3.0801819999999998e-09 66.737499999999997p 3.8962770000000004e-09 66.75p 4.7051269999999997e-09 66.762500000000003p 5.5057769999999999e-09 66.774999999999991p 6.2972849999999999e-09 66.787499999999994p 7.0787239999999998e-09 66.800000000000011p 7.8491809999999995e-09 66.8125p 8.6077599999999996e-09 66.825000000000003p 9.3535840000000003e-09
+ 66.837500000000006p 1.0085789999999999e-08 66.849999999999994p 1.0803550000000001e-08 66.862499999999997p 1.150603e-08 66.875p 1.2192440000000001e-08 66.887500000000003p 1.2862e-08 66.899999999999991p 1.351396e-08 66.912499999999994p 1.41476e-08 66.924999999999997p 1.4762199999999999e-08 66.9375p 1.5357089999999999e-08 66.950000000000003p 1.5931630000000001e-08 66.962500000000006p 1.648518e-08 66.974999999999994p 1.7017150000000001e-08 66.987499999999997p 1.7526969999999999e-08 67p 1.80141e-08 67.012500000000003p 1.8478040000000001e-08 67.024999999999991p 1.8918300000000001e-08 67.037499999999994p 1.9334440000000001e-08 67.049999999999997p 1.972604e-08
+ 67.0625p 2.009271e-08 67.075000000000003p 2.0434100000000002e-08 67.087500000000006p 2.0749889999999999e-08 67.100000000000009p 2.1039780000000001e-08 67.112499999999997p 2.1303529999999999e-08 67.125p 2.1540899999999999e-08 67.137500000000003p 2.1751709999999999e-08 67.149999999999991p 2.1935790000000001e-08 67.162499999999994p 2.2093030000000001e-08 67.174999999999997p 2.2223329999999999e-08 67.1875p 2.232664e-08 67.200000000000003p 2.240292e-08 67.212500000000006p 2.2452189999999999e-08 67.225000000000009p 2.2474490000000001e-08 67.237499999999997p 2.24699e-08 67.25p 2.2438509999999999e-08 67.262500000000003p 2.238046e-08 67.274999999999991p 2.2295940000000001e-08
+ 67.287499999999994p 2.2185140000000001e-08 67.299999999999997p 2.204829e-08 67.3125p 2.1885669999999999e-08 67.325000000000003p 2.1697559999999999e-08 67.337500000000006p 2.1484289999999999e-08 67.350000000000009p 2.1246220000000001e-08 67.362499999999997p 2.0983730000000001e-08 67.375p 2.0697230000000001e-08 67.387500000000003p 2.0387160000000001e-08 67.399999999999991p 2.0053999999999999e-08 67.412499999999994p 1.9698229999999999e-08 67.424999999999997p 1.9320369999999999e-08 67.4375p 1.8920970000000002e-08 67.450000000000003p 1.85006e-08 67.462500000000006p 1.8059849999999999e-08 67.475000000000009p 1.759934e-08 67.487499999999997p 1.7119690000000001e-08 67.5p 1.662158e-08
+ 67.512500000000003p 1.6105669999999999e-08 67.524999999999991p 1.5572660000000001e-08 67.537499999999994p 1.5023280000000001e-08 67.549999999999997p 1.445824e-08 67.5625p 1.38783e-08 67.575000000000003p 1.3284230000000001e-08 67.587500000000006p 1.2676800000000001e-08 67.600000000000009p 1.2056800000000001e-08 67.612499999999997p 1.1425039999999999e-08 67.625p 1.078233e-08 67.637500000000003p 1.01295e-08 67.649999999999991p 9.4673779999999994e-09 67.662499999999994p 8.7968089999999996e-09 67.674999999999997p 8.1186419999999998e-09 67.6875p 7.4337329999999999e-09 67.700000000000003p 6.7429409999999998e-09 67.712500000000006p 6.0471300000000004e-09 67.725000000000009p 5.3471659999999998e-09
+ 67.737499999999997p 4.6439170000000001e-09 67.75p 3.938251e-09 67.762500000000003p 3.231036e-09 67.775000000000006p 2.5231379999999998e-09 67.787499999999994p 1.815421e-09 67.799999999999997p 1.1087440000000001e-09 67.8125p 4.0396260000000002e-10 67.825000000000003p -2.9807519999999999e-10 67.837500000000006p -9.9652699999999994e-10 67.850000000000009p -1.690558e-09 67.862499999999997p -2.3793439999999998e-09 67.875p -3.062069e-09 67.887500000000003p -3.7379280000000003e-09 67.900000000000006p -4.4061289999999996e-09 67.912499999999994p -5.065892e-09 67.924999999999997p -5.7164489999999997e-09 67.9375p -6.3570499999999997e-09 67.949999999999989p -6.9869579999999998e-09
+ 67.962500000000006p -7.6054529999999998e-09 67.975000000000009p -8.2118310000000001e-09 67.987499999999997p -8.8054079999999995e-09 68p -9.385516e-09 68.012500000000003p -9.9515099999999997e-09 68.025000000000006p -1.0502759999999999e-08 68.037499999999994p -1.103866e-08 68.049999999999997p -1.1558630000000001e-08 68.0625p -1.2062109999999999e-08 68.074999999999989p -1.2548549999999999e-08 68.087500000000006p -1.301743e-08 68.100000000000009p -1.346828e-08 68.112499999999997p -1.390061e-08 68.125p -1.431398e-08 68.137500000000003p -1.470798e-08 68.150000000000006p -1.508222e-08 68.162499999999994p -1.5436319999999999e-08 68.174999999999997p -1.5769949999999999e-08
+ 68.1875p -1.6082789999999998e-08 68.199999999999989p -1.6374570000000001e-08 68.212499999999991p -1.6645010000000001e-08 68.225000000000009p -1.689389e-08 68.237500000000011p -1.7121010000000001e-08 68.25p -1.732619e-08 68.262500000000003p -1.7509280000000001e-08 68.275000000000006p -1.767016e-08 68.287499999999994p -1.7808740000000001e-08 68.299999999999997p -1.7924950000000001e-08 68.3125p -1.801877e-08 68.324999999999989p -1.809018e-08 68.337499999999991p -1.8139199999999999e-08 68.350000000000009p -1.816588e-08 68.362500000000011p -1.817029e-08 68.375p -1.8152539999999999e-08 68.387500000000003p -1.8112750000000001e-08 68.400000000000006p -1.805109e-08
+ 68.412499999999994p -1.7967729999999999e-08 68.424999999999997p -1.7862870000000001e-08 68.4375p -1.7736770000000001e-08 68.449999999999989p -1.7589670000000001e-08 68.462499999999991p -1.7421850000000001e-08 68.474999999999994p -1.7233639999999998e-08 68.487500000000011p -1.7025350000000001e-08 68.5p -1.679736e-08 68.512500000000003p -1.6550019999999999e-08 68.525000000000006p -1.6283749999999998e-08 68.537499999999994p -1.599898e-08 68.549999999999997p -1.5696129999999999e-08 68.5625p -1.5375679999999999e-08 68.575000000000003p -1.5038120000000001e-08 68.587499999999991p -1.468394e-08 68.599999999999994p -1.4313660000000001e-08 68.612500000000011p -1.3927829999999999e-08 68.625p -1.3526999999999999e-08
+ 68.637500000000003p -1.311175e-08 68.650000000000006p -1.2682659999999999e-08 68.662499999999994p -1.224033e-08 68.674999999999997p -1.178539e-08 68.6875p -1.131845e-08 68.700000000000003p -1.084016e-08 68.712499999999991p -1.0351180000000001e-08 68.724999999999994p -9.8521540000000006e-09 68.737500000000011p -9.3437669999999993e-09 68.75p -8.8266969999999996e-09 68.762500000000003p -8.3016320000000006e-09 68.775000000000006p -7.7692660000000004e-09 68.787499999999994p -7.2302999999999997e-09 68.799999999999997p -6.6854399999999996e-09 68.8125p -6.1353950000000002e-09 68.825000000000003p -5.5808800000000003e-09 68.837499999999991p -5.0226079999999997e-09 68.849999999999994p -4.4612969999999998e-09
+ 68.862499999999997p -3.897664e-09 68.875p -3.3324259999999998e-09 68.887500000000003p -2.7662970000000001e-09 68.900000000000006p -2.1999909999999999e-09 68.912500000000009p -1.6342179999999999e-09 68.924999999999997p -1.0696830000000001e-09 68.9375p -5.0708890000000001e-10 68.950000000000003p 5.2870460000000001e-11 68.962499999999991p 6.095058e-10 68.974999999999994p 1.162136e-09 68.987499999999997p 1.7100869999999999e-09 69p 2.2526959999999998e-09 69.012500000000003p 2.7893089999999998e-09 69.025000000000006p 3.319281e-09 69.037500000000009p 3.84198e-09 69.049999999999997p 4.3567869999999997e-09 69.0625p 4.8630939999999996e-09 69.075000000000003p 5.3603080000000003e-09
+ 69.087499999999991p 5.847848e-09 69.099999999999994p 6.325152e-09 69.112499999999997p 6.7916690000000001e-09 69.125p 7.2468670000000001e-09 69.137500000000003p 7.6902310000000006e-09 69.150000000000006p 8.1212609999999992e-09 69.162500000000009p 8.5394769999999994e-09 69.174999999999997p 8.9444179999999998e-09 69.1875p 9.3356390000000007e-09 69.200000000000003p 9.7127180000000001e-09 69.212499999999991p 1.007525e-08 69.224999999999994p 1.042285e-08 69.237499999999997p 1.0755160000000001e-08 69.25p 1.107183e-08 69.262500000000003p 1.1372550000000001e-08 69.275000000000006p 1.165702e-08 69.287500000000009p 1.192495e-08 69.299999999999997p 1.21761e-08
+ 69.3125p 1.241024e-08 69.325000000000003p 1.2627149999999999e-08 69.337499999999991p 1.2826640000000001e-08 69.349999999999994p 1.300856e-08 69.362499999999997p 1.3172769999999999e-08 69.375p 1.331914e-08 69.387500000000003p 1.3447590000000001e-08 69.400000000000006p 1.3558039999999999e-08 69.412500000000009p 1.3650439999999999e-08 69.424999999999997p 1.372478e-08 69.4375p 1.3781050000000001e-08 69.450000000000003p 1.381927e-08 69.462499999999991p 1.383949e-08 69.474999999999994p 1.384177e-08 69.487499999999997p 1.382621e-08 69.5p 1.3792920000000001e-08 69.512500000000003p 1.374203e-08 69.525000000000006p 1.3673699999999999e-08
+ 69.537500000000009p 1.3588099999999999e-08 69.549999999999997p 1.3485450000000001e-08 69.5625p 1.3365949999999999e-08 69.575000000000003p 1.322984e-08 69.587499999999991p 1.30774e-08 69.599999999999994p 1.290889e-08 69.612499999999997p 1.2724619999999999e-08 69.625p 1.2524910000000001e-08 69.637500000000003p 1.231009e-08 69.650000000000006p 1.208052e-08 69.662500000000009p 1.1836570000000001e-08 69.674999999999997p 1.157863e-08 69.6875p 1.130711e-08 69.700000000000003p 1.1022419999999999e-08 69.712500000000006p 1.0725e-08 69.724999999999994p 1.0415300000000001e-08 69.737499999999997p 1.009378e-08 69.75p 9.7609270000000004e-09
+ 69.762499999999989p 9.4172210000000002e-09 69.775000000000006p 9.0631649999999995e-09 69.787500000000009p 8.6992719999999997e-09 69.799999999999997p 8.3260629999999998e-09 69.8125p 7.9440709999999993e-09 69.825000000000003p 7.553836e-09 69.837500000000006p 7.1559069999999998e-09 69.849999999999994p 6.7508410000000001e-09 69.862499999999997p 6.3391999999999998e-09 69.875p 5.9215549999999996e-09 69.887499999999989p 5.4984790000000003e-09 69.900000000000006p 5.0705510000000004e-09 69.912500000000009p 4.6383540000000003e-09 69.924999999999997p 4.2024730000000004e-09 69.9375p 3.7634950000000001e-09 69.950000000000003p 3.3220110000000001e-09 69.962500000000006p 2.8786089999999999e-09 69.974999999999994p 2.4338780000000001e-09
+ 69.987499999999997p 1.9884089999999998e-09 70p 1.5427870000000001e-09 70.012499999999989p 1.0975970000000001e-09 70.025000000000006p 6.5342200000000002e-10 70.037500000000009p 2.1083819999999999e-10 70.050000000000011p -2.2958069999999999e-10 70.0625p -6.6726680000000003e-10 70.075000000000003p -1.1016580000000001e-09 70.087500000000006p -1.5321999999999999e-09 70.099999999999994p -1.9583440000000001e-09 70.112499999999997p -2.379551e-09 70.125p -2.7952889999999999e-09 70.137499999999989p -3.2050369999999998e-09 70.149999999999991p -3.6082839999999999e-09 70.162500000000009p -4.0045280000000002e-09 70.175000000000011p -4.3932799999999999e-09 70.1875p -4.7740609999999999e-09 70.200000000000003p -5.1464070000000001e-09
+ 70.212500000000006p -5.5098639999999999e-09 70.224999999999994p -5.8639929999999999e-09 70.237499999999997p -6.2083690000000002e-09 70.25p -6.5425820000000002e-09 70.262499999999989p -6.866236e-09 70.274999999999991p -7.1789499999999999e-09 70.287500000000009p -7.4803600000000004e-09 70.300000000000011p -7.7701180000000007e-09 70.3125p -8.0478920000000006e-09 70.325000000000003p -8.3133669999999993e-09 70.337500000000006p -8.5662469999999997e-09 70.349999999999994p -8.8062510000000002e-09 70.362499999999997p -9.0331190000000004e-09 70.375p -9.2466060000000002e-09 70.387500000000003p -9.4464880000000007e-09 70.399999999999991p -9.6325589999999993e-09 70.412499999999994p -9.8046300000000003e-09 70.425000000000011p -9.9625350000000003e-09
+ 70.4375p -1.010612e-08 70.450000000000003p -1.023527e-08 70.462500000000006p -1.034985e-08 70.474999999999994p -1.044979e-08 70.487499999999997p -1.053501e-08 70.5p -1.0605460000000001e-08 70.512500000000003p -1.0661110000000001e-08 70.524999999999991p -1.070194e-08 70.537499999999994p -1.0727970000000001e-08 70.550000000000011p -1.073921e-08 70.5625p -1.0735719999999999e-08 70.575000000000003p -1.0717549999999999e-08 70.587500000000006p -1.06848e-08 70.599999999999994p -1.0637559999999999e-08 70.612499999999997p -1.057596e-08 70.625p -1.050013e-08 70.637500000000003p -1.0410240000000001e-08 70.649999999999991p -1.0306449999999999e-08
+ 70.662499999999994p -1.018896e-08 70.674999999999997p -1.005799e-08 70.6875p -9.9137539999999996e-09 70.700000000000003p -9.7565029999999997e-09 70.712500000000006p -9.5864939999999993e-09 70.724999999999994p -9.4040049999999993e-09 70.737499999999997p -9.2093259999999996e-09 70.75p -9.0027640000000005e-09 70.762500000000003p -8.78464e-09 70.774999999999991p -8.5552890000000006e-09 70.787499999999994p -8.3150589999999993e-09 70.799999999999997p -8.0643120000000005e-09 70.8125p -7.8034229999999996e-09 70.825000000000003p -7.5327760000000001e-09 70.837500000000006p -7.25277e-09 70.850000000000009p -6.9638139999999998e-09 70.862499999999997p -6.6663259999999996e-09 70.875p -6.3607349999999997e-09
+ 70.887500000000003p -6.047479e-09 70.899999999999991p -5.7270049999999997e-09 70.912499999999994p -5.3997669999999997e-09 70.924999999999997p -5.0662270000000001e-09 70.9375p -4.7268530000000002e-09 70.950000000000003p -4.3821200000000002e-09 70.962500000000006p -4.0325090000000003e-09 70.975000000000009p -3.6785040000000001e-09 70.987499999999997p -3.3205949999999999e-09 71p -2.9592739999999999e-09 71.012500000000003p -2.5950360000000001e-09 71.024999999999991p -2.228381e-09 71.037499999999994p -1.859806e-09 71.049999999999997p -1.489813e-09 71.0625p -1.1189019999999999e-09 71.075000000000003p -7.4757309999999999e-10 71.087500000000006p -3.7632549999999999e-10 71.100000000000009p -5.6566149999999997e-12
+ 71.112499999999997p 3.6393830000000001e-10 71.125p 7.3196699999999998e-10 71.137500000000003p 1.0979409999999999e-09 71.149999999999991p 1.4613759999999999e-09 71.162499999999994p 1.821792e-09 71.174999999999997p 2.1787150000000002e-09 71.1875p 2.531677e-09 71.200000000000003p 2.8802160000000002e-09 71.212500000000006p 3.2238789999999999e-09 71.225000000000009p 3.5622189999999998e-09 71.237499999999997p 3.8947970000000001e-09 71.25p 4.2211840000000001e-09 71.262500000000003p 4.5409609999999999e-09 71.274999999999991p 4.8537159999999996e-09 71.287499999999994p 5.1590520000000001e-09 71.299999999999997p 5.456578e-09 71.3125p 5.7459180000000001e-09 71.325000000000003p 6.0267059999999997e-09
+ 71.337500000000006p 6.2985890000000004e-09 71.350000000000009p 6.5612270000000004e-09 71.362499999999997p 6.8142920000000003e-09 71.375p 7.0574689999999997e-09 71.387500000000003p 7.2904599999999997e-09 71.399999999999991p 7.5129780000000004e-09 71.412499999999994p 7.7247509999999997e-09 71.424999999999997p 7.9255229999999995e-09 71.4375p 8.1150530000000006e-09 71.450000000000003p 8.2931150000000005e-09 71.462500000000006p 8.4594979999999998e-09 71.475000000000009p 8.6140079999999995e-09 71.487499999999997p 8.7564660000000004e-09 71.5p 8.8867100000000006e-09 71.512500000000003p 9.0045939999999999e-09 71.525000000000006p 9.109989e-09 71.537499999999994p 9.2027830000000001e-09 71.549999999999997p 9.2828799999999993e-09
+ 71.5625p 9.3502010000000006e-09 71.575000000000003p 9.4046830000000004e-09 71.587500000000006p 9.4462819999999996e-09 71.600000000000009p 9.4749709999999995e-09 71.612499999999997p 9.4907360000000006e-09 71.625p 9.4935859999999992e-09 71.637500000000003p 9.483541e-09 71.650000000000006p 9.4606419999999995e-09 71.662499999999994p 9.4249440000000004e-09 71.674999999999997p 9.3765209999999997e-09 71.6875p 9.3154610000000007e-09 71.699999999999989p 9.2418699999999992e-09 71.712500000000006p 9.1558690000000007e-09 71.725000000000009p 9.0575959999999994e-09 71.737499999999997p 8.9472029999999992e-09 71.75p 8.8248599999999997e-09 71.762500000000003p 8.6907489999999993e-09 71.775000000000006p 8.5450690000000002e-09
+ 71.787499999999994p 8.3880339999999997e-09 71.799999999999997p 8.2198710000000004e-09 71.8125p 8.0408199999999995e-09 71.824999999999989p 7.8511379999999996e-09 71.837500000000006p 7.6510919999999997e-09 71.850000000000009p 7.440963e-09 71.862500000000011p 7.2210450000000001e-09 71.875p 6.9916439999999997e-09 71.887500000000003p 6.7530769999999999e-09 71.900000000000006p 6.5056720000000002e-09 71.912499999999994p 6.2497680000000002e-09 71.924999999999997p 5.9857149999999999e-09 71.9375p 5.713873e-09 71.949999999999989p 5.4346089999999998e-09 71.962499999999991p 5.1483020000000003e-09 71.975000000000009p 4.8553359999999999e-09 71.987500000000011p 4.5561069999999998e-09 72p 4.2510139999999998e-09
+ 72.012500000000003p 3.9404650000000002e-09 72.025000000000006p 3.6248729999999998e-09 72.037499999999994p 3.30466e-09 72.049999999999997p 2.9802480000000001e-09 72.0625p 2.6520670000000002e-09 72.074999999999989p 2.3205510000000001e-09 72.087499999999991p 1.986135e-09 72.100000000000009p 1.649259e-09 72.112500000000011p 1.3103660000000001e-09 72.125p 9.6989790000000009e-10 72.137500000000003p 6.2829980000000003e-10 72.150000000000006p 2.8601699999999999e-10 72.162499999999994p -5.6505400000000001e-11 72.174999999999997p -3.9882279999999999e-10 72.1875p -7.4049149999999995e-10 72.199999999999989p -1.0810700000000001e-09 72.212499999999991p -1.420118e-09 72.224999999999994p -1.7572000000000001e-09
+ 72.237500000000011p -2.0918809999999999e-09 72.25p -2.4237320000000001e-09 72.262500000000003p -2.7523289999999998e-09 72.275000000000006p -3.0772499999999999e-09 72.287499999999994p -3.3980809999999998e-09 72.299999999999997p -3.7144139999999998e-09 72.3125p -4.025847e-09 72.325000000000003p -4.3319840000000002e-09 72.337499999999991p -4.6324370000000001e-09 72.349999999999994p -4.9268270000000003e-09 72.362500000000011p -5.2147830000000002e-09 72.375p -5.4959430000000001e-09 72.387500000000003p -5.7699520000000001e-09 72.400000000000006p -6.0364679999999997e-09 72.412499999999994p -6.2951580000000002e-09 72.424999999999997p -6.5456999999999998e-09 72.4375p -6.7877800000000003e-09 72.450000000000003p -7.0211000000000001e-09
+ 72.462499999999991p -7.2453709999999997e-09 72.474999999999994p -7.4603160000000001e-09 72.487500000000011p -7.6656699999999996e-09 72.5p -7.8611820000000002e-09 72.512500000000003p -8.0466129999999999e-09 72.525000000000006p -8.2217390000000003e-09 72.537499999999994p -8.3863459999999992e-09 72.549999999999997p -8.5402359999999998e-09 72.5625p -8.6832249999999997e-09 72.575000000000003p -8.8151430000000008e-09 72.587499999999991p -8.9358339999999998e-09 72.599999999999994p -9.0451550000000007e-09 72.612499999999997p -9.1429810000000001e-09 72.625p -9.229199e-09 72.637500000000003p -9.3037119999999993e-09 72.650000000000006p -9.3664359999999993e-09 72.662500000000009p -9.4173060000000008e-09 72.674999999999997p -9.4562679999999998e-09
+ 72.6875p -9.4832859999999998e-09 72.700000000000003p -9.4983380000000003e-09 72.712499999999991p -9.5014150000000001e-09 72.724999999999994p -9.4925270000000008e-09 72.737499999999997p -9.4716969999999997e-09 72.75p -9.4389630000000008e-09 72.762500000000003p -9.3943779999999993e-09 72.775000000000006p -9.3380090000000002e-09 72.787500000000009p -9.2699400000000004e-09 72.799999999999997p -9.1902670000000006e-09 72.8125p -9.0991020000000004e-09 72.825000000000003p -8.9965699999999997e-09 72.837499999999991p -8.8828110000000002e-09 72.849999999999994p -8.7579789999999997e-09 72.862499999999997p -8.6222410000000001e-09 72.875p -8.4757779999999996e-09 72.887500000000003p -8.3187830000000002e-09 72.900000000000006p -8.1514619999999997e-09
+ 72.912500000000009p -7.9740350000000004e-09 72.924999999999997p -7.7867329999999998e-09 72.9375p -7.5897980000000006e-09 72.950000000000003p -7.3834870000000004e-09 72.962499999999991p -7.1680659999999996e-09 72.974999999999994p -6.9438099999999998e-09 72.987499999999997p -6.7110079999999997e-09 73p -6.469958e-09 73.012500000000003p -6.2209659999999998e-09 73.025000000000006p -5.9643509999999999e-09 73.037500000000009p -5.7004370000000001e-09 73.049999999999997p -5.4295589999999997e-09 73.0625p -5.1520599999999997e-09 73.075000000000003p -4.8682889999999996e-09 73.087499999999991p -4.5786040000000003e-09 73.099999999999994p -4.2833690000000004e-09 73.112499999999997p -3.9829540000000002e-09 73.125p -3.6777349999999998e-09
+ 73.137500000000003p -3.3680940000000001e-09 73.150000000000006p -3.0544159999999998e-09 73.162500000000009p -2.7370919999999999e-09 73.174999999999997p -2.4165170000000001e-09 73.1875p -2.093088e-09 73.200000000000003p -1.7672059999999999e-09 73.212499999999991p -1.4392730000000001e-09 73.224999999999994p -1.1096950000000001e-09 73.237499999999997p -7.7887720000000004e-10 73.25p -4.472267e-10 73.262500000000003p -1.1515079999999999e-10 73.275000000000006p 2.1694360000000001e-10 73.287500000000009p 5.4865029999999995e-10 73.299999999999997p 8.7956400000000005e-10 73.3125p 1.2092810000000001e-09 73.325000000000003p 1.537401e-09 73.337499999999991p 1.8635250000000001e-09 73.349999999999994p 2.187257e-09
+ 73.362499999999997p 2.508205e-09 73.375p 2.8259829999999999e-09 73.387500000000003p 3.1402070000000001e-09 73.400000000000006p 3.4504979999999998e-09 73.412500000000009p 3.7564849999999998e-09 73.424999999999997p 4.0578010000000001e-09 73.4375p 4.3540859999999998e-09 73.450000000000003p 4.6449860000000001e-09 73.462500000000006p 4.9301560000000002e-09 73.474999999999994p 5.2092569999999997e-09 73.487499999999997p 5.4819579999999997e-09 73.5p 5.7479379999999997e-09 73.512499999999989p 6.0068830000000004e-09 73.525000000000006p 6.2584900000000004e-09 73.537500000000009p 6.5024639999999999e-09 73.549999999999997p 6.7385210000000003e-09 73.5625p 6.9663859999999999e-09 73.575000000000003p 7.1857960000000001e-09
+ 73.587500000000006p 7.3964970000000001e-09 73.599999999999994p 7.5982479999999993e-09 73.612499999999997p 7.790818e-09 73.625p 7.9739880000000003e-09 73.637499999999989p 8.1475510000000004e-09 73.650000000000006p 8.3113119999999993e-09 73.662500000000009p 8.4650890000000003e-09 73.674999999999997p 8.6087120000000004e-09 73.6875p 8.7420220000000002e-09 73.700000000000003p 8.8648770000000008e-09 73.712500000000006p 8.9771420000000005e-09 73.724999999999994p 9.0787020000000007e-09 73.737499999999997p 9.1694490000000001e-09 73.75p 9.2492919999999994e-09 73.762499999999989p 9.3181540000000006e-09 73.774999999999991p 9.3759670000000001e-09 73.787500000000009p 9.4226820000000006e-09 73.800000000000011p 9.4582599999999996e-09
+ 73.8125p 9.4826769999999992e-09 73.825000000000003p 9.4959219999999994e-09 73.837500000000006p 9.4979970000000008e-09 73.849999999999994p 9.4889190000000005e-09 73.862499999999997p 9.4687179999999997e-09 73.875p 9.4374370000000007e-09 73.887499999999989p 9.3951309999999995e-09 73.899999999999991p 9.3418710000000004e-09 73.912500000000009p 9.2777389999999999e-09 73.925000000000011p 9.2028300000000002e-09 73.9375p 9.1172539999999998e-09 73.950000000000003p 9.0211310000000006e-09 73.962500000000006p 8.9145940000000004e-09 73.974999999999994p 8.7977889999999993e-09 73.987499999999997p 8.6708750000000002e-09 74p 8.5340200000000003e-09 74.012499999999989p 8.3874059999999996e-09 74.024999999999991p 8.231225e-09
+ 74.037500000000009p 8.0656810000000001e-09 74.050000000000011p 7.8909890000000008e-09 74.0625p 7.7073720000000003e-09 74.075000000000003p 7.5150669999999996e-09 74.087500000000006p 7.3143190000000001e-09 74.099999999999994p 7.1053809999999996e-09 74.112499999999997p 6.8885179999999999e-09 74.125p 6.6640030000000003e-09 74.137500000000003p 6.4321159999999999e-09 74.149999999999991p 6.1931479999999996e-09 74.162499999999994p 5.9473949999999996e-09 74.175000000000011p 5.6951620000000002e-09 74.1875p 5.4367610000000001e-09 74.200000000000003p 5.1725100000000004e-09 74.212500000000006p 4.9027339999999997e-09 74.224999999999994p 4.6277620000000004e-09 74.237499999999997p 4.3479320000000001e-09 74.25p 4.0635839999999998e-09
+ 74.262500000000003p 3.7750619999999998e-09 74.274999999999991p 3.4827160000000001e-09 74.287499999999994p 3.1869010000000001e-09 74.300000000000011p 2.8879699999999999e-09 74.3125p 2.5862849999999998e-09 74.325000000000003p 2.282207e-09 74.337500000000006p 1.976098e-09 74.349999999999994p 1.668325e-09 74.362499999999997p 1.3592520000000001e-09 74.375p 1.0492469999999999e-09 74.387500000000003p 7.3867569999999995e-10 74.399999999999991p 4.2790510000000001e-10 74.412499999999994p 1.1730060000000001e-10 74.424999999999997p -1.927734e-10 74.4375p -5.0195390000000001e-10 74.450000000000003p -8.0988029999999999e-10 74.462500000000006p -1.1161940000000001e-09 74.474999999999994p -1.420541e-09
+ 74.487499999999997p -1.7225670000000001e-09 74.5p -2.0219259999999998e-09 74.512500000000003p -2.3182719999999999e-09 74.524999999999991p -2.6112670000000001e-09 74.537499999999994p -2.9005759999999999e-09 74.549999999999997p -3.185869e-09 74.5625p -3.4668239999999999e-09 74.575000000000003p -3.743122e-09 74.587500000000006p -4.0144530000000001e-09 74.600000000000009p -4.2805129999999999e-09 74.612499999999997p -4.5410049999999999e-09 74.625p -4.7956390000000003e-09 74.637500000000003p -5.0441350000000004e-09 74.649999999999991p -5.2862180000000002e-09 74.662499999999994p -5.5216230000000003e-09 74.674999999999997p -5.7500949999999999e-09 74.6875p -5.971386e-09 74.700000000000003p -6.1852590000000003e-09
+ 74.712500000000006p -6.3914849999999999e-09 74.725000000000009p -6.589845e-09 74.737499999999997p -6.7801309999999997e-09 74.75p -6.9621449999999996e-09 74.762500000000003p -7.1356999999999997e-09 74.774999999999991p -7.3006169999999998e-09 74.787499999999994p -7.4567310000000005e-09 74.799999999999997p -7.6038859999999999e-09 74.8125p -7.7419389999999995e-09 74.825000000000003p -7.8707559999999998e-09 74.837500000000006p -7.9902170000000004e-09 74.850000000000009p -8.1002100000000005e-09 74.862499999999997p -8.2006380000000005e-09 74.875p -8.2914139999999992e-09 74.887500000000003p -8.3724639999999995e-09 74.899999999999991p -8.4437240000000007e-09 74.912499999999994p -8.505143e-09 74.924999999999997p -8.5566809999999994e-09
+ 74.9375p -8.5983120000000005e-09 74.950000000000003p -8.6300199999999999e-09 74.962500000000006p -8.6517999999999994e-09 74.975000000000009p -8.6636610000000002e-09 74.987499999999997p -8.6656219999999999e-09 75p -8.6577159999999993e-09 75.012500000000003p -8.6399850000000001e-09 75.024999999999991p -8.6124840000000001e-09 75.037499999999994p -8.5752790000000003e-09 75.049999999999997p -8.5284460000000002e-09 75.0625p -8.4720760000000008e-09 75.075000000000003p -8.4062659999999997e-09 75.087500000000006p -8.3311279999999997e-09 75.100000000000009p -8.2467819999999993e-09 75.112499999999997p -8.1533609999999996e-09 75.125p -8.0510050000000004e-09 75.137500000000003p -7.9398669999999993e-09 75.149999999999991p -7.8201079999999996e-09
+ 75.162499999999994p -7.6919010000000002e-09 75.174999999999997p -7.5554250000000003e-09 75.1875p -7.4108719999999999e-09 75.200000000000003p -7.2584389999999997e-09 75.212500000000006p -7.0983339999999999e-09 75.225000000000009p -6.9307729999999998e-09 75.237499999999997p -6.7559799999999997e-09 75.25p -6.5741869999999999e-09 75.262500000000003p -6.3856320000000002e-09 75.275000000000006p -6.190562e-09 75.287499999999994p -5.9892290000000001e-09 75.299999999999997p -5.7818940000000002e-09 75.3125p -5.5688210000000001e-09 75.325000000000003p -5.3502819999999997e-09 75.337500000000006p -5.1265540000000003e-09 75.350000000000009p -4.8979190000000001e-09 75.362499999999997p -4.6646619999999997e-09 75.375p -4.4270759999999999e-09
+ 75.387500000000003p -4.1854539999999999e-09 75.400000000000006p -3.940096e-09 75.412499999999994p -3.6913020000000001e-09 75.424999999999997p -3.4393789999999999e-09 75.4375p -3.1846319999999998e-09 75.449999999999989p -2.9273709999999999e-09 75.462500000000006p -2.667907e-09 75.475000000000009p -2.4065519999999999e-09 75.487499999999997p -2.1436200000000001e-09 75.5p -1.8794240000000001e-09 75.512500000000003p -1.614277e-09 75.525000000000006p -1.3484949999999999e-09 75.537499999999994p -1.0823889999999999e-09 75.549999999999997p -8.1627349999999999e-10 75.5625p -5.5045790000000003e-10 75.574999999999989p -2.8525199999999999e-10 75.587500000000006p -2.0962960000000001e-11 75.600000000000009p 2.4210439999999998e-10
+ 75.612500000000011p 5.03648e-10 75.625p 7.6336889999999998e-10 75.637500000000003p 1.0209720000000001e-09 75.650000000000006p 1.276165e-09 75.662499999999994p 1.5286610000000001e-09 75.674999999999997p 1.7781759999999999e-09 75.6875p 2.0244329999999999e-09 75.699999999999989p 2.2671589999999999e-09 75.712499999999991p 2.5060859999999999e-09 75.725000000000009p 2.7409519999999999e-09 75.737500000000011p 2.9715009999999998e-09 75.75p 3.197484e-09 75.762500000000003p 3.4186570000000001e-09 75.775000000000006p 3.6347850000000001e-09 75.787499999999994p 3.8456390000000001e-09 75.799999999999997p 4.050997e-09 75.8125p 4.2506449999999996e-09 75.824999999999989p 4.4443770000000002e-09
+ 75.837499999999991p 4.6319940000000003e-09 75.850000000000009p 4.8133070000000001e-09 75.862500000000011p 4.9881340000000003e-09 75.875p 5.1563029999999998e-09 75.887500000000003p 5.3176489999999998e-09 75.900000000000006p 5.4720160000000003e-09 75.912499999999994p 5.6192599999999999e-09 75.924999999999997p 5.7592439999999997e-09 75.9375p 5.8918389999999999e-09 75.949999999999989p 6.0169279999999996e-09 75.962499999999991p 6.1344019999999996e-09 75.974999999999994p 6.2441639999999997e-09 75.987500000000011p 6.3461229999999997e-09 76p 6.4402009999999996e-09 76.012500000000003p 6.5263280000000003e-09 76.025000000000006p 6.6044450000000003e-09 76.037499999999994p 6.6745029999999998e-09 76.049999999999997p 6.7364619999999999e-09
+ 76.0625p 6.7902920000000004e-09 76.075000000000003p 6.835974e-09 76.087499999999991p 6.8734970000000002e-09 76.099999999999994p 6.902863e-09 76.112500000000011p 6.9240800000000004e-09 76.125p 6.9371689999999996e-09 76.137500000000003p 6.9421599999999999e-09 76.150000000000006p 6.9390899999999999e-09 76.162499999999994p 6.9280089999999996e-09 76.174999999999997p 6.9089750000000003e-09 76.1875p 6.8820539999999999e-09 76.200000000000003p 6.8473239999999999e-09 76.212499999999991p 6.8048700000000003e-09 76.224999999999994p 6.7547860000000004e-09 76.237500000000011p 6.6971760000000002e-09 76.25p 6.6321509999999996e-09 76.262500000000003p 6.5598310000000004e-09 76.275000000000006p 6.4803449999999999e-09
+ 76.287499999999994p 6.3938290000000001e-09 76.299999999999997p 6.3004269999999998e-09 76.3125p 6.2002899999999999e-09 76.325000000000003p 6.0935789999999996e-09 76.337499999999991p 5.9804590000000003e-09 76.349999999999994p 5.8611030000000001e-09 76.362499999999997p 5.735691e-09 76.375p 5.6044089999999998e-09 76.387500000000003p 5.4674490000000003e-09 76.400000000000006p 5.3250100000000004e-09 76.412500000000009p 5.1772950000000004e-09 76.424999999999997p 5.0245140000000001e-09 76.4375p 4.8668790000000001e-09 76.450000000000003p 4.7046120000000002e-09 76.462499999999991p 4.537933e-09 76.474999999999994p 4.3670720000000001e-09 76.487499999999997p 4.1922590000000003e-09 76.5p 4.013729e-09
+ 76.512500000000003p 3.8317200000000001e-09 76.525000000000006p 3.6464729999999998e-09 76.537500000000009p 3.4582320000000002e-09 76.549999999999997p 3.2672430000000001e-09 76.5625p 3.0737530000000002e-09 76.575000000000003p 2.8780130000000002e-09 76.587499999999991p 2.6802720000000001e-09 76.599999999999994p 2.4807839999999998e-09 76.612499999999997p 2.2797999999999999e-09 76.625p 2.077573e-09 76.637500000000003p 1.8743579999999999e-09 76.650000000000006p 1.6704070000000001e-09 76.662500000000009p 1.465971e-09 76.674999999999997p 1.2613029999999999e-09 76.6875p 1.0566540000000001e-09 76.700000000000003p 8.5227070000000001e-10 76.712499999999991p 6.4840190000000004e-10 76.724999999999994p 4.4529210000000002e-10
+ 76.737499999999997p 2.4318400000000002e-10 76.75p 4.2317760000000002e-11 76.762500000000003p -1.5706969999999999e-10 76.775000000000006p -3.5474429999999998e-10 76.787500000000009p -5.5047589999999998e-10 76.799999999999997p -7.4403770000000004e-10 76.8125p -9.3520710000000003e-10 76.825000000000003p -1.1237659999999999e-09 76.837499999999991p -1.3095000000000001e-09 76.849999999999994p -1.492201e-09 76.862499999999997p -1.6716649999999999e-09 76.875p -1.8476920000000001e-09 76.887500000000003p -2.0200889999999999e-09 76.900000000000006p -2.1886700000000001e-09 76.912500000000009p -2.3532520000000001e-09 76.924999999999997p -2.5136589999999999e-09 76.9375p -2.669722e-09 76.950000000000003p -2.8212790000000001e-09
+ 76.962499999999991p -2.9681719999999999e-09 76.974999999999994p -3.1102519999999999e-09 76.987499999999997p -3.2473769999999999e-09 77p -3.3794109999999999e-09 77.012500000000003p -3.5062249999999999e-09 77.025000000000006p -3.6276989999999999e-09 77.037500000000009p -3.7437190000000001e-09 77.049999999999997p -3.8541790000000001e-09 77.0625p -3.9589800000000003e-09 77.075000000000003p -4.0580309999999998e-09 77.087499999999991p -4.151251e-09 77.099999999999994p -4.2385629999999996e-09 77.112499999999997p -4.3199009999999998e-09 77.125p -4.3952049999999998e-09 77.137500000000003p -4.4644239999999998e-09 77.150000000000006p -4.5275150000000002e-09 77.162500000000009p -4.5844429999999997e-09 77.174999999999997p -4.6351800000000001e-09
+ 77.1875p -4.6797069999999996e-09 77.200000000000003p -4.7180120000000001e-09 77.212500000000006p -4.7500939999999997e-09 77.224999999999994p -4.7759560000000001e-09 77.237499999999997p -4.7956100000000002e-09 77.25p -4.8090780000000003e-09 77.262499999999989p -4.8163859999999997e-09 77.275000000000006p -4.8175719999999997e-09 77.287500000000009p -4.8126779999999997e-09 77.299999999999997p -4.8017550000000002e-09 77.3125p -4.7848609999999999e-09 77.325000000000003p -4.7620610000000003e-09 77.337500000000006p -4.7334290000000004e-09 77.349999999999994p -4.6990430000000001e-09 77.362499999999997p -4.6589899999999999e-09 77.375p -4.6133639999999999e-09 77.387499999999989p -4.562263e-09 77.400000000000006p -4.5057949999999999e-09
+ 77.412500000000009p -4.4440710000000003e-09 77.424999999999997p -4.37721e-09 77.4375p -4.3053349999999996e-09 77.450000000000003p -4.2285779999999997e-09 77.462500000000006p -4.147073e-09 77.474999999999994p -4.0609609999999999e-09 77.487499999999997p -3.9703870000000003e-09 77.5p -3.8755029999999998e-09 77.512499999999989p -3.776464e-09 77.524999999999991p -3.6734289999999999e-09 77.537500000000009p -3.566561e-09 77.550000000000011p -3.4560300000000001e-09 77.5625p -3.3420050000000002e-09 77.575000000000003p -3.224663e-09 77.587500000000006p -3.1041799999999999e-09 77.599999999999994p -2.9807389999999999e-09 77.612499999999997p -2.8545229999999999e-09 77.625p -2.7257180000000002e-09
+ 77.637499999999989p -2.5945130000000001e-09 77.649999999999991p -2.4610989999999998e-09 77.662500000000009p -2.3256659999999999e-09 77.675000000000011p -2.1884099999999999e-09 77.6875p -2.0495250000000001e-09 77.700000000000003p -1.9092059999999998e-09 77.712500000000006p -1.7676490000000001e-09 77.724999999999994p -1.625053e-09 77.737499999999997p -1.4816129999999999e-09 77.75p -1.337526e-09 77.762499999999989p -1.19299e-09 77.774999999999991p -1.0481979999999999e-09 77.787500000000009p -9.033481e-10 77.800000000000011p -7.5863219999999997e-10 77.8125p -6.1424339999999999e-10 77.825000000000003p -4.7037249999999997e-10 77.837500000000006p -3.2720849999999999e-10 77.849999999999994p -1.849385e-10
+ 77.862499999999997p -4.3747050000000001e-11 77.875p 9.6183739999999998e-11 77.887500000000003p 2.3467450000000002e-10 77.899999999999991p 3.7154900000000002e-10 77.912499999999994p 5.0663399999999997e-10 77.925000000000011p 6.3975990000000004e-10 77.9375p 7.7076049999999999e-10 77.950000000000003p 8.9947360000000001e-10 77.962500000000006p 1.0257409999999999e-09 77.974999999999994p 1.149408e-09 77.987499999999997p 1.2703260000000001e-09 78p 1.3883500000000001e-09 78.012500000000003p 1.5033380000000001e-09 78.024999999999991p 1.615156e-09 78.037499999999994p 1.723673e-09 78.050000000000011p 1.8287629999999999e-09 78.0625p 1.930307e-09 78.075000000000003p 2.0281899999999998e-09
+ 78.087500000000006p 2.122304e-09 78.099999999999994p 2.2125449999999998e-09 78.112499999999997p 2.2988150000000002e-09 78.125p 2.3810229999999998e-09 78.137500000000003p 2.4590829999999999e-09 78.149999999999991p 2.5329159999999999e-09 78.162499999999994p 2.6024489999999999e-09 78.174999999999997p 2.6676140000000001e-09 78.1875p 2.7283509999999999e-09 78.200000000000003p 2.784605e-09 78.212500000000006p 2.8363280000000001e-09 78.225000000000009p 2.8834769999999999e-09 78.237499999999997p 2.9260189999999999e-09 78.25p 2.9639239999999999e-09 78.262500000000003p 2.9971680000000001e-09 78.274999999999991p 3.0257380000000001e-09 78.287499999999994p 3.0496219999999999e-09 78.299999999999997p 3.0688179999999999e-09
+ 78.3125p 3.0833280000000001e-09 78.325000000000003p 3.0931629999999998e-09 78.337500000000006p 3.098339e-09 78.350000000000009p 3.0988769999999998e-09 78.362499999999997p 3.0948069999999999e-09 78.375p 3.0861609999999999e-09 78.387500000000003p 3.0729820000000001e-09 78.399999999999991p 3.0553160000000001e-09 78.412499999999994p 3.0332150000000001e-09 78.424999999999997p 3.0067370000000002e-09 78.4375p 2.9759470000000001e-09 78.450000000000003p 2.940914e-09 78.462500000000006p 2.901713e-09 78.475000000000009p 2.8584250000000001e-09 78.487499999999997p 2.811134e-09 78.5p 2.7599319999999998e-09 78.512500000000003p 2.7049149999999999e-09 78.524999999999991p 2.6461819999999999e-09
+ 78.537499999999994p 2.5838390000000001e-09 78.549999999999997p 2.5179949999999998e-09 78.5625p 2.4487640000000002e-09 78.575000000000003p 2.3762639999999999e-09 78.587500000000006p 2.3006159999999998e-09 78.600000000000009p 2.2219479999999999e-09 78.612499999999997p 2.1403859999999999e-09 78.625p 2.0560659999999999e-09 78.637500000000003p 1.9691209999999998e-09 78.649999999999991p 1.8796910000000001e-09 78.662499999999994p 1.7879190000000001e-09 78.674999999999997p 1.693947e-09 78.6875p 1.597924e-09 78.700000000000003p 1.4999970000000001e-09 78.712500000000006p 1.400318e-09 78.725000000000009p 1.2990400000000001e-09 78.737499999999997p 1.196316e-09 78.75p 1.092303e-09
+ 78.762500000000003p 9.8715809999999994e-10 78.774999999999991p 8.8103799999999997e-10 78.787499999999994p 7.7410169999999997e-10 78.799999999999997p 6.6650819999999995e-10 78.8125p 5.584167e-10 78.825000000000003p 4.499867e-10 78.837500000000006p 3.4137740000000001e-10 78.850000000000009p 2.3274760000000001e-10 78.862499999999997p 1.2425569999999999e-10 78.875p 1.6059279999999999e-11 78.887500000000003p -9.1685209999999996e-11 78.899999999999991p -1.9882240000000001e-10 78.912499999999994p -3.0519819999999999e-10 78.924999999999997p -4.1066039999999998e-10 78.9375p -5.1505839999999998e-10 78.950000000000003p -6.1824360000000004e-10 78.962500000000006p -7.2006959999999995e-10 78.975000000000009p -8.2039249999999997e-10
+ 78.987499999999997p -9.1907079999999996e-10 79p -1.0159659999999999e-09 79.012500000000003p -1.1109419999999999e-09 79.025000000000006p -1.2038660000000001e-09 79.037499999999994p -1.294609e-09 79.049999999999997p -1.3830460000000001e-09 79.0625p -1.469052e-09 79.075000000000003p -1.552511e-09 79.087500000000006p -1.6333070000000001e-09 79.100000000000009p -1.711329e-09 79.112499999999997p -1.7864719999999999e-09 79.125p -1.858632e-09 79.137500000000003p -1.927712e-09 79.150000000000006p -1.9936190000000001e-09 79.162499999999994p -2.0562640000000001e-09 79.174999999999997p -2.1155640000000001e-09 79.1875p -2.1714379999999999e-09 79.199999999999989p -2.223814e-09
+ 79.212500000000006p -2.2726220000000002e-09 79.225000000000009p -2.3177990000000001e-09 79.237499999999997p -2.3592850000000001e-09 79.25p -2.3970280000000001e-09 79.262500000000003p -2.4309799999999998e-09 79.275000000000006p -2.4610960000000001e-09 79.287499999999994p -2.487342e-09 79.299999999999997p -2.5096830000000001e-09 79.3125p -2.528095e-09 79.324999999999989p -2.5425559999999999e-09 79.337500000000006p -2.5530509999999999e-09 79.350000000000009p -2.5595690000000002e-09 79.362500000000011p -2.5621080000000001e-09 79.375p -2.5606669999999999e-09 79.387500000000003p -2.5552539999999999e-09 79.400000000000006p -2.5458799999999999e-09 79.412499999999994p -2.5325639999999998e-09 79.424999999999997p -2.515328e-09
+ 79.4375p -2.4941999999999999e-09 79.449999999999989p -2.4692149999999999e-09 79.462499999999991p -2.4404120000000001e-09 79.475000000000009p -2.4078330000000001e-09 79.487500000000011p -2.37153e-09 79.5p -2.3315549999999998e-09 79.512500000000003p -2.287969e-09 79.525000000000006p -2.2408359999999999e-09 79.537499999999994p -2.1902239999999999e-09 79.549999999999997p -2.1362069999999999e-09 79.5625p -2.0788630000000001e-09 79.574999999999989p -2.0182760000000002e-09 79.587499999999991p -1.9545320000000001e-09 79.600000000000009p -1.887722e-09 79.612500000000011p -1.8179409999999999e-09 79.625p -1.7452900000000001e-09 79.637500000000003p -1.6698710000000001e-09 79.650000000000006p -1.5917899999999999e-09
+ 79.662499999999994p -1.511158e-09 79.674999999999997p -1.4280890000000001e-09 79.6875p -1.3426999999999999e-09 79.699999999999989p -1.25511e-09 79.712499999999991p -1.1654420000000001e-09 79.724999999999994p -1.0738219999999999e-09 79.737500000000011p -9.8037790000000003e-10 79.75p -8.8523979999999997e-10 79.762500000000003p -7.885405e-10 79.775000000000006p -6.9041460000000002e-10 79.787499999999994p -5.9099859999999999e-10 79.799999999999997p -4.9043060000000002e-10 79.8125p -3.8885009999999999e-10 79.825000000000003p -2.8639809999999998e-10 79.837499999999991p -1.832164e-10 79.849999999999994p -7.9447899999999997e-11 79.862500000000011p 2.4763830000000001e-11 79.875p 1.2927470000000001e-10
+ 79.887500000000003p 2.3394039999999999e-10 79.900000000000006p 3.3861640000000001e-10 79.912499999999994p 4.4315810000000001e-10 79.924999999999997p 5.4742129999999996e-10 79.9375p 6.5126229999999999e-10 79.950000000000003p 7.5453779999999998e-10 79.962499999999991p 8.5710540000000003e-10 79.974999999999994p 9.5882390000000001e-10 79.987499999999997p 1.0595530000000001e-09 80p 1.1591539999999999e-09 80.012500000000003p 1.2574890000000001e-09 80.025000000000006p 1.3544230000000001e-09 80.037499999999994p 1.449823e-09 80.049999999999997p 1.543556e-09 80.0625p 1.635493e-09 80.075000000000003p 1.725508e-09 80.087499999999991p 1.813476e-09 80.099999999999994p 1.8992750000000001e-09
+ 80.112499999999997p 1.9827869999999998e-09 80.125p 2.0638949999999999e-09 80.137500000000003p 2.1424879999999999e-09 80.150000000000006p 2.2184560000000002e-09 80.162500000000009p 2.2916930000000001e-09 80.174999999999997p 2.3620980000000001e-09 80.1875p 2.4295720000000001e-09 80.200000000000003p 2.4940190000000001e-09 80.212499999999991p 2.5553510000000002e-09 80.224999999999994p 2.61348e-09 80.237499999999997p 2.6683240000000002e-09 80.25p 2.719805e-09 80.262500000000003p 2.7678489999999998e-09 80.275000000000006p 2.8123879999999998e-09 80.287500000000009p 2.853357e-09 80.299999999999997p 2.8906959999999999e-09 80.3125p 2.9243489999999998e-09 80.325000000000003p 2.9542669999999998e-09
+ 80.337499999999991p 2.9804040000000002e-09 80.349999999999994p 3.0027200000000002e-09 80.362499999999997p 3.0211779999999999e-09 80.375p 3.0357490000000001e-09 80.387500000000003p 3.046406e-09 80.400000000000006p 3.0531289999999999e-09 80.412500000000009p 3.0559029999999999e-09 80.424999999999997p 3.0547169999999998e-09 80.4375p 3.0495659999999998e-09 80.450000000000003p 3.0404500000000002e-09 80.462499999999991p 3.0273740000000001e-09 80.474999999999994p 3.0103479999999998e-09 80.487499999999997p 2.989387e-09 80.5p 2.9645119999999999e-09 80.512500000000003p 2.9357470000000002e-09 80.525000000000006p 2.9031229999999999e-09 80.537500000000009p 2.8666749999999999e-09 80.549999999999997p 2.8264430000000001e-09
+ 80.5625p 2.782472e-09 80.575000000000003p 2.7348109999999999e-09 80.587499999999991p 2.6835159999999998e-09 80.599999999999994p 2.628646e-09 80.612499999999997p 2.5702629999999999e-09 80.625p 2.508436e-09 80.637500000000003p 2.4432369999999998e-09 80.650000000000006p 2.374744e-09 80.662500000000009p 2.3030369999999998e-09 80.674999999999997p 2.2282010000000001e-09 80.6875p 2.1503259999999999e-09 80.700000000000003p 2.0695049999999999e-09 80.712499999999991p 1.9858330000000001e-09 80.724999999999994p 1.8994110000000001e-09 80.737499999999997p 1.810344e-09 80.75p 1.718738e-09 80.762500000000003p 1.624704e-09 80.775000000000006p 1.528354e-09
+ 80.787500000000009p 1.429806e-09 80.799999999999997p 1.329179e-09 80.8125p 1.2265929999999999e-09 80.825000000000003p 1.122175e-09 80.837499999999991p 1.0160489999999999e-09 80.849999999999994p 9.0834539999999995e-10 80.862499999999997p 7.991942e-10 80.875p 6.8872809999999997e-10 80.887500000000003p 5.7708130000000004e-10 80.900000000000006p 4.6438960000000001e-10 80.912500000000009p 3.507899e-10 80.924999999999997p 2.364205e-10 80.9375p 1.2142050000000001e-10 80.950000000000003p 5.9299409999999998e-12 80.962500000000006p -1.099107e-10 80.974999999999994p -2.2596030000000001e-10 80.987499999999997p -3.420775e-10 81p -4.5812100000000003e-10
+ 81.012499999999989p -5.7394929999999995e-10 81.025000000000006p -6.8942140000000002e-10 81.037500000000009p -8.0439659999999998e-10 81.049999999999997p -9.1873470000000004e-10 81.0625p -1.0322969999999999e-09 81.075000000000003p -1.144944e-09 81.087500000000006p -1.256539e-09 81.099999999999994p -1.3669460000000001e-09 81.112499999999997p -1.476031e-09 81.125p -1.5836600000000001e-09 81.137499999999989p -1.689703e-09 81.150000000000006p -1.7940300000000001e-09 81.162500000000009p -1.8965140000000001e-09 81.174999999999997p -1.997031e-09 81.1875p -2.095457e-09 81.200000000000003p -2.1916740000000002e-09 81.212500000000006p -2.2855629999999998e-09 81.224999999999994p -2.3770099999999998e-09
+ 81.237499999999997p -2.465904e-09 81.25p -2.5521370000000001e-09 81.262499999999989p -2.635603e-09 81.274999999999991p -2.7162000000000002e-09 81.287500000000009p -2.7938319999999999e-09 81.300000000000011p -2.868402e-09 81.3125p -2.939819e-09 81.325000000000003p -3.0079980000000001e-09 81.337500000000006p -3.0728539999999998e-09 81.349999999999994p -3.1343090000000002e-09 81.362499999999997p -3.1922869999999998e-09 81.375p -3.246717e-09 81.387499999999989p -3.297533e-09 81.399999999999991p -3.344672e-09 81.412500000000009p -3.388077e-09 81.425000000000011p -3.4276950000000001e-09 81.4375p -3.4634760000000001e-09 81.450000000000003p -3.4953769999999999e-09
+ 81.462500000000006p -3.523357e-09 81.474999999999994p -3.547382e-09 81.487499999999997p -3.5674219999999999e-09 81.5p -3.5834519999999999e-09 81.512499999999989p -3.5954509999999999e-09 81.524999999999991p -3.6034029999999999e-09 81.537500000000009p -3.607297e-09 81.550000000000011p -3.6071279999999999e-09 81.5625p -3.6028929999999999e-09 81.575000000000003p -3.5945969999999998e-09 81.587500000000006p -3.5822479999999999e-09 81.599999999999994p -3.565859e-09 81.612499999999997p -3.5454480000000002e-09 81.625p -3.5210369999999999e-09 81.637500000000003p -3.492654e-09 81.649999999999991p -3.4603310000000001e-09 81.662499999999994p -3.4241050000000001e-09 81.675000000000011p -3.3840179999999998e-09
+ 81.6875p -3.3401130000000001e-09 81.700000000000003p -3.292443e-09 81.712500000000006p -3.2410620000000002e-09 81.724999999999994p -3.1860290000000001e-09 81.737499999999997p -3.127406e-09 81.75p -3.065262e-09 81.762500000000003p -2.999668e-09 81.774999999999991p -2.9306989999999999e-09 81.787499999999994p -2.8584340000000001e-09 81.800000000000011p -2.7829579999999999e-09 81.8125p -2.7043559999999999e-09 81.825000000000003p -2.6227189999999999e-09 81.837500000000006p -2.5381400000000001e-09 81.849999999999994p -2.4507180000000002e-09 81.862499999999997p -2.3605529999999998e-09 81.875p -2.2677479999999999e-09 81.887500000000003p -2.172409e-09 81.899999999999991p -2.074646e-09
+ 81.912499999999994p -1.974571e-09 81.924999999999997p -1.8722989999999999e-09 81.9375p -1.767946e-09 81.950000000000003p -1.6616329999999999e-09 81.962500000000006p -1.5534800000000001e-09 81.975000000000009p -1.4436110000000001e-09 81.987499999999997p -1.3321509999999999e-09 82p -1.2192279999999999e-09 82.012500000000003p -1.1049690000000001e-09 82.024999999999991p -9.8950519999999995e-10 82.037499999999994p -8.7296719999999997e-10 82.049999999999997p -7.5548740000000004e-10 82.0625p -6.3719870000000003e-10 82.075000000000003p -5.1823519999999998e-10 82.087500000000006p -3.987312e-10 82.100000000000009p -2.7882179999999998e-10 82.112499999999997p -1.5864189999999999e-10 82.125p -3.8327019999999997e-11
+ 82.137500000000003p 8.1987719999999995e-11 82.149999999999991p 2.021673e-10 82.162499999999994p 3.2207700000000001e-10 82.174999999999997p 4.4158259999999999e-10 82.1875p 5.6055089999999997e-10 82.200000000000003p 6.7884899999999998e-10 82.212500000000006p 7.9634549999999996e-10 82.225000000000009p 9.1290970000000001e-10 82.237499999999997p 1.0284130000000001e-09 82.25p 1.142726e-09 82.262500000000003p 1.2557239999999999e-09 82.274999999999991p 1.367283e-09 82.287499999999994p 1.477279e-09 82.299999999999997p 1.585593e-09 82.3125p 1.6921049999999999e-09 82.325000000000003p 1.7966989999999999e-09 82.337500000000006p 1.899263e-09 82.350000000000009p 1.9996849999999998e-09
+ 82.362499999999997p 2.0978550000000001e-09 82.375p 2.1936699999999999e-09 82.387500000000003p 2.2870250000000002e-09 82.399999999999991p 2.3778220000000002e-09 82.412499999999994p 2.4659619999999998e-09 82.424999999999997p 2.5513539999999999e-09 82.4375p 2.6339079999999998e-09 82.450000000000003p 2.7135350000000002e-09 82.462500000000006p 2.790154e-09 82.475000000000009p 2.8636839999999998e-09 82.487499999999997p 2.9340510000000001e-09 82.5p 3.0011810000000001e-09 82.512500000000003p 3.0650080000000001e-09 82.524999999999991p 3.1254659999999999e-09 82.537499999999994p 3.1824950000000002e-09 82.549999999999997p 3.236039e-09 82.5625p 3.2860470000000001e-09 82.575000000000003p 3.3324689999999999e-09
+ 82.587500000000006p 3.3752629999999999e-09 82.600000000000009p 3.414388e-09 82.612499999999997p 3.4498100000000001e-09 82.625p 3.4814979999999998e-09 82.637500000000003p 3.5094240000000001e-09 82.649999999999991p 3.5335660000000002e-09 82.662499999999994p 3.553908e-09 82.674999999999997p 3.5704340000000001e-09 82.6875p 3.5831350000000002e-09 82.700000000000003p 3.5920080000000001e-09 82.712500000000006p 3.597051e-09 82.725000000000009p 3.598268e-09 82.737499999999997p 3.5956670000000001e-09 82.75p 3.589261e-09 82.762500000000003p 3.579067e-09 82.775000000000006p 3.565105e-09 82.787499999999994p 3.5474009999999999e-09 82.799999999999997p 3.525983e-09
+ 82.8125p 3.5008859999999999e-09 82.825000000000003p 3.4721470000000001e-09 82.837500000000006p 3.4398080000000001e-09 82.850000000000009p 3.4039140000000001e-09 82.862499999999997p 3.364514e-09 82.875p 3.3216620000000001e-09 82.887500000000003p 3.275414e-09 82.900000000000006p 3.2258310000000001e-09 82.912499999999994p 3.1729780000000001e-09 82.924999999999997p 3.1169219999999998e-09 82.9375p 3.057734e-09 82.949999999999989p 2.9954880000000002e-09 82.962500000000006p 2.930262e-09 82.975000000000009p 2.862138e-09 82.987499999999997p 2.7911969999999999e-09 83p 2.717528e-09 83.012500000000003p 2.6412190000000002e-09 83.025000000000006p 2.562363e-09
+ 83.037499999999994p 2.4810539999999999e-09 83.049999999999997p 2.3973889999999998e-09 83.0625p 2.3114679999999999e-09 83.074999999999989p 2.2233929999999998e-09 83.087500000000006p 2.133266e-09 83.100000000000009p 2.041195e-09 83.112500000000011p 1.9472849999999999e-09 83.125p 1.8516460000000001e-09 83.137500000000003p 1.7543890000000001e-09 83.150000000000006p 1.6556270000000001e-09 83.162499999999994p 1.5554709999999999e-09 83.174999999999997p 1.4540380000000001e-09 83.1875p 1.3514420000000001e-09 83.199999999999989p 1.2477990000000001e-09 83.212499999999991p 1.143228e-09 83.225000000000009p 1.0378449999999999e-09 83.237500000000011p 9.3176950000000003e-10 83.25p 8.2511909999999996e-10
+ 83.262500000000003p 7.1801270000000002e-10 83.275000000000006p 6.1056920000000005e-10 83.287499999999994p 5.0290709999999998e-10 83.299999999999997p 3.951449e-10 83.3125p 2.8740050000000001e-10 83.324999999999989p 1.797916e-10 83.337499999999991p 7.2435060000000002e-11 83.350000000000009p -3.4553070000000001e-11 83.362500000000011p -1.4105750000000001e-10 83.375p -2.4696410000000001e-10 83.387500000000003p -3.5215979999999999e-10 83.400000000000006p -4.5653290000000002e-10 83.412499999999994p -5.5997289999999997e-10 83.424999999999997p -6.6237120000000003e-10 83.4375p -7.6362050000000005e-10 83.449999999999989p -8.6361549999999997e-10 83.462499999999991p -9.6225260000000007e-10 83.474999999999994p -1.0594299999999999e-09
+ 83.487500000000011p -1.1550489999999999e-09 83.5p -1.249012e-09 83.512500000000003p -1.3412240000000001e-09 83.525000000000006p -1.4315929999999999e-09 83.537499999999994p -1.5200290000000001e-09 83.549999999999997p -1.6064439999999999e-09 83.5625p -1.6907529999999999e-09 83.575000000000003p -1.772875e-09 83.587499999999991p -1.852731e-09 83.599999999999994p -1.9302440000000002e-09 83.612500000000011p -2.0053419999999998e-09 83.625p -2.0779550000000002e-09 83.637500000000003p -2.1480149999999998e-09 83.650000000000006p -2.2154589999999998e-09 83.662499999999994p -2.280227e-09 83.674999999999997p -2.342261e-09 83.6875p -2.4015080000000001e-09 83.700000000000003p -2.4579179999999999e-09
+ 83.712499999999991p -2.5114429999999999e-09 83.724999999999994p -2.5620409999999999e-09 83.737499999999997p -2.609672e-09 83.75p -2.6542999999999998e-09 83.762500000000003p -2.6958920000000001e-09 83.775000000000006p -2.7344179999999999e-09 83.787499999999994p -2.7698549999999998e-09 83.799999999999997p -2.802179e-09 83.8125p -2.8313739999999999e-09 83.825000000000003p -2.8574239999999999e-09 83.837499999999991p -2.8803189999999999e-09 83.849999999999994p -2.900051e-09 83.862499999999997p -2.916618e-09 83.875p -2.9300189999999999e-09 83.887500000000003p -2.9402569999999998e-09 83.900000000000006p -2.9473410000000002e-09 83.912500000000009p -2.9512810000000001e-09 83.924999999999997p -2.9520920000000001e-09
+ 83.9375p -2.94979e-09 83.950000000000003p -2.9443980000000001e-09 83.962499999999991p -2.9359400000000001e-09 83.974999999999994p -2.9244439999999999e-09 83.987499999999997p -2.9099419999999998e-09 84p -2.8924669999999999e-09 84.012500000000003p -2.8720579999999999e-09 84.025000000000006p -2.848756e-09 84.037500000000009p -2.8226050000000001e-09 84.049999999999997p -2.7936500000000002e-09 84.0625p -2.7619429999999998e-09 84.075000000000003p -2.7275359999999998e-09 84.087499999999991p -2.6904849999999999e-09 84.099999999999994p -2.6508470000000001e-09 84.112499999999997p -2.6086829999999999e-09 84.125p -2.5640569999999998e-09 84.137500000000003p -2.517034e-09 84.150000000000006p -2.467683e-09
+ 84.162500000000009p -2.416073e-09 84.174999999999997p -2.3622770000000001e-09 84.1875p -2.3063700000000002e-09 84.200000000000003p -2.248428e-09 84.212499999999991p -2.1885300000000001e-09 84.224999999999994p -2.126754e-09 84.237499999999997p -2.0631839999999999e-09 84.25p -1.9979020000000001e-09 84.262500000000003p -1.9309939999999998e-09 84.275000000000006p -1.8625440000000001e-09 84.287500000000009p -1.7926399999999999e-09 84.299999999999997p -1.7213709999999999e-09 84.3125p -1.6488259999999999e-09 84.325000000000003p -1.575094e-09 84.337499999999991p -1.500268e-09 84.349999999999994p -1.4244380000000001e-09 84.362499999999997p -1.3476970000000001e-09 84.375p -1.270137e-09
+ 84.387500000000003p -1.191852e-09 84.400000000000006p -1.1129329999999999e-09 84.412500000000009p -1.0334750000000001e-09 84.424999999999997p -9.5357060000000003e-10 84.4375p -8.7331280000000002e-10 84.450000000000003p -7.927945e-10 84.462499999999991p -7.1210810000000005e-10 84.474999999999994p -6.3134560000000004e-10 84.487499999999997p -5.5059840000000005e-10 84.5p -4.699574e-10 84.512500000000003p -3.895125e-10 84.525000000000006p -3.0935279999999998e-10 84.537500000000009p -2.295664e-10 84.549999999999997p -1.5024049999999999e-10 84.5625p -7.1460949999999997e-11 84.575000000000003p 6.6877070000000003e-12 84.587500000000006p 8.4122170000000002e-11 84.599999999999994p 1.6076060000000001e-10
+ 84.612499999999997p 2.3652279999999999e-10 84.625p 3.1133009999999998e-10 84.637500000000003p 3.8510560000000002e-10 84.650000000000006p 4.5777420000000001e-10 84.662500000000009p 5.2926259999999999e-10 84.674999999999997p 5.9949949999999999e-10 84.6875p 6.684156e-10 84.700000000000003p 7.3594380000000002e-10 84.712500000000006p 8.0201899999999998e-10 84.724999999999994p 8.6657840000000003e-10 84.737499999999997p 9.2956139999999997e-10 84.75p 9.9091010000000008e-10 84.762499999999989p 1.050568e-09 84.775000000000006p 1.108483e-09 84.787500000000009p 1.164603e-09 84.799999999999997p 1.2188809999999999e-09 84.8125p 1.2712700000000001e-09 84.825000000000003p 1.3217279999999999e-09
+ 84.837500000000006p 1.370214e-09 84.849999999999994p 1.41669e-09 84.862499999999997p 1.4611209999999999e-09 84.875p 1.5034749999999999e-09 84.887499999999989p 1.543723e-09 84.900000000000006p 1.581838e-09 84.912500000000009p 1.617795e-09 84.924999999999997p 1.6515739999999999e-09 84.9375p 1.683156e-09 84.950000000000003p 1.7125249999999999e-09 84.962500000000006p 1.7396689999999999e-09 84.974999999999994p 1.764579e-09 84.987499999999997p 1.787246e-09 85p 1.807666e-09 85.012499999999989p 1.825838e-09 85.024999999999991p 1.841763e-09 85.037500000000009p 1.8554450000000001e-09 85.050000000000011p 1.86689e-09
+ 85.0625p 1.8761069999999999e-09 85.075000000000003p 1.8831089999999998e-09 85.087500000000006p 1.8879099999999999e-09 85.099999999999994p 1.890527e-09 85.112499999999997p 1.8909790000000001e-09 85.125p 1.8892900000000002e-09 85.137499999999989p 1.8854819999999998e-09 85.149999999999991p 1.8795839999999999e-09 85.162500000000009p 1.8716239999999998e-09 85.175000000000011p 1.8616339999999999e-09 85.1875p 1.8496479999999999e-09 85.200000000000003p 1.835702e-09 85.212500000000006p 1.8198339999999999e-09 85.224999999999994p 1.8020840000000001e-09 85.237499999999997p 1.7824939999999999e-09 85.25p 1.761109e-09 85.262499999999989p 1.7379730000000001e-09 85.274999999999991p 1.713135e-09
+ 85.287500000000009p 1.686645e-09 85.300000000000011p 1.658552e-09 85.3125p 1.6289099999999999e-09 85.325000000000003p 1.5977730000000001e-09 85.337500000000006p 1.5651960000000001e-09 85.349999999999994p 1.531235e-09 85.362499999999997p 1.4959490000000001e-09 85.375p 1.4593959999999999e-09 85.387500000000003p 1.4216369999999999e-09 85.399999999999991p 1.382733e-09 85.412499999999994p 1.3427459999999999e-09 85.425000000000011p 1.3017380000000001e-09 85.4375p 1.2597719999999999e-09 85.450000000000003p 1.2169139999999999e-09 85.462500000000006p 1.1732280000000001e-09 85.474999999999994p 1.1287780000000001e-09 85.487499999999997p 1.0836299999999999e-09 85.5p 1.0378500000000001e-09
+ 85.512500000000003p 9.9150389999999994e-10 85.524999999999991p 9.4465730000000009e-10 85.537499999999994p 8.9737640000000005e-10 85.550000000000011p 8.49727e-10 85.5625p 8.0177499999999995e-10 85.575000000000003p 7.5358579999999998e-10 85.587500000000006p 7.0522459999999999e-10 85.599999999999994p 6.5675629999999997e-10 85.612499999999997p 6.08245e-10 85.625p 5.5975450000000004e-10 85.637500000000003p 5.1134790000000005e-10 85.649999999999991p 4.6308749999999998e-10 85.662499999999994p 4.1503470000000001e-10 85.674999999999997p 3.6725020000000001e-10 85.6875p 3.197936e-10 85.700000000000003p 2.7272370000000001e-10 85.712500000000006p 2.260979e-10 85.725000000000009p 1.799726e-10
+ 85.737499999999997p 1.34403e-10 85.75p 8.9442899999999997e-11 85.762500000000003p 4.5144769999999999e-11 85.774999999999991p 1.5596999999999999e-12 85.787499999999994p -4.1262730000000001e-11 85.799999999999997p -8.3274460000000003e-11 85.8125p -1.2442899999999999e-10 85.825000000000003p -1.6468150000000001e-10 85.837500000000006p -2.039889e-10 85.850000000000009p -2.4230959999999999e-10 85.862499999999997p -2.7960410000000001e-10 85.875p -3.1583450000000002e-10 85.887500000000003p -3.5096469999999999e-10 85.899999999999991p -3.849607e-10 85.912499999999994p -4.177903e-10 85.924999999999997p -4.4942309999999999e-10 85.9375p -4.7983089999999996e-10 85.950000000000003p -5.0898750000000005e-10
+ 85.962500000000006p -5.3686840000000004e-10 85.975000000000009p -5.6345150000000002e-10 85.987499999999997p -5.8871659999999996e-10 86p -6.1264549999999996e-10 86.012500000000003p -6.3522209999999995e-10 86.024999999999991p -6.5643250000000005e-10 86.037499999999994p -6.7626470000000005e-10 86.049999999999997p -6.947088e-10 86.0625p -7.1175719999999997e-10 86.075000000000003p -7.2740419999999999e-10 86.087500000000006p -7.4164610000000002e-10 86.100000000000009p -7.5448129999999996e-10 86.112499999999997p -7.6591040000000002e-10 86.125p -7.7593590000000005e-10 86.137500000000003p -7.8456220000000001e-10 86.149999999999991p -7.9179599999999996e-10 86.162499999999994p -7.9764550000000005e-10 86.174999999999997p -8.0212140000000005e-10
+ 86.1875p -8.0523580000000001e-10 86.200000000000003p -8.0700309999999996e-10 86.212500000000006p -8.0743920000000001e-10 86.225000000000009p -8.0656190000000004e-10 86.237499999999997p -8.0439109999999999e-10 86.25p -8.0094780000000003e-10 86.262500000000003p -7.9625539999999998e-10 86.274999999999991p -7.9033829999999996e-10 86.287499999999994p -7.8322300000000004e-10 86.299999999999997p -7.7493719999999995e-10 86.3125p -7.655104e-10 86.325000000000003p -7.5497320000000002e-10 86.337500000000006p -7.4335789999999996e-10 86.350000000000009p -7.3069809999999998e-10 86.362499999999997p -7.1702839999999996e-10 86.375p -7.0238490000000002e-10 86.387500000000003p -6.8680489999999996e-10 86.399999999999991p -6.7032650000000002e-10
+ 86.412499999999994p -6.5298919999999999e-10 86.424999999999997p -6.3483319999999995e-10 86.4375p -6.1589979999999995e-10 86.450000000000003p -5.9623100000000003e-10 86.462500000000006p -5.7586970000000001e-10 86.475000000000009p -5.5485929999999997e-10 86.487499999999997p -5.3324420000000001e-10 86.5p -5.110691e-10 86.512500000000003p -4.8837930000000001e-10 86.525000000000006p -4.652204e-10 86.537499999999994p -4.4163869999999999e-10 86.549999999999997p -4.176805e-10 86.5625p -3.9339249999999999e-10 86.574999999999989p -3.6882140000000001e-10 86.587500000000006p -3.440141e-10 86.600000000000009p -3.1901749999999998e-10 86.612499999999997p -2.9387859999999999e-10 86.625p -2.6864390000000002e-10
+ 86.637500000000003p -2.4336019999999999e-10 86.650000000000006p -2.180738e-10 86.662499999999994p -1.9283060000000001e-10 86.674999999999997p -1.6767620000000001e-10 86.6875p -1.4265589999999999e-10 86.699999999999989p -1.1781430000000001e-10 86.712500000000006p -9.3195429999999997e-11 86.725000000000009p -6.8842840000000003e-11 86.737499999999997p -4.4799239999999997e-11 86.75p -2.1106640000000001e-11 86.762500000000003p 2.1937979999999999e-12 86.775000000000006p 2.5061750000000001e-11 86.787499999999994p 4.7457850000000003e-11 86.799999999999997p 6.9343709999999999e-11 86.8125p 9.0681950000000005e-11 86.824999999999989p 1.114363e-10 86.837500000000006p 1.3157160000000001e-10 86.850000000000009p 1.5105399999999999e-10
+ 86.862500000000011p 1.698506e-10 86.875p 1.879301e-10 86.887500000000003p 2.0526230000000001e-10 86.900000000000006p 2.218184e-10 86.912499999999994p 2.37571e-10 86.924999999999997p 2.5249409999999999e-10 86.9375p 2.6656319999999999e-10 86.949999999999989p 2.7975530000000003e-10 86.962499999999991p 2.920489e-10 86.975000000000009p 3.0342389999999997e-10 86.987500000000011p 3.1386209999999999e-10 87p 3.2334659999999998e-10 87.012500000000003p 3.3186220000000001e-10 87.025000000000006p 3.3939529999999999e-10 87.037499999999994p 3.4593409999999998e-10 87.049999999999997p 3.514683e-10 87.0625p 3.5598919999999998e-10 87.074999999999989p 3.5948989999999999e-10
+ 87.087499999999991p 3.6196529999999999e-10 87.100000000000009p 3.6341159999999998e-10 87.112500000000011p 3.6382720000000001e-10 87.125p 3.632117e-10 87.137500000000003p 3.6156670000000001e-10 87.150000000000006p 3.5889530000000002e-10 87.162499999999994p 3.5520240000000001e-10 87.174999999999997p 3.5049430000000002e-10 87.1875p 3.4477930000000001e-10 87.199999999999989p 3.3806699999999998e-10 87.212499999999991p 3.3036889999999998e-10 87.224999999999994p 3.2169769999999998e-10 87.237500000000011p 3.120681e-10 87.25p 3.0149609999999999e-10 87.262500000000003p 2.899991e-10 87.275000000000006p 2.7759630000000001e-10 87.287499999999994p 2.6430800000000002e-10 87.299999999999997p 2.501563e-10
+ 87.3125p 2.351644e-10 87.325000000000003p 2.1935700000000001e-10 87.337499999999991p 2.027599e-10 87.349999999999994p 1.8540050000000001e-10 87.362500000000011p 1.673072e-10 87.375p 1.4850959999999999e-10 87.387500000000003p 1.2903849999999999e-10 87.400000000000006p 1.089259e-10 87.412499999999994p 8.8204619999999995e-11 87.424999999999997p 6.6908650000000001e-11 87.4375p 4.5072860000000002e-11 87.450000000000003p 2.2733060000000001e-11 87.462499999999991p -7.4128850000000001e-14 87.474999999999994p -2.331128e-11 87.487499999999997p -4.6940229999999999e-11 87.5p -7.0922139999999994e-11 87.512500000000003p -9.5217539999999997e-11 87.525000000000006p -1.197864e-10
+ 87.537499999999994p -1.445881e-10 87.549999999999997p -1.695818e-10 87.5625p -1.94726e-10 87.575000000000003p -2.199791e-10 87.587499999999991p -2.4529889999999998e-10 87.599999999999994p -2.7064340000000001e-10 87.612499999999997p -2.9597020000000003e-10 87.625p -3.2123679999999998e-10 87.637500000000003p -3.4640089999999999e-10 87.650000000000006p -3.7141990000000002e-10 87.662500000000009p -3.9625159999999999e-10 87.674999999999997p -4.2085369999999999e-10 87.6875p -4.4518440000000001e-10 87.700000000000003p -4.6920180000000005e-10 87.712499999999991p -4.9286470000000004e-10 87.724999999999994p -5.1613220000000003e-10 87.737499999999997p -5.3896359999999998e-10 87.75p -5.6131899999999997e-10
+ 87.762500000000003p -5.8315899999999997e-10 87.775000000000006p -6.0444480000000001e-10 87.787500000000009p -6.2513829999999995e-10 87.799999999999997p -6.4520200000000002e-10 87.8125p -6.6459930000000005e-10 87.825000000000003p -6.8329450000000001e-10 87.837499999999991p -7.012528e-10 87.849999999999994p -7.1844009999999998e-10 87.862499999999997p -7.3482350000000003e-10 87.875p -7.5037120000000004e-10 87.887500000000003p -7.6505220000000004e-10 87.900000000000006p -7.7883690000000002e-10 87.912500000000009p -7.9169670000000005e-10 87.924999999999997p -8.0360439999999995e-10 87.9375p -8.1453370000000002e-10 87.950000000000003p -8.244601e-10 87.962499999999991p -8.3335989999999997e-10 87.974999999999994p -8.4121109999999997e-10
+ 87.987499999999997p -8.4799300000000001e-10 88p -8.536862e-10 88.012500000000003p -8.58273e-10 88.025000000000006p -8.6173690000000001e-10 88.037500000000009p -8.6406309999999997e-10 88.049999999999997p -8.6523820000000005e-10 88.0625p -8.6525050000000004e-10 88.075000000000003p -8.6408969999999997e-10 88.087499999999991p -8.6174709999999995e-10 88.099999999999994p -8.5821579999999996e-10 88.112499999999997p -8.5349019999999998e-10 88.125p -8.4756659999999995e-10 88.137500000000003p -8.4044269999999998e-10 88.150000000000006p -8.3211789999999997e-10 88.162500000000009p -8.225934e-10 88.174999999999997p -8.1187179999999996e-10 88.1875p -7.9995739999999999e-10 88.200000000000003p -7.8685629999999997e-10
+ 88.212499999999991p -7.72576e-10 88.224999999999994p -7.5712579999999995e-10 88.237499999999997p -7.4051659999999999e-10 88.25p -7.2276059999999998e-10 88.262500000000003p -7.0387220000000005e-10 88.275000000000006p -6.8386670000000002e-10 88.287500000000009p -6.6276140000000003e-10 88.299999999999997p -6.4057500000000003e-10 88.3125p -6.173278e-10 88.325000000000003p -5.9304139999999998e-10 88.337500000000006p -5.6773900000000004e-10 88.349999999999994p -5.4144529999999998e-10 88.362499999999997p -5.1418630000000002e-10 88.375p -4.8598940000000001e-10 88.387500000000003p -4.5688339999999998e-10 88.400000000000006p -4.268984e-10 88.412500000000009p -3.9606569999999998e-10 88.424999999999997p -3.6441790000000002e-10
+ 88.4375p -3.3198890000000002e-10 88.450000000000003p -2.988135e-10 88.462500000000006p -2.6492789999999999e-10 88.474999999999994p -2.3036920000000001e-10 88.487499999999997p -1.9517560000000001e-10 88.5p -1.5938620000000001e-10 88.512499999999989p -1.2304110000000001e-10 88.525000000000006p -8.6181239999999998e-11 88.537500000000009p -4.8848479999999999e-11 88.549999999999997p -1.108535e-11 88.5625p 2.7064819999999999e-11 88.575000000000003p 6.5558070000000002e-11 88.587500000000006p 1.0434979999999999e-10 88.599999999999994p 1.4339479999999999e-10 88.612499999999997p 1.8264749999999999e-10 88.625p 2.220616e-10 88.637499999999989p 2.6159080000000002e-10 88.650000000000006p 3.0118809999999998e-10
+ 88.662500000000009p 3.4080629999999999e-10 88.674999999999997p 3.8039819999999999e-10 88.6875p 4.1991629999999999e-10 88.700000000000003p 4.593128e-10 88.712500000000006p 4.9854010000000005e-10 88.724999999999994p 5.3755059999999995e-10 88.737499999999997p 5.7629670000000005e-10 88.75p 6.1473100000000001e-10 88.762499999999989p 6.5280619999999997e-10 88.774999999999991p 6.9047539999999996e-10 88.787500000000009p 7.2769179999999995e-10 88.800000000000011p 7.6440909999999997e-10 88.8125p 8.005815e-10 88.825000000000003p 8.3616360000000005e-10 88.837500000000006p 8.7111049999999996e-10 88.849999999999994p 9.0537789999999998e-10 88.862499999999997p 9.3892240000000004e-10 88.875p 9.7170089999999994e-10
+ 88.887499999999989p 1.003671e-09 88.899999999999991p 1.0347919999999999e-09 88.912500000000009p 1.0650239999999999e-09 88.925000000000011p 1.0943260000000001e-09 88.9375p 1.1226599999999999e-09 88.950000000000003p 1.149989e-09 88.962500000000006p 1.1762750000000001e-09 88.974999999999994p 1.201485e-09 88.987499999999997p 1.2255829999999999e-09 89p 1.248537e-09 89.012499999999989p 1.270314e-09 89.024999999999991p 1.2908849999999999e-09 89.037500000000009p 1.3102200000000001e-09 89.050000000000011p 1.3282910000000001e-09 89.0625p 1.345072e-09 89.075000000000003p 1.3605379999999999e-09 89.087500000000006p 1.3746659999999999e-09 89.099999999999994p 1.387433e-09
+ 89.112499999999997p 1.3988179999999999e-09 89.125p 1.408804e-09 89.137500000000003p 1.4173720000000001e-09 89.149999999999991p 1.4245069999999999e-09 89.162499999999994p 1.430194e-09 89.175000000000011p 1.4344219999999999e-09 89.1875p 1.437178e-09 89.200000000000003p 1.4384550000000001e-09 89.212500000000006p 1.4382429999999999e-09 89.224999999999994p 1.4365380000000001e-09 89.237499999999997p 1.433335e-09 89.25p 1.4286320000000001e-09 89.262500000000003p 1.4224289999999999e-09 89.274999999999991p 1.414725e-09 89.287499999999994p 1.405524e-09 89.300000000000011p 1.39483e-09 89.3125p 1.38265e-09 89.325000000000003p 1.36899e-09
+ 89.337500000000006p 1.3538619999999999e-09 89.349999999999994p 1.337275e-09 89.362499999999997p 1.319243e-09 89.375p 1.2997809999999999e-09 89.387500000000003p 1.278904e-09 89.399999999999991p 1.2566309999999999e-09 89.412499999999994p 1.23298e-09 89.424999999999997p 1.2079739999999999e-09 89.4375p 1.181634e-09 89.450000000000003p 1.153986e-09 89.462500000000006p 1.125054e-09 89.475000000000009p 1.094865e-09 89.487499999999997p 1.063449e-09 89.5p 1.0308360000000001e-09 89.512500000000003p 9.9705699999999994e-10 89.524999999999991p 9.6214480000000003e-10 89.537499999999994p 9.261336e-10 89.549999999999997p 8.8905900000000002e-10
+ 89.5625p 8.5095770000000002e-10 89.575000000000003p 8.1186759999999997e-10 89.587500000000006p 7.718277e-10 89.600000000000009p 7.3087820000000001e-10 89.612499999999997p 6.8906049999999995e-10 89.625p 6.4641670000000001e-10 89.637500000000003p 6.0299019999999996e-10 89.649999999999991p 5.5882510000000001e-10 89.662499999999994p 5.1396649999999995e-10 89.674999999999997p 4.6846030000000005e-10 89.6875p 4.2235319999999998e-10 89.700000000000003p 3.7569260000000002e-10 89.712500000000006p 3.2852650000000002e-10 89.725000000000009p 2.8090359999999999e-10 89.737499999999997p 2.3287300000000002e-10 89.75p 1.8448469999999999e-10 89.762500000000003p 1.357886e-10 89.774999999999991p 8.6835490000000002e-11
+ 89.787499999999994p 3.7676140000000001e-11 89.799999999999997p -1.163826e-11 89.8125p -6.1056300000000003e-11 89.825000000000003p -1.105265e-10 89.837500000000006p -1.599971e-10 89.850000000000009p -2.0941650000000001e-10 89.862499999999997p -2.5873300000000002e-10 89.875p -3.07895e-10 89.887500000000003p -3.568511e-10 89.899999999999991p -4.0554989999999998e-10 89.912499999999994p -4.5394060000000002e-10 89.924999999999997p -5.0197229999999998e-10 89.9375p -5.4959470000000001e-10 89.950000000000003p -5.9675789999999997e-10 89.962500000000006p -6.4341239999999999e-10 89.975000000000009p -6.8950940000000005e-10 89.987499999999997p -7.350005e-10 90p -7.7983790000000002e-10
+ 90.012500000000003p -8.2397479999999998e-10 90.024999999999991p -8.6736479999999997e-10 90.037499999999994p -9.0996260000000003e-10 90.049999999999997p -9.5172339999999994e-10 90.0625p -9.9260359999999997e-10 90.075000000000003p -1.03256e-09 90.087500000000006p -1.0715519999999999e-09 90.100000000000009p -1.1095380000000001e-09 90.112499999999997p -1.1464779999999999e-09 90.125p -1.182334e-09 90.137500000000003p -1.2170689999999999e-09 90.149999999999991p -1.250646e-09 90.162499999999994p -1.283031e-09 90.174999999999997p -1.31419e-09 90.1875p -1.3440900000000001e-09 90.200000000000003p -1.372702e-09 90.212500000000006p -1.3999940000000001e-09 90.225000000000009p -1.4259399999999999e-09
+ 90.237499999999997p -1.450512e-09 90.25p -1.473685e-09 90.262500000000003p -1.4954359999999999e-09 90.275000000000006p -1.515742e-09 90.287499999999994p -1.534583e-09 90.299999999999997p -1.5519399999999999e-09 90.3125p -1.5677960000000001e-09 90.324999999999989p -1.582134e-09 90.337500000000006p -1.594941e-09 90.350000000000009p -1.606203e-09 90.362499999999997p -1.615911e-09 90.375p -1.624054e-09 90.387500000000003p -1.6306259999999999e-09 90.400000000000006p -1.63562e-09 90.412499999999994p -1.6390320000000001e-09 90.424999999999997p -1.6408600000000001e-09 90.4375p -1.641103e-09 90.449999999999989p -1.639761e-09
+ 90.462500000000006p -1.6368380000000001e-09 90.475000000000009p -1.632337e-09 90.487499999999997p -1.6262650000000001e-09 90.5p -1.618628e-09 90.512500000000003p -1.6094359999999999e-09 90.525000000000006p -1.5987000000000001e-09 90.537499999999994p -1.586433e-09 90.549999999999997p -1.572647e-09 90.5625p -1.557359e-09 90.574999999999989p -1.5405859999999999e-09 90.587500000000006p -1.5223470000000001e-09 90.600000000000009p -1.5026620000000001e-09 90.612500000000011p -1.4815519999999999e-09 90.625p -1.4590410000000001e-09 90.637500000000003p -1.4351530000000001e-09 90.650000000000006p -1.4099150000000001e-09 90.662499999999994p -1.3833529999999999e-09 90.674999999999997p -1.355497e-09
+ 90.6875p -1.3263760000000001e-09 90.699999999999989p -1.2960220000000001e-09 90.712499999999991p -1.264467e-09 90.725000000000009p -1.2317450000000001e-09 90.737500000000011p -1.197891e-09 90.75p -1.162941e-09 90.762500000000003p -1.126932e-09 90.775000000000006p -1.0899019999999999e-09 90.787499999999994p -1.0518910000000001e-09 90.799999999999997p -1.0129370000000001e-09 90.8125p -9.7308310000000007e-10 90.824999999999989p -9.3236989999999992e-10 90.837499999999991p -8.9084019999999996e-10 90.850000000000009p -8.4853740000000005e-10 90.862500000000011p -8.0550540000000003e-10 90.875p -7.6178910000000004e-10 90.887500000000003p -7.1743370000000001e-10 90.900000000000006p -6.7248499999999998e-10
+ 90.912499999999994p -6.2698949999999997e-10 90.924999999999997p -5.8099370000000002e-10 90.9375p -5.3454509999999997e-10 90.950000000000003p -4.8769100000000001e-10 90.962499999999991p -4.4047939999999998e-10 90.974999999999994p -3.9295829999999998e-10 90.987500000000011p -3.4517589999999998e-10 91p -2.9718059999999999e-10 91.012500000000003p -2.4902079999999998e-10 91.025000000000006p -2.0074509999999999e-10 91.037499999999994p -1.524019e-10 91.049999999999997p -1.040396e-10 91.0625p -5.570645e-11 91.075000000000003p -7.4504730000000008e-12 91.087499999999991p 4.0680480000000001e-11 91.099999999999994p 8.8638869999999998e-11 91.112500000000011p 1.363775e-10 91.125p 1.8384950000000001e-10
+ 91.137500000000003p 2.3100860000000001e-10 91.150000000000006p 2.7780869999999999e-10 91.162499999999994p 3.2420469999999998e-10 91.174999999999997p 3.701516e-10 91.1875p 4.1560529999999998e-10 91.200000000000003p 4.6052229999999999e-10 91.212499999999991p 5.0485990000000002e-10 91.224999999999994p 5.4857609999999998e-10 91.237499999999997p 5.9162960000000003e-10 91.25p 6.3398000000000002e-10 91.262500000000003p 6.7558800000000002e-10 91.275000000000006p 7.1641490000000002e-10 91.287499999999994p 7.5642320000000005e-10 91.299999999999997p 7.9557630000000002e-10 91.3125p 8.3383850000000003e-10 91.325000000000003p 8.711755e-10 91.337499999999991p 9.0755380000000001e-10 91.349999999999994p 9.4294120000000002e-10
+ 91.362499999999997p 9.7730669999999999e-10 91.375p 1.01062e-09 91.387500000000003p 1.0428530000000001e-09 91.400000000000006p 1.073978e-09 91.412500000000009p 1.103969e-09 91.424999999999997p 1.132801e-09 91.4375p 1.1604500000000001e-09 91.450000000000003p 1.186895e-09 91.462499999999991p 1.2121140000000001e-09 91.474999999999994p 1.2360870000000001e-09 91.487499999999997p 1.258798e-09 91.5p 1.280228e-09 91.512500000000003p 1.3003640000000001e-09 91.525000000000006p 1.3191900000000001e-09 91.537500000000009p 1.3366940000000001e-09 91.549999999999997p 1.3528660000000001e-09 91.5625p 1.367695e-09 91.575000000000003p 1.3811739999999999e-09
+ 91.587499999999991p 1.3932959999999999e-09 91.599999999999994p 1.404056e-09 91.612499999999997p 1.413449e-09 91.625p 1.4214740000000001e-09 91.637500000000003p 1.428129e-09 91.650000000000006p 1.4334150000000001e-09 91.662500000000009p 1.4373340000000001e-09 91.674999999999997p 1.439889e-09 91.6875p 1.4410850000000001e-09 91.700000000000003p 1.4409280000000001e-09 91.712499999999991p 1.4394249999999999e-09 91.724999999999994p 1.436585e-09 91.737499999999997p 1.4324180000000001e-09 91.75p 1.4269369999999999e-09 91.762500000000003p 1.4201519999999999e-09 91.775000000000006p 1.4120799999999999e-09 91.787500000000009p 1.402734e-09 91.799999999999997p 1.392132e-09
+ 91.8125p 1.3802909999999999e-09 91.825000000000003p 1.36723e-09 91.837499999999991p 1.3529699999999999e-09 91.849999999999994p 1.3375309999999999e-09 91.862499999999997p 1.320936e-09 91.875p 1.3032080000000001e-09 91.887500000000003p 1.284372e-09 91.900000000000006p 1.264453e-09 91.912500000000009p 1.243477e-09 91.924999999999997p 1.2214719999999999e-09 91.9375p 1.198467e-09 91.950000000000003p 1.174489e-09 91.962499999999991p 1.1495690000000001e-09 91.974999999999994p 1.1237380000000001e-09 91.987499999999997p 1.097027e-09 92p 1.0694689999999999e-09 92.012500000000003p 1.0410949999999999e-09 92.025000000000006p 1.0119399999999999e-09
+ 92.037500000000009p 9.8203829999999993e-10 92.049999999999997p 9.5142330000000003e-10 92.0625p 9.2013059999999999e-10 92.075000000000003p 8.8819590000000003e-10 92.087500000000006p 8.5565499999999998e-10 92.099999999999994p 8.2254429999999996e-10 92.112499999999997p 7.8890060000000002e-10 92.125p 7.547607e-10 92.137500000000003p 7.2016209999999997e-10 92.150000000000006p 6.8514210000000002e-10 92.162500000000009p 6.4973830000000005e-10 92.174999999999997p 6.1398860000000004e-10 92.1875p 5.779307e-10 92.200000000000003p 5.4160259999999997e-10 92.212500000000006p 5.0504199999999996e-10 92.224999999999994p 4.6828689999999999e-10 92.237499999999997p 4.3137500000000002e-10 92.25p 3.9434390000000001e-10
+ 92.262499999999989p 3.5723110000000001e-10 92.275000000000006p 3.200737e-10 92.287500000000009p 2.8290890000000002e-10 92.299999999999997p 2.4577340000000002e-10 92.3125p 2.0870349999999999e-10 92.325000000000003p 1.7173519999999999e-10 92.337500000000006p 1.3490429999999999e-10 92.349999999999994p 9.8246000000000001e-11 92.362499999999997p 6.1794939999999996e-11 92.375p 2.55854e-11 92.387499999999989p -1.034893e-11 92.400000000000006p -4.5974910000000001e-11 92.412500000000009p -8.1260019999999998e-11 92.424999999999997p -1.161724e-10 92.4375p -1.5068070000000001e-10 92.450000000000003p -1.847546e-10 92.462500000000006p -2.183641e-10 92.474999999999994p -2.5148020000000001e-10
+ 92.487499999999997p -2.8407469999999998e-10 92.5p -3.1611999999999999e-10 92.512499999999989p -3.4758960000000001e-10 92.524999999999991p -3.7845749999999998e-10 92.537500000000009p -4.0869879999999997e-10 92.550000000000011p -4.3828949999999999e-10 92.5625p -4.672065e-10 92.575000000000003p -4.9542750000000005e-10 92.587500000000006p -5.2293129999999997e-10 92.599999999999994p -5.4969760000000004e-10 92.612499999999997p -5.7570690000000002e-10 92.625p -6.0094110000000004e-10 92.637499999999989p -6.2538259999999997e-10 92.649999999999991p -6.4901530000000005e-10 92.662500000000009p -6.718237e-10 92.675000000000011p -6.9379350000000002e-10 92.6875p -7.1491159999999996e-10 92.700000000000003p -7.3516570000000003e-10
+ 92.712500000000006p -7.5454450000000005e-10 92.724999999999994p -7.7303809999999996e-10 92.737499999999997p -7.9063720000000001e-10 92.75p -8.0733390000000005e-10 92.762499999999989p -8.2312120000000002e-10 92.774999999999991p -8.3799320000000001e-10 92.787499999999994p -8.5194489999999997e-10 92.800000000000011p -8.6497250000000003e-10 92.8125p -8.7707320000000004e-10 92.825000000000003p -8.8824520000000003e-10 92.837500000000006p -8.9848769999999996e-10 92.849999999999994p -9.0780089999999999e-10 92.862499999999997p -9.1618620000000005e-10 92.875p -9.2364559999999995e-10 92.887500000000003p -9.3018240000000003e-10 92.899999999999991p -9.3580080000000006e-10 92.912499999999994p -9.4050590000000003e-10 92.925000000000011p -9.4430360000000005e-10
+ 92.9375p -9.4720109999999993e-10 92.950000000000003p -9.4920600000000004e-10 92.962500000000006p -9.5032729999999993e-10 92.974999999999994p -9.5057430000000008e-10 92.987499999999997p -9.4995769999999999e-10 93p -9.484887000000001e-10 93.012500000000003p -9.4617920000000009e-10 93.024999999999991p -9.4304219999999996e-10 93.037499999999994p -9.3909129999999991e-10 93.050000000000011p -9.3434069999999991e-10 93.0625p -9.2880550000000003e-10 93.075000000000003p -9.2250129999999997e-10 93.087500000000006p -9.1544460000000001e-10 93.099999999999994p -9.0765229999999997e-10 93.112499999999997p -8.9914199999999997e-10 93.125p -8.8993190000000003e-10 93.137500000000003p -8.8004059999999998e-10 93.149999999999991p -8.6948739999999996e-10
+ 93.162499999999994p -8.5829199999999996e-10 93.174999999999997p -8.4647459999999999e-10 93.1875p -8.3405569999999999e-10 93.200000000000003p -8.2105640000000005e-10 93.212500000000006p -8.0749800000000004e-10 93.225000000000009p -7.9340220000000005e-10 93.237499999999997p -7.7879109999999999e-10 93.25p -7.6368699999999995e-10 93.262500000000003p -7.4811249999999998e-10 93.274999999999991p -7.3209029999999999e-10 93.287499999999994p -7.1564339999999997e-10 93.299999999999997p -6.9879490000000004e-10 93.3125p -6.815682e-10 93.325000000000003p -6.6398650000000002e-10 93.337500000000006p -6.4607339999999997e-10 93.350000000000009p -6.2785229999999997e-10 93.362499999999997p -6.0934679999999998e-10 93.375p -5.9058030000000004e-10
+ 93.387500000000003p -5.7157620000000003e-10 93.399999999999991p -5.5235800000000003e-10 93.412499999999994p -5.32949e-10 93.424999999999997p -5.1337220000000004e-10 93.4375p -4.9365060000000003e-10 93.450000000000003p -4.7380719999999998e-10 93.462500000000006p -4.5386439999999998e-10 93.475000000000009p -4.338448e-10 93.487499999999997p -4.137703e-10 93.5p -3.9366279999999998e-10 93.512500000000003p -3.7354400000000002e-10 93.524999999999991p -3.534349e-10 93.537499999999994p -3.333565e-10 93.549999999999997p -3.1332910000000002e-10 93.5625p -2.9337300000000002e-10 93.575000000000003p -2.7350790000000002e-10 93.587500000000006p -2.5375279999999999e-10 93.600000000000009p -2.3412669999999998e-10
+ 93.612499999999997p -2.1464790000000001e-10 93.625p -1.953341e-10 93.637500000000003p -1.7620289999999999e-10 93.649999999999991p -1.5727080000000001e-10 93.662499999999994p -1.3855440000000001e-10 93.674999999999997p -1.2006920000000001e-10 93.6875p -1.018304e-10 93.700000000000003p -8.3852769999999996e-11 93.712500000000006p -6.615018e-11 93.725000000000009p -4.8736100000000002e-11 93.737499999999997p -3.1623349999999998e-11 93.75p -1.4824150000000002e-11 93.762500000000003p 1.6499119999999999e-12 93.774999999999991p 1.7787869999999999e-11 93.787499999999994p 3.3579389999999999e-11 93.799999999999997p 4.901478e-11 93.8125p 6.4084959999999994e-11 93.825000000000003p 7.8781539999999996e-11
+ 93.837500000000006p 9.3096730000000006e-11 93.850000000000009p 1.0702339999999999e-10 93.862499999999997p 1.2055510000000001e-10 93.875p 1.33686e-10 93.887500000000003p 1.4641089999999999e-10 93.899999999999991p 1.5872530000000001e-10 93.912499999999994p 1.706252e-10 93.924999999999997p 1.821074e-10 93.9375p 1.931693e-10 93.950000000000003p 2.038088e-10 93.962500000000006p 2.1402449999999999e-10 93.975000000000009p 2.2381570000000001e-10 93.987499999999997p 2.3318219999999999e-10 94p 2.4212439999999999e-10 94.012500000000003p 2.5064320000000001e-10 94.025000000000006p 2.5874030000000002e-10 94.037499999999994p 2.6641780000000002e-10 94.049999999999997p 2.7367830000000001e-10
+ 94.0625p 2.805251e-10 94.074999999999989p 2.869619e-10 94.087500000000006p 2.9299300000000001e-10 94.100000000000009p 2.9862319999999998e-10 94.112499999999997p 3.0385759999999998e-10 94.125p 3.08702e-10 94.137500000000003p 3.131625e-10 94.150000000000006p 3.1724580000000002e-10 94.162499999999994p 3.2095879999999998e-10 94.174999999999997p 3.243089e-10 94.1875p 3.2730399999999998e-10 94.199999999999989p 3.2995209999999998e-10 94.212500000000006p 3.322618e-10 94.225000000000009p 3.3424199999999999e-10 94.237499999999997p 3.3590170000000002e-10 94.25p 3.3725040000000002e-10 94.262500000000003p 3.3829790000000001e-10 94.275000000000006p 3.3905389999999998e-10
+ 94.287499999999994p 3.3952879999999999e-10 94.299999999999997p 3.3973290000000002e-10 94.3125p 3.3967680000000002e-10 94.324999999999989p 3.3937120000000001e-10 94.337500000000006p 3.3882710000000001e-10 94.350000000000009p 3.3805549999999998e-10 94.362500000000011p 3.3706749999999998e-10 94.375p 3.3587430000000003e-10 94.387500000000003p 3.3448730000000002e-10 94.400000000000006p 3.3291770000000002e-10 94.412499999999994p 3.3117700000000001e-10 94.424999999999997p 3.292765e-10 94.4375p 3.2722770000000001e-10 94.449999999999989p 3.2504170000000002e-10 94.462499999999991p 3.227299e-10 94.475000000000009p 3.2030359999999998e-10 94.487500000000011p 3.177738e-10 94.5p 3.1515159999999999e-10
+ 94.512500000000003p 3.1244780000000001e-10 94.525000000000006p 3.0967320000000001e-10 94.537499999999994p 3.0683849999999998e-10 94.549999999999997p 3.0395390000000002e-10 94.5625p 3.010297e-10 94.574999999999989p 2.9807599999999998e-10 94.587499999999991p 2.9510250000000002e-10 94.600000000000009p 2.9211870000000002e-10 94.612500000000011p 2.89134e-10 94.625p 2.8615729999999999e-10 94.637500000000003p 2.8319729999999998e-10 94.650000000000006p 2.8026260000000002e-10 94.662499999999994p 2.773611e-10 94.674999999999997p 2.7450079999999998e-10 94.6875p 2.7168909999999999e-10 94.700000000000003p 2.6893309999999998e-10 94.712499999999991p 2.6623959999999998e-10 94.724999999999994p 2.6361500000000002e-10
+ 94.737500000000011p 2.6106530000000001e-10 94.75p 2.5859619999999999e-10 94.762500000000003p 2.5621289999999998e-10 94.775000000000006p 2.5392049999999999e-10 94.787499999999994p 2.5172320000000002e-10 94.799999999999997p 2.496253e-10 94.8125p 2.4763029999999999e-10 94.825000000000003p 2.4574160000000002e-10 94.837499999999991p 2.4396189999999999e-10 94.849999999999994p 2.4229369999999999e-10 94.862500000000011p 2.4073899999999998e-10 94.875p 2.3929930000000003e-10 94.887500000000003p 2.3797589999999997e-10 94.900000000000006p 2.3676940000000002e-10 94.912499999999994p 2.3568020000000002e-10 94.924999999999997p 2.347082e-10 94.9375p 2.3385279999999999e-10 94.950000000000003p 2.3311309999999999e-10
+ 94.962499999999991p 2.3248780000000001e-10 94.974999999999994p 2.319751e-10 94.987499999999997p 2.315729e-10 95p 2.312787e-10 95.012500000000003p 8.053736e-07 95.025000000000006p 1.5532640000000001e-06 95.037499999999994p 2.2430579999999999e-06 95.049999999999997p 2.877594e-06 95.0625p 3.4608240000000002e-06 95.075000000000003p 3.9969380000000004e-06 95.087499999999991p 4.4900680000000004e-06 95.099999999999994p 4.9441900000000002e-06 95.112499999999997p 5.3630920000000002e-06 95.125p 5.7503669999999998e-06 95.137500000000003p 6.1094110000000004e-06 95.150000000000006p 6.4434269999999997e-06 95.162500000000009p 6.7554289999999999e-06 95.174999999999997p 7.0482459999999997e-06
+ 95.1875p 7.3245279999999998e-06 95.200000000000003p 7.5867489999999996e-06 95.212499999999991p 7.8372140000000001e-06 95.224999999999994p 8.0780619999999992e-06 95.237499999999997p 8.3112719999999996e-06 95.25p 8.5386699999999997e-06 95.262500000000003p 8.7619309999999997e-06 95.275000000000006p 8.9825859999999994e-06 95.287500000000009p 9.2020290000000003e-06 95.299999999999997p 9.4215210000000003e-06 95.3125p 9.6421929999999998e-06 95.325000000000003p 9.8650559999999994e-06 95.337499999999991p 1.0091e-05 95.349999999999994p 1.0320819999999999e-05 95.362499999999997p 1.055518e-05 95.375p 1.079465e-05 95.387500000000003p 1.1039730000000001e-05 95.400000000000006p 1.129079e-05
+ 95.412500000000009p 1.1548150000000001e-05 95.424999999999997p 1.1812019999999999e-05 95.4375p 1.2082560000000001e-05 95.450000000000003p 1.2359839999999999e-05 95.462499999999991p 1.264388e-05 95.474999999999994p 1.293463e-05 95.487499999999997p 1.3231990000000001e-05 95.5p 1.35358e-05 95.512500000000003p 1.384586e-05 95.525000000000006p 1.416192e-05 95.537500000000009p 1.4483689999999999e-05 95.549999999999997p 1.4810850000000001e-05 95.5625p 1.5143050000000001e-05 95.575000000000003p 1.5479910000000001e-05 95.587499999999991p 1.5821020000000001e-05 95.599999999999994p 1.6165950000000001e-05 95.612499999999997p 1.6514259999999999e-05 95.625p 1.68655e-05
+ 95.637500000000003p 1.7219180000000001e-05 95.650000000000006p 1.7574839999999999e-05 95.662500000000009p 1.7931979999999999e-05 95.674999999999997p 1.829011e-05 95.6875p 1.8648760000000001e-05 95.700000000000003p 1.9007419999999998e-05 95.712499999999991p 1.9365629999999998e-05 95.724999999999994p 1.972289e-05 95.737499999999997p 2.0078740000000001e-05 95.75p 2.043272e-05 95.762500000000003p 2.078439e-05 95.775000000000006p 2.11333e-05 95.787500000000009p 2.1479040000000002e-05 95.799999999999997p 2.1821210000000001e-05 95.8125p 2.2159420000000001e-05 95.825000000000003p 2.24933e-05 95.837500000000006p 2.2822510000000001e-05 95.849999999999994p 2.3146720000000001e-05
+ 95.862499999999997p 2.346563e-05 95.875p 2.3778960000000001e-05 95.887500000000003p 2.408644e-05 95.900000000000006p 2.4387860000000001e-05 95.912500000000009p 2.468299e-05 95.924999999999997p 2.4971660000000001e-05 95.9375p 2.5253699999999998e-05 95.950000000000003p 2.5528989999999998e-05 95.962500000000006p 2.5797419999999999e-05 95.974999999999994p 2.605891e-05 95.987499999999997p 2.6313400000000001e-05 96p 2.6560859999999999e-05 96.012499999999989p 2.5996160000000001e-05 96.025000000000006p 2.54817e-05 96.037500000000009p 2.5018369999999999e-05 96.049999999999997p 2.460342e-05 96.0625p 2.4232989999999999e-05 96.075000000000003p 2.3903000000000001e-05
+ 96.087500000000006p 2.3609469999999999e-05 96.099999999999994p 2.3348580000000001e-05 96.112499999999997p 2.3116749999999999e-05 96.125p 2.2910569999999998e-05 96.137499999999989p 2.2726879999999999e-05 96.150000000000006p 2.2562729999999999e-05 96.162500000000009p 2.2415349999999999e-05 96.174999999999997p 2.2282209999999999e-05 96.1875p 2.2160929999999999e-05 96.200000000000003p 2.204936e-05 96.212500000000006p 2.1945499999999999e-05 96.224999999999994p 2.184754e-05 96.237499999999997p 2.1753840000000001e-05 96.25p 2.166292e-05 96.262499999999989p 2.1573449999999999e-05 96.274999999999991p 2.148425e-05 96.287500000000009p 2.1394280000000001e-05 96.300000000000011p 2.130263e-05
+ 96.3125p 2.1208540000000001e-05 96.325000000000003p 2.1111330000000001e-05 96.337500000000006p 2.1010469999999999e-05 96.349999999999994p 2.0905509999999999e-05 96.362499999999997p 2.079611e-05 96.375p 2.0682020000000001e-05 96.387499999999989p 2.0563080000000002e-05 96.399999999999991p 2.043921e-05 96.412500000000009p 2.031038e-05 96.425000000000011p 2.0176649999999999e-05 96.4375p 2.0038129999999999e-05 96.450000000000003p 1.9894990000000001e-05 96.462500000000006p 1.9747439999999999e-05 96.474999999999994p 1.959575e-05 96.487499999999997p 1.944019e-05 96.5p 1.9281110000000001e-05 96.512499999999989p 1.9118860000000001e-05 96.524999999999991p 1.8953809999999999e-05
+ 96.537499999999994p 1.8786360000000001e-05 96.550000000000011p 1.8616909999999999e-05 96.5625p 1.8445889999999998e-05 96.575000000000003p 1.827373e-05 96.587500000000006p 1.8100840000000001e-05 96.599999999999994p 1.7927669999999999e-05 96.612499999999997p 1.775463e-05 96.625p 1.7582139999999998e-05 96.637500000000003p 1.741061e-05 96.649999999999991p 1.7240449999999999e-05 96.662499999999994p 1.7072030000000001e-05 96.675000000000011p 1.6905739999999999e-05 96.6875p 1.6741920000000001e-05 96.700000000000003p 1.6580899999999999e-05 96.712500000000006p 1.642302e-05 96.724999999999994p 1.6268549999999999e-05 96.737499999999997p 1.6117779999999999e-05 96.75p 1.5970960000000001e-05
+ 96.762500000000003p 1.582831e-05 96.774999999999991p 1.5690050000000001e-05 96.787499999999994p 1.5556349999999999e-05 96.800000000000011p 1.5427379999999999e-05 96.8125p 1.530326e-05 96.825000000000003p 1.518411e-05 96.837500000000006p 1.507001e-05 96.849999999999994p 1.496103e-05 96.862499999999997p 1.485722e-05 96.875p 1.475858e-05 96.887500000000003p 1.4665119999999999e-05 96.899999999999991p 1.457681e-05 96.912499999999994p 1.44936e-05 96.924999999999997p 1.441544e-05 96.9375p 1.434225e-05 96.950000000000003p 1.427391e-05 96.962500000000006p 1.421032e-05 96.975000000000009p 1.415133e-05
+ 96.987499999999997p 1.40968e-05 97p 1.4046580000000001e-05 97.012500000000003p 1.400047e-05 97.024999999999991p 1.39583e-05 97.037499999999994p 1.391985e-05 97.049999999999997p 1.3884939999999999e-05 97.0625p 1.385333e-05 97.075000000000003p 1.3824789999999999e-05 97.087500000000006p 1.37991e-05 97.100000000000009p 1.377602e-05 97.112499999999997p 1.375529e-05 97.125p 1.373667e-05 97.137500000000003p 1.371991e-05 97.149999999999991p 1.370475e-05 97.162499999999994p 1.369093e-05 97.174999999999997p 1.367819e-05 97.1875p 1.366628e-05 97.200000000000003p 1.365494e-05
+ 97.212500000000006p 1.3643910000000001e-05 97.225000000000009p 1.363293e-05 97.237499999999997p 1.3621759999999999e-05 97.25p 1.361014e-05 97.262500000000003p 1.359784e-05 97.274999999999991p 1.3584609999999999e-05 97.287499999999994p 1.3570220000000001e-05 97.299999999999997p 1.355444e-05 97.3125p 1.353704e-05 97.325000000000003p 1.35178e-05 97.337500000000006p 1.3496530000000001e-05 97.350000000000009p 1.3473e-05 97.362499999999997p 1.3447030000000001e-05 97.375p 1.3418430000000001e-05 97.387500000000003p 1.338702e-05 97.399999999999991p 1.335262e-05 97.412499999999994p 1.331507e-05 97.424999999999997p 1.327421e-05
+ 97.4375p 1.3229889999999999e-05 97.450000000000003p 1.318198e-05 97.462500000000006p 1.313034e-05 97.475000000000009p 1.3074850000000001e-05 97.487499999999997p 1.3015400000000001e-05 97.5p 1.295187e-05 97.512500000000003p 1.288419e-05 97.524999999999991p 1.2812249999999999e-05 97.537499999999994p 1.273598e-05 97.549999999999997p 1.2655300000000001e-05 97.5625p 1.2570159999999999e-05 97.575000000000003p 1.2480489999999999e-05 97.587500000000006p 1.2386259999999999e-05 97.600000000000009p 1.228742e-05 97.612499999999997p 1.218394e-05 97.625p 1.20758e-05 97.637500000000003p 1.1962980000000001e-05 97.649999999999991p 1.184547e-05
+ 97.662499999999994p 1.172328e-05 97.674999999999997p 1.15964e-05 97.6875p 1.1464849999999999e-05 97.700000000000003p 1.132865e-05 97.712500000000006p 1.118782e-05 97.725000000000009p 1.1042390000000001e-05 97.737499999999997p 1.089239e-05 97.75p 1.073788e-05 97.762500000000003p 1.05789e-05 97.775000000000006p 1.04155e-05 97.787499999999994p 1.024774e-05 97.799999999999997p 1.007569e-05 97.8125p 9.8994030000000003e-06 97.824999999999989p 9.7189620000000007e-06 97.837500000000006p 9.5344419999999996e-06 97.850000000000009p 9.3459229999999993e-06 97.862499999999997p 9.1534910000000001e-06 97.875p 8.9572350000000003e-06
+ 97.887500000000003p 8.757247e-06 97.900000000000006p 8.5536239999999995e-06 97.912499999999994p 8.3464649999999997e-06 97.924999999999997p 8.135874e-06 97.9375p 7.9219549999999999e-06 97.949999999999989p 7.7048180000000004e-06 97.962500000000006p 7.4845750000000002e-06 97.975000000000009p 7.2613409999999999e-06 97.987499999999997p 7.035232e-06 98p 6.806369e-06 98.012500000000003p 6.5748729999999998e-06 98.025000000000006p 6.3408700000000002e-06 98.037499999999994p 6.1044850000000004e-06 98.049999999999997p 5.8658480000000003e-06 98.0625p 5.6250889999999996e-06 98.074999999999989p 5.3823409999999998e-06 98.087500000000006p 5.1377400000000002e-06 98.100000000000009p 4.89142e-06
+ 98.112500000000011p 4.6435219999999999e-06 98.125p 4.3941839999999998e-06 98.137500000000003p 4.1435479999999999e-06 98.150000000000006p 3.8917569999999996e-06 98.162499999999994p 3.638955e-06 98.174999999999997p 3.3852880000000001e-06 98.1875p 3.1309040000000001e-06 98.199999999999989p 2.8759510000000002e-06 98.212499999999991p 2.6205769999999999e-06 98.225000000000009p 2.3649349999999999e-06 98.237500000000011p 2.109175e-06 98.25p 1.853451e-06 98.262500000000003p 1.597915e-06 98.275000000000006p 1.3427230000000001e-06 98.287499999999994p 1.08803e-06 98.299999999999997p 8.3399129999999997e-07 98.3125p 5.8076410000000002e-07 98.324999999999989p 3.2850540000000001e-07
+ 98.337499999999991p 7.7372819999999996e-08 98.350000000000009p -1.7247570000000001e-07 98.362500000000011p -4.2088170000000002e-07 98.375p -6.6768679999999995e-07 98.387500000000003p -9.1273230000000003e-07 98.400000000000006p -1.1558589999999999e-06 98.412499999999994p -1.39691e-06 98.424999999999997p -1.6357249999999999e-06 98.4375p -1.872146e-06 98.450000000000003p -2.1060159999999998e-06 98.462499999999991p -2.3371769999999998e-06 98.474999999999994p -2.565474e-06 98.487500000000011p -2.7907490000000001e-06 98.5p -3.0128479999999998e-06 98.512500000000003p -3.2316160000000001e-06 98.525000000000006p -3.4469009999999998e-06 98.537499999999994p -3.6585510000000001e-06 98.549999999999997p -3.8664160000000004e-06
+ 98.5625p -4.0703459999999998e-06 98.575000000000003p -4.2701949999999999e-06 98.587499999999991p -4.4658160000000001e-06 98.599999999999994p -4.6570670000000004e-06 98.612500000000011p -4.8438059999999999e-06 98.625p -5.0258950000000001e-06 98.637500000000003p -5.2031950000000001e-06 98.650000000000006p -5.3755740000000004e-06 98.662499999999994p -5.5428989999999997e-06 98.674999999999997p -5.7050420000000003e-06 98.6875p -5.8618780000000004e-06 98.700000000000003p -6.0132829999999998e-06 98.712499999999991p -6.1591400000000003e-06 98.724999999999994p -6.299332e-06 98.737499999999997p -6.4337480000000004e-06 98.75p -6.5622789999999999e-06 98.762500000000003p -6.6848220000000001e-06 98.775000000000006p -6.801277e-06
+ 98.787499999999994p -6.9115480000000003e-06 98.799999999999997p -7.0155449999999998e-06 98.8125p -7.1131800000000002e-06 98.825000000000003p -7.2043730000000003e-06 98.837499999999991p -7.289046e-06 98.849999999999994p -7.3671290000000003e-06 98.862499999999997p -7.4385540000000002e-06 98.875p -7.503262e-06 98.887500000000003p -7.5611950000000002e-06 98.900000000000006p -7.6123050000000003e-06 98.912500000000009p -7.6565479999999999e-06 98.924999999999997p -7.6938849999999999e-06 98.9375p -7.7242839999999994e-06 98.950000000000003p -7.7477190000000007e-06 98.962499999999991p -7.7641700000000006e-06 98.974999999999994p -7.7736240000000002e-06 98.987499999999997p -7.7760740000000005e-06 99p -7.7715179999999993e-06
+ 99.012500000000003p -7.7599619999999996e-06 99.025000000000006p -7.7414190000000004e-06 99.037500000000009p -7.7159080000000003e-06 99.049999999999997p -7.6834539999999994e-06 99.0625p -7.6440899999999995e-06 99.075000000000003p -7.597855e-06 99.087499999999991p -7.5447939999999996e-06 99.099999999999994p -7.4849600000000001e-06 99.112499999999997p -7.4184129999999997e-06 99.125p -7.3452179999999996e-06 99.137500000000003p -7.2654470000000002e-06 99.150000000000006p -7.1791810000000003e-06 99.162500000000009p -7.0865039999999999e-06 99.174999999999997p -6.9875100000000003e-06 99.1875p -6.8822970000000003e-06 99.200000000000003p -6.7709690000000003e-06 99.212499999999991p -6.6536390000000001e-06 99.224999999999994p -6.5304229999999998e-06
+ 99.237499999999997p -6.401445e-06 99.25p -6.2668340000000004e-06 99.262500000000003p -6.1267259999999996e-06 99.275000000000006p -5.9812600000000004e-06 99.287500000000009p -5.8305829999999999e-06 99.299999999999997p -5.6748469999999997e-06 99.3125p -5.5142069999999996e-06 99.325000000000003p -5.3488250000000004e-06 99.337499999999991p -5.178866e-06 99.349999999999994p -5.0045010000000004e-06 99.362499999999997p -4.8259060000000004e-06 99.375p -4.643257e-06 99.387500000000003p -4.4567379999999998e-06 99.400000000000006p -4.2665349999999996e-06 99.412500000000009p -4.072838e-06 99.424999999999997p -3.875838e-06 99.4375p -3.675731e-06 99.450000000000003p -3.4727159999999998e-06
+ 99.462499999999991p -3.2669910000000002e-06 99.474999999999994p -3.05876e-06 99.487499999999997p -2.8482269999999998e-06 99.5p -2.6355969999999999e-06 99.512500000000003p -2.421077e-06 99.525000000000006p -2.2048749999999998e-06 99.537500000000009p -1.9871999999999998e-06 99.549999999999997p -1.76826e-06 99.5625p -1.5482649999999999e-06 99.575000000000003p -1.327423e-06 99.587500000000006p -1.105944e-06 99.599999999999994p -8.840349e-07 99.612499999999997p -6.619036e-07 99.625p -4.3975590000000002e-07 99.637500000000003p -2.177963e-07 99.650000000000006p 3.7724370000000001e-09 99.662500000000009p 2.2474920000000001e-07 99.674999999999997p 4.4493530000000001e-07
+ 99.6875p 6.6413439999999998e-07 99.700000000000003p 8.8215270000000005e-07 99.712500000000006p 1.0987989999999999e-06 99.724999999999994p 1.3138870000000001e-06 99.737499999999997p 1.5272299999999999e-06 99.75p 1.738649e-06 99.762499999999989p 1.9479660000000001e-06 99.775000000000006p 2.1550070000000001e-06 99.787500000000009p 2.3596039999999999e-06 99.799999999999997p 2.5615910000000001e-06 99.8125p 2.7608080000000001e-06 99.825000000000003p 2.9570989999999998e-06 99.837500000000006p 3.1503120000000001e-06 99.849999999999994p 3.3403020000000001e-06 99.862499999999997p 3.5269250000000001e-06 99.875p 3.7100469999999999e-06 99.887499999999989p 3.8895359999999999e-06 99.900000000000006p 4.0652669999999996e-06
+ 99.912500000000009p 4.2371170000000003e-06 99.924999999999997p 4.4049739999999999e-06 99.9375p 4.5687260000000003e-06 99.950000000000003p 4.7282699999999997e-06 99.962500000000006p 4.8835080000000001e-06 99.974999999999994p 5.0343469999999996e-06 99.987499999999997p 5.1807000000000002e-06 100p 5.3224860000000003e-06 100.01249999999999p 5.4596280000000001e-06 100.02499999999999p 5.5920580000000003e-06 100.03750000000001p 5.7197090000000001e-06 100.05000000000001p 5.8425249999999996e-06 100.0625p 5.9604510000000001e-06 100.075p 6.0734400000000004e-06 100.08750000000001p 6.1814489999999997e-06 100.09999999999999p 6.2844429999999996e-06 100.1125p 6.3823879999999998e-06 100.125p 6.4752609999999996e-06
+ 100.13749999999999p 6.5630380000000003e-06 100.14999999999999p 6.6457039999999999e-06 100.16250000000001p 6.7232479999999999e-06 100.17500000000001p 6.7956650000000001e-06 100.1875p 6.8629510000000003e-06 100.2p 6.9251110000000001e-06 100.21250000000001p 6.982151e-06 100.22499999999999p 7.0340839999999997e-06 100.2375p 7.0809259999999997e-06 100.25p 7.1226960000000003e-06 100.26249999999999p 7.1594179999999997e-06 100.27499999999999p 7.1911200000000002e-06 100.28749999999999p 7.2178340000000003e-06 100.30000000000001p 7.2395930000000001e-06 100.3125p 7.2564349999999996e-06 100.325p 7.2684020000000002e-06 100.33750000000001p 7.2755379999999998e-06 100.34999999999999p 7.2778879999999999e-06
+ 100.3625p 7.2755019999999997e-06 100.375p 7.2684319999999998e-06 100.3875p 7.2567320000000004e-06 100.39999999999999p 7.2404570000000003e-06 100.41249999999999p 7.2196670000000002e-06 100.42500000000001p 7.1944199999999998e-06 100.4375p 7.1647799999999999e-06 100.45p 7.1308079999999998e-06 100.46250000000001p 7.0925700000000001e-06 100.47499999999999p 7.0501310000000003e-06 100.4875p 7.0035589999999997e-06 100.5p 6.9529209999999999e-06 100.5125p 6.8982869999999999e-06 100.52499999999999p 6.8397269999999996e-06 100.53749999999999p 6.7773110000000004e-06 100.55000000000001p 6.7111110000000001e-06 100.5625p 6.6411970000000002e-06 100.575p 6.5676420000000003e-06
+ 100.58750000000001p 6.4905190000000003e-06 100.59999999999999p 6.4099000000000002e-06 100.6125p 6.3258590000000002e-06 100.625p 6.2384670000000002e-06 100.6375p 6.1477989999999996e-06 100.64999999999999p 6.0539279999999997e-06 100.66249999999999p 5.956926e-06 100.675p 5.8568679999999997e-06 100.6875p 5.7538249999999999e-06 100.7p 5.6478719999999998e-06 100.71250000000001p 5.539082e-06 100.72500000000001p 5.4275280000000001e-06 100.7375p 5.3132820000000004e-06 100.75p 5.1964169999999998e-06 100.7625p 5.0770069999999998e-06 100.77499999999999p 4.9551250000000003e-06 100.78749999999999p 4.8308429999999997e-06 100.8p 4.7042340000000003e-06
+ 100.8125p 4.5753729999999997e-06 100.825p 4.4443309999999997e-06 100.83750000000001p 4.3111829999999996e-06 100.85000000000001p 4.176002e-06 100.8625p 4.038863e-06 100.875p 3.8998399999999997e-06 100.8875p 3.7590080000000001e-06 100.89999999999999p 3.6164429999999999e-06 100.91249999999999p 3.4722200000000001e-06 100.925p 3.3264169999999999e-06 100.9375p 3.17911e-06 100.95p 3.0303789999999999e-06 100.96250000000001p 2.8803019999999998e-06 100.97500000000001p 2.728959e-06 100.9875p 2.5764309999999998e-06 101p 2.422802e-06 101.0125p 2.2681529999999999e-06 101.02499999999999p 2.1125710000000002e-06
+ 101.03749999999999p 1.9561409999999999e-06 101.05p 1.7989499999999999e-06 101.0625p 1.6410869999999999e-06 101.075p 1.4826420000000001e-06 101.08750000000001p 1.323709e-06 101.10000000000001p 1.1643790000000001e-06 101.1125p 1.004749e-06 101.125p 8.4491439999999999e-07 101.1375p 6.8497499999999995e-07 101.14999999999999p 5.2503079999999997e-07 101.16249999999999p 3.6518409999999999e-07 101.175p 2.0553879999999999e-07 101.1875p 4.6200640000000002e-08 101.2p -1.127228e-07 101.21250000000001p -2.711221e-07 101.22500000000001p -4.288863e-07 101.2375p -5.859024e-07 101.25p -7.4205600000000001e-07
+ 101.2625p -8.9723090000000003e-07 101.27499999999999p -1.051309e-06 101.28749999999999p -1.2041719999999999e-06 101.3p -1.355699e-06 101.3125p -1.505767e-06 101.325p -1.654254e-06 101.33750000000001p -1.8010349999999999e-06 101.35000000000001p -1.9459849999999999e-06 101.3625p -2.0889780000000001e-06 101.375p -2.2298860000000001e-06 101.3875p -2.3685840000000001e-06 101.39999999999999p -2.5049430000000001e-06 101.41249999999999p -2.638835e-06 101.425p -2.770132e-06 101.4375p -2.8987069999999999e-06 101.45p -3.0244330000000001e-06 101.46250000000001p -3.1471840000000001e-06 101.47500000000001p -3.2668330000000001e-06
+ 101.4875p -3.3832570000000002e-06 101.5p -3.4963319999999999e-06 101.5125p -3.605937e-06 101.52500000000001p -3.7119540000000002e-06 101.53749999999999p -3.8142639999999999e-06 101.55p -3.912754e-06 101.5625p -4.0073109999999998e-06 101.57499999999999p -4.0978269999999997e-06 101.58750000000001p -4.1841960000000004e-06 101.60000000000001p -4.2663180000000002e-06 101.6125p -4.3440929999999996e-06 101.625p -4.4174289999999996e-06 101.6375p -4.4862369999999999e-06 101.65000000000001p -4.5504329999999999e-06 101.66249999999999p -4.6099370000000001e-06 101.675p -4.6646780000000002e-06 101.6875p -4.7145859999999998e-06 101.69999999999999p -4.7596000000000001e-06
+ 101.71250000000001p -4.7996660000000003e-06 101.72500000000001p -4.8347329999999999e-06 101.7375p -4.8647600000000002e-06 101.75p -4.889711e-06 101.7625p -4.9095589999999999e-06 101.77500000000001p -4.924284e-06 101.78749999999999p -4.9338720000000004e-06 101.8p -4.9383179999999999e-06 101.8125p -4.9376260000000003e-06 101.82499999999999p -4.9318050000000003e-06 101.83750000000001p -4.9208770000000002e-06 101.85000000000001p -4.9048680000000002e-06 101.86250000000001p -4.8838139999999997e-06 101.875p -4.8577589999999998e-06 101.8875p -4.8267580000000002e-06 101.90000000000001p -4.790871e-06 101.91249999999999p -4.7501679999999998e-06 101.925p -4.704728e-06
+ 101.9375p -4.6546369999999998e-06 101.94999999999999p -4.5999919999999998e-06 101.96249999999999p -4.5408959999999999e-06 101.97500000000001p -4.4774599999999996e-06 101.98750000000001p -4.409805e-06 102p -4.3380559999999997e-06 102.0125p -4.2623510000000002e-06 102.02500000000001p -4.1828300000000004e-06 102.03749999999999p -4.0996429999999998e-06 102.05p -4.0129470000000004e-06 102.0625p -3.9229049999999997e-06 102.07499999999999p -3.8296849999999997e-06 102.08749999999999p -3.733463e-06 102.10000000000001p -3.6344190000000002e-06 102.11250000000001p -3.5327390000000001e-06 102.125p -3.4286129999999998e-06 102.1375p -3.3222370000000001e-06 102.15000000000001p -3.2138090000000001e-06
+ 102.16249999999999p -3.1035329999999999e-06 102.175p -2.991613e-06 102.1875p -2.8782569999999999e-06 102.2p -2.7636780000000001e-06 102.21249999999999p -2.6480860000000001e-06 102.22499999999999p -2.5316949999999999e-06 102.23750000000001p -2.4147200000000001e-06 102.25p -2.2973750000000002e-06 102.2625p -2.179875e-06 102.27500000000001p -2.0624329999999998e-06 102.28749999999999p -1.9452629999999999e-06 102.3p -1.8285749999999999e-06 102.3125p -1.7125779999999999e-06 102.325p -1.59748e-06 102.33749999999999p -1.483482e-06 102.34999999999999p -1.3707869999999999e-06 102.36250000000001p -1.2595880000000001e-06 102.375p -1.150078e-06
+ 102.3875p -1.0424449999999999e-06 102.40000000000001p -9.3686870000000005e-07 102.41249999999999p -8.3352639999999999e-07 102.425p -7.3258799999999997e-07 102.4375p -6.3421709999999999e-07 102.45p -5.3857090000000002e-07 102.46249999999999p -4.4579939999999998e-07 102.47499999999999p -3.5604530000000001e-07 102.4875p -2.6944359999999999e-07 102.5p -1.8612130000000001e-07 102.5125p -1.061975e-07 102.52500000000001p -2.978243e-08 102.53749999999999p 4.3021969999999997e-08 102.55p 1.121227e-07 102.5625p 1.77436e-07 102.575p 2.3888679999999998e-07 102.58749999999999p 2.9640980000000001e-07 102.59999999999999p 3.4994890000000001e-07
+ 102.6125p 3.9945749999999999e-07 102.625p 4.4489849999999998e-07 102.6375p 4.8624449999999996e-07 102.65000000000001p 5.234776e-07 102.66250000000001p 5.5658959999999996e-07 102.675p 5.855818e-07 102.6875p 6.1046500000000001e-07 102.7p 6.3125950000000004e-07 102.71249999999999p 6.4799479999999996e-07 102.72499999999999p 6.6070979999999995e-07 102.7375p 6.6945240000000003e-07 102.75p 6.7427950000000001e-07 102.7625p 6.7525660000000003e-07 102.77500000000001p 6.724577e-07 102.78750000000001p 6.6596549999999996e-07 102.8p 6.5587020000000005e-07 102.8125p 6.4227039999999996e-07 102.825p 6.2527179999999995e-07
+ 102.83749999999999p 6.0498760000000005e-07 102.84999999999999p 5.8153790000000001e-07 102.8625p 5.5504949999999997e-07 102.875p 5.2565520000000002e-07 102.8875p 4.9349420000000005e-07 102.90000000000001p 4.587108e-07 102.91250000000001p 4.2145489999999999e-07 102.925p 3.8188090000000001e-07 102.9375p 3.4014789999999999e-07 102.95p 2.9641889999999998e-07 102.96249999999999p 2.5086050000000002e-07 102.97499999999999p 2.0364240000000001e-07 102.9875p 1.549374e-07 103p 1.0492030000000001e-07 103.0125p 5.3767940000000003e-08 103.02500000000001p 1.658747e-09 103.03750000000001p -5.1227900000000002e-08 103.05p -1.04712e-07
+ 103.0625p -1.586132e-07 103.075p -2.127517e-07 103.08749999999999p -2.669479e-07 103.09999999999999p -3.2102380000000002e-07 103.1125p -3.7480240000000002e-07 103.125p -4.2810890000000002e-07 103.1375p -4.8077070000000003e-07 103.15000000000001p -5.3261779999999997e-07 103.16250000000001p -5.8348349999999997e-07 103.175p -6.3320429999999996e-07 103.1875p -6.816205e-07 103.2p -7.2857660000000003e-07 103.21249999999999p -7.7392160000000002e-07 103.22499999999999p -8.1750929999999997e-07 103.2375p -8.5919839999999998e-07 103.25p -8.988531e-07 103.2625p -9.3634329999999999e-07 103.27500000000001p -9.7154470000000009e-07
+ 103.28750000000001p -1.0043390000000001e-06 103.3p -1.034615e-06 103.3125p -1.0622669999999999e-06 103.325p -1.087196e-06 103.33750000000001p -1.109311e-06 103.34999999999999p -1.128527e-06 103.3625p -1.144768e-06 103.375p -1.157962e-06 103.3875p -1.1680479999999999e-06 103.40000000000001p -1.174969e-06 103.41250000000001p -1.1786780000000001e-06 103.425p -1.179136e-06 103.4375p -1.1763080000000001e-06 103.45p -1.1701700000000001e-06 103.46250000000001p -1.160703e-06 103.47499999999999p -1.147899e-06 103.4875p -1.1317539999999999e-06 103.5p -1.112272e-06
+ 103.51249999999999p -1.089465e-06 103.52500000000001p -1.063353e-06 103.53750000000001p -1.033961e-06 103.55p -1.001321e-06 103.5625p -9.6547400000000003e-07 103.575p -9.2646529999999995e-07 103.58750000000001p -8.8434760000000003e-07 103.59999999999999p -8.3917950000000001e-07 103.6125p -7.9102589999999996e-07 103.625p -7.3995710000000003e-07 103.63749999999999p -6.8604920000000004e-07 103.65000000000001p -6.2938379999999996e-07 103.66250000000001p -5.7004740000000004e-07 103.67500000000001p -5.0813129999999999e-07 103.6875p -4.4373179999999998e-07 103.7p -3.7694910000000001e-07 103.71250000000001p -3.078878e-07 103.72499999999999p -2.3665639999999999e-07
+ 103.7375p -1.6336670000000001e-07 103.75p -8.8133929999999998e-08 103.76249999999999p -1.107647e-08 103.77499999999999p 6.7684680000000004e-08 103.78750000000001p 1.48026e-07 103.80000000000001p 2.2982179999999999e-07 103.8125p 3.1294450000000001e-07 103.825p 3.9726460000000001e-07 103.83750000000001p 4.8265160000000003e-07 103.84999999999999p 5.6897369999999997e-07 103.8625p 6.5609810000000005e-07 103.875p 7.4389170000000005e-07 103.88749999999999p 8.3222080000000001e-07 103.89999999999999p 9.2095180000000002e-07 103.91250000000001p 1.009951e-06 103.92500000000001p 1.099086e-06 103.9375p 1.1882239999999999e-06 103.95p 1.2772330000000001e-06
+ 103.96250000000001p 1.3659820000000001e-06 103.97499999999999p 1.4543439999999999e-06 103.9875p 1.5421889999999999e-06 104p 1.629392e-06 104.01249999999999p 1.7158289999999999e-06 104.02499999999999p 1.8013780000000001e-06 104.03749999999999p 1.8859199999999999e-06 104.05000000000001p 1.9693360000000001e-06 104.0625p 2.0515120000000001e-06 104.075p 2.1323369999999999e-06 104.08750000000001p 2.2116999999999999e-06 104.09999999999999p 2.289497e-06 104.1125p 2.3656229999999998e-06 104.125p 2.439979e-06 104.1375p 2.5124689999999999e-06 104.14999999999999p 2.5829989999999998e-06 104.16249999999999p 2.651479e-06 104.17500000000001p 2.7178250000000001e-06
+ 104.1875p 2.781953e-06 104.2p 2.8437840000000002e-06 104.21250000000001p 2.9032450000000002e-06 104.22499999999999p 2.9602629999999999e-06 104.2375p 3.0147710000000002e-06 104.25p 3.066706e-06 104.2625p 3.1160080000000001e-06 104.27499999999999p 3.162621e-06 104.28749999999999p 3.206494e-06 104.30000000000001p 3.247577e-06 104.3125p 3.2858279999999999e-06 104.325p 3.3212059999999998e-06 104.33750000000001p 3.3536730000000001e-06 104.34999999999999p 3.3831970000000002e-06 104.3625p 3.4097499999999998e-06 104.375p 3.4333050000000002e-06 104.3875p 3.4538409999999999e-06 104.39999999999999p 3.4713390000000001e-06
+ 104.41249999999999p 3.4857849999999999e-06 104.425p 3.4971680000000001e-06 104.4375p 3.5054790000000002e-06 104.45p 3.5107149999999999e-06 104.46250000000001p 3.5128730000000002e-06 104.47500000000001p 3.5119560000000001e-06 104.4875p 3.5079689999999999e-06 104.5p 3.5009199999999999e-06 104.5125p 3.4908199999999998e-06 104.52499999999999p 3.4776820000000001e-06 104.53749999999999p 3.4615229999999998e-06 104.55p 3.4423620000000001e-06 104.5625p 3.4202220000000001e-06 104.575p 3.3951260000000002e-06 104.58750000000001p 3.3671010000000002e-06 104.60000000000001p 3.3361769999999999e-06 104.6125p 3.3023830000000001e-06 104.625p 3.265755e-06
+ 104.6375p 3.2263279999999999e-06 104.64999999999999p 3.1841379999999999e-06 104.66249999999999p 3.1392259999999998e-06 104.675p 3.0916319999999998e-06 104.6875p 3.041399e-06 104.7p 2.9885720000000001e-06 104.71250000000001p 2.9331969999999998e-06 104.72500000000001p 2.875322e-06 104.7375p 2.8149949999999998e-06 104.75p 2.7522679999999999e-06 104.7625p 2.68719e-06 104.77499999999999p 2.6198159999999999e-06 104.78749999999999p 2.5501989999999999e-06 104.8p 2.4783949999999999e-06 104.8125p 2.4044589999999999e-06 104.825p 2.3284489999999999e-06 104.83750000000001p 2.2504219999999998e-06 104.85000000000001p 2.170437e-06
+ 104.8625p 2.088555e-06 104.875p 2.0048339999999999e-06 104.8875p 1.9193380000000002e-06 104.89999999999999p 1.8321260000000001e-06 104.91249999999999p 1.7432619999999999e-06 104.925p 1.6528099999999999e-06 104.9375p 1.560831e-06 104.95p 1.4673919999999999e-06 104.96250000000001p 1.3725560000000001e-06 104.97500000000001p 1.2763890000000001e-06 104.9875p 1.1789569999999999e-06 105p 1.0803259999999999e-06 105.0125p 9.8056169999999996e-07 105.02499999999999p 8.7973220000000004e-07 105.03749999999999p 7.7790480000000005e-07 105.05p 6.7514709999999997e-07 105.0625p 5.7152760000000001e-07 105.075p 4.6711460000000002e-07
+ 105.08750000000001p 3.6197730000000002e-07 105.10000000000001p 2.561848e-07 105.1125p 1.4980670000000001e-07 105.125p 4.2913009999999998e-08 105.1375p -6.4426170000000005e-08 105.14999999999999p -1.7214030000000001e-07 105.16249999999999p -2.8015859999999999e-07 105.175p -3.8840989999999998e-07 105.1875p -4.9682309999999999e-07 105.2p -6.0532650000000004e-07 105.21250000000001p -7.1384830000000003e-07 105.22500000000001p -8.2231649999999998e-07 105.2375p -9.3065879999999998e-07 105.25p -1.038803e-06 105.2625p -1.1466759999999999e-06 105.27500000000001p -1.2542049999999999e-06 105.28749999999999p -1.3613180000000001e-06 105.3p -1.4679420000000001e-06
+ 105.3125p -1.5740019999999999e-06 105.32499999999999p -1.6794270000000001e-06 105.33750000000001p -1.7841429999999999e-06 105.35000000000001p -1.8880759999999999e-06 105.3625p -1.9911540000000001e-06 105.375p -2.093302e-06 105.3875p -2.194449e-06 105.40000000000001p -2.294522e-06 105.41249999999999p -2.3934459999999998e-06 105.425p -2.4911499999999999e-06 105.4375p -2.587561e-06 105.44999999999999p -2.6826080000000002e-06 105.46250000000001p -2.7762179999999999e-06 105.47500000000001p -2.8683199999999998e-06 105.4875p -2.9588430000000001e-06 105.5p -3.0477169999999999e-06 105.5125p -3.1348719999999999e-06 105.52500000000001p -3.2202379999999999e-06
+ 105.53749999999999p -3.303747e-06 105.55p -3.38533e-06 105.5625p -3.4649219999999998e-06 105.57499999999999p -3.542454e-06 105.58749999999999p -3.6178630000000002e-06 105.60000000000001p -3.6910840000000001e-06 105.61250000000001p -3.7620519999999999e-06 105.625p -3.8307070000000004e-06 105.6375p -3.8969870000000004e-06 105.65000000000001p -3.9608320000000003e-06 105.66249999999999p -4.0221839999999998e-06 105.675p -4.0809850000000002e-06 105.6875p -4.1371809999999996e-06 105.69999999999999p -4.1907170000000002e-06 105.71249999999999p -4.2415400000000002e-06 105.72500000000001p -4.2896009999999998e-06 105.73750000000001p -4.3348499999999997e-06 105.75p -4.3772390000000002e-06
+ 105.7625p -4.4167249999999996e-06 105.77500000000001p -4.4532629999999998e-06 105.78749999999999p -4.4868129999999997e-06 105.8p -4.5173349999999998e-06 105.8125p -4.5447930000000001e-06 105.82499999999999p -4.5691519999999998e-06 105.83749999999999p -4.5903799999999996e-06 105.85000000000001p -4.608447e-06 105.86250000000001p -4.6233259999999997e-06 105.875p -4.6349910000000001e-06 105.8875p -4.6434210000000002e-06 105.90000000000001p -4.6485950000000003e-06 105.91249999999999p -4.6504969999999999e-06 105.925p -4.6491110000000002e-06 105.9375p -4.6444269999999996e-06 105.95p -4.6364360000000003e-06 105.96249999999999p -4.6251309999999998e-06 105.97499999999999p -4.61051e-06
+ 105.98750000000001p -4.5925719999999999e-06 106p -4.5713200000000003e-06 106.0125p -4.54676e-06 106.02500000000001p -4.5189000000000001e-06 106.03749999999999p -4.487752e-06 106.05p -4.4533299999999998e-06 106.0625p -4.4156529999999997e-06 106.075p -4.3747400000000001e-06 106.08749999999999p -4.3306160000000001e-06 106.09999999999999p -4.2833080000000004e-06 106.11250000000001p -4.2328439999999999e-06 106.125p -4.1792580000000001e-06 106.1375p -4.1225849999999999e-06 106.15000000000001p -4.0628640000000004e-06 106.16249999999999p -4.0001369999999996e-06 106.175p -3.9344479999999996e-06 106.1875p -3.8658439999999998e-06 106.2p -3.7943759999999998e-06
+ 106.21249999999999p -3.7200960000000001e-06 106.22499999999999p -3.6430600000000001e-06 106.2375p -3.5633269999999999e-06 106.25p -3.4809579999999999e-06 106.2625p -3.396015e-06 106.27500000000001p -3.3085659999999999e-06 106.28749999999999p -3.2186789999999998e-06 106.3p -3.1264249999999999e-06 106.3125p -3.0318770000000001e-06 106.325p -2.9351110000000002e-06 106.33749999999999p -2.8362029999999999e-06 106.34999999999999p -2.735235e-06 106.3625p -2.632287e-06 106.375p -2.5274440000000001e-06 106.3875p -2.4207899999999999e-06 106.40000000000001p -2.3124129999999998e-06 106.41250000000001p -2.2024019999999999e-06 106.425p -2.090846e-06
+ 106.4375p -1.9778380000000001e-06 106.45p -1.86347e-06 106.46249999999999p -1.747836e-06 106.47499999999999p -1.631033e-06 106.4875p -1.513155e-06 106.5p -1.394301e-06 106.5125p -1.274568e-06 106.52500000000001p -1.1540549999999999e-06 106.53750000000001p -1.0328619999999999e-06 106.55p -9.1108680000000003e-07 106.5625p -7.8883079999999999e-07 106.575p -6.6619400000000002e-07 106.58749999999999p -5.4327679999999996e-07 106.59999999999999p -4.2017949999999998e-07 106.6125p -2.9700249999999999e-07 106.625p -1.738461e-07 106.6375p -5.0809850000000002e-08 106.65000000000001p 7.2006610000000006e-08
+ 106.66250000000001p 1.945044e-07 106.675p 3.165853e-07 106.6875p 4.3815149999999998e-07 106.7p 5.591064e-07 106.71249999999999p 6.7935409999999995e-07 106.72499999999999p 7.9879969999999995e-07 106.7375p 9.1734940000000004e-07 106.75p 1.0349109999999999e-06 106.7625p 1.1513920000000001e-06 106.77500000000001p 1.266704e-06 106.78750000000001p 1.3807580000000001e-06 106.8p 1.4934660000000001e-06 106.8125p 1.604744e-06 106.825p 1.7145080000000001e-06 106.83749999999999p 1.8226750000000001e-06 106.84999999999999p 1.9291669999999998e-06 106.8625p 2.033903e-06 106.875p 2.1368090000000001e-06
+ 106.8875p 2.2378110000000001e-06 106.90000000000001p 2.3368339999999999e-06 106.91250000000001p 2.433811e-06 106.925p 2.5286720000000001e-06 106.9375p 2.6213530000000002e-06 106.95p 2.7117880000000001e-06 106.96249999999999p 2.799919e-06 106.97499999999999p 2.8856840000000002e-06 106.9875p 2.969029e-06 107p 3.049899e-06 107.0125p 3.1282419999999999e-06 107.02500000000001p 3.204008e-06 107.03750000000001p 3.2771520000000001e-06 107.05p 3.3476290000000001e-06 107.0625p 3.4153970000000001e-06 107.075p 3.4804160000000002e-06 107.08750000000001p 3.5426499999999999e-06 107.09999999999999p 3.6020640000000001e-06
+ 107.1125p 3.6586270000000001e-06 107.125p 3.7123079999999998e-06 107.1375p 3.7630819999999999e-06 107.15000000000001p 3.810924e-06 107.16250000000001p 3.8558109999999997e-06 107.175p 3.897725e-06 107.1875p 3.9366480000000002e-06 107.2p 3.972565e-06 107.21250000000001p 4.0054660000000004e-06 107.22499999999999p 4.0353390000000002e-06 107.2375p 4.0621779999999996e-06 107.25p 4.0859769999999999e-06 107.26249999999999p 4.1067330000000003e-06 107.27500000000001p 4.1244470000000001e-06 107.28750000000001p 4.1391190000000002e-06 107.3p 4.1507550000000004e-06 107.3125p 4.1593600000000001e-06 107.325p 4.1649419999999996e-06
+ 107.33750000000001p 4.1675119999999998e-06 107.34999999999999p 4.1670829999999996e-06 107.3625p 4.1636689999999998e-06 107.375p 4.1572870000000003e-06 107.38749999999999p 4.1479560000000004e-06 107.40000000000001p 4.135696e-06 107.41250000000001p 4.1205289999999999e-06 107.42500000000001p 4.102482e-06 107.4375p 4.0815779999999998e-06 107.45p 4.057848e-06 107.46250000000001p 4.0313190000000002e-06 107.47499999999999p 4.002025e-06 107.4875p 3.9699979999999996e-06 107.5p 3.9352720000000003e-06 107.51249999999999p 3.8978859999999996e-06 107.52499999999999p 3.8578760000000001e-06 107.53750000000001p 3.8152819999999996e-06 107.55000000000001p 3.7701460000000001e-06
+ 107.5625p 3.7225100000000002e-06 107.575p 3.6724179999999998e-06 107.58750000000001p 3.6199159999999999e-06 107.59999999999999p 3.5650510000000001e-06 107.6125p 3.5078699999999999e-06 107.625p 3.4484229999999999e-06 107.63749999999999p 3.3867609999999999e-06 107.64999999999999p 3.3229360000000001e-06 107.66250000000001p 3.257002e-06 107.67500000000001p 3.1890120000000002e-06 107.6875p 3.1190230000000001e-06 107.7p 3.047091e-06 107.71250000000001p 2.9732740000000001e-06 107.72499999999999p 2.8976309999999998e-06 107.7375p 2.8202219999999999e-06 107.75p 2.7411089999999999e-06 107.76249999999999p 2.6603519999999999e-06 107.77499999999999p 2.5780160000000002e-06
+ 107.78749999999999p 2.494164e-06 107.80000000000001p 2.4088620000000001e-06 107.8125p 2.3221740000000001e-06 107.825p 2.2341689999999999e-06 107.83750000000001p 2.1449119999999999e-06 107.84999999999999p 2.0544740000000001e-06 107.8625p 1.9629220000000001e-06 107.875p 1.870328e-06 107.8875p 1.7767610000000001e-06 107.89999999999999p 1.682294e-06 107.91249999999999p 1.586998e-06 107.92500000000001p 1.490946e-06 107.9375p 1.394212e-06 107.95p 1.29687e-06 107.96250000000001p 1.1989939999999999e-06 107.97499999999999p 1.1006600000000001e-06 107.9875p 1.001943e-06 108p 9.0291969999999996e-07
+ 108.0125p 8.0366629999999997e-07 108.02499999999999p 7.042597e-07 108.03749999999999p 6.0477750000000003e-07 108.05000000000001p 5.0529710000000002e-07 108.0625p 4.0589640000000002e-07 108.075p 3.0665359999999999e-07 108.08750000000001p 2.076467e-07 108.09999999999999p 1.089543e-07 108.1125p 1.065462e-08 108.125p -8.7173889999999995e-08 108.1375p -1.844529e-07 108.14999999999999p -2.8110419999999998e-07 108.16249999999999p -3.7704969999999998e-07 108.175p -4.7221169999999999e-07 108.1875p -5.6651259999999996e-07 108.2p -6.5987540000000005e-07 108.21250000000001p -7.5222349999999999e-07 108.22500000000001p -8.4348070000000003e-07
+ 108.2375p -9.3357160000000005e-07 108.25p -1.0224210000000001e-06 108.2625p -1.109956e-06 108.27499999999999p -1.1961019999999999e-06 108.28749999999999p -1.2807869999999999e-06 108.3p -1.36394e-06 108.3125p -1.4454909999999999e-06 108.325p -1.5253719999999999e-06 108.33750000000001p -1.6035129999999999e-06 108.35000000000001p -1.6798490000000001e-06 108.3625p -1.7543160000000001e-06 108.375p -1.8268489999999999e-06 108.3875p -1.8973870000000001e-06 108.39999999999999p -1.9658709999999999e-06 108.41249999999999p -2.0322429999999999e-06 108.425p -2.096446e-06 108.4375p -2.1584259999999998e-06 108.45p -2.2181310000000002e-06
+ 108.46250000000001p -2.2755129999999998e-06 108.47500000000001p -2.330523e-06 108.4875p -2.3831160000000001e-06 108.5p -2.4332510000000002e-06 108.5125p -2.4808870000000001e-06 108.52499999999999p -2.5259880000000001e-06 108.53749999999999p -2.5685180000000001e-06 108.55p -2.6084470000000001e-06 108.5625p -2.6457450000000001e-06 108.575p -2.6803879999999999e-06 108.58750000000001p -2.712352e-06 108.60000000000001p -2.7416179999999998e-06 108.6125p -2.76817e-06 108.625p -2.791996e-06 108.6375p -2.8130840000000002e-06 108.64999999999999p -2.8314300000000001e-06 108.66249999999999p -2.84703e-06 108.675p -2.8598850000000001e-06
+ 108.6875p -2.869998e-06 108.7p -2.877378e-06 108.71250000000001p -2.882035e-06 108.72500000000001p -2.8839839999999998e-06 108.7375p -2.8832429999999999e-06 108.75p -2.879834e-06 108.7625p -2.8737819999999998e-06 108.77499999999999p -2.8651159999999999e-06 108.78749999999999p -2.853867e-06 108.8p -2.8400720000000002e-06 108.8125p -2.8237690000000002e-06 108.825p -2.8050019999999999e-06 108.83750000000001p -2.7838159999999999e-06 108.85000000000001p -2.760259e-06 108.8625p -2.7343849999999998e-06 108.875p -2.7062489999999999e-06 108.8875p -2.6759099999999999e-06 108.89999999999999p -2.6434279999999999e-06
+ 108.91249999999999p -2.6088689999999999e-06 108.925p -2.5722999999999999e-06 108.9375p -2.5337890000000001e-06 108.95p -2.4934109999999998e-06 108.96250000000001p -2.4512400000000002e-06 108.97500000000001p -2.407352e-06 108.9875p -2.3618270000000001e-06 109p -2.3147480000000001e-06 109.0125p -3.0713379999999999e-06 109.02500000000001p -3.7692900000000002e-06 109.03749999999999p -4.4078460000000004e-06 109.05p -4.989934e-06 109.0625p -5.5195950000000001e-06 109.07499999999999p -6.0011129999999997e-06 109.08750000000001p -6.4387150000000001e-06 109.10000000000001p -6.836473e-06 109.1125p -7.1982750000000001e-06 109.125p -7.5278119999999996e-06
+ 109.1375p -7.8285830000000001e-06 109.15000000000001p -8.1038940000000007e-06 109.16249999999999p -8.3568650000000005e-06 109.175p -8.5904309999999997e-06 109.1875p -8.8073499999999996e-06 109.19999999999999p -9.0102049999999992e-06 109.21250000000001p -9.2014109999999998e-06 109.22500000000001p -9.3832179999999994e-06 109.2375p -9.5577169999999998e-06 109.25p -9.7268449999999995e-06 109.2625p -9.8923910000000007e-06 109.27500000000001p -1.0056e-05 109.28749999999999p -1.0219180000000001e-05 109.3p -1.038329e-05 109.3125p -1.05496e-05 109.32499999999999p -1.071921e-05 109.33749999999999p -1.0893129999999999e-05 109.35000000000001p -1.107226e-05
+ 109.36250000000001p -1.125738e-05 109.375p -1.144917e-05 109.3875p -1.1648219999999999e-05 109.40000000000001p -1.1855020000000001e-05 109.41249999999999p -1.2069969999999999e-05 109.425p -1.2293410000000001e-05 109.4375p -1.252557e-05 109.44999999999999p -1.276664e-05 109.46249999999999p -1.30167e-05 109.47500000000001p -1.327581e-05 109.48750000000001p -1.354394e-05 109.5p -1.382102e-05 109.5125p -1.410692e-05 109.52500000000001p -1.440146e-05 109.53749999999999p -1.470444e-05 109.55p -1.5015579999999999e-05 109.5625p -1.533459e-05 109.57499999999999p -1.5661150000000002e-05
+ 109.58749999999999p -1.5994900000000002e-05 109.60000000000001p -1.633545e-05 109.61250000000001p -1.6682400000000001e-05 109.625p -1.703531e-05 109.6375p -1.7393739999999999e-05 109.65000000000001p -1.7757229999999999e-05 109.66249999999999p -1.8125310000000001e-05 109.675p -1.8497479999999999e-05 109.6875p -1.8873260000000002e-05 109.7p -1.9252150000000002e-05 109.71249999999999p -1.9633650000000001e-05 109.72499999999999p -2.001726e-05 109.73750000000001p -2.040246e-05 109.75p -2.0788770000000001e-05 109.7625p -2.1175669999999999e-05 109.77500000000001p -2.1562689999999999e-05 109.78749999999999p -2.1949320000000001e-05 109.8p -2.2335099999999999e-05
+ 109.8125p -2.2719540000000001e-05 109.825p -2.31022e-05 109.83749999999999p -2.3482609999999998e-05 109.84999999999999p -2.3860339999999999e-05 109.86250000000001p -2.4234969999999999e-05 109.875p -2.460608e-05 109.8875p -2.4973279999999999e-05 109.90000000000001p -2.5336179999999998e-05 109.91249999999999p -2.569441e-05 109.925p -2.604763e-05 109.9375p -2.6395500000000002e-05 109.95p -2.67377e-05 109.96249999999999p -2.707393e-05 109.97499999999999p -2.7403910000000001e-05 109.9875p -2.7727369999999999e-05 110p -2.8044069999999999e-05 110.0125p -2.7548639999999999e-05 110.02500000000001p -2.7103249999999998e-05
+ 110.03749999999999p -2.6708570000000002e-05 110.05p -2.636158e-05 110.0625p -2.6058169999999999e-05 110.075p -2.5794029999999999e-05 110.08749999999999p -2.5564889999999999e-05 110.09999999999999p -2.5366699999999999e-05 110.1125p -2.5195570000000001e-05 110.125p -2.5047859999999998e-05 110.1375p -2.4920130000000001e-05 110.15000000000001p -2.4809149999999999e-05 110.16250000000001p -2.471191e-05 110.175p -2.4625579999999999e-05 110.1875p -2.4547549999999998e-05 110.2p -2.4475389999999999e-05 110.21249999999999p -2.4406859999999999e-05 110.22499999999999p -2.4339910000000001e-05 110.2375p -2.4272649999999999e-05 110.25p -2.4203389999999999e-05
+ 110.2625p -2.413056e-05 110.27500000000001p -2.405279e-05 110.28750000000001p -2.396885e-05 110.3p -2.3877639999999999e-05 110.3125p -2.3778230000000001e-05 110.325p -2.3669809999999999e-05 110.33749999999999p -2.3551689999999999e-05 110.34999999999999p -2.3423320000000001e-05 110.3625p -2.328425e-05 110.375p -2.3134149999999999e-05 110.3875p -2.2972800000000001e-05 110.40000000000001p -2.280007e-05 110.41250000000001p -2.2615909999999999e-05 110.425p -2.2420380000000002e-05 110.4375p -2.22136e-05 110.45p -2.1995779999999999e-05 110.46249999999999p -2.1767179999999999e-05 110.47499999999999p -2.1528140000000001e-05
+ 110.4875p -2.1279050000000001e-05 110.5p -2.1020339999999999e-05 110.5125p -2.075252e-05 110.52500000000001p -2.0476099999999999e-05 110.53750000000001p -2.0191649999999998e-05 110.55p -1.9899780000000001e-05 110.5625p -1.9601100000000001e-05 110.575p -1.9296260000000001e-05 110.58749999999999p -1.8985929999999999e-05 110.59999999999999p -1.867079e-05 110.6125p -1.8351530000000001e-05 110.625p -1.8028839999999999e-05 110.6375p -1.7703429999999999e-05 110.65000000000001p -1.737599e-05 110.66250000000001p -1.704722e-05 110.675p -1.6717800000000001e-05 110.6875p -1.6388419999999999e-05 110.7p -1.6059740000000001e-05
+ 110.71249999999999p -1.5732409999999999e-05 110.72499999999999p -1.5407079999999999e-05 110.7375p -1.508436e-05 110.75p -1.4764840000000001e-05 110.7625p -1.4449109999999999e-05 110.77500000000001p -1.41377e-05 110.78750000000001p -1.383116e-05 110.8p -1.352998e-05 110.8125p -1.3234630000000001e-05 110.825p -1.2945560000000001e-05 110.83750000000001p -1.266318e-05 110.84999999999999p -1.238789e-05 110.8625p -1.212004e-05 110.875p -1.1859960000000001e-05 110.8875p -1.1607940000000001e-05 110.90000000000001p -1.1364250000000001e-05 110.91250000000001p -1.1129139999999999e-05 110.925p -1.09028e-05
+ 110.9375p -1.068543e-05 110.95p -1.047715e-05 110.96250000000001p -1.0278100000000001e-05 110.97499999999999p -1.008836e-05 110.9875p -9.9080060000000004e-06 111p -9.7370619999999997e-06 111.01249999999999p -9.5755419999999999e-06 111.02500000000001p -9.4234289999999996e-06 111.03750000000001p -9.2806829999999992e-06 111.05p -9.1472380000000001e-06 111.0625p -9.0230059999999996e-06 111.075p -8.9078759999999992e-06 111.08750000000001p -8.8017159999999995e-06 111.09999999999999p -8.7043750000000008e-06 111.1125p -8.6156799999999998e-06 111.125p -8.5354430000000006e-06 111.13749999999999p -8.4634549999999998e-06 111.15000000000001p -8.3994930000000007e-06
+ 111.16250000000001p -8.3433190000000005e-06 111.17500000000001p -8.2946800000000007e-06 111.1875p -8.2533090000000007e-06 111.2p -8.2189289999999995e-06 111.21250000000001p -8.191251e-06 111.22499999999999p -8.1699740000000003e-06 111.2375p -8.1547899999999996e-06 111.25p -8.1453820000000007e-06 111.26249999999999p -8.1414260000000008e-06 111.27499999999999p -8.1425920000000004e-06 111.28750000000001p -8.1485449999999998e-06 111.30000000000001p -8.1589439999999994e-06 111.3125p -8.1734450000000001e-06 111.325p -8.1917020000000003e-06 111.33750000000001p -8.2133680000000008e-06 111.34999999999999p -8.2380930000000008e-06 111.3625p -8.2655269999999996e-06 111.375p -8.2953210000000008e-06
+ 111.38749999999999p -8.3271280000000002e-06 111.39999999999999p -8.3606019999999997e-06 111.41250000000001p -8.3953989999999999e-06 111.42500000000001p -8.4311800000000001e-06 111.4375p -8.4676089999999997e-06 111.45p -8.5043540000000003e-06 111.46250000000001p -8.5410890000000002e-06 111.47499999999999p -8.5774929999999996e-06 111.4875p -8.6132510000000003e-06 111.5p -8.6480560000000007e-06 111.51249999999999p -8.6816059999999998e-06 111.52499999999999p -8.7136090000000003e-06 111.53749999999999p -8.7437780000000007e-06 111.55000000000001p -8.7718370000000008e-06 111.5625p -8.7975190000000004e-06 111.575p -8.8205630000000003e-06 111.58750000000001p -8.8407190000000002e-06 111.59999999999999p -8.8577490000000006e-06
+ 111.6125p -8.8714210000000003e-06 111.625p -8.8815169999999994e-06 111.6375p -8.8878259999999993e-06 111.64999999999999p -8.8901499999999999e-06 111.66249999999999p -8.8882999999999992e-06 111.67500000000001p -8.8821010000000003e-06 111.6875p -8.8713859999999995e-06 111.7p -8.8559999999999996e-06 111.71250000000001p -8.8357999999999993e-06 111.72499999999999p -8.8106550000000004e-06 111.7375p -8.7804440000000002e-06 111.75p -8.7450580000000005e-06 111.7625p -8.7043999999999992e-06 111.77499999999999p -8.6583839999999995e-06 111.78749999999999p -8.6069360000000007e-06 111.8p -8.5499930000000003e-06 111.8125p -8.4875029999999995e-06 111.825p -8.4194279999999993e-06
+ 111.83750000000001p -8.3457369999999999e-06 111.84999999999999p -8.2664139999999993e-06 111.8625p -8.1814519999999999e-06 111.875p -8.0908560000000004e-06 111.8875p -7.9946400000000008e-06 111.89999999999999p -7.8928309999999999e-06 111.91249999999999p -7.7854660000000006e-06 111.925p -7.6725899999999993e-06 111.9375p -7.5542609999999998e-06 111.95p -7.430545e-06 111.96250000000001p -7.3015180000000004e-06 111.97500000000001p -7.1672669999999997e-06 111.9875p -7.0278860000000001e-06 112p -6.8834790000000003e-06 112.0125p -6.7341590000000002e-06 112.02499999999999p -6.5800469999999999e-06 112.03749999999999p -6.4212709999999997e-06 112.05p -6.2579690000000003e-06
+ 112.0625p -6.0902849999999997e-06 112.075p -5.918372e-06 112.08750000000001p -5.7423869999999997e-06 112.10000000000001p -5.5624960000000004e-06 112.1125p -5.3788720000000004e-06 112.125p -5.1916910000000002e-06 112.1375p -5.0011369999999998e-06 112.14999999999999p -4.8073989999999997e-06 112.16249999999999p -4.6106709999999996e-06 112.175p -4.4111519999999997e-06 112.1875p -4.2090440000000002e-06 112.2p -4.004555e-06 112.21250000000001p -3.7978939999999999e-06 112.22500000000001p -3.5892770000000001e-06 112.2375p -3.3789200000000001e-06 112.25p -3.1670419999999998e-06 112.2625p -2.9538669999999999e-06 112.27499999999999p -2.7396169999999998e-06
+ 112.28749999999999p -2.5245199999999998e-06 112.3p -2.3088010000000001e-06 112.3125p -2.092688e-06 112.325p -1.8764120000000001e-06 112.33750000000001p -1.6602e-06 112.35000000000001p -1.444281e-06 112.3625p -1.228886e-06 112.375p -1.01424e-06 112.3875p -8.0057289999999996e-07 112.39999999999999p -5.8810929999999999e-07 112.41249999999999p -3.7707389999999999e-07 112.425p -1.6768929999999999e-07 112.4375p 3.982402e-08 112.45p 2.4524809999999999e-07 112.46250000000001p 4.483678e-07 112.47500000000001p 6.4897060000000003e-07 112.4875p 8.4684759999999997e-07 112.5p 1.0417929999999999e-06
+ 112.5125p 1.2336060000000001e-06 112.52499999999999p 1.422088e-06 112.53749999999999p 1.607046e-06 112.55p 1.78829e-06 112.5625p 1.9656380000000001e-06 112.575p 2.138909e-06 112.58750000000001p 2.3079299999999999e-06 112.60000000000001p 2.4725309999999998e-06 112.6125p 2.6325510000000001e-06 112.625p 2.787831e-06 112.6375p 2.9382199999999998e-06 112.64999999999999p 3.0835729999999999e-06 112.66249999999999p 3.2237519999999999e-06 112.675p 3.3586220000000001e-06 112.6875p 3.488059e-06 112.7p 3.6119429999999998e-06 112.71250000000001p 3.7301620000000001e-06 112.72500000000001p 3.8426100000000001e-06
+ 112.7375p 3.9491890000000001e-06 112.75p 4.0498069999999997e-06 112.7625p 4.14438e-06 112.77500000000001p 4.2328320000000004e-06 112.78749999999999p 4.3150929999999996e-06 112.8p 4.3911019999999998e-06 112.8125p 4.4608029999999996e-06 112.82499999999999p 4.5241499999999997e-06 112.83750000000001p 4.5811040000000002e-06 112.85000000000001p 4.6316330000000001e-06 112.8625p 4.6757120000000003e-06 112.875p 4.7133250000000003e-06 112.8875p 4.7444639999999999e-06 112.90000000000001p 4.7691260000000001e-06 112.91249999999999p 4.787318e-06 112.925p 4.7990540000000004e-06 112.9375p 4.8043540000000001e-06 112.94999999999999p 4.8032479999999997e-06
+ 112.96250000000001p 4.7957700000000003e-06 112.97500000000001p 4.7819650000000002e-06 112.9875p 4.7618830000000003e-06 113p 4.7355809999999997e-06 113.0125p 4.7031230000000003e-06 113.02500000000001p 4.6645820000000001e-06 113.03749999999999p 4.620036e-06 113.05p 4.5695689999999996e-06 113.0625p 4.5132729999999999e-06 113.07499999999999p 4.4512459999999998e-06 113.08749999999999p 4.3835919999999996e-06 113.10000000000001p 4.3104229999999998e-06 113.11250000000001p 4.2318529999999999e-06 113.125p 4.1480050000000003e-06 113.1375p 4.0590079999999998e-06 113.15000000000001p 3.9649949999999998e-06 113.16249999999999p 3.8661040000000002e-06 113.175p 3.7624779999999998e-06
+ 113.1875p 3.6542679999999999e-06 113.19999999999999p 3.541626e-06 113.21249999999999p 3.4247099999999999e-06 113.22500000000001p 3.3036820000000002e-06 113.23750000000001p 3.17871e-06 113.25p 3.0499630000000001e-06 113.2625p 2.917615e-06 113.27500000000001p 2.7818429999999999e-06 113.28749999999999p 2.6428290000000001e-06 113.3p 2.5007559999999999e-06 113.3125p 2.3558099999999998e-06 113.32499999999999p 2.208181e-06 113.33749999999999p 2.05806e-06 113.35000000000001p 1.905639e-06 113.36250000000001p 1.751115e-06 113.375p 1.5946839999999999e-06 113.3875p 1.4365440000000001e-06 113.40000000000001p 1.2768950000000001e-06
+ 113.41249999999999p 1.1159359999999999e-06 113.425p 9.5386809999999999e-07 113.4375p 7.9089259999999997e-07 113.45p 6.2721069999999996e-07 113.46249999999999p 4.6302350000000002e-07 113.47499999999999p 2.9853169999999999e-07 113.48750000000001p 1.3393570000000001e-07 113.5p -3.0565160000000001e-08 113.5125p -1.9477250000000001e-07 113.52500000000001p -3.5848909999999999e-07 113.53749999999999p -5.2151939999999997e-07 113.55p -6.8366950000000002e-07 113.5625p -8.4474740000000004e-07 113.575p -1.0045629999999999e-06 113.58749999999999p -1.1629300000000001e-06 113.59999999999999p -1.3196620000000001e-06 113.61250000000001p -1.474577e-06 113.625p -1.627497e-06
+ 113.6375p -1.7782449999999999e-06 113.65000000000001p -1.92665e-06 113.66249999999999p -2.0725410000000001e-06 113.675p -2.2157529999999998e-06 113.6875p -2.3561260000000001e-06 113.7p -2.493502e-06 113.71249999999999p -2.6277280000000002e-06 113.72499999999999p -2.7586550000000002e-06 113.7375p -2.8861389999999998e-06 113.75p -3.0100410000000001e-06 113.7625p -3.130226e-06 113.77500000000001p -3.2465650000000001e-06 113.78750000000001p -3.358933e-06 113.8p -3.4672099999999999e-06 113.8125p -3.5712830000000002e-06 113.825p -3.671044e-06 113.83749999999999p -3.766389e-06 113.84999999999999p -3.857221e-06
+ 113.8625p -3.9434479999999999e-06 113.875p -4.024984e-06 113.8875p -4.1017500000000002e-06 113.90000000000001p -4.1736710000000002e-06 113.91250000000001p -4.240679e-06 113.925p -4.3027110000000004e-06 113.9375p -4.3597129999999997e-06 113.95p -4.4116329999999997e-06 113.96249999999999p -4.4584280000000003e-06 113.97499999999999p -4.5000600000000001e-06 113.9875p -4.536498e-06 114p -4.5677159999999999e-06 114.0125p -4.593694e-06 114.02500000000001p -4.6144210000000002e-06 114.03750000000001p -4.6298869999999998e-06 114.05p -4.6400929999999999e-06 114.0625p -4.6450439999999999e-06 114.075p -4.6447510000000001e-06
+ 114.08749999999999p -4.63923e-06 114.09999999999999p -4.6285050000000002e-06 114.1125p -4.6126060000000003e-06 114.125p -4.5915650000000003e-06 114.1375p -4.5654249999999996e-06 114.15000000000001p -4.5342310000000004e-06 114.16250000000001p -4.4980339999999996e-06 114.175p -4.4568929999999996e-06 114.1875p -4.4108689999999998e-06 114.2p -4.3600300000000002e-06 114.21249999999999p -4.3044499999999999e-06 114.22499999999999p -4.2442069999999999e-06 114.2375p -4.1793839999999997e-06 114.25p -4.110069e-06 114.2625p -4.036354e-06 114.27500000000001p -3.9583379999999996e-06 114.28750000000001p -3.876121e-06 114.3p -3.7898109999999998e-06
+ 114.3125p -3.699518e-06 114.325p -3.6053570000000001e-06 114.33749999999999p -3.5074449999999998e-06 114.34999999999999p -3.4059049999999998e-06 114.3625p -3.3008639999999999e-06 114.375p -3.1924510000000001e-06 114.3875p -3.080799e-06 114.40000000000001p -2.9660430000000002e-06 114.41250000000001p -2.8483229999999999e-06 114.425p -2.7277819999999999e-06 114.4375p -2.6045639999999999e-06 114.45p -2.4788159999999999e-06 114.46249999999999p -2.3506879999999999e-06 114.47499999999999p -2.220333e-06 114.4875p -2.0879049999999999e-06 114.5p -1.95356e-06 114.5125p -1.817455e-06 114.52500000000001p -1.6797519999999999e-06
+ 114.53750000000001p -1.540611e-06 114.55p -1.400194e-06 114.5625p -1.258665e-06 114.575p -1.1161899999999999e-06 114.58750000000001p -9.729323000000001e-07 114.59999999999999p -8.2905929999999999e-07 114.6125p -6.8473749999999996e-07 114.625p -5.4013380000000003e-07 114.6375p -3.9541550000000001e-07 114.65000000000001p -2.5074980000000001e-07 114.66250000000001p -1.0630369999999999e-07 114.675p 3.7756010000000001e-08 114.6875p 1.8126309999999999e-07 114.7p 3.2405180000000001e-07 114.71250000000001p 4.6595740000000002e-07 114.72499999999999p 6.0681610000000002e-07 114.7375p 7.464651e-07 114.75p 8.8474310000000004e-07
+ 114.76249999999999p 1.02149e-06 114.77500000000001p 1.1565479999999999e-06 114.78750000000001p 1.2897600000000001e-06 114.8p 1.4209719999999999e-06 114.8125p 1.550031e-06 114.825p 1.6767880000000001e-06 114.83750000000001p 1.8010950000000001e-06 114.84999999999999p 1.922807e-06 114.8625p 2.0417829999999998e-06 114.875p 2.1578820000000001e-06 114.88749999999999p 2.2709710000000002e-06 114.90000000000001p 2.3809150000000001e-06 114.91250000000001p 2.4875860000000002e-06 114.92500000000001p 2.5908599999999998e-06 114.9375p 2.6906140000000001e-06 114.95p 2.786732e-06 114.96250000000001p 2.8791000000000001e-06 114.97499999999999p 2.9676089999999998e-06
+ 114.9875p 3.0521559999999998e-06 115p 3.1326409999999999e-06 115.01249999999999p 3.2089689999999999e-06 115.02499999999999p 3.2810509999999999e-06 115.03750000000001p 3.3488020000000001e-06 115.05000000000001p 3.4121419999999998e-06 115.0625p 3.4709999999999999e-06 115.075p 3.5253049999999999e-06 115.08750000000001p 3.574996e-06 115.09999999999999p 3.6200160000000001e-06 115.1125p 3.6603139999999999e-06 115.125p 3.6958459999999998e-06 115.13749999999999p 3.7265740000000002e-06 115.14999999999999p 3.7524650000000002e-06 115.16250000000001p 3.773493e-06 115.17500000000001p 3.7896399999999999e-06 115.1875p 3.8008920000000001e-06 115.2p 3.8072429999999999e-06
+ 115.21250000000001p 3.8086939999999999e-06 115.22499999999999p 3.8052509999999999e-06 115.2375p 3.7969279999999999e-06 115.25p 3.7837450000000001e-06 115.26249999999999p 3.7657300000000002e-06 115.27499999999999p 3.742915e-06 115.28749999999999p 3.7153429999999999e-06 115.30000000000001p 3.6830580000000001e-06 115.3125p 3.6461160000000001e-06 115.325p 3.6045759999999999e-06 115.33750000000001p 3.5585049999999998e-06 115.34999999999999p 3.5079759999999999e-06 115.3625p 3.4530670000000002e-06 115.375p 3.3938649999999999e-06 115.3875p 3.3304599999999999e-06 115.39999999999999p 3.2629499999999998e-06 115.41249999999999p 3.1914390000000001e-06 115.42500000000001p 3.1160330000000002e-06
+ 115.4375p 3.0368479999999999e-06 115.45p 2.9540040000000001e-06 115.46250000000001p 2.8676229999999999e-06 115.47499999999999p 2.777836e-06 115.4875p 2.6847759999999999e-06 115.5p 2.5885810000000002e-06 115.5125p 2.4893940000000001e-06 115.52499999999999p 2.387362e-06 115.53749999999999p 2.2826329999999998e-06 115.55p 2.1753620000000002e-06 115.5625p 2.0657060000000001e-06 115.575p 1.9538229999999998e-06 115.58750000000001p 1.839877e-06 115.59999999999999p 1.724032e-06 115.6125p 1.606454e-06 115.625p 1.4873120000000001e-06 115.6375p 1.366777e-06 115.64999999999999p 1.245019e-06
+ 115.66249999999999p 1.1222119999999999e-06 115.675p 9.9852729999999998e-07 115.6875p 8.7413990000000003e-07 115.7p 7.4922299999999996e-07 115.71250000000001p 6.239503e-07 115.72500000000001p 4.9849509999999998e-07 115.7375p 3.7302990000000001e-07 115.75p 2.4772650000000002e-07 115.7625p 1.2275529999999999e-07 115.77499999999999p -1.714398e-09 115.78749999999999p -1.255153e-07 115.8p -2.4848169999999998e-07 115.8125p -3.7045040000000001e-07 115.825p -4.9126009999999996e-07 115.83750000000001p -6.1075260000000005e-07 115.85000000000001p -7.2877199999999998e-07 115.8625p -8.4516590000000005e-07 115.875p -9.5978459999999994e-07
+ 115.8875p -1.072482e-06 115.89999999999999p -1.183116e-06 115.91249999999999p -1.2915480000000001e-06 115.925p -1.3976420000000001e-06 115.9375p -1.5012689999999999e-06 115.95p -1.6023009999999999e-06 115.96250000000001p -1.7006169999999999e-06 115.97500000000001p -1.796098e-06 115.9875p -1.8886330000000001e-06 116p -1.9781120000000001e-06 116.0125p -2.0644320000000001e-06 116.02499999999999p -2.1474949999999998e-06 116.03749999999999p -2.227207e-06 116.05p -2.3034810000000002e-06 116.0625p -2.3762330000000001e-06 116.075p -2.4453850000000001e-06 116.08750000000001p -2.5108650000000001e-06 116.10000000000001p -2.5726070000000001e-06
+ 116.1125p -2.6305489999999999e-06 116.125p -2.684635e-06 116.1375p -2.734814e-06 116.14999999999999p -2.7810429999999998e-06 116.16249999999999p -2.8232820000000001e-06 116.175p -2.861498e-06 116.1875p -2.8956630000000001e-06 116.2p -2.9257549999999998e-06 116.21250000000001p -2.951758e-06 116.22500000000001p -2.973661e-06 116.2375p -2.991459e-06 116.25p -3.005154e-06 116.2625p -3.0147519999999999e-06 116.27499999999999p -3.020264e-06 116.28749999999999p -3.021708e-06 116.3p -3.0191079999999998e-06 116.3125p -3.0124920000000002e-06 116.325p -3.0018950000000001e-06
+ 116.33750000000001p -2.9873549999999998e-06 116.35000000000001p -2.968919e-06 116.3625p -2.9466350000000002e-06 116.375p -2.920559e-06 116.3875p -2.8907530000000001e-06 116.39999999999999p -2.85728e-06 116.41249999999999p -2.8202109999999998e-06 116.42499999999998p -2.7796219999999998e-06 116.43749999999999p -2.7355919999999999e-06 116.45p -2.6882049999999999e-06 116.46250000000001p -2.6375499999999998e-06 116.47500000000001p -2.5837200000000001e-06 116.48750000000001p -2.526812e-06 116.50000000000001p -2.4669270000000002e-06 116.51249999999999p -2.4041699999999998e-06 116.52499999999999p -2.338648e-06 116.53749999999999p -2.2704750000000001e-06 116.55p -2.199764e-06
+ 116.5625p -2.126635e-06 116.575p -2.051209e-06 116.58750000000001p -1.9736079999999998e-06 116.59999999999999p -1.8939599999999999e-06 116.6125p -1.812393e-06 116.625p -1.7290370000000001e-06 116.6375p -1.6440249999999999e-06 116.65000000000001p -1.5574900000000001e-06 116.66250000000001p -1.4695690000000001e-06 116.67499999999998p -1.380396e-06 116.68749999999999p -1.290111e-06 116.69999999999999p -1.1988489999999999e-06 116.71250000000001p -1.1067510000000001e-06 116.72500000000001p -1.0139539999999999e-06 116.73750000000001p -9.2059589999999997e-07 116.75000000000001p -8.268158e-07 116.76249999999999p -7.3275069999999999e-07 116.77499999999999p -6.3853740000000004e-07
+ 116.78749999999999p -5.4431150000000002e-07 116.8p -4.502074e-07 116.8125p -3.5635780000000001e-07 116.825p -2.6289390000000001e-07 116.83750000000001p -1.69945e-07 116.84999999999999p -7.7637980000000004e-08 116.8625p 1.3902419999999999e-08 116.875p 1.045541e-07 116.8875p 1.9419779999999999e-07 116.90000000000001p 2.82717e-07 116.91250000000001p 3.6999840000000002e-07 116.92500000000001p 4.5593199999999998e-07 116.93749999999999p 5.4041129999999996e-07 116.94999999999999p 6.2333319999999997e-07 116.96249999999999p 7.0459849999999995e-07 116.97500000000001p 7.8411159999999998e-07 116.98750000000001p 8.6178120000000004e-07 117.00000000000001p 9.3751970000000002e-07
+ 117.01249999999999p 1.0112440000000001e-06 117.02499999999999p 1.082875e-06 117.03749999999999p 1.152338e-06 117.05p 1.2195619999999999e-06 117.0625p 1.2844820000000001e-06 117.075p 1.3470359999999999e-06 117.08750000000001p 1.407167e-06 117.09999999999999p 1.4648219999999999e-06 117.1125p 1.519953e-06 117.125p 1.572517e-06 117.1375p 1.6224740000000001e-06 117.15000000000001p 1.669789e-06 117.16250000000001p 1.7144320000000001e-06 117.17500000000001p 1.756377e-06 117.18749999999999p 1.7956020000000001e-06 117.19999999999999p 1.8320880000000001e-06 117.21249999999999p 1.865823e-06 117.22499999999999p 1.8967969999999999e-06
+ 117.23750000000001p 1.9250039999999999e-06 117.25000000000001p 1.9504430000000001e-06 117.26250000000002p 1.9731140000000002e-06 117.27499999999999p 1.9930249999999999e-06 117.28749999999999p 2.010183e-06 117.3p 2.0246020000000001e-06 117.3125p 2.0362960000000002e-06 117.325p 2.0452849999999999e-06 117.33750000000001p 2.0515909999999999e-06 117.34999999999999p 2.055238e-06 117.3625p 2.0562529999999999e-06 117.375p 2.054668e-06 117.3875p 2.0505140000000001e-06 117.40000000000001p 2.0438269999999999e-06 117.41250000000001p 2.0346430000000001e-06 117.42500000000001p 2.023002e-06 117.43749999999999p 2.0089450000000001e-06 117.44999999999999p 1.992516e-06
+ 117.46249999999999p 1.973759e-06 117.47499999999999p 1.9527209999999999e-06 117.4875p 1.9294499999999998e-06 117.50000000000001p 1.903995e-06 117.51250000000002p 1.8764079999999999e-06 117.52499999999999p 1.8467390000000001e-06 117.53749999999999p 1.8150429999999999e-06 117.55p 1.7813720000000001e-06 117.5625p 1.745783e-06 117.575p 1.708331e-06 117.58750000000001p 1.6690729999999999e-06 117.60000000000001p 1.628065e-06 117.6125p 1.585367e-06 117.625p 1.5410369999999999e-06 117.6375p 1.4951329999999999e-06 117.65000000000001p 1.447717e-06 117.66250000000001p 1.3988460000000001e-06 117.67500000000001p 1.3485840000000001e-06
+ 117.68749999999999p 1.2969889999999999e-06 117.69999999999999p 1.2441239999999999e-06 117.71249999999999p 1.190051e-06 117.72499999999999p 1.1348309999999999e-06 117.7375p 1.078526e-06 117.75p 1.0212000000000001e-06 117.76250000000002p 9.6291480000000003e-07 117.77499999999999p 9.037342e-07 117.78749999999999p 8.4372170000000001e-07 117.8p 7.8294089999999998e-07 117.8125p 7.2145600000000005e-07 117.825p 6.5933139999999996e-07 117.83750000000001p 5.9663170000000004e-07 117.85000000000001p 5.3342200000000002e-07 117.86249999999998p 4.697674e-07 117.875p 4.057336e-07 117.8875p 3.4138650000000002e-07 117.90000000000001p 2.7679209999999997e-07
+ 117.91250000000001p 2.1201700000000001e-07 117.92500000000001p 1.4712780000000001e-07 117.93750000000001p 8.2191600000000004e-08 117.94999999999999p 1.7275669999999999e-08 117.96249999999999p -4.7552480000000002e-08 117.97499999999999p -1.1222510000000001e-07 117.9875p -1.766741e-07 118p -2.4083150000000001e-07 118.0125p -3.0462879999999998e-07 118.02499999999999p -3.6799769999999998e-07 118.03749999999999p -4.3086949999999998e-07 118.05p -4.9317579999999998e-07 118.0625p -5.5484789999999997e-07 118.075p -6.1581740000000001e-07 118.08750000000001p -6.760158e-07 118.10000000000001p -7.3537489999999999e-07 118.11249999999998p -7.938267e-07 118.12499999999999p -8.5130360000000004e-07
+ 118.1375p -9.0773830000000003e-07 118.15000000000001p -9.63064e-07 118.16250000000001p -1.0172139999999999e-06 118.17500000000001p -1.070124e-06 118.18750000000001p -1.1217270000000001e-06 118.19999999999999p -1.1719609999999999e-06 118.21249999999999p -1.220761e-06 118.22499999999999p -1.2680669999999999e-06 118.2375p -1.313815e-06 118.25p -1.357948e-06 118.2625p -1.4004059999999999e-06 118.27500000000002p -1.4411320000000001e-06 118.28749999999999p -1.4800710000000001e-06 118.3p -1.5171690000000001e-06 118.3125p -1.5523730000000001e-06 118.325p -1.585633e-06 118.33750000000001p -1.616901e-06 118.35000000000001p -1.646131e-06
+ 118.36249999999998p -1.673278e-06 118.37499999999999p -1.6983009999999999e-06 118.38749999999999p -1.7211600000000001e-06 118.40000000000001p -1.7418180000000001e-06 118.41250000000001p -1.7602399999999999e-06 118.42500000000001p -1.7763949999999999e-06 118.43750000000001p -1.790254e-06 118.44999999999999p -1.80179e-06 118.46249999999999p -1.810979e-06 118.47499999999999p -1.817801e-06 118.4875p -1.8222389999999999e-06 118.5p -1.8242790000000001e-06 118.5125p -1.823908e-06 118.52500000000001p -1.8211189999999999e-06 118.53749999999999p -1.815907e-06 118.55p -1.808271e-06 118.5625p -1.7982110000000001e-06 118.575p -1.785733e-06
+ 118.58750000000001p -1.7708460000000001e-06 118.60000000000001p -1.753561e-06 118.61249999999998p -1.733892e-06 118.62499999999999p -1.711859e-06 118.63749999999999p -1.6874839999999999e-06 118.65000000000001p -1.66079e-06 118.66250000000001p -1.631807e-06 118.67500000000001p -1.6005669999999999e-06 118.68750000000001p -1.5671030000000001e-06 118.69999999999999p -1.5314559999999999e-06 118.71249999999999p -1.4936650000000001e-06 118.72499999999999p -1.4537749999999999e-06 118.7375p -1.4118340000000001e-06 118.75p -1.3678930000000001e-06 118.7625p -1.3220039999999999e-06 118.77500000000001p -1.2742250000000001e-06 118.78749999999999p -1.2246140000000001e-06 118.8p -1.1732339999999999e-06
+ 118.8125p -1.120149e-06 118.825p -1.0654260000000001e-06 118.83750000000001p -1.0091349999999999e-06 118.85000000000001p -9.5134729999999995e-07 118.86250000000001p -8.9213729999999999e-07 118.87499999999999p -8.3158130000000004e-07 118.88749999999999p -7.6975759999999995e-07 118.89999999999999p -7.0674649999999996e-07 118.91250000000001p -6.4262999999999998e-07 118.92500000000001p -5.7749199999999997e-07 118.93750000000001p -5.1141770000000003e-07 118.94999999999999p -4.4449389999999999e-07 118.96249999999999p -3.7680879999999999e-07 118.97499999999999p -3.0845160000000002e-07 118.9875p -2.395128e-07 119p -1.700837e-07 119.0125p -1.002565e-07 119.02500000000001p -3.0124159999999997e-08
+ 119.03749999999999p 4.0220030000000002e-08 119.05p 1.106821e-07 119.0625p 1.81168e-07 119.075p 2.5158329999999999e-07 119.08750000000001p 3.2183369999999999e-07 119.10000000000001p 3.9182480000000002e-07 119.11250000000001p 4.614627e-07 119.12499999999999p 5.3065370000000003e-07 119.13749999999999p 5.993044e-07 119.14999999999999p 6.6732239999999999e-07 119.16249999999999p 7.3461570000000002e-07 119.17500000000001p 8.0109349999999997e-07 119.18750000000001p 8.6666560000000004e-07 119.20000000000002p 9.3124319999999998e-07 119.21249999999999p 9.9473879999999991e-07 119.22499999999999p 1.0570659999999999e-06 119.2375p 1.11814e-06 119.25p 1.177878e-06
+ 119.2625p 1.236197e-06 119.27500000000001p 1.2930200000000001e-06 119.28749999999999p 1.348267e-06 119.3p 1.4018629999999999e-06 119.3125p 1.4537350000000001e-06 119.325p 1.503811e-06 119.33750000000001p 1.5520229999999999e-06 119.35000000000001p 1.5983039999999999e-06 119.36250000000001p 1.6425900000000001e-06 119.37499999999999p 1.684819e-06 119.38749999999999p 1.7249340000000001e-06 119.39999999999999p 1.7628779999999999e-06 119.41249999999999p 1.798598e-06 119.425p 1.832045e-06 119.43750000000001p 1.8631720000000001e-06 119.45000000000002p 1.8919339999999999e-06 119.46249999999999p 1.9182920000000001e-06 119.47499999999999p 1.9422070000000002e-06
+ 119.4875p 1.9636460000000001e-06 119.5p 1.9825769999999999e-06 119.5125p 1.998974e-06 119.52500000000001p 2.0128119999999999e-06 119.53750000000001p 2.0240699999999998e-06 119.55p 2.0327320000000001e-06 119.5625p 2.0387839999999998e-06 119.575p 2.0422149999999999e-06 119.58750000000001p 2.0430190000000001e-06 119.60000000000001p 2.0411939999999999e-06 119.61250000000001p 2.0367389999999999e-06 119.62499999999999p 2.0296590000000002e-06 119.63749999999999p 2.0199619999999999e-06 119.64999999999999p 2.0076590000000002e-06 119.66249999999999p 1.9927640000000001e-06 119.675p 1.9752959999999998e-06 119.6875p 1.955278e-06 119.70000000000002p 1.932733e-06
+ 119.71249999999999p 1.9076920000000002e-06 119.72499999999999p 1.880185e-06 119.7375p 1.85025e-06 119.75p 1.817924e-06 119.7625p 1.783249e-06 119.77500000000001p 1.746272e-06 119.78750000000001p 1.70704e-06 119.79999999999998p 1.6656049999999999e-06 119.8125p 1.622021e-06 119.825p 1.5763470000000001e-06 119.83750000000001p 1.5286409999999999e-06 119.85000000000001p 1.4789670000000001e-06 119.86250000000001p 1.4273910000000001e-06 119.87500000000001p 1.373981e-06 119.88749999999999p 1.318808e-06 119.89999999999999p 1.2619449999999999e-06 119.91249999999999p 1.2034659999999999e-06 119.925p 1.1434510000000001e-06
+ 119.9375p 1.081977e-06 119.95p 1.019127e-06 119.96249999999999p 9.5498429999999997e-07 119.97499999999999p 8.8963330000000001e-07 119.9875p 8.2316080000000001e-07 120p 7.5565479999999996e-07 120.0125p 6.8720469999999996e-07 120.02500000000001p 6.1790110000000001e-07 120.03750000000001p 5.478355e-07 120.04999999999998p 4.7710040000000003e-07 120.06249999999999p 4.0578939999999998e-07 120.075p 3.3399630000000002e-07 120.08750000000001p 2.6181580000000001e-07 120.10000000000001p 1.8934290000000001e-07 120.11250000000001p 1.166728e-07 120.12500000000001p 4.3900959999999998e-08 120.13749999999999p -2.8877290000000001e-08 120.14999999999999p -1.015667e-07
+ 120.16249999999999p -1.7407209999999999e-07 120.175p -2.46299e-07 120.1875p -3.1815340000000003e-07 120.2p -3.8954170000000001e-07 120.21250000000001p -4.6037129999999999e-07 120.22499999999999p -5.305506e-07 120.2375p -5.9998869999999996e-07 120.25p -6.6859629999999996e-07 120.2625p -7.3628499999999995e-07 120.27500000000001p -8.0296809999999999e-07 120.28750000000001p -8.6856030000000002e-07 120.29999999999998p -9.3297789999999999e-07 120.31249999999999p -9.961390000000001e-07 120.32499999999999p -1.0579639999999999e-06 120.33750000000001p -1.1183740000000001e-06 120.35000000000001p -1.177293e-06 120.36250000000001p -1.2346480000000001e-06 120.37500000000001p -1.2903669999999999e-06
+ 120.38749999999999p -1.3443810000000001e-06 120.39999999999999p -1.3966230000000001e-06 120.41249999999999p -1.447029e-06 120.425p -1.4955379999999999e-06 120.4375p -1.5420889999999999e-06 120.45p -1.5866279999999999e-06 120.46250000000001p -1.629101e-06 120.47499999999999p -1.669458e-06 120.4875p -1.7076510000000001e-06 120.5p -1.743635e-06 120.5125p -1.7773699999999999e-06 120.52500000000001p -1.808817e-06 120.53750000000001p -1.8379410000000001e-06 120.55000000000001p -1.864711e-06 120.56249999999999p -1.8890959999999999e-06 120.57499999999999p -1.9110730000000001e-06 120.58749999999999p -1.9306179999999999e-06 120.60000000000001p -1.947714e-06
+ 120.61250000000001p -1.9623440000000002e-06 120.62500000000001p -1.9744959999999998e-06 120.63749999999999p -1.984161e-06 120.64999999999999p -1.991334e-06 120.66249999999999p -1.9960119999999999e-06 120.675p -1.9981960000000001e-06 120.6875p -1.9978909999999999e-06 120.7p -1.9951039999999999e-06 120.71250000000001p -1.989846e-06 120.72499999999999p -1.98213e-06 120.7375p -1.9719749999999999e-06 120.75p -1.9593999999999998e-06 120.7625p -1.9444279999999999e-06 120.77500000000001p -1.9270860000000002e-06 120.78750000000001p -1.9074039999999998e-06 120.80000000000001p -1.8854139999999999e-06 120.81249999999999p -1.861151e-06 120.82499999999999p -1.834653e-06
+ 120.83749999999999p -1.805962e-06 120.85000000000001p -1.7751200000000001e-06 120.86250000000001p -1.7421739999999999e-06 120.87500000000001p -1.707172e-06 120.88749999999999p -1.670166e-06 120.89999999999999p -1.63121e-06 120.91249999999999p -1.590359e-06 120.925p -1.5476710000000001e-06 120.9375p -1.503206e-06 120.95p -1.4570279999999999e-06 120.96250000000001p -1.409199e-06 120.97499999999999p -1.3597859999999999e-06 120.9875p -1.308857e-06 121p -1.25648e-06 121.0125p -1.2027280000000001e-06 121.02500000000001p -1.1476719999999999e-06 121.03750000000001p -1.0913860000000001e-06 121.05000000000001p -1.0339449999999999e-06
+ 121.06249999999999p -9.7542479999999998e-07 121.07499999999999p -9.1590240000000001e-07 121.08749999999999p -8.5545599999999995e-07 121.09999999999999p -7.9416409999999996e-07 121.11250000000001p -7.3210610000000005e-07 121.12500000000001p -6.6936209999999995e-07 121.13750000000002p -6.0601239999999998e-07 121.14999999999999p -5.4213790000000001e-07 121.16249999999999p -4.7781959999999995e-07 121.175p -4.1313850000000002e-07 121.1875p -3.4817610000000003e-07 121.2p -2.8301320000000001e-07 121.21250000000001p -2.1773100000000001e-07 121.22499999999999p -1.5241e-07 121.2375p -8.7130509999999997e-08 121.25p -2.197227e-08 121.2625p 4.2985550000000001e-08 121.27500000000001p 1.076645e-07
+ 121.28750000000001p 1.7198680000000001e-07 121.30000000000001p 2.3587570000000001e-07 121.31249999999999p 2.9925539999999998e-07 121.32499999999999p 3.620512e-07 121.33749999999999p 4.2418929999999999e-07 121.34999999999999p 4.8559760000000004e-07 121.3625p 5.4620490000000005e-07 121.37500000000001p 6.0594160000000002e-07 121.38750000000002p 6.6473969999999998e-07 121.39999999999999p 7.2253250000000001e-07 121.41249999999999p 7.7925520000000001e-07 121.425p 8.348445e-07 121.4375p 8.8923900000000001e-07 121.45p 9.4237920000000001e-07 121.46250000000001p 9.9420729999999995e-07 121.47500000000001p 1.0446680000000001e-06 121.4875p 1.093707e-06 121.5p 1.1412720000000001e-06
+ 121.5125p 1.1873160000000001e-06 121.52500000000001p 1.2317889999999999e-06 121.53750000000001p 1.2746470000000001e-06 121.55000000000001p 1.315848e-06 121.56249999999999p 1.3553500000000001e-06 121.57499999999999p 1.393115e-06 121.58749999999999p 1.429108e-06 121.59999999999999p 1.4632940000000001e-06 121.6125p 1.495643e-06 121.625p 1.526126e-06 121.63750000000002p 1.554717e-06 121.64999999999999p 1.581392e-06 121.66249999999999p 1.6061299999999999e-06 121.675p 1.6289110000000001e-06 121.6875p 1.649719e-06 121.7p 1.6685410000000001e-06 121.71250000000001p 1.6853650000000001e-06 121.72500000000001p 1.7001809999999999e-06
+ 121.73749999999998p 1.7129839999999999e-06 121.75p 1.7237689999999999e-06 121.7625p 1.732535e-06 121.77500000000001p 1.739283e-06 121.78750000000001p 1.7440149999999999e-06 121.80000000000001p 1.7467369999999999e-06 121.81250000000001p 1.7474570000000001e-06 121.82499999999999p 1.7461859999999999e-06 121.83749999999999p 1.742936e-06 121.84999999999999p 1.7377210000000001e-06 121.8625p 1.7305589999999999e-06 121.875p 1.7214679999999999e-06 121.8875p 1.710471e-06 121.89999999999999p 1.697591e-06 121.91249999999999p 1.682853e-06 121.925p 1.666285e-06 121.9375p 1.6479159999999999e-06 121.95p 1.627779e-06
+ 121.96250000000001p 1.6059050000000001e-06 121.97500000000001p 1.5823310000000001e-06 121.98749999999998p 1.5570929999999999e-06 121.99999999999999p 1.53023e-06 122.0125p 1.5017820000000001e-06 122.02500000000001p 1.471791e-06 122.03750000000001p 1.440301e-06 122.05000000000001p 1.4073559999999999e-06 122.06250000000001p 1.3730029999999999e-06 122.07499999999999p 1.337289e-06 122.08749999999999p 1.3002629999999999e-06 122.09999999999999p 1.2619759999999999e-06 122.1125p 1.222478e-06 122.125p 1.181822e-06 122.1375p 1.1400610000000001e-06 122.15000000000001p 1.09725e-06 122.16249999999999p 1.0534430000000001e-06 122.175p 1.0086970000000001e-06
+ 122.1875p 9.6306819999999999e-07 122.2p 9.1661369999999998e-07 122.21250000000001p 8.6939169999999995e-07 122.22500000000001p 8.2146040000000002e-07 122.23749999999998p 7.7287880000000001e-07 122.24999999999999p 7.2370600000000001e-07 122.26249999999999p 6.7400149999999996e-07 122.27500000000001p 6.2382500000000002e-07 122.28750000000001p 5.7323639999999998e-07 122.30000000000001p 5.2229570000000003e-07 122.31250000000001p 4.7106259999999999e-07 122.32499999999999p 4.1959719999999998e-07 122.33749999999999p 3.6795909999999999e-07 122.34999999999999p 3.1620799999999999e-07 122.3625p 2.644029e-07 122.375p 2.126029e-07 122.3875p 1.6086649999999999e-07 122.40000000000001p 1.092516e-07
+ 122.41249999999999p 5.7815740000000003e-08 122.425p 6.6157749999999997e-09 122.4375p -4.4292109999999999e-08 122.45p -9.4852470000000005e-08 122.46250000000001p -1.4501060000000001e-07 122.47500000000001p -1.9471279999999999e-07 122.48750000000001p -2.4390610000000001e-07 122.49999999999999p -2.9253869999999999e-07 122.51249999999999p -3.4055950000000001e-07 122.52499999999999p -3.8791889999999998e-07 122.53750000000001p -4.3456819999999999e-07 122.55000000000001p -4.8045979999999996e-07 122.56250000000001p -5.2554759999999997e-07 122.57499999999999p -5.6978640000000004e-07 122.58749999999999p -6.1313279999999998e-07 122.59999999999999p -6.5554429999999999e-07 122.6125p -6.9698009999999998e-07 122.625p -7.3740070000000002e-07
+ 122.6375p -7.7676810000000003e-07 122.65000000000001p -8.1504589999999999e-07 122.66249999999999p -8.5219909999999999e-07 122.675p -8.8819440000000004e-07 122.6875p -9.2299989999999995e-07 122.7p -9.565855e-07 122.71250000000001p -9.889226e-07 122.72500000000001p -1.019984e-06 122.73750000000001p -1.0497460000000001e-06 122.74999999999999p -1.0781830000000001e-06 122.76249999999999p -1.105275e-06 122.77499999999999p -1.1310000000000001e-06 122.78749999999999p -1.155341e-06 122.80000000000001p -1.1782819999999999e-06 122.81250000000001p -1.1998060000000001e-06 122.82500000000002p -1.2199e-06 122.83749999999999p -1.2385540000000001e-06 122.84999999999999p -1.255758e-06
+ 122.8625p -1.2715020000000001e-06 122.875p -1.2857809999999999e-06 122.8875p -1.2985900000000001e-06 122.90000000000001p -1.309925e-06 122.91249999999999p -1.3197860000000001e-06 122.925p -1.3281719999999999e-06 122.9375p -1.3350849999999999e-06 122.95p -1.3405280000000001e-06 122.96250000000001p -1.344507e-06 122.97500000000001p -1.3470270000000001e-06 122.98750000000001p -1.348097e-06 122.99999999999999p -1.3477250000000001e-06 123.01249999999999p -1.3459229999999999e-06 123.02499999999999p -1.3427019999999999e-06 123.03749999999999p -1.3380769999999999e-06 123.05p -1.3320619999999999e-06 123.06250000000001p -1.3246730000000001e-06 123.07500000000002p -1.3159279999999999e-06
+ 123.08749999999999p -1.3058460000000001e-06 123.09999999999999p -1.294446e-06 123.1125p -1.2817500000000001e-06 123.125p -1.267779e-06 123.1375p -1.252558e-06 123.15000000000001p -1.23611e-06 123.16250000000001p -1.21846e-06 123.175p -1.1996360000000001e-06 123.1875p -1.179664e-06 123.2p -1.1585720000000001e-06 123.21250000000001p -1.1363889999999999e-06 123.22500000000001p -1.113146e-06 123.23750000000001p -1.0888719999999999e-06 123.24999999999999p -1.063599e-06 123.26249999999999p -1.0373589999999999e-06 123.27499999999999p -1.0101850000000001e-06 123.28749999999999p -9.8210920000000001e-07 123.3p -9.5316679999999999e-07
+ 123.31250000000001p -9.2339169999999998e-07 123.32500000000002p -8.9281900000000005e-07 123.33749999999999p -8.6148409999999995e-07 123.34999999999999p -8.2942309999999999e-07 123.3625p -7.9667230000000003e-07 123.375p -7.6326859999999998e-07 123.3875p -7.2924909999999996e-07 123.40000000000001p -6.9465150000000003e-07 123.41250000000001p -6.5951350000000005e-07 123.42499999999998p -6.2387340000000004e-07 123.4375p -5.8776950000000001e-07 123.45p -5.5124049999999997e-07 123.46250000000001p -5.1432520000000003e-07 123.47500000000001p -4.7706290000000005e-07 123.48750000000001p -4.3949249999999999e-07 123.49999999999999p -4.0165369999999998e-07 123.51249999999999p -3.6358570000000001e-07 123.52499999999999p -3.2532829999999999e-07
+ 123.53749999999999p -2.8692100000000001e-07 123.55p -2.4840360000000001e-07 123.5625p -2.098157e-07 123.57500000000002p -1.7119720000000001e-07 123.58749999999999p -1.3258769999999999e-07 123.59999999999999p -9.402688e-08 123.6125p -5.5554330000000002e-08 123.625p -1.7209559999999999e-08 123.6375p 2.0968049999999999e-08 123.65000000000001p 5.893924e-08 123.66250000000001p 9.6664929999999997e-08 123.67499999999998p 1.3410620000000001e-07 123.6875p 1.7122439999999999e-07 123.7p 2.079812e-07 123.71250000000001p 2.4433820000000001e-07 123.72500000000001p 2.8025780000000001e-07 123.73750000000001p 3.1570219999999999e-07 123.75000000000001p 3.5063439999999998e-07
+ 123.76249999999999p 3.8501760000000002e-07 123.77499999999999p 4.1881550000000002e-07 123.78749999999999p 4.5199200000000001e-07 123.8p 4.8451190000000005e-07 123.8125p 5.1634010000000002e-07 123.825p 5.4744249999999995e-07 123.83749999999999p 5.7778519999999999e-07 123.84999999999999p 6.0733519999999999e-07 123.8625p 6.3605999999999999e-07 123.875p 6.6392809999999998e-07 123.8875p 6.9090829999999996e-07 123.90000000000001p 7.1697069999999999e-07 123.91250000000001p 7.4208580000000001e-07 123.92499999999998p 7.662252e-07 123.93749999999999p 7.8936159999999995e-07 123.95p 8.1146829999999997e-07 123.96250000000001p 8.3251980000000001e-07 123.97500000000001p 8.5249169999999995e-07
+ 123.98750000000001p 8.7136060000000005e-07 124.00000000000001p 8.8910439999999996e-07 124.01249999999999p 9.0570189999999997e-07 124.02499999999999p 9.2113350000000003e-07 124.03749999999999p 9.3538049999999996e-07 124.05p 9.4842590000000003e-07 124.0625p 9.6025369999999991e-07 124.075p 9.7084960000000002e-07 124.08750000000001p 9.8020050000000007e-07 124.09999999999999p 9.88295e-07 124.1125p 9.9512300000000001e-07 124.125p 1.000676e-06 124.1375p 1.0049469999999999e-06 124.15000000000001p 1.0079319999999999e-06 124.16250000000001p 1.0096250000000001e-06 124.17499999999998p 1.0100259999999999e-06 124.18749999999999p 1.0091340000000001e-06 124.19999999999999p 1.006951e-06
+ 124.21250000000001p 1.0034790000000001e-06 124.22500000000001p 9.9872459999999994e-07 124.23750000000001p 9.9269319999999994e-07 124.25000000000001p 9.8539380000000008e-07 124.26249999999999p 9.7683670000000005e-07 124.27499999999999p 9.6703370000000008e-07 124.28749999999999p 9.5599890000000007e-07 124.3p 9.4374780000000003e-07 124.3125p 9.3029779999999997e-07 124.325p 9.1566809999999998e-07 124.33750000000001p 8.9987950000000002e-07 124.34999999999999p 8.829548e-07 124.3625p 8.6491820000000003e-07 124.375p 8.4579580000000003e-07 124.3875p 8.2561519999999996e-07 124.40000000000001p 8.0440589999999999e-07 124.41250000000001p 7.8219860000000001e-07 124.42500000000001p 7.5902580000000005e-07
+ 124.43749999999999p 7.3492150000000001e-07 124.44999999999999p 7.0992100000000002e-07 124.46249999999999p 6.8406120000000001e-07 124.47500000000001p 6.5738009999999997e-07 124.48750000000001p 6.2991720000000003e-07 124.50000000000001p 6.0171320000000002e-07 124.51249999999999p 5.7280989999999996e-07 124.52499999999999p 5.4325029999999997e-07 124.53749999999999p 5.1307829999999996e-07 124.55p 4.8233879999999995e-07 124.5625p 4.5107770000000001e-07 124.575p 4.1934159999999998e-07 124.58750000000001p 3.8717790000000001e-07 124.59999999999999p 3.5463450000000001e-07 124.6125p 3.2176019999999998e-07 124.625p 2.8860389999999999e-07 124.6375p 2.5521509999999999e-07 124.65000000000001p 2.2164380000000001e-07
+ 124.66250000000001p 1.8793990000000001e-07 124.67500000000001p 1.5415369999999999e-07 124.68749999999999p 1.2033550000000001e-07 124.69999999999999p 8.6535490000000004e-08 124.71249999999999p 5.2803889999999999e-08 124.72499999999999p 1.919066e-08 124.73750000000001p -1.4254470000000001e-08 124.75000000000001p -4.7482190000000002e-08 124.76250000000002p -8.0443559999999994e-08 124.77499999999999p -1.130902e-07 124.78749999999999p -1.4537440000000001e-07 124.8p -1.77249e-07 124.8125p -2.086676e-07 124.825p -2.3958479999999997e-07 124.83750000000001p -2.699561e-07 124.84999999999999p -2.9973769999999998e-07 124.8625p -3.2888719999999998e-07 124.875p -3.5736319999999998e-07
+ 124.8875p -3.8512530000000001e-07 124.90000000000001p -4.1213469999999997e-07 124.91250000000001p -4.3835359999999999e-07 124.92500000000001p -4.6374570000000003e-07 124.93749999999999p -4.8827620000000001e-07 124.94999999999999p -5.1191159999999996e-07 124.96249999999999p -5.346201e-07 124.97499999999999p -5.5637120000000001e-07 124.9875p -5.7713639999999996e-07 125.00000000000001p -5.9688849999999995e-07 125.01250000000002p -6.1560220000000002e-07 125.02499999999999p -6.3325370000000001e-07 125.03749999999999p -6.4982129999999998e-07 125.05p -6.6528469999999999e-07 125.0625p -6.7962569999999997e-07 125.075p -6.9282769999999996e-07 125.08750000000001p -7.0487599999999999e-07 125.10000000000001p -7.1575789999999995e-07
+ 125.1125p -7.2546239999999996e-07 125.125p -7.3398040000000003e-07 125.1375p -7.413047e-07 125.15000000000001p -7.4743009999999996e-07 125.16250000000001p -7.5235310000000001e-07 125.17500000000001p -7.5607209999999996e-07 125.18749999999999p -7.5858760000000005e-07 125.19999999999999p -7.599016e-07 125.21249999999999p -7.6001819999999998e-07 125.22499999999999p -7.5894340000000004e-07 125.2375p -7.5668480000000002e-07 125.25p -7.5325189999999996e-07 125.26250000000002p -7.4865610000000002e-07 125.27499999999999p -7.429103e-07 125.28749999999999p -7.3602930000000001e-07 125.3p -7.2802970000000001e-07 125.3125p -7.1892949999999998e-07 125.325p -7.0874849999999995e-07
+ 125.33750000000001p -6.97508e-07 125.35000000000001p -6.8523109999999997e-07 125.36249999999998p -6.7194199999999997e-07 125.375p -6.5766680000000002e-07 125.3875p -6.4243279999999996e-07 125.40000000000001p -6.2626859999999996e-07 125.41250000000001p -6.0920429999999996e-07 125.42500000000001p -5.9127130000000003e-07 125.43750000000001p -5.7250199999999997e-07 125.44999999999999p -5.5293030000000004e-07 125.46249999999999p -5.3259090000000002e-07 125.47499999999999p -5.1151989999999997e-07 125.4875p -4.8975399999999995e-07 125.5p -4.6733110000000001e-07 125.5125p -4.4428990000000002e-07 125.52499999999999p -4.2067010000000001e-07 125.53749999999999p -3.9651190000000001e-07 125.55p -3.7185619999999998e-07
+ 125.5625p -3.467447e-07 125.575p -3.212195e-07 125.58750000000001p -2.9532319999999999e-07 125.60000000000001p -2.6909900000000002e-07 125.61249999999998p -2.425901e-07 125.62499999999999p -2.1584019999999999e-07 125.6375p -1.888933e-07 125.65000000000001p -1.617933e-07 125.66250000000001p -1.3458419999999999e-07 125.67500000000001p -1.073101e-07 125.68750000000001p -8.0014949999999996e-08 125.69999999999999p -5.2742560000000003e-08 125.71249999999999p -2.5536489999999999e-08 125.72499999999999p 1.5599770000000001e-09 125.7375p 2.8503949999999999e-08 125.75p 5.5252959999999999e-08 125.7625p 8.1765059999999997e-08 125.77500000000002p 1.0799889999999999e-07
+ 125.78749999999999p 1.339136e-07 125.8p 1.5946940000000001e-07 125.8125p 1.8462679999999999e-07 125.825p 2.0934749999999999e-07 125.83750000000001p 2.3359410000000001e-07 125.85000000000001p 2.573299e-07 125.86249999999998p 2.8051940000000002e-07 125.87499999999999p 3.0312820000000002e-07 125.88749999999999p 3.2512300000000002e-07 125.90000000000001p 3.4647159999999999e-07 125.91250000000001p 3.6714310000000001e-07 125.92500000000001p 3.8710799999999997e-07 125.93750000000001p 4.0633789999999998e-07 125.94999999999999p 4.24806e-07 125.96249999999999p 4.4248659999999999e-07 125.97499999999999p 4.5935580000000002e-07 125.9875p 4.7539090000000001e-07 126p 4.9057090000000001e-07
+ 126.0125p 5.0487619999999998e-07 126.02500000000001p 5.1828899999999999e-07 126.03749999999999p 5.3079260000000001e-07 126.05p 5.4237249999999997e-07 126.0625p 5.5301550000000005e-07 126.075p 5.6270990000000005e-07 126.08750000000001p 5.714459e-07 126.10000000000001p 5.7921539999999996e-07 126.11249999999998p 5.8601160000000002e-07 126.12499999999999p 5.918296e-07 126.13749999999999p 5.9666620000000004e-07 126.15000000000001p 6.005197e-07 126.16250000000001p 6.0338999999999995e-07 126.17500000000001p 6.0527880000000002e-07 126.18750000000001p 6.0618909999999997e-07 126.19999999999999p 6.061258e-07 126.21249999999999p 6.0509510000000005e-07 126.22499999999999p 6.0310489999999998e-07
+ 126.2375p 6.0016440000000002e-07 126.25p 5.9628459999999995e-07 126.2625p 5.9147760000000003e-07 126.27500000000001p 5.8575700000000005e-07 126.28749999999999p 5.7913790000000004e-07 126.3p 5.7163650000000001e-07 126.3125p 5.6327039999999996e-07 126.325p 5.5405839999999999e-07 126.33750000000001p 5.4402059999999998e-07 126.35000000000001p 5.3317790000000002e-07 126.36250000000001p 5.215528e-07 126.37499999999999p 5.0916830000000003e-07 126.38749999999999p 4.9604870000000005e-07 126.39999999999999p 4.8221909999999995e-07 126.41250000000001p 4.6770560000000002e-07 126.42500000000001p 4.5253500000000002e-07 126.43750000000001p 4.3673480000000002e-07 126.44999999999999p 4.203334e-07
+ 126.46249999999999p 4.0335960000000001e-07 126.47499999999999p 3.858429e-07 126.4875p 3.678135e-07 126.5p 3.4930170000000001e-07 126.5125p 3.303384e-07 126.52500000000001p 3.109549e-07 126.53749999999999p 2.9118279999999998e-07 126.55p 2.710538e-07 126.5625p 2.5059989999999999e-07 126.575p 2.2985299999999999e-07 126.58750000000001p 2.088455e-07 126.60000000000001p 1.8760939999999999e-07 126.61250000000001p 1.661769e-07 126.62499999999999p 1.445799e-07 126.63749999999999p 1.2285050000000001e-07 126.64999999999999p 1.010203e-07 126.66249999999999p 7.9120790000000003e-08 126.67500000000001p 5.7183189999999998e-08
+ 126.68750000000001p 3.5238380000000003e-08 126.70000000000002p 1.3316890000000001e-08 126.71249999999999p -8.5511649999999996e-09 126.72499999999999p -3.03361e-08 126.7375p -5.2008700000000003e-08 126.75p -7.3540290000000002e-08 126.7625p -9.4902720000000003e-08 126.77500000000001p -1.160684e-07 126.78749999999999p -1.370104e-07 126.8p -1.5770229999999999e-07 126.8125p -1.7811849999999999e-07 126.825p -1.9823390000000001e-07 126.83750000000001p -2.1802439999999999e-07 126.85000000000001p -2.3746610000000001e-07 126.86250000000001p -2.5653640000000001e-07 126.87499999999999p -2.752132e-07 126.88749999999999p -2.9347500000000003e-07 126.89999999999999p -3.1130139999999998e-07
+ 126.91249999999999p -3.2867250000000001e-07 126.925p -3.4556949999999998e-07 126.93750000000001p -3.619741e-07 126.95000000000002p -3.778691e-07 126.96249999999999p -3.9323780000000001e-07 126.97499999999999p -4.0806460000000003e-07 126.9875p -4.2233450000000002e-07 127p -4.360336e-07 127.0125p -4.4914839999999999e-07 127.02500000000001p -4.6166670000000002e-07 127.03750000000001p -4.7357680000000002e-07 127.05p -4.8486779999999999e-07 127.0625p -4.9552979999999995e-07 127.075p -5.0555360000000001e-07 127.08750000000001p -5.1493059999999997e-07 127.10000000000001p -5.2365340000000001e-07 127.11250000000001p -5.3171509999999996e-07 127.12499999999999p -5.391095e-07
+ 127.13749999999999p -5.4583129999999996e-07 127.14999999999999p -5.5187609999999998e-07 127.16249999999999p -5.5723990000000004e-07 127.175p -5.6191969999999996e-07 127.1875p -5.6591310000000004e-07 127.20000000000002p -5.6921840000000003e-07 127.21249999999999p -5.7183460000000002e-07 127.22499999999999p -5.7376159999999995e-07 127.2375p -5.7499969999999997e-07 127.25p -5.755499e-07 127.2625p -5.7541410000000004e-07 127.27500000000001p -5.7459450000000003e-07 127.28750000000001p -5.7309430000000004e-07 127.29999999999998p -5.7091699999999995e-07 127.3125p -5.6806699999999995e-07 127.325p -5.6454900000000003e-07 127.33750000000001p -5.6036859999999998e-07 127.35000000000001p -5.5553170000000002e-07
+ 127.36250000000001p -5.5004510000000004e-07 127.37500000000001p -5.4391580000000003e-07 127.38749999999999p -5.3715170000000004e-07 127.39999999999999p -5.2976099999999998e-07 127.41249999999999p -5.2175249999999999e-07 127.425p -5.1313570000000002e-07 127.4375p -5.0392019999999996e-07 127.45p -4.9411669999999997e-07 127.46249999999999p -4.8373590000000002e-07 127.47499999999999p -4.727892e-07 127.4875p -4.6128839999999999e-07 127.5p -4.4924600000000002e-07 127.5125p -4.3667470000000001e-07 127.52500000000001p -4.235879e-07 127.53750000000001p -4.0999910000000001e-07 127.54999999999998p -3.9592249999999998e-07 127.56249999999999p -3.8137290000000002e-07 127.575p -3.6636509999999998e-07
+ 127.58750000000001p -3.5091460000000002e-07 127.60000000000001p -3.3503720000000002e-07 127.61250000000001p -3.1874909999999998e-07 127.62500000000001p -3.0206710000000002e-07 127.63749999999999p -2.8500799999999998e-07 127.64999999999999p -2.6758919999999999e-07 127.66249999999999p -2.4982839999999997e-07 127.675p -2.3174359999999999e-07 127.6875p -2.1335329999999999e-07 127.7p -1.9467610000000001e-07 127.71250000000001p -1.7573109999999999e-07 127.72499999999999p -1.5653739999999999e-07 127.7375p -1.3711480000000001e-07 127.75p -1.1748299999999999e-07 127.7625p -9.7662209999999999e-08 127.77500000000001p -7.7672640000000001e-08 127.78750000000001p -5.7534889999999997e-08 127.79999999999998p -3.7269719999999999e-08
+ 127.81249999999999p -1.6898069999999999e-08 127.82499999999999p 3.558937e-09 127.83750000000001p 2.4080030000000001e-08 127.85000000000001p 4.4643809999999998e-08 127.86250000000001p 6.5228729999999995e-08 127.87500000000001p 8.5813169999999997e-08 127.88749999999999p 1.0637540000000001e-07 127.89999999999999p 1.2689369999999999e-07 127.91249999999999p 1.473463e-07 127.925p 1.677112e-07 127.9375p 1.879667e-07 127.95p 2.0809100000000001e-07 127.96250000000001p 2.280623e-07 127.97499999999999p 2.4785889999999998e-07 127.9875p 2.674592e-07 128p 2.8684180000000001e-07 128.01249999999999p 3.0598510000000002e-07 128.02500000000001p 3.2486820000000001e-07
+ 128.03750000000002p 3.4346980000000001e-07 128.05000000000001p 3.617692e-07 128.0625p 3.797459e-07 128.07499999999999p 3.9737940000000002e-07 128.08750000000001p 4.1464969999999999e-07 128.09999999999999p 4.3153699999999998e-07 128.11250000000001p 4.4802190000000002e-07 128.125p 4.6408519999999997e-07 128.13749999999999p 4.7970820000000003e-07 128.15000000000001p 4.948725e-07 128.16249999999999p 5.095602e-07 128.17500000000001p 5.2375379999999998e-07 128.1875p 5.374363e-07 128.20000000000002p 5.5059089999999999e-07 128.21250000000001p 5.6320169999999999e-07 128.22499999999999p 5.7525310000000004e-07 128.23749999999998p 5.8673009999999995e-07 128.25p 5.9761810000000002e-07
+ 128.26249999999999p 6.0790339999999998e-07 128.27500000000001p 6.1757260000000005e-07 128.28749999999999p 6.2661310000000005e-07 128.30000000000001p 6.3501280000000001e-07 128.3125p 6.427603e-07 128.32499999999999p 6.4984490000000004e-07 128.33750000000001p 6.5625659999999998e-07 128.34999999999999p 6.6198609999999995e-07 128.36250000000001p 6.6702460000000001e-07 128.375p 6.7136439999999997e-07 128.38750000000002p 6.7499820000000003e-07 128.39999999999998p 6.7791959999999995e-07 128.41249999999999p 6.8012299999999996e-07 128.42500000000001p 6.8160340000000001e-07 128.4375p 6.8235689999999996e-07 128.45000000000002p 6.8238e-07 128.46250000000001p 6.8167019999999997e-07 128.47499999999999p 6.802259e-07
+ 128.48749999999998p 6.7804609999999995e-07 128.5p 6.7513069999999998e-07 128.51249999999999p 6.714804e-07 128.52500000000001p 6.6709679999999997e-07 128.53749999999999p 6.6198219999999999e-07 128.55000000000001p 6.5613989999999995e-07 128.5625p 6.4957380000000003e-07 128.57499999999999p 6.422888e-07 128.58750000000001p 6.3429040000000002e-07 128.59999999999999p 6.2558530000000003e-07 128.61250000000001p 6.1618059999999996e-07 128.625p 6.0608439999999996e-07 128.63750000000002p 5.9530569999999997e-07 128.64999999999998p 5.8385409999999997e-07 128.66249999999999p 5.7174009999999995e-07 128.67500000000001p 5.5897500000000001e-07 128.6875p 5.4557079999999997e-07 128.70000000000002p 5.3154040000000003e-07
+ 128.71250000000001p 5.1689719999999998e-07 128.72499999999999p 5.0165550000000004e-07 128.73749999999998p 4.8583040000000002e-07 128.75p 4.6943759999999998e-07 128.76249999999999p 4.5249359999999998e-07 128.77500000000001p 4.3501529999999998e-07 128.78749999999999p 4.1702070000000001e-07 128.80000000000001p 3.985281e-07 128.8125p 3.795565e-07 128.82499999999999p 3.6012579999999999e-07 128.83750000000001p 3.40256e-07 128.84999999999999p 3.1996820000000001e-07 128.86250000000001p 2.9928350000000001e-07 128.875p 2.7822410000000001e-07 128.88750000000002p 2.5681220000000002e-07 128.89999999999998p 2.3507079999999999e-07 128.91249999999999p 2.1302340000000001e-07 128.92499999999998p 1.906936e-07
+ 128.9375p 1.681058e-07 128.95000000000002p 1.4528439999999999e-07 128.96250000000001p 1.2225460000000001e-07 128.97500000000002p 9.9041609999999996e-08 128.98749999999998p 7.5670990000000007e-08 129p 5.2168670000000003e-08 129.01249999999999p 2.856077e-08 129.02500000000001p 4.8736369999999996e-09 129.03749999999999p -1.8866179999999999e-08 129.05000000000001p -4.2631989999999998e-08 129.0625p -6.639695e-08 129.07499999999999p -9.0134139999999997e-08 129.08750000000001p -1.138166e-07 129.09999999999999p -1.374172e-07 129.11250000000001p -1.6090890000000001e-07 129.125p -1.842649e-07 129.13750000000002p -2.07458e-07 129.14999999999998p -2.3046140000000001e-07
+ 129.16249999999999p -2.5324849999999998e-07 129.17499999999998p -2.7579260000000002e-07 129.1875p -2.9806730000000002e-07 129.20000000000002p -3.2004650000000002e-07 129.21250000000001p -3.4170419999999998e-07 129.22500000000002p -3.6301480000000001e-07 129.23749999999998p -3.8395310000000002e-07 129.25p -4.0449409999999999e-07 129.26249999999999p -4.246132e-07 129.27500000000001p -4.442862e-07 129.28749999999999p -4.6348950000000002e-07 129.30000000000001p -4.8219980000000003e-07 129.3125p -5.0039449999999996e-07 129.32499999999999p -5.1805139999999995e-07 129.33750000000001p -5.3514879999999996e-07 129.34999999999999p -5.5166590000000002e-07 129.36250000000001p -5.6758219999999999e-07 129.375p -5.8287799999999999e-07
+ 129.38750000000002p -5.9753439999999995e-07 129.39999999999998p -6.1153309999999999e-07 129.41249999999999p -6.2485660000000005e-07 129.42499999999998p -6.3748800000000002e-07 129.4375p -6.4941140000000004e-07 129.44999999999999p -6.6061169999999996e-07 129.46250000000001p -6.7107449999999995e-07 129.47500000000002p -6.8078649999999995e-07 129.48749999999998p -6.8973499999999995e-07 129.5p -6.9790850000000005e-07 129.51249999999999p -7.0529609999999998e-07 129.52500000000001p -7.1188830000000003e-07 129.53749999999999p -7.1767610000000005e-07 129.55000000000001p -7.226517e-07 129.5625p -7.2680839999999995e-07 129.57499999999999p -7.3014029999999998e-07 129.58750000000001p -7.3264260000000004e-07 129.59999999999999p -7.3431169999999999e-07
+ 129.61250000000001p -7.3514470000000001e-07 129.625p -7.3514e-07 129.63750000000002p -7.3429700000000003e-07 129.65000000000001p -7.3261610000000005e-07 129.66249999999999p -7.3009899999999998e-07 129.67499999999998p -7.267482e-07 129.6875p -7.225672e-07 129.69999999999999p -7.17561e-07 129.71250000000001p -7.1173530000000004e-07 129.72500000000002p -7.0509679999999997e-07 129.73749999999998p -6.9765369999999998e-07 129.75p -6.8941469999999998e-07 129.76249999999999p -6.8039000000000002e-07 129.77500000000001p -6.7059050000000004e-07 129.78749999999999p -6.6002829999999999e-07 129.80000000000001p -6.4871649999999996e-07 129.8125p -6.3666899999999997e-07 129.82499999999999p -6.23901e-07
+ 129.83750000000001p -6.1042840000000001e-07 129.84999999999999p -5.9626799999999998e-07 129.86250000000001p -5.8143770000000002e-07 129.875p -5.6595630000000005e-07 129.88750000000002p -5.4984320000000002e-07 129.90000000000001p -5.3311889999999998e-07 129.91249999999999p -5.1580450000000002e-07 129.92499999999998p -4.9792219999999999e-07 129.9375p -4.7949449999999998e-07 129.94999999999999p -4.6054509999999999e-07 129.96250000000001p -4.41098e-07 129.97500000000002p -4.2117810000000001e-07 129.98750000000001p -4.0081079999999999e-07 130p -3.8002209999999998e-07 130.01249999999999p -3.5883860000000001e-07 130.02500000000001p -3.3728730000000002e-07 130.03749999999999p -3.1539579999999999e-07 130.05000000000001p -2.93192e-07
+ 130.0625p -2.7070429999999999e-07 130.07499999999999p -2.479614e-07 130.08750000000001p -2.2499230000000001e-07 130.09999999999999p -2.0182620000000001e-07 130.11250000000001p -1.7849270000000001e-07 130.125p -1.550213e-07 130.13750000000002p -1.3144199999999999e-07 130.15000000000001p -1.0778449999999999e-07 130.16249999999999p -8.4078850000000006e-08 130.17499999999998p -6.0354880000000002e-08 130.1875p -3.6642490000000002e-08 130.19999999999999p -1.297148e-08 130.21250000000001p 1.062851e-08 130.22499999999999p 3.4128010000000003e-08 130.23750000000001p 5.7497750000000003e-08 130.25p 8.0708760000000001e-08 130.26249999999999p 1.037323e-07 130.27500000000001p 1.265402e-07
+ 130.28749999999999p 1.4910430000000001e-07 130.30000000000001p 1.7139730000000001e-07 130.3125p 1.9339199999999999e-07 130.32500000000002p 2.150619e-07 130.33749999999998p 2.363811e-07 130.34999999999999p 2.5732420000000002e-07 130.36250000000001p 2.7786630000000001e-07 130.375p 2.9798340000000002e-07 130.38750000000002p 3.1765209999999998e-07 130.40000000000001p 3.3684959999999998e-07 130.41249999999999p 3.5555399999999998e-07 130.42499999999998p 3.737442e-07 130.4375p 3.9139979999999999e-07 130.44999999999999p 4.085012e-07 130.46250000000001p 4.250299e-07 130.47499999999999p 4.4096800000000001e-07 130.48750000000001p 4.5629870000000003e-07 130.5p 4.7100610000000002e-07
+ 130.51249999999999p 4.8507519999999995e-07 130.52500000000001p 4.9849199999999996e-07 130.53749999999999p 5.1124350000000001e-07 130.55000000000001p 5.2331760000000003e-07 130.5625p 5.3470330000000005e-07 130.57500000000002p 5.4539059999999999e-07 130.58749999999998p 5.5537050000000004e-07 130.59999999999999p 5.6463499999999997e-07 130.61250000000001p 5.7317719999999996e-07 130.625p 5.8099119999999998e-07 130.63750000000002p 5.8807219999999998e-07 130.65000000000001p 5.9441639999999996e-07 130.66250000000002p 6.0002089999999998e-07 130.67499999999998p 6.0488400000000001e-07 130.6875p 6.0900509999999999e-07 130.69999999999999p 6.1238440000000001e-07 130.71250000000001p 6.1502320000000002e-07 130.72499999999999p 6.1692389999999995e-07
+ 130.73750000000001p 6.1808969999999997e-07 130.75p 6.185249e-07 130.76249999999999p 6.1823469999999995e-07 130.77500000000001p 6.1722540000000002e-07 130.78749999999999p 6.1550399999999998e-07 130.80000000000001p 6.1307850000000005e-07 130.8125p 6.099578e-07 130.82500000000002p 6.0615170000000004e-07 130.83749999999998p 6.0167070000000001e-07 130.84999999999999p 5.9652630000000003e-07 130.86249999999998p 5.9073059999999995e-07 130.875p 5.8429669999999995e-07 130.88750000000002p 5.7723820000000003e-07 130.90000000000001p 5.6956959999999996e-07 130.91250000000002p 5.6130590000000004e-07 130.92499999999998p 5.5246300000000004e-07 130.9375p 5.430572e-07 130.94999999999999p 5.3310540000000003e-07
+ 130.96250000000001p 5.2262529999999996e-07 130.97499999999999p 5.1163489999999997e-07 130.98750000000001p 5.0015279999999998e-07 131p 4.8819790000000005e-07 131.01249999999999p 4.7578990000000001e-07 131.02500000000001p 4.6294850000000001e-07 131.03749999999999p 4.496941e-07 131.05000000000001p 4.3604710000000001e-07 131.0625p 4.2202859999999998e-07 131.07500000000002p 4.0765960000000002e-07 131.08749999999998p 3.9296159999999997e-07 131.09999999999999p 3.7795610000000002e-07 131.11249999999998p 3.6266489999999998e-07 131.125p 3.4710999999999999e-07 131.13750000000002p 3.3131340000000002e-07 131.15000000000001p 3.1529699999999999e-07 131.16250000000002p 2.9908320000000002e-07 131.17499999999998p 2.826941e-07
+ 131.1875p 2.6615160000000002e-07 131.19999999999999p 2.4947799999999998e-07 131.21250000000001p 2.3269530000000001e-07 131.22499999999999p 2.158252e-07 131.23750000000001p 1.9888949999999999e-07 131.25p 1.819099e-07 131.26249999999999p 1.6490770000000001e-07 131.27500000000001p 1.4790390000000001e-07 131.28749999999999p 1.3091959999999999e-07 131.30000000000001p 1.139754e-07 131.3125p 9.7091510000000003e-08 131.32500000000002p 8.0287969999999994e-08 131.33749999999998p 6.3584429999999994e-08 131.34999999999999p 4.7000140000000002e-08 131.36249999999998p 3.0553979999999997e-08 131.375p 1.42644e-08 131.38749999999999p -1.850598e-09 131.40000000000001p -1.7773440000000001e-08
+ 131.41250000000002p -3.348706e-08 131.42499999999998p -4.8974869999999998e-08 131.4375p -6.4220789999999996e-08 131.44999999999999p -7.9209259999999995e-08 131.46250000000001p -9.3925300000000005e-08 131.47499999999999p -1.083544e-07 131.48750000000001p -1.2248279999999999e-07 131.5p -1.3629710000000001e-07 131.51249999999999p -1.4978459999999999e-07 131.52500000000001p -1.629332e-07 131.53749999999999p -1.757314e-07 131.55000000000001p -1.8816839999999999e-07 131.5625p -2.0023380000000001e-07 131.57500000000002p -2.119181e-07 131.58750000000001p -2.232124e-07 131.59999999999999p -2.3410820000000001e-07 131.61249999999998p -2.4459790000000001e-07 131.625p -2.5467440000000002e-07
+ 131.63749999999999p -2.6433139999999998e-07 131.65000000000001p -2.73563e-07 131.66250000000002p -2.8236429999999998e-07 131.67499999999998p -2.907308e-07 131.6875p -2.9865860000000001e-07 131.69999999999999p -3.0614449999999998e-07 131.71250000000001p -3.131861e-07 131.72499999999999p -3.1978150000000001e-07 131.73750000000001p -3.2592930000000001e-07 131.75p -3.3162889999999999e-07 131.76249999999999p -3.3688020000000002e-07 131.77500000000001p -3.416837e-07 131.78749999999999p -3.460406e-07 131.80000000000001p -3.499525e-07 131.8125p -3.5342170000000002e-07 131.82500000000002p -3.5645100000000002e-07 131.83750000000001p -3.5904369999999999e-07 131.84999999999999p -3.6120370000000001e-07
+ 131.86249999999998p -3.6293529999999999e-07 131.875p -3.6424329999999999e-07 131.88749999999999p -3.651332e-07 131.90000000000001p -3.6561060000000001e-07 131.91249999999999p -3.6568179999999999e-07 131.92500000000001p -3.6535350000000002e-07 131.9375p -3.646327e-07 131.94999999999999p -3.6352680000000001e-07 131.96250000000001p -3.6204360000000001e-07 131.97499999999999p -3.601913e-07 131.98750000000001p -3.5797830000000001e-07 132p -3.5541339999999998e-07 132.01249999999999p -3.525056e-07 132.02499999999998p -3.4926440000000002e-07 132.03749999999999p -3.4569919999999999e-07 132.05000000000001p -3.4181989999999998e-07 132.0625p -3.3763650000000001e-07 132.07500000000002p -3.3315910000000002e-07
+ 132.08750000000001p -3.2839819999999998e-07 132.09999999999999p -3.233641e-07 132.11249999999998p -3.1806760000000002e-07 132.125p -3.125193e-07 132.13749999999999p -3.0673009999999999e-07 132.15000000000001p -3.0071079999999999e-07 132.16249999999999p -2.9447239999999999e-07 132.17500000000001p -2.8802569999999998e-07 132.1875p -2.8138180000000001e-07 132.19999999999999p -2.7455170000000001e-07 132.21250000000001p -2.6754620000000002e-07 132.22499999999999p -2.6037619999999999e-07 132.23750000000001p -2.5305260000000001e-07 132.25p -2.455862e-07 132.26250000000002p -2.379876e-07 132.27499999999998p -2.302674e-07 132.28749999999999p -2.224362e-07 132.30000000000001p -2.1450420000000001e-07
+ 132.3125p -2.064818e-07 132.32500000000002p -1.9837889999999999e-07 132.33750000000001p -1.9020549999999999e-07 132.34999999999999p -1.819714e-07 132.36249999999998p -1.736862e-07 132.375p -1.6535929999999999e-07 132.38749999999999p -1.569999e-07 132.40000000000001p -1.4861710000000001e-07 132.41249999999999p -1.4021980000000001e-07 132.42500000000001p -1.3181650000000001e-07 132.4375p -1.2341579999999999e-07 132.44999999999999p -1.150259e-07 132.46250000000001p -1.066548e-07 132.47499999999999p -9.8310370000000004e-08 132.48750000000001p -9.0000239999999996e-08 132.5p -8.1731799999999996e-08 132.51250000000002p -7.3512270000000003e-08 132.52499999999998p -6.5348640000000003e-08
+ 132.53749999999999p -5.7247700000000001e-08 132.55000000000001p -4.9216040000000002e-08 132.5625p -4.1260059999999999e-08 132.57500000000002p -3.3385930000000003e-08 132.58750000000001p -2.5599659999999998e-08 132.60000000000002p -1.7907059999999999e-08 132.61249999999998p -1.031375e-08 132.625p -2.8251560000000002e-09 132.63749999999999p 4.5534440000000004e-09 132.65000000000001p 1.181696e-08 132.66249999999999p 1.896047e-08 132.67500000000001p 2.5979220000000001e-08 132.6875p 3.286858e-08 132.69999999999999p 3.9624120000000003e-08 132.71250000000001p 4.6241519999999997e-08 132.72499999999999p 5.2716610000000003e-08 132.73750000000001p 5.9045359999999999e-08 132.75p 6.5223880000000004e-08
+ 132.76250000000002p 7.1248390000000002e-08 132.77499999999998p 7.7115250000000006e-08 132.78749999999999p 8.2820929999999995e-08 132.79999999999998p 8.836202e-08 132.8125p 9.3735220000000003e-08 132.82500000000002p 9.893733e-08 132.83750000000001p 1.0396529999999999e-07 132.85000000000002p 1.0881610000000001e-07 132.86249999999998p 1.134869e-07 132.875p 1.179749e-07 132.88749999999999p 1.2227749999999999e-07 132.90000000000001p 1.2639200000000001e-07 132.91249999999999p 1.3031610000000001e-07 132.92500000000001p 1.3404730000000001e-07 132.9375p 1.3758339999999999e-07 132.94999999999999p 1.409223e-07 132.96250000000001p 1.440618e-07 132.97499999999999p 1.470001e-07
+ 132.98750000000001p 1.4973540000000001e-07 133p 1.522659e-07 133.01250000000002p 1.545901e-07 133.02499999999998p 1.5670649999999999e-07 133.03749999999999p 1.5861369999999999e-07 133.04999999999998p 1.6031070000000001e-07 133.0625p 1.617963e-07 133.07500000000002p 1.6306980000000001e-07 133.08750000000001p 1.6413020000000001e-07 133.10000000000002p 1.649771e-07 133.11249999999998p 1.6561000000000001e-07 133.125p 1.660288e-07 133.13749999999999p 1.6623330000000001e-07 133.15000000000001p 1.6622380000000001e-07 133.16249999999999p 1.660004e-07 133.17500000000001p 1.6556389999999999e-07 133.1875p 1.649149e-07 133.19999999999999p 1.6405439999999999e-07
+ 133.21250000000001p 1.6298350000000001e-07 133.22499999999999p 1.6170379999999999e-07 133.23750000000001p 1.6021689999999999e-07 133.25p 1.585247e-07 133.26250000000002p 1.566293e-07 133.27500000000001p 1.5453320000000001e-07 133.28749999999999p 1.5223910000000001e-07 133.29999999999998p 1.4974979999999999e-07 133.3125p 1.4706860000000001e-07 133.32499999999999p 1.4419900000000001e-07 133.33750000000001p 1.411448e-07 133.35000000000002p 1.379099e-07 133.36249999999998p 1.3449880000000001e-07 133.375p 1.3091589999999999e-07 133.38749999999999p 1.2716629999999999e-07 133.40000000000001p 1.23255e-07 133.41249999999999p 1.1918749999999999e-07 133.42500000000001p 1.1496959999999999e-07
+ 133.4375p 1.106072e-07 133.44999999999999p 1.061067e-07 133.46250000000001p 1.014745e-07 133.47499999999999p 9.6717470000000003e-08 133.48750000000001p 9.1842710000000004e-08 133.5p 8.6857499999999995e-08 133.51250000000002p 8.1769419999999997e-08 133.52500000000001p 7.6586250000000002e-08 133.53749999999999p 7.1316030000000004e-08 133.54999999999998p 6.5966980000000005e-08 133.5625p 6.0547559999999999e-08 133.57499999999999p 5.506638e-08 133.58750000000001p 4.953228e-08 133.60000000000002p 4.3954240000000001e-08 133.61249999999998p 3.8341380000000001e-08 133.625p 3.2702999999999998e-08 133.63749999999999p 2.7048489999999999e-08 133.65000000000001p 2.138737e-08
+ 133.66249999999999p 1.5729249999999998e-08 133.67500000000001p 1.008379e-08 133.6875p 4.4607480000000001e-09 133.69999999999999p -1.1300969999999999e-09 133.71250000000001p -6.6789399999999997e-09 133.72499999999999p -1.217597e-08 133.73750000000001p -1.761138e-08 133.75p -2.297542e-08 133.76250000000002p -2.825836e-08 133.77500000000001p -3.3450550000000002e-08 133.78749999999999p -3.854245e-08 133.79999999999998p -4.3524599999999999e-08 133.8125p -4.8387689999999997e-08 133.82499999999999p -5.3122530000000001e-08 133.83750000000001p -5.7720120000000002e-08 133.84999999999999p -6.217164e-08 133.86250000000001p -6.6468459999999998e-08 133.875p -7.060219e-08
+ 133.88749999999999p -7.456467e-08 133.90000000000001p -7.8347989999999998e-08 133.91249999999999p -8.1944520000000003e-08 133.92500000000001p -8.5346930000000001e-08 133.9375p -8.8548189999999994e-08 133.94999999999999p -9.1541589999999995e-08 133.96249999999998p -9.4320749999999994e-08 133.97499999999999p -9.6879679999999995e-08 133.98750000000001p -9.9212709999999997e-08 134p -1.013146e-07 134.01250000000002p -1.031804e-07 134.02500000000001p -1.048057e-07 134.03749999999999p -1.061864e-07 134.04999999999998p -1.073189e-07 134.0625p -1.082e-07 134.07499999999999p -1.0882689999999999e-07 134.08750000000001p -1.091973e-07 134.09999999999999p -1.093094e-07
+ 134.11250000000001p -1.091618e-07 134.125p -1.087535e-07 134.13749999999999p -1.080841e-07 134.15000000000001p -1.071536e-07 134.16249999999999p -1.0596249999999999e-07 134.17500000000001p -1.045119e-07 134.1875p -1.028031e-07 134.20000000000002p -1.0083800000000001e-07 134.21249999999998p -9.8619160000000003e-08 134.22499999999999p -9.6149379999999998e-08 134.23750000000001p -9.3432020000000006e-08 134.25p -9.0470899999999998e-08 134.26250000000002p -8.7270290000000006e-08 134.27500000000001p -8.3834940000000003e-08 134.28749999999999p -8.0170020000000002e-08 134.29999999999998p -7.6281160000000005e-08 134.3125p -7.2174400000000003e-08 134.32499999999999p -6.7856240000000006e-08
+ 134.33750000000001p -6.3333549999999999e-08 134.34999999999999p -5.8613629999999999e-08 134.36250000000001p -5.370416e-08 134.375p -4.8613199999999998e-08 134.38749999999999p -4.3349190000000001e-08 134.40000000000001p -3.7920880000000001e-08 134.41249999999999p -3.2337409999999999e-08 134.42500000000001p -2.66082e-08 134.4375p -2.0743009999999999e-08 134.45000000000002p -1.475187e-08 134.46249999999998p -8.6450820000000003e-09 134.47499999999999p -2.4332230000000001e-09 134.48749999999998p 3.872901e-09 134.5p 1.026226e-08 134.51250000000002p 1.6723619999999999e-08 134.52500000000001p 2.324557e-08 134.53750000000002p 2.9816509999999998e-08 134.54999999999998p 3.6424729999999997e-08
+ 134.5625p 4.305835e-08 134.57499999999999p 4.9705429999999999e-08 134.58750000000001p 5.6353899999999997e-08 134.59999999999999p 6.2991659999999997e-08 134.61250000000001p 6.9606539999999995e-08 134.625p 7.618636e-08 134.63749999999999p 8.2718929999999999e-08 134.65000000000001p 8.9192069999999998e-08 134.66249999999999p 9.559366e-08 134.67500000000001p 1.019116e-07 134.6875p 1.0813399999999999e-07 134.70000000000002p 1.142488e-07 134.71249999999998p 1.202443e-07 134.72499999999999p 1.2610900000000001e-07 134.73749999999998p 1.318312e-07 134.75p 1.3739979999999999e-07 134.76250000000002p 1.4280370000000001e-07 134.77500000000001p 1.4803200000000001e-07
+ 134.78750000000002p 1.5307400000000001e-07 134.79999999999998p 1.5791960000000001e-07 134.8125p 1.6255850000000001e-07 134.82499999999999p 1.66981e-07 134.83750000000001p 1.711776e-07 134.84999999999999p 1.7513929999999999e-07 134.86250000000001p 1.788573e-07 134.875p 1.823231e-07 134.88749999999999p 1.8552880000000001e-07 134.90000000000001p 1.8846670000000001e-07 134.91249999999999p 1.9112969999999999e-07 134.92500000000001p 1.935109e-07 134.9375p 1.956041e-07 134.95000000000002p 1.9740329999999999e-07 134.96249999999998p 1.989032e-07 134.97499999999999p 2.0009880000000001e-07 134.98749999999998p 2.009856e-07 135p 2.015598e-07
+ 135.01250000000002p 2.018178e-07 135.02500000000001p 2.0175679999999999e-07 135.03750000000002p 2.0137429999999999e-07 135.04999999999998p 2.0066849999999999e-07 135.0625p 1.99638e-07 135.07499999999999p 1.98282e-07 135.08750000000001p 1.966003e-07 135.09999999999999p 1.94593e-07 135.11250000000001p 1.9226119999999999e-07 135.125p 1.8960600000000001e-07 135.13749999999999p 1.8662939999999999e-07 135.15000000000001p 1.8333399999999999e-07 135.16249999999999p 1.7972249999999999e-07 135.17500000000001p 1.757987e-07 135.1875p 1.715666e-07 135.20000000000002p 1.6703070000000001e-07 135.21250000000001p 1.6219619999999999e-07 135.22499999999999p 1.5706870000000001e-07
+ 135.23749999999998p 1.5165429999999999e-07 135.25p 1.4595969999999999e-07 135.26249999999999p 1.39992e-07 135.27500000000001p 1.3375879999999999e-07 135.28750000000002p 1.2726809999999999e-07 135.29999999999998p 1.2052849999999999e-07 135.3125p 1.1354900000000001e-07 135.32499999999999p 1.0633869999999999e-07 135.33750000000001p 9.8907699999999998e-08 135.34999999999999p 9.1265970000000002e-08 135.36250000000001p 8.3424120000000005e-08 135.375p 7.5393040000000005e-08 135.38749999999999p 6.7183969999999998e-08 135.40000000000001p 5.8808469999999997e-08 135.41249999999999p 5.027841e-08 135.42500000000001p 4.160591e-08 135.4375p 3.2803389999999998e-08 135.45000000000002p 2.388347e-08
+ 135.46250000000001p 1.4859020000000001e-08 135.47499999999999p 5.7430749999999996e-09 135.48749999999998p -3.4511310000000002e-09 135.5p -1.271023e-08 135.51249999999999p -2.2020719999999999e-08 135.52500000000001p -3.1369009999999998e-08 135.53750000000002p -4.0741400000000002e-08 135.55000000000001p -5.0124170000000001e-08 135.5625p -5.9503520000000001e-08 135.57499999999999p -6.8865690000000003e-08 135.58750000000001p -7.8196900000000003e-08 135.59999999999999p -8.7483409999999995e-08 135.61250000000001p -9.6711570000000001e-08 135.625p -1.0586779999999999e-07 135.63749999999999p -1.1493849999999999e-07 135.65000000000001p -1.2391049999999999e-07 135.66249999999999p -1.327705e-07 135.67500000000001p -1.4150550000000001e-07
+ 135.6875p -1.5010260000000001e-07 135.70000000000002p -1.5854920000000001e-07 135.71250000000001p -1.6683309999999999e-07 135.72499999999999p -1.7494189999999999e-07 135.73749999999998p -1.8286399999999999e-07 135.75p -1.9058770000000001e-07 135.76249999999999p -1.981018e-07 135.77500000000001p -2.0539539999999999e-07 135.78749999999999p -2.1245800000000001e-07 135.80000000000001p -2.1927940000000001e-07 135.8125p -2.258497e-07 135.82499999999999p -2.3215970000000001e-07 135.83750000000001p -2.3820020000000001e-07 135.84999999999999p -2.4396270000000002e-07 135.86250000000001p -2.4943910000000001e-07 135.875p -2.5462160000000002e-07 135.88750000000002p -2.5950309999999998e-07 135.89999999999998p -2.6407670000000001e-07
+ 135.91249999999999p -2.6833620000000001e-07 135.92500000000001p -2.7227570000000002e-07 135.9375p -2.7589000000000002e-07 135.95000000000002p -2.7917420000000002e-07 135.96250000000001p -2.8212399999999999e-07 135.97499999999999p -2.8473549999999998e-07 135.98749999999998p -2.8700540000000002e-07 136p -2.8893100000000001e-07 136.01249999999999p -2.9050979999999999e-07 136.02500000000001p -2.9174019999999997e-07 136.03749999999999p -2.9262080000000003e-07 136.05000000000001p -2.9315089999999998e-07 136.0625p -2.9333009999999999e-07 136.07499999999999p -2.931588e-07 136.08750000000001p -2.9263759999999998e-07 136.09999999999999p -2.9176769999999999e-07 136.11250000000001p -2.9055080000000001e-07 136.125p -2.8898910000000001e-07
+ 136.13750000000002p -2.8708530000000001e-07 136.14999999999998p -2.8484240000000003e-07 136.16249999999999p -2.8226409999999998e-07 136.17500000000001p -2.7935420000000001e-07 136.1875p -2.7611720000000002e-07 136.20000000000002p -2.7255809999999999e-07 136.21250000000001p -2.686819e-07 136.22499999999999p -2.6449450000000003e-07 136.23749999999998p -2.6000180000000002e-07 136.25p -2.552103e-07 136.26249999999999p -2.5012659999999998e-07 136.27500000000001p -2.4475799999999997e-07 136.28749999999999p -2.3911189999999999e-07 136.30000000000001p -2.3319599999999999e-07 136.3125p -2.270184e-07 136.32499999999999p -2.205875e-07 136.33750000000001p -2.1391169999999999e-07 136.34999999999999p -2.0700010000000001e-07
+ 136.36250000000001p -1.9986169999999999e-07 136.375p -1.9250569999999999e-07 136.38750000000002p -1.8494180000000001e-07 136.39999999999998p -1.771797e-07 136.41249999999999p -1.692292e-07 136.42499999999998p -1.6110030000000001e-07 136.4375p -1.528033e-07 136.45000000000002p -1.4434840000000001e-07 136.46250000000001p -1.357461e-07 136.47500000000002p -1.2700680000000001e-07 136.48749999999998p -1.181412e-07 136.5p -1.091599e-07 136.51249999999999p -1.000735e-07 136.52500000000001p -9.0892829999999997e-08 136.53749999999999p -8.1628569999999998e-08 136.55000000000001p -7.2291459999999996e-08 136.5625p -6.2892230000000005e-08 136.57499999999999p -5.3441580000000001e-08
+ 136.58750000000001p -4.3950159999999998e-08 136.59999999999999p -3.4428580000000002e-08 136.61250000000001p -2.4887389999999998e-08 136.625p -1.533704e-08 136.63750000000002p -5.7879060000000001e-09 136.64999999999998p 3.7497290000000001e-09 136.66249999999999p 1.326571e-08 136.67499999999998p 2.2749989999999999e-08 136.6875p 3.2192670000000003e-08 136.70000000000002p 4.158399e-08 136.71250000000001p 5.0914330000000001e-08 136.72500000000002p 6.0174240000000004e-08 136.73749999999998p 6.9354439999999995e-08 136.75p 7.8445830000000005e-08 136.76249999999999p 8.743948e-08 136.77500000000001p 9.6326669999999994e-08 136.78749999999999p 1.050989e-07 136.80000000000001p 1.137478e-07
+ 136.8125p 1.222652e-07 136.82499999999999p 1.3064329999999999e-07 136.83750000000001p 1.3887449999999999e-07 136.84999999999999p 1.4695119999999999e-07 136.86250000000001p 1.5486619999999999e-07 136.875p 1.6261260000000001e-07 136.88750000000002p 1.7018359999999999e-07 136.89999999999998p 1.7757269999999999e-07 136.91249999999999p 1.8477370000000001e-07 136.92499999999998p 1.9178040000000001e-07 136.9375p 1.9858730000000001e-07 136.94999999999999p 2.051887e-07 136.96250000000001p 2.1157929999999999e-07 136.97500000000002p 2.1775430000000001e-07 136.98749999999998p 2.2370870000000001e-07 137p 2.294382e-07 137.01249999999999p 2.349384e-07 137.02500000000001p 2.402053e-07
+ 137.03749999999999p 2.4523529999999999e-07 137.05000000000001p 2.5002480000000001e-07 137.0625p 2.5457059999999999e-07 137.07499999999999p 2.5886970000000001e-07 137.08750000000001p 2.6291940000000002e-07 137.09999999999999p 2.667172e-07 137.11250000000001p 2.7026079999999998e-07 137.125p 2.7354839999999998e-07 137.13750000000002p 2.76578e-07 137.15000000000001p 2.793483e-07 137.16249999999999p 2.8185800000000001e-07 137.17499999999998p 2.8410600000000002e-07 137.1875p 2.8609160000000002e-07 137.19999999999999p 2.8781420000000002e-07 137.21250000000001p 2.8927359999999998e-07 137.22500000000002p 2.9046960000000001e-07 137.23749999999998p 2.9140230000000001e-07 137.25p 2.9207209999999999e-07
+ 137.26249999999999p 2.9247970000000001e-07 137.27500000000001p 2.9262580000000001e-07 137.28749999999999p 2.9251130000000002e-07 137.30000000000001p 2.921376e-07 137.3125p 2.9150609999999998e-07 137.32499999999999p 2.9061830000000002e-07 137.33750000000001p 2.894762e-07 137.34999999999999p 2.880817e-07 137.36250000000001p 2.8643709999999998e-07 137.375p 2.8454479999999997e-07 137.38750000000002p 2.8240739999999999e-07 137.40000000000001p 2.8002759999999998e-07 137.41249999999999p 2.7740850000000001e-07 137.42499999999998p 2.745531e-07 137.4375p 2.7146480000000002e-07 137.44999999999999p 2.68147e-07 137.46250000000001p 2.6460340000000003e-07 137.47500000000002p 2.6083770000000002e-07
+ 137.48750000000001p 2.5685399999999998e-07 137.5p 2.5265630000000001e-07 137.51249999999999p 2.482488e-07 137.52500000000001p 2.4363589999999998e-07 137.53749999999999p 2.388223e-07 137.55000000000001p 2.3381249999999999e-07 137.5625p 2.2861130000000001e-07 137.57499999999999p 2.2322359999999999e-07 137.58749999999998p 2.176546e-07 137.59999999999999p 2.119093e-07 137.61250000000001p 2.059931e-07 137.625p 1.999113e-07 137.63750000000002p 1.9366940000000001e-07 137.65000000000001p 1.8727300000000001e-07 137.66249999999999p 1.8072779999999999e-07 137.67499999999998p 1.7403959999999999e-07 137.6875p 1.6721430000000001e-07 137.69999999999999p 1.6025779999999999e-07
+ 137.71250000000001p 1.5317609999999999e-07 137.72499999999999p 1.459755e-07 137.73750000000001p 1.38662e-07 137.75p 1.31242e-07 137.76249999999999p 1.237217e-07 137.77500000000001p 1.161076e-07 137.78749999999999p 1.084061e-07 137.80000000000001p 1.0062360000000001e-07 137.8125p 9.2766819999999995e-08 137.82500000000002p 8.4842199999999997e-08 137.83749999999998p 7.6856419999999998e-08 137.84999999999999p 6.8816129999999994e-08 137.86250000000001p 6.0728020000000006e-08 137.875p 5.2598829999999999e-08 137.88750000000002p 4.443529e-08 137.90000000000001p 3.6244160000000002e-08 137.91249999999999p 2.803224e-08 137.92499999999998p 1.9806309999999998e-08
+ 137.9375p 1.157317e-08 137.94999999999999p 3.3396259999999999e-09 137.96250000000001p -4.8875170000000004e-09 137.97499999999999p -1.310146e-08 137.98750000000001p -2.1295410000000001e-08 138p -2.9462579999999999e-08 138.01249999999999p -3.7596210000000002e-08 138.02500000000001p -4.568956e-08 138.03749999999999p -5.3735910000000003e-08 138.05000000000001p -6.1728560000000002e-08 138.0625p -6.9660850000000003e-08 138.07500000000002p -7.752616e-08 138.08749999999998p -8.5317900000000005e-08 138.09999999999999p -9.3029540000000005e-08 138.11250000000001p -1.006546e-07 138.125p -1.0818660000000001e-07 138.13750000000002p -1.156191e-07 138.15000000000001p -1.2294599999999999e-07
+ 138.16250000000002p -1.3016080000000001e-07 138.17499999999998p -1.3725750000000001e-07 138.1875p -1.442298e-07 138.19999999999999p -1.5107180000000001e-07 138.21250000000001p -1.577776e-07 138.22499999999999p -1.6434120000000001e-07 138.23750000000001p -1.7075690000000001e-07 138.25p -1.7701900000000001e-07 138.26249999999999p -1.831219e-07 138.27500000000001p -1.8906020000000001e-07 138.28749999999999p -1.9482860000000001e-07 138.30000000000001p -2.0042169999999999e-07 138.3125p -2.058345e-07 138.32500000000002p -2.110619e-07 138.33749999999998p -2.1609919999999999e-07 138.34999999999999p -2.209416e-07 138.36249999999998p -2.255845e-07 138.375p -2.3002339999999999e-07
+ 138.38750000000002p -2.3425420000000001e-07 138.40000000000001p -2.3827260000000001e-07 138.41250000000002p -2.420747e-07 138.42499999999998p -2.4565669999999998e-07 138.4375p -2.4901500000000001e-07 138.44999999999999p -2.5214620000000002e-07 138.46250000000001p -2.5504689999999998e-07 138.47499999999999p -2.5771409999999999e-07 138.48750000000001p -2.6014489999999999e-07 138.5p -2.6233660000000001e-07 138.51249999999999p -2.6428679999999998e-07 138.52500000000001p -2.6599319999999998e-07 138.53749999999999p -2.674537e-07 138.55000000000001p -2.6866649999999999e-07 138.5625p -2.6963000000000001e-07 138.57500000000002p -2.7034270000000002e-07 138.58749999999998p -2.708036e-07 138.59999999999999p -2.7101180000000001e-07
+ 138.61249999999998p -2.7096640000000001e-07 138.625p -2.7066719999999998e-07 138.63750000000002p -2.7011389999999999e-07 138.65000000000001p -2.6930660000000002e-07 138.66250000000002p -2.682457e-07 138.67499999999998p -2.669316e-07 138.6875p -2.6536539999999999e-07 138.69999999999999p -2.63548e-07 138.71250000000001p -2.6148090000000002e-07 138.72499999999999p -2.5916559999999998e-07 138.73750000000001p -2.5660429999999999e-07 138.75p -2.5379889999999999e-07 138.76249999999999p -2.5075199999999999e-07 138.77500000000001p -2.474663e-07 138.78749999999999p -2.4394489999999999e-07 138.80000000000001p -2.4019100000000001e-07 138.8125p -2.362082e-07 138.82500000000002p -2.3200029999999999e-07
+ 138.83749999999998p -2.275713e-07 138.84999999999999p -2.2292580000000001e-07 138.86249999999998p -2.1806829999999999e-07 138.875p -2.1300369999999999e-07 138.88749999999999p -2.0773719999999999e-07 138.90000000000001p -2.0227420000000001e-07 138.91250000000002p -1.966203e-07 138.92499999999998p -1.907816e-07 138.9375p -1.8476409999999999e-07 138.94999999999999p -1.7857420000000001e-07 138.96250000000001p -1.7221870000000001e-07 138.97499999999999p -1.6570429999999999e-07 138.98750000000001p -1.5903809999999999e-07 139p -1.5222749999999999e-07 139.01249999999999p -1.452799e-07 139.02500000000001p -1.3820300000000001e-07 139.03749999999999p -1.3100460000000001e-07 139.05000000000001p -1.236929e-07
+ 139.0625p -1.16276e-07 139.07500000000002p -1.0876229999999999e-07 139.08750000000001p -1.011604e-07 139.09999999999999p -9.3478819999999995e-08 139.11249999999998p -8.5726410000000001e-08 139.125p -7.7912040000000003e-08 139.13749999999999p -7.0044720000000006e-08 139.15000000000001p -6.2133500000000005e-08 139.16250000000002p -5.4187560000000001e-08 139.17499999999998p -4.6216089999999997e-08 139.1875p -3.8228359999999999e-08 139.19999999999999p -3.0233669999999999e-08 139.21250000000001p -2.224135e-08 139.22499999999999p -1.426071e-08 139.23750000000001p -6.3010909999999997e-09 139.25p 1.6282170000000001e-09 139.26249999999999p 9.5179400000000003e-09 139.27500000000001p 1.7358859999999999e-08
+ 139.28749999999999p 2.514181e-08 139.30000000000001p 3.2857719999999999e-08 139.3125p 4.0497600000000001e-08 139.32500000000002p 4.8052550000000002e-08 139.33750000000001p 5.5513819999999999e-08 139.34999999999999p 6.287276e-08 139.36249999999998p 7.0120900000000004e-08 139.375p 7.7249900000000001e-08 139.38749999999999p 8.4251620000000004e-08 139.40000000000001p 9.1118079999999995e-08 139.41249999999999p 9.7841520000000003e-08 139.42500000000001p 1.0441440000000001e-07 139.4375p 1.108293e-07 139.44999999999999p 1.170793e-07 139.46250000000001p 1.2315739999999999e-07 139.47499999999999p 1.2905710000000001e-07 139.48750000000001p 1.347721e-07 139.5p 1.4029620000000001e-07
+ 139.51249999999999p 1.4562389999999999e-07 139.52499999999998p 1.5074950000000001e-07 139.53749999999999p 1.5566799999999999e-07 139.55000000000001p 1.6037449999999999e-07 139.5625p 1.6486459999999999e-07 139.57500000000002p 1.6913400000000001e-07 139.58750000000001p 1.731789e-07 139.59999999999999p 1.7699579999999999e-07 139.61249999999998p 1.8058150000000001e-07 139.625p 1.8393319999999999e-07 139.63749999999999p 1.8704850000000001e-07 139.65000000000001p 1.8992520000000001e-07 139.66249999999999p 1.925617e-07 139.67500000000001p 1.9495640000000001e-07 139.6875p 1.9710850000000001e-07 139.69999999999999p 1.990172e-07 139.71250000000001p 2.0068220000000001e-07 139.72499999999999p 2.021036e-07
+ 139.73750000000001p 2.032818e-07 139.75p 2.0421759999999999e-07 139.76250000000002p 2.04912e-07 139.77499999999998p 2.053665e-07 139.78749999999999p 2.05583e-07 139.80000000000001p 2.0556360000000001e-07 139.8125p 2.0531079999999999e-07 139.82500000000002p 2.0482729999999999e-07 139.83750000000001p 2.041163e-07 139.84999999999999p 2.0318120000000001e-07 139.86249999999998p 2.020258e-07 139.875p 2.0065410000000001e-07 139.88749999999999p 1.9907039999999999e-07 139.90000000000001p 1.9727930000000001e-07 139.91249999999999p 1.952856e-07 139.92500000000001p 1.930946e-07 139.9375p 1.9071150000000001e-07 139.94999999999999p 1.881419e-07
+ 139.96250000000001p 1.8539169999999999e-07 139.97499999999999p 1.824669e-07 139.98750000000001p 1.793737e-07 140p 1.761186e-07 140.01250000000002p 1.7270810000000001e-07 140.02499999999998p 1.69149e-07 140.03749999999999p 1.6544810000000001e-07 140.05000000000001p 1.6161260000000001e-07 140.0625p 1.576495e-07 140.07500000000002p 1.535662e-07 140.08750000000001p 1.4936999999999999e-07 140.10000000000002p 1.450682e-07 140.11249999999998p 1.4066850000000001e-07 140.125p 1.3617840000000001e-07 140.13749999999999p 1.3160550000000001e-07 140.15000000000001p 1.2695729999999999e-07 140.16249999999999p 1.222416e-07 140.17500000000001p 1.17466e-07
+ 140.1875p 1.126381e-07 140.19999999999999p 1.077655e-07 140.21250000000001p 1.028557e-07 140.22499999999999p 9.7916319999999998e-08 140.23750000000001p 9.2954760000000004e-08 140.25p 8.7978370000000001e-08 140.26250000000002p 8.299445e-08 140.27499999999998p 7.801018e-08 140.28749999999999p 7.3032629999999997e-08 140.29999999999998p 6.8068750000000005e-08 140.3125p 6.3125369999999997e-08 140.32500000000002p 5.820916e-08 140.33750000000001p 5.3326640000000003e-08 140.35000000000002p 4.848419e-08 140.36249999999998p 4.3688000000000001e-08 140.375p 3.89441e-08 140.38749999999999p 3.4258299999999998e-08 140.40000000000001p 2.9636260000000002e-08
+ 140.41249999999999p 2.5083399999999999e-08 140.42500000000001p 2.0604949999999999e-08 140.4375p 1.6205930000000001e-08 140.44999999999999p 1.189113e-08 140.46250000000001p 7.6651139999999994e-09 140.47499999999999p 3.5322209999999999e-09 140.48750000000001p -5.0345099999999996e-10 140.5p -4.4380419999999999e-09 140.51250000000002p -8.2679330000000001e-09 140.52499999999998p -1.198975e-08 140.53749999999999p -1.5600379999999999e-08 140.54999999999998p -1.9096949999999999e-08 140.5625p -2.2476829999999999e-08 140.57500000000002p -2.5737659999999999e-08 140.58750000000001p -2.887733e-08 140.60000000000002p -3.1893980000000001e-08 140.61249999999998p -3.4786010000000001e-08 140.625p -3.7552059999999997e-08
+ 140.63749999999999p -4.0191050000000002e-08 140.65000000000001p -4.2702119999999999e-08 140.66249999999999p -4.5084669999999997e-08 140.67500000000001p -4.7338339999999999e-08 140.6875p -4.9463039999999997e-08 140.69999999999999p -5.1458879999999999e-08 140.71250000000001p -5.3326240000000001e-08 140.72499999999999p -5.5065700000000002e-08 140.73750000000001p -5.6678079999999999e-08 140.75p -5.8164439999999999e-08 140.76250000000002p -5.9526030000000003e-08 140.77500000000001p -6.0764319999999997e-08 140.78749999999999p -6.1880980000000004e-08 140.79999999999998p -6.287789e-08 140.8125p -6.3757109999999995e-08 140.82499999999999p -6.4520899999999994e-08 140.83750000000001p -6.5171659999999994e-08 140.85000000000002p -6.5712009999999996e-08
+ 140.86249999999998p -6.6144699999999998e-08 140.875p -6.6472639999999993e-08 140.88749999999999p -6.6698869999999999e-08 140.90000000000001p -6.6826599999999998e-08 140.91249999999999p -6.6859139999999995e-08 140.92500000000001p -6.679993e-08 140.9375p -6.6652520000000001e-08 140.94999999999999p -6.6420560000000002e-08 140.96250000000001p -6.6107790000000005e-08 140.97499999999999p -6.5718040000000006e-08 140.98750000000001p -6.5255189999999999e-08 141p -6.4723200000000001e-08 141.01250000000002p -6.4126099999999993e-08 141.02500000000001p -6.3467929999999994e-08 141.03749999999999p -6.2752789999999999e-08 141.04999999999998p -6.1984790000000001e-08 141.0625p -6.1168060000000001e-08 141.07499999999999p -6.0306750000000005e-08
+ 141.08750000000001p -5.9404969999999999e-08 141.10000000000002p -5.8466870000000002e-08 141.11250000000001p -5.7496529999999998e-08 141.125p -5.649802e-08 141.13749999999999p -5.5475380000000001e-08 141.15000000000001p -5.4432569999999997e-08 141.16249999999999p -5.3373539999999998e-08 141.17500000000001p -5.2302139999999999e-08 141.1875p -5.1222150000000002e-08 141.19999999999999p -5.0137279999999997e-08 141.21250000000001p -4.9051159999999998e-08 141.22499999999999p -4.7967290000000002e-08 141.23750000000001p -4.6889109999999999e-08 141.25p -4.581993e-08 141.26250000000002p -4.4762940000000003e-08 141.27500000000001p -4.3721229999999999e-08 141.28749999999999p -4.2697739999999999e-08 141.29999999999998p -4.1695289999999997e-08
+ 141.3125p -4.0716570000000002e-08 141.32499999999999p -3.976413e-08 141.33750000000001p -3.8840350000000001e-08 141.34999999999999p -3.7947500000000003e-08 141.36250000000001p -3.7087670000000002e-08 141.375p -3.6262809999999998e-08 141.38749999999999p -3.5474709999999999e-08 141.40000000000001p -3.4725000000000002e-08 141.41249999999999p -3.4015160000000002e-08 141.42500000000001p -3.33465e-08 141.4375p -3.2720169999999999e-08 141.44999999999999p -3.2137160000000003e-08 141.46249999999998p -3.1598290000000003e-08 141.47499999999999p -3.1104249999999999e-08 141.48750000000001p -3.0655530000000002e-08 141.5p -3.0252490000000003e-08 141.51250000000002p -2.9895330000000003e-08 141.52500000000001p -2.9584080000000001e-08
+ 141.53749999999999p -2.9318630000000001e-08 141.54999999999998p -2.9098740000000001e-08 141.5625p -2.8923990000000002e-08 141.57499999999999p -2.8793840000000002e-08 141.58750000000001p -2.8707609999999999e-08 141.59999999999999p -2.8664489999999998e-08 141.61250000000001p -2.866353e-08 141.625p -2.8703680000000001e-08 141.63749999999999p -2.8783750000000001e-08 141.65000000000001p -2.8902440000000001e-08 141.66249999999999p -2.905835e-08 141.67500000000001p -2.9249980000000001e-08 141.6875p -2.9475739999999999e-08 141.70000000000002p -2.9733920000000001e-08 141.71249999999998p -3.002278e-08 141.72499999999999p -3.0340449999999997e-08 141.73750000000001p -3.0685030000000003e-08 141.75p -3.1054549999999998e-08
+ 141.76250000000002p -3.1446959999999997e-08 141.77500000000001p -3.18602e-08 141.78749999999999p -3.2292129999999997e-08 141.79999999999998p -3.2740589999999997e-08 141.8125p -3.3203419999999998e-08 141.82499999999999p -3.3678380000000001e-08 141.83750000000001p -3.416327e-08 141.84999999999999p -3.4655850000000001e-08 141.86250000000001p -3.5153890000000003e-08 141.875p -3.5655149999999999e-08 141.88749999999999p -3.6157430000000002e-08 141.90000000000001p -3.6658519999999997e-08 141.91249999999999p -3.7156240000000002e-08 141.92500000000001p -3.7648449999999999e-08 141.9375p -3.8133029999999998e-08 141.95000000000002p -3.8607899999999999e-08 141.96249999999998p -3.9071030000000003e-08 141.97499999999999p -3.952044e-08
+ 141.98749999999998p -3.9954210000000002e-08 142p -4.0370459999999998e-08 142.01250000000002p -4.0767379999999999e-08 142.02500000000001p -4.114323e-08 142.03750000000002p -4.1496339999999999e-08 142.04999999999998p -4.1825110000000001e-08 142.0625p -4.2128010000000002e-08 142.07499999999999p -4.2403599999999999e-08 142.08750000000001p -4.2650500000000002e-08 142.09999999999999p -4.2867419999999998e-08 142.11250000000001p -4.3053170000000003e-08 142.125p -4.3206629999999999e-08 142.13749999999999p -4.3326750000000001e-08 142.15000000000001p -4.3412599999999998e-08 142.16249999999999p -4.3463310000000003e-08 142.17500000000001p -4.3478099999999999e-08 142.1875p -4.3456290000000002e-08 142.20000000000002p -4.3397259999999998e-08
+ 142.21249999999998p -4.3300510000000001e-08 142.22499999999999p -4.3165589999999999e-08 142.23749999999998p -4.299215e-08 142.25p -4.2779910000000001e-08 142.26250000000002p -4.252868e-08 142.27500000000001p -4.2238350000000003e-08 142.28750000000002p -4.190885e-08 142.29999999999998p -4.1540230000000001e-08 142.3125p -4.113258e-08 142.32499999999999p -4.0686050000000001e-08 142.33750000000001p -4.0200879999999999e-08 142.34999999999999p -3.9677349999999998e-08 142.36250000000001p -3.91158e-08 142.375p -3.8516630000000001e-08 142.38749999999999p -3.7880289999999999e-08 142.40000000000001p -3.720726e-08 142.41249999999999p -3.6498090000000003e-08 142.42500000000001p -3.5753359999999998e-08
+ 142.4375p -3.4973659999999997e-08 142.45000000000002p -3.4159649999999997e-08 142.46249999999998p -3.3312009999999997e-08 142.47499999999999p -3.2431429999999999e-08 142.48749999999998p -3.151863e-08 142.5p -3.0574360000000002e-08 142.51250000000002p -2.9599360000000001e-08 142.52500000000001p -2.8594409999999999e-08 142.53750000000002p -2.756029e-08 142.54999999999998p -2.649777e-08 142.5625p -2.5407629999999999e-08 142.57499999999999p -2.429068e-08 142.58750000000001p -2.314768e-08 142.59999999999999p -2.1979409999999999e-08 142.61250000000001p -2.078665e-08 142.625p -1.9570150000000001e-08 142.63749999999999p -1.8330660000000001e-08 142.65000000000001p -1.706893e-08
+ 142.66249999999999p -1.5785660000000001e-08 142.67500000000001p -1.448157e-08 142.6875p -1.3157350000000001e-08 142.70000000000002p -1.181365e-08 142.71250000000001p -1.045114e-08 142.72499999999999p -9.0704319999999999e-09 142.73749999999998p -7.6721509999999993e-09 142.75p -6.2568819999999998e-09 142.76249999999999p -4.825194e-09 142.77500000000001p -3.3776369999999998e-09 142.78750000000002p -1.9147399999999999e-09 142.79999999999998p -4.3701600000000002e-10 142.8125p 1.0550439999999999e-09 142.82499999999999p 2.5609629999999999e-09 142.83750000000001p 4.0802819999999997e-09 142.84999999999999p 5.6125569999999998e-09 142.86250000000001p 7.1573549999999998e-09 142.875p 8.7142580000000007e-09
+ 142.88749999999999p 1.028285e-08 142.90000000000001p 1.186274e-08 142.91249999999999p 1.345353e-08 142.92500000000001p 1.505482e-08 142.9375p 1.6666229999999999e-08 142.95000000000002p 1.8287359999999999e-08 142.96250000000001p 1.9917829999999999e-08 142.97499999999999p 2.155723e-08 142.98749999999998p 2.320516e-08 143p 2.4861200000000001e-08 143.01249999999999p 2.6524919999999999e-08 143.02500000000001p 2.8195880000000001e-08 143.03750000000002p 2.9873619999999998e-08 143.05000000000001p 3.1557660000000001e-08 143.0625p 3.3247480000000001e-08 143.07499999999999p 3.4942560000000003e-08 143.08750000000001p 3.6642349999999997e-08 143.09999999999999p 3.8346249999999998e-08
+ 143.11250000000001p 4.005364e-08 143.125p 4.1763870000000001e-08 143.13749999999999p 4.3476240000000002e-08 143.15000000000001p 4.5190029999999999e-08 143.16249999999999p 4.6904469999999999e-08 143.17500000000001p 4.861873e-08 143.1875p 5.0331970000000001e-08 143.20000000000002p 5.2043269999999998e-08 143.21250000000001p 5.3751689999999998e-08 143.22499999999999p 5.5456220000000001e-08 143.23749999999998p 5.7155820000000001e-08 143.25p 5.8849389999999998e-08 143.26249999999999p 6.0535780000000003e-08 143.27500000000001p 6.221378e-08 143.28749999999999p 6.3882139999999994e-08 143.30000000000001p 6.5539549999999999e-08 143.3125p 6.7184650000000003e-08 143.32499999999999p 6.8816020000000005e-08
+ 143.33750000000001p 7.0432209999999999e-08 143.34999999999999p 7.2031700000000003e-08 143.36250000000001p 7.3612910000000003e-08 143.375p 7.5174229999999996e-08 143.38750000000002p 7.6713989999999998e-08 143.39999999999998p 7.8230480000000001e-08 143.41249999999999p 7.9721939999999998e-08 143.42500000000001p 8.1186550000000006e-08 143.4375p 8.2622480000000004e-08 143.45000000000002p 8.4027819999999999e-08 143.46250000000001p 8.5400659999999996e-08 143.47499999999999p 8.673902e-08 143.48749999999998p 8.8040910000000005e-08 143.5p 8.9304289999999997e-08 143.51249999999999p 9.0527110000000003e-08 143.52500000000001p 9.1707289999999995e-08 143.53749999999999p 9.284271e-08 143.55000000000001p 9.3931250000000003e-08
+ 143.5625p 9.4970780000000007e-08 143.57499999999999p 9.5959130000000001e-08 143.58750000000001p 9.6894149999999995e-08 143.59999999999999p 9.7773680000000003e-08 143.61250000000001p 9.8595540000000004e-08 143.625p 9.9357579999999994e-08 143.63750000000002p 1.000576e-07 143.64999999999998p 1.0069360000000001e-07 143.66249999999999p 1.012633e-07 143.67500000000001p 1.017646e-07 143.6875p 1.021955e-07 143.70000000000002p 1.0255400000000001e-07 143.71250000000001p 1.0283790000000001e-07 143.72500000000002p 1.030454e-07 143.73749999999998p 1.031745e-07 143.75p 1.0322319999999999e-07 143.76249999999999p 1.0318989999999999e-07 143.77500000000001p 1.030726e-07
+ 143.78749999999999p 1.028697e-07 143.80000000000001p 1.025796e-07 143.8125p 1.0220059999999999e-07 143.82499999999999p 1.017313e-07 143.83750000000001p 1.011702e-07 143.84999999999999p 1.00516e-07 143.86250000000001p 9.9767440000000004e-08 143.875p 9.8923379999999994e-08 143.88750000000002p 9.7982760000000001e-08 143.89999999999998p 9.694461e-08 143.91249999999999p 9.5808080000000006e-08 143.92499999999998p 9.4572430000000006e-08 143.9375p 9.3237019999999996e-08 143.95000000000002p 9.1801359999999998e-08 143.96250000000001p 9.0265029999999998e-08 143.97500000000002p 8.8627770000000004e-08 143.98749999999998p 8.6889430000000003e-08 144p 8.5049999999999997e-08
+ 144.01249999999999p 8.3109599999999999e-08 144.02500000000001p 8.1068480000000003e-08 144.03749999999999p 7.8927019999999996e-08 144.05000000000001p 7.6685749999999996e-08 144.0625p 7.4345349999999994e-08 144.07499999999999p 7.1906619999999995e-08 144.08750000000001p 6.9370529999999995e-08 144.09999999999999p 6.6738170000000006e-08 144.11250000000001p 6.4010810000000002e-08 144.125p 6.1189839999999996e-08 144.13750000000002p 5.8276800000000002e-08 144.14999999999998p 5.5273400000000003e-08 144.16249999999999p 5.218149e-08 144.17499999999998p 4.9003059999999998e-08 144.1875p 4.5740260000000001e-08 144.20000000000002p 4.2395379999999999e-08 144.21250000000001p 3.8970869999999997e-08 144.22500000000002p 3.5469309999999998e-08
+ 144.23749999999998p 3.1893429999999998e-08 144.25p 2.8246119999999999e-08 144.26249999999999p 2.4530390000000001e-08 144.27500000000001p 2.0749380000000001e-08 144.28749999999999p 1.6906410000000001e-08 144.30000000000001p 1.3004879999999999e-08 144.3125p 9.0483579999999993e-09 144.32499999999999p 5.0405209999999998e-09 144.33750000000001p 9.8517439999999998e-10 144.34999999999999p -3.1137599999999998e-09 144.36250000000001p -7.2522440000000002e-09 144.375p -1.1426129999999999e-08 144.38750000000002p -1.5631160000000001e-08 144.39999999999998p -1.9862990000000001e-08 144.41249999999999p -2.4117170000000001e-08 144.42499999999998p -2.8389149999999998e-08 144.4375p -3.2674320000000001e-08 144.44999999999999p -3.6967970000000001e-08
+ 144.46250000000001p -4.1265340000000002e-08 144.47500000000002p -4.5561590000000003e-08 144.48749999999998p -4.9851819999999998e-08 144.5p -5.4131089999999999e-08 144.51249999999999p -5.8394389999999999e-08 144.52500000000001p -6.2636710000000001e-08 144.53749999999999p -6.685299e-08 144.55000000000001p -7.1038129999999999e-08 144.5625p -7.5187039999999996e-08 144.57499999999999p -7.9294619999999994e-08 144.58750000000001p -8.3355759999999998e-08 144.59999999999999p -8.7365359999999997e-08 144.61250000000001p -9.131834e-08 144.625p -9.5209629999999998e-08 144.63750000000002p -9.9034220000000003e-08 144.65000000000001p -1.027871e-07 144.66249999999999p -1.064634e-07 144.67499999999998p -1.100582e-07
+ 144.6875p -1.1356660000000001e-07 144.69999999999999p -1.1698390000000001e-07 144.71250000000001p -1.203056e-07 144.72500000000002p -1.235269e-07 144.73749999999998p -1.266434e-07 144.75p -1.2965079999999999e-07 144.76249999999999p -1.325447e-07 144.77500000000001p -1.3532109999999999e-07 144.78749999999999p -1.3797580000000001e-07 144.80000000000001p -1.4050509999999999e-07 144.8125p -1.4290520000000001e-07 144.82499999999999p -1.4517250000000001e-07 144.83750000000001p -1.4730349999999999e-07 144.84999999999999p -1.4929499999999999e-07 144.86250000000001p -1.511439e-07 144.875p -1.5284710000000001e-07 144.88750000000002p -1.5440200000000001e-07 144.90000000000001p -1.5580600000000001e-07
+ 144.91249999999999p -1.570567e-07 144.92499999999998p -1.5815179999999999e-07 144.9375p -1.5908949999999999e-07 144.94999999999999p -1.598678e-07 144.96250000000001p -1.6048520000000001e-07 144.97500000000002p -1.6094029999999999e-07 144.98750000000001p -1.61232e-07 145p -1.6135919999999999e-07 145.01249999999999p -1.613213e-07 145.02500000000001p -1.611177e-07 145.03749999999999p -1.60748e-07 145.05000000000001p -1.602124e-07 145.0625p -1.595107e-07 145.07499999999999p -1.5864349999999999e-07 145.08749999999998p -1.5761139999999999e-07 145.09999999999999p -1.5641499999999999e-07 145.11250000000001p -1.550555e-07 145.125p -1.535341e-07
+ 145.13750000000002p -1.5185220000000001e-07 145.15000000000001p -1.5001160000000001e-07 145.16249999999999p -1.4801410000000001e-07 145.17499999999998p -1.4586189999999999e-07 145.1875p -1.435572e-07 145.19999999999999p -1.4110259999999999e-07 145.21250000000001p -1.3850079999999999e-07 145.22499999999999p -1.3575470000000001e-07 145.23750000000001p -1.3286739999999999e-07 145.25p -1.2984230000000001e-07 145.26249999999999p -1.2668269999999999e-07 145.27500000000001p -1.233923e-07 145.28749999999999p -1.1997499999999999e-07 145.30000000000001p -1.1643469999999999e-07 145.3125p -1.127756e-07 145.32500000000002p -1.0900189999999999e-07 145.33749999999998p -1.0511809999999999e-07 145.34999999999999p -1.011289e-07
+ 145.36250000000001p -9.703873e-08 145.375p -9.2852599999999996e-08 145.38750000000002p -8.8575389999999996e-08 145.40000000000001p -8.4212150000000001e-08 145.41249999999999p -7.9768019999999996e-08 145.42499999999998p -7.5248220000000004e-08 145.4375p -7.0658060000000002e-08 145.44999999999999p -6.6002940000000006e-08 145.46250000000001p -6.1288290000000006e-08 145.47499999999999p -5.6519619999999997e-08 145.48750000000001p -5.170247e-08 145.5p -4.6842450000000001e-08 145.51249999999999p -4.1945160000000001e-08 145.52500000000001p -3.7016249999999999e-08 145.53749999999999p -3.2061369999999997e-08 145.55000000000001p -2.708617e-08 145.5625p -2.2096310000000001e-08 145.57500000000002p -1.7097439999999999e-08
+ 145.58749999999998p -1.209515e-08 145.59999999999999p -7.0950609999999996e-09 145.61250000000001p -2.102706e-09 145.625p 2.8764019999999999e-09 145.63750000000002p 7.8368110000000003e-09 145.65000000000001p 1.277313e-08 145.66250000000002p 1.768002e-08 145.67499999999998p 2.2552249999999999e-08 145.6875p 2.7384650000000001e-08 145.69999999999999p 3.217213e-08 145.71250000000001p 3.6909709999999998e-08 145.72499999999999p 4.159252e-08 145.73750000000001p 4.6215770000000001e-08 145.75p 5.0774819999999999e-08 145.76249999999999p 5.5265130000000001e-08 145.77500000000001p 5.9682270000000005e-08 145.78749999999999p 6.4021960000000003e-08 145.80000000000001p 6.8280060000000006e-08
+ 145.8125p 7.2452559999999999e-08 145.82500000000002p 7.6535570000000006e-08 145.83749999999998p 8.052539e-08 145.84999999999999p 8.4418440000000003e-08 145.86249999999998p 8.8211299999999998e-08 145.875p 9.1900710000000004e-08 145.88750000000002p 9.5483569999999998e-08 145.90000000000001p 9.8956939999999998e-08 145.91250000000002p 1.02318e-07 145.92499999999998p 1.055642e-07 145.9375p 1.086931e-07 145.94999999999999p 1.117024e-07 145.96250000000001p 1.145899e-07 145.97499999999999p 1.173538e-07 145.98750000000001p 1.1999219999999999e-07 146p 1.2250350000000001e-07 146.01249999999999p 1.2488639999999999e-07 146.02500000000001p 1.271395e-07
+ 146.03749999999999p 1.2926170000000001e-07 146.05000000000001p 1.312522e-07 146.0625p 1.3311000000000001e-07 146.07500000000002p 1.348347e-07 146.08749999999998p 1.364257e-07 146.09999999999999p 1.3788269999999999e-07 146.11249999999998p 1.3920570000000001e-07 146.125p 1.4039460000000001e-07 146.13750000000002p 1.4144959999999999e-07 146.15000000000001p 1.42371e-07 146.16250000000002p 1.4315929999999999e-07 146.17499999999998p 1.4381499999999999e-07 146.1875p 1.4433900000000001e-07 146.19999999999999p 1.44732e-07 146.21250000000001p 1.449951e-07 146.22499999999999p 1.451294e-07 146.23750000000001p 1.4513619999999999e-07 146.25p 1.4501689999999999e-07
+ 146.26249999999999p 1.4477280000000001e-07 146.27500000000001p 1.444057e-07 146.28749999999999p 1.4391719999999999e-07 146.30000000000001p 1.433091e-07 146.3125p 1.425834e-07 146.32500000000002p 1.4174190000000001e-07 146.33749999999998p 1.4078690000000001e-07 146.34999999999999p 1.397205e-07 146.36249999999998p 1.3854490000000001e-07 146.375p 1.3726249999999999e-07 146.38749999999999p 1.358756e-07 146.40000000000001p 1.3438669999999999e-07 146.41250000000002p 1.327983e-07 146.42499999999998p 1.3111310000000001e-07 146.4375p 1.293335e-07 146.44999999999999p 1.274624e-07 146.46250000000001p 1.255024e-07 146.47499999999999p 1.2345629999999999e-07
+ 146.48750000000001p 1.2132689999999999e-07 146.5p 1.191171e-07 146.51249999999999p 1.1682949999999999e-07 146.52500000000001p 1.144673e-07 146.53749999999999p 1.120331e-07 146.55000000000001p 1.0953009999999999e-07 146.5625p 1.069609e-07 146.57500000000002p 1.043287e-07 146.58750000000001p 1.016363e-07 146.59999999999999p 9.8886690000000004e-08 146.61249999999998p 9.6082749999999994e-08 146.625p 9.3227420000000006e-08 146.63749999999999p 9.0323620000000007e-08 146.65000000000001p 8.7374229999999999e-08 146.66250000000002p 8.4382160000000005e-08 146.67499999999998p 8.1350269999999997e-08 146.6875p 7.8281400000000006e-08 146.69999999999999p 7.5178370000000005e-08
+ 146.71250000000001p 7.2044000000000006e-08 146.72499999999999p 6.8881029999999996e-08 146.73750000000001p 6.5692230000000004e-08 146.75p 6.2480279999999998e-08 146.76249999999999p 5.924787e-08 146.77500000000001p 5.5997640000000001e-08 146.78749999999999p 5.2732180000000003e-08 146.80000000000001p 4.945406e-08 146.8125p 4.61658e-08 146.82500000000002p 4.2869889999999997e-08 146.83750000000001p 3.9568759999999998e-08 146.84999999999999p 3.6264800000000003e-08 146.86249999999998p 3.2960380000000001e-08 146.875p 2.9657789999999999e-08 146.88749999999999p 2.6359300000000001e-08 146.90000000000001p 2.3067119999999999e-08 146.91249999999999p 1.9783430000000001e-08 146.92500000000001p 1.6510339999999999e-08
+ 146.9375p 1.324993e-08 146.94999999999999p 1.000423e-08 146.96250000000001p 6.7752289999999997e-09 146.97499999999999p 3.5648540000000002e-09 146.98750000000001p 3.7499760000000001e-10 147p -2.7924969999999999e-09 147.01249999999999p -5.9358320000000004e-09 147.02499999999998p -9.0532550000000003e-09 147.03749999999999p -1.2143059999999999e-08 147.05000000000001p -1.520358e-08 147.0625p -1.823319e-08 147.07500000000002p -2.1230320000000002e-08 147.08750000000001p -2.4193429999999998e-08 147.09999999999999p -2.7121030000000001e-08 147.11249999999998p -3.0011660000000002e-08 147.125p -3.2863899999999997e-08 147.13749999999999p -3.5676379999999997e-08 147.15000000000001p -3.8447750000000001e-08
+ 147.16249999999999p -4.1176720000000002e-08 147.17500000000001p -4.3861999999999999e-08 147.1875p -4.6502370000000001e-08 147.19999999999999p -4.9096630000000001e-08 147.21250000000001p -5.1643600000000001e-08 147.22499999999999p -5.4142140000000001e-08 147.23750000000001p -5.6591150000000002e-08 147.25p -5.8989550000000003e-08 147.26250000000002p -6.1336289999999994e-08 147.27499999999998p -6.3630339999999997e-08 147.28749999999999p -6.5870700000000005e-08 147.30000000000001p -6.8056410000000002e-08 147.3125p -7.0186519999999998e-08 147.32500000000002p -7.2260100000000005e-08 147.33750000000001p -7.427626e-08 147.34999999999999p -7.6234120000000005e-08 147.36249999999998p -7.8132819999999998e-08 147.375p -7.9971539999999995e-08
+ 147.38749999999999p -8.1749460000000001e-08 147.40000000000001p -8.3465789999999994e-08 147.41249999999999p -8.5119769999999997e-08 147.42500000000001p -8.6710650000000002e-08 147.4375p -8.823769e-08 147.44999999999999p -8.97002e-08 147.46250000000001p -9.1097480000000006e-08 147.47499999999999p -9.2428870000000005e-08 147.48750000000001p -9.3693730000000005e-08 147.5p -9.4891429999999997e-08 147.51250000000002p -9.6021379999999999e-08 147.52499999999998p -9.708299e-08 147.53749999999999p -9.8075699999999995e-08 147.54999999999998p -9.8998990000000002e-08 147.5625p -9.9852359999999995e-08 147.57500000000002p -1.006353e-07 147.58750000000001p -1.013474e-07 147.60000000000002p -1.019882e-07
+ 147.61249999999998p -1.0255719999999999e-07 147.625p -1.0305429999999999e-07 147.63749999999999p -1.034789e-07 147.65000000000001p -1.038308e-07 147.66249999999999p -1.0410969999999999e-07 147.67500000000001p -1.043154e-07 147.6875p -1.044476e-07 147.69999999999999p -1.045063e-07 147.71250000000001p -1.044912e-07 147.72499999999999p -1.0440240000000001e-07 147.73750000000001p -1.042397e-07 147.75p -1.0400320000000001e-07 147.76250000000002p -1.036929e-07 147.77499999999998p -1.033089e-07 147.78749999999999p -1.028513e-07 147.79999999999998p -1.023204e-07 147.8125p -1.017164e-07 147.82500000000002p -1.010396e-07
+ 147.83750000000001p -1.002904e-07 147.85000000000002p -9.9469150000000004e-08 147.86249999999998p -9.8576349999999995e-08 147.875p -9.7612530000000004e-08 147.88749999999999p -9.6578299999999996e-08 147.90000000000001p -9.5474300000000001e-08 147.91249999999999p -9.4301259999999995e-08 147.92500000000001p -9.3059960000000001e-08 147.9375p -9.1751239999999996e-08 147.94999999999999p -9.0376030000000004e-08 147.96250000000001p -8.8935309999999995e-08 147.97499999999999p -8.7430130000000004e-08 147.98750000000001p -8.5861599999999996e-08 148p -8.4230909999999999e-08 148.01250000000002p -8.2539320000000005e-08 148.02499999999998p -8.0788149999999997e-08 148.03749999999999p -7.8978790000000001e-08 148.04999999999998p -7.7112689999999998e-08
+ 148.0625p -7.5191399999999997e-08 148.07500000000002p -7.3216499999999999e-08 148.08750000000001p -7.1189660000000002e-08 148.10000000000002p -6.9112599999999996e-08 148.11249999999998p -6.6987120000000001e-08 148.125p -6.4815070000000004e-08 148.13749999999999p -6.2598369999999995e-08 148.15000000000001p -6.0338999999999995e-08 148.16249999999999p -5.8039000000000001e-08 148.17500000000001p -5.5700459999999997e-08 148.1875p -5.332553e-08 148.19999999999999p -5.0916430000000002e-08 148.21250000000001p -4.8475390000000001e-08 148.22499999999999p -4.6004719999999997e-08 148.23750000000001p -4.3506780000000003e-08 148.25p -4.0983939999999999e-08 148.26250000000002p -3.8438640000000002e-08 148.27500000000001p -3.5873349999999999e-08
+ 148.28749999999999p -3.3290560000000002e-08 148.29999999999998p -3.0692799999999998e-08 148.3125p -2.8082629999999999e-08 148.32499999999999p -2.5462619999999999e-08 148.33750000000001p -2.2835370000000001e-08 148.35000000000002p -2.020349e-08 148.36249999999998p -1.7569609999999999e-08 148.375p -1.4936360000000001e-08 148.38749999999999p -1.230637e-08 148.40000000000001p -9.6822769999999992e-09 148.41249999999999p -7.0667039999999996e-09 148.42500000000001p -4.4622729999999999e-09 148.4375p -1.8715900000000002e-09 148.44999999999999p 7.0275690000000001e-10 148.46250000000001p 3.258202e-09 148.47499999999999p 5.7922060000000002e-09 148.48750000000001p 8.3022569999999997e-09 148.5p 1.078588e-08
+ 148.51250000000002p 1.324065e-08 148.52500000000001p 1.5664149999999999e-08 148.53749999999999p 1.805406e-08 148.54999999999998p 2.0408069999999999e-08 148.5625p 2.272394e-08 148.57499999999999p 2.4999489999999998e-08 148.58750000000001p 2.7232600000000001e-08 148.60000000000002p 2.942123e-08 148.61250000000001p 3.1563379999999998e-08 148.625p 3.3657150000000003e-08 148.63749999999999p 3.5700709999999997e-08 148.65000000000001p 3.7692289999999997e-08 148.66249999999999p 3.9630240000000002e-08 148.67500000000001p 4.1512960000000003e-08 148.6875p 4.3338949999999999e-08 148.69999999999999p 4.5106799999999997e-08 148.71250000000001p 4.681521e-08 148.72499999999999p 4.8462940000000003e-08
+ 148.73750000000001p 5.0048880000000002e-08 148.75p 5.1571989999999997e-08 148.76250000000002p 5.3031340000000003e-08 148.77500000000001p 5.4426119999999999e-08 148.78749999999999p 5.5755590000000001e-08 148.79999999999998p 5.7019129999999998e-08 148.8125p 5.8216220000000001e-08 148.82499999999999p 5.9346449999999999e-08 148.83750000000001p 6.0409489999999999e-08 148.84999999999999p 6.1405140000000005e-08 148.86250000000001p 6.233329e-08 148.875p 6.3193939999999997e-08 148.88749999999999p 6.3987179999999994e-08 148.90000000000001p 6.4713219999999996e-08 148.91249999999999p 6.5372340000000001e-08 148.92500000000001p 6.5964949999999999e-08 148.9375p 6.6491539999999996e-08 148.94999999999999p 6.6952690000000004e-08
+ 148.96249999999998p 6.7349080000000002e-08 148.97499999999999p 6.768149e-08 148.98750000000001p 6.7950769999999997e-08 149p 6.8157869999999999e-08 149.01250000000002p 6.8303819999999996e-08 149.02500000000001p 6.8389719999999996e-08 149.03749999999999p 6.8416750000000003e-08 149.04999999999998p 6.8386180000000005e-08 149.0625p 6.8299339999999998e-08 149.07499999999999p 6.8157609999999995e-08 149.08750000000001p 6.7962459999999998e-08 149.09999999999999p 6.771541e-08 149.11250000000001p 6.7418030000000005e-08 149.125p 6.7071949999999997e-08 149.13749999999999p 6.667884e-08 149.15000000000001p 6.6240430000000001e-08 149.16249999999999p 6.575846e-08 149.17500000000001p 6.5234739999999998e-08
+ 149.1875p 6.4671090000000006e-08 149.20000000000002p 6.4069350000000002e-08 149.21249999999998p 6.3431409999999999e-08 149.22499999999999p 6.2759169999999994e-08 149.23750000000001p 6.2054510000000005e-08 149.25p 6.1319379999999997e-08 149.26250000000002p 6.0555679999999994e-08 149.27500000000001p 5.9765339999999995e-08 149.28749999999999p 5.8950290000000002e-08 149.29999999999998p 5.8112430000000003e-08 149.3125p 5.7253680000000002e-08 149.32499999999999p 5.6375920000000002e-08 149.33750000000001p 5.5481019999999999e-08 149.34999999999999p 5.4570829999999998e-08 149.36250000000001p 5.3647169999999998e-08 149.375p 5.2711819999999998e-08 149.38749999999999p 5.1766540000000002e-08 149.40000000000001p 5.0813059999999999e-08
+ 149.41249999999999p 4.9853040000000003e-08 149.42500000000001p 4.8888119999999999e-08 149.4375p 4.7919880000000003e-08 149.45000000000002p 4.6949860000000002e-08 149.46249999999998p 4.5979550000000001e-08 149.47499999999999p 4.501036e-08 149.48749999999998p 4.4043670000000001e-08 149.5p 4.308079e-08 149.51250000000002p 4.212296e-08 149.52500000000001p 4.1171360000000001e-08 149.53750000000002p 4.0227110000000002e-08 149.54999999999998p 3.9291249999999998e-08 149.5625p 3.8364760000000003e-08 149.57499999999999p 3.7448550000000002e-08 149.58750000000001p 3.6543450000000003e-08 149.59999999999999p 3.5650220000000002e-08 149.61250000000001p 3.4769550000000002e-08 149.625p 3.3902040000000001e-08
+ 149.63749999999999p 3.3048249999999999e-08 149.65000000000001p 3.2208630000000002e-08 149.66249999999999p 3.138357e-08 149.67500000000001p 3.0573389999999997e-08 149.6875p 2.977832e-08 149.70000000000002p 2.899853e-08 149.71249999999998p 2.8234109999999999e-08 149.72499999999999p 2.748508e-08 149.73749999999998p 2.6751380000000001e-08 149.75p 2.603291e-08 149.76250000000002p 2.5329459999999999e-08 149.77500000000001p 2.4640770000000002e-08 149.78750000000002p 2.3966530000000001e-08 149.79999999999998p 2.330634e-08 149.8125p 2.2659749999999999e-08 149.82499999999999p 2.2026260000000002e-08 149.83750000000001p 2.1405299999999998e-08 149.84999999999999p 2.079624e-08
+ 149.86250000000001p 2.0198420000000001e-08 149.875p 1.9611100000000001e-08 149.88749999999999p 1.903351e-08 149.90000000000001p 1.8464839999999999e-08 149.91249999999999p 1.790422e-08 149.92500000000001p 1.735077e-08 149.9375p 1.6803550000000002e-08 149.95000000000002p 1.6261589999999999e-08 149.96249999999998p 1.572391e-08 149.97499999999999p 1.5189479999999999e-08 149.98749999999998p 1.465726e-08 150p 1.412619e-08 150.01249999999999p 1.35952e-08 150.02500000000001p 1.306321e-08 150.03750000000002p 1.252911e-08 150.04999999999998p 1.199181e-08 150.0625p 1.1450210000000001e-08 150.07499999999999p 1.0903209999999999e-08
+ 150.08750000000001p 1.034973e-08 150.09999999999999p 9.7886710000000002e-09 150.11250000000001p 9.218975e-09 150.125p 8.6395910000000003e-09 150.13749999999999p 8.0494859999999992e-09 150.15000000000001p 7.447655e-09 150.16249999999999p 6.8331169999999999e-09 150.17500000000001p 6.2049239999999997e-09 150.1875p 5.5621580000000003e-09 150.20000000000002p 4.9039429999999996e-09 150.21250000000001p 4.229438e-09 150.22499999999999p 3.5378489999999998e-09 150.23749999999998p 2.828425e-09 150.25p 2.1004659999999998e-09 150.26249999999999p 1.35332e-09 150.27500000000001p 5.8639289999999997e-10 150.28750000000002p -2.008558e-10 150.29999999999998p -1.0089070000000001e-09
+ 150.3125p -1.8381810000000001e-09 150.32499999999999p -2.6890339999999998e-09 150.33750000000001p -3.5617609999999998e-09 150.34999999999999p -4.4565860000000002e-09 150.36250000000001p -5.3736690000000002e-09 150.375p -6.3130979999999998e-09 150.38749999999999p -7.2748909999999998e-09 150.40000000000001p -8.2589949999999998e-09 150.41249999999999p -9.2652840000000001e-09 150.42500000000001p -1.029356e-08 150.4375p -1.1343539999999999e-08 150.45000000000002p -1.24149e-08 150.46250000000001p -1.3507190000000001e-08 150.47499999999999p -1.461993e-08 150.48749999999998p -1.5752550000000001e-08 150.5p -1.6904399999999999e-08 150.51249999999999p -1.8074770000000001e-08 150.52500000000001p -1.926286e-08
+ 150.53750000000002p -2.0467810000000001e-08 150.55000000000001p -2.168869e-08 150.5625p -2.2924510000000001e-08 150.57499999999999p -2.417418e-08 150.58750000000001p -2.543658e-08 150.59999999999999p -2.67105e-08 150.61250000000001p -2.7994690000000001e-08 150.625p -2.9287819999999999e-08 150.63749999999999p -3.0588509999999999e-08 150.65000000000001p -3.1895319999999998e-08 150.66249999999999p -3.320677e-08 150.67500000000001p -3.4521310000000001e-08 150.6875p -3.5837369999999997e-08 150.70000000000002p -3.7153299999999998e-08 150.71250000000001p -3.8467430000000001e-08 150.72499999999999p -3.9778070000000003e-08 150.73749999999998p -4.1083450000000003e-08 150.75p -4.2381799999999998e-08
+ 150.76249999999999p -4.3671319999999997e-08 150.77500000000001p -4.495018e-08 150.78749999999999p -4.6216529999999999e-08 150.80000000000001p -4.7468499999999999e-08 150.8125p -4.8704220000000001e-08 150.82499999999999p -4.9921790000000001e-08 150.83750000000001p -5.1119319999999999e-08 150.84999999999999p -5.2294909999999997e-08 150.86250000000001p -5.3446679999999999e-08 150.875p -5.4572730000000002e-08 150.88750000000002p -5.5671189999999997e-08 150.89999999999998p -5.6740189999999998e-08 150.91249999999999p -5.7777899999999998e-08 150.92500000000001p -5.8782490000000001e-08 150.9375p -5.9752160000000003e-08 150.95000000000002p -6.0685150000000005e-08 150.96250000000001p -6.1579720000000003e-08 150.97499999999999p -6.2434169999999996e-08
+ 150.98749999999998p -6.3246860000000005e-08 151p -6.4016170000000004e-08 151.01249999999999p -6.474053e-08 151.02500000000001p -6.5418440000000005e-08 151.03749999999999p -6.6048429999999995e-08 151.05000000000001p -6.6629090000000003e-08 151.0625p -6.7159100000000005e-08 151.07499999999999p -6.7637159999999997e-08 151.08750000000001p -6.8062069999999993e-08 151.09999999999999p -6.8432669999999995e-08 151.11250000000001p -6.8747899999999996e-08 151.125p -6.9006749999999997e-08 151.13750000000002p -6.920829e-08 151.14999999999998p -6.9351670000000005e-08 151.16249999999999p -6.9436129999999996e-08 151.17500000000001p -6.9460960000000003e-08 151.1875p -6.9425559999999995e-08 151.20000000000002p -6.9329399999999993e-08
+ 151.21250000000001p -6.9172040000000005e-08 151.22500000000002p -6.8953109999999997e-08 151.23749999999998p -6.8672349999999994e-08 151.25p -6.8329559999999996e-08 151.26249999999999p -6.7924649999999995e-08 151.27500000000001p -6.7457599999999999e-08 151.28749999999999p -6.6928479999999996e-08 151.30000000000001p -6.6337449999999998e-08 151.3125p -6.5684759999999998e-08 151.32499999999999p -6.4970730000000006e-08 151.33750000000001p -6.4195779999999997e-08 151.34999999999999p -6.3360400000000001e-08 151.36250000000001p -6.2465180000000002e-08 151.375p -6.1510779999999997e-08 151.38750000000002p -6.0497930000000001e-08 151.39999999999998p -5.9427469999999998e-08 151.41249999999999p -5.8300280000000002e-08 151.42499999999998p -5.7117339999999997e-08
+ 151.4375p -5.5879699999999998e-08 151.45000000000002p -5.4588470000000003e-08 151.46250000000001p -5.3244829999999997e-08 151.47500000000002p -5.1850039999999997e-08 151.48749999999998p -5.0405409999999999e-08 151.5p -4.8912319999999998e-08 151.51249999999999p -4.7372210000000003e-08 151.52500000000001p -4.578657e-08 151.53749999999999p -4.4156939999999997e-08 151.55000000000001p -4.2484920000000001e-08 151.5625p -4.0772149999999998e-08 151.57499999999999p -3.9020319999999997e-08 151.58750000000001p -3.7231160000000002e-08 151.59999999999999p -3.5406440000000001e-08 151.61250000000001p -3.3547959999999998e-08 151.625p -3.165755e-08 151.63750000000002p -2.9737079999999999e-08 151.64999999999998p -2.7788450000000002e-08
+ 151.66249999999999p -2.5813560000000001e-08 151.67499999999998p -2.381434e-08 151.6875p -2.1792760000000002e-08 151.70000000000002p -1.9750759999999999e-08 151.71250000000001p -1.7690320000000001e-08 151.72500000000002p -1.561342e-08 151.73749999999998p -1.352204e-08 151.75p -1.141818e-08 151.76249999999999p -9.3038150000000007e-09 151.77500000000001p -7.1809219999999999e-09 151.78749999999999p -5.0514769999999999e-09 151.80000000000001p -2.9174410000000001e-09 151.8125p -7.8076539999999996e-10 151.82499999999999p 1.3566150000000001e-09 151.83750000000001p 3.4927830000000001e-09 151.84999999999999p 5.6258399999999997e-09 151.86250000000001p 7.7539100000000006e-09 151.875p 9.8751419999999997e-09
+ 151.88750000000002p 1.198771e-08 151.89999999999998p 1.408982e-08 151.91249999999999p 1.617969e-08 151.92499999999998p 1.825561e-08 151.9375p 2.031586e-08 151.94999999999999p 2.2358770000000001e-08 151.96250000000001p 2.4382720000000001e-08 151.97500000000002p 2.6386120000000001e-08 151.98749999999998p 2.83674e-08 152p 3.0325060000000001e-08 152.01249999999999p 3.2257620000000001e-08 152.02500000000001p 3.4163650000000002e-08 152.03749999999999p 3.6041760000000002e-08 152.05000000000001p 3.7890600000000003e-08 152.0625p 3.970887e-08 152.07499999999999p 4.1495319999999998e-08 152.08750000000001p 4.3248720000000002e-08 152.09999999999999p 4.4967919999999997e-08
+ 152.11250000000001p 4.6651780000000002e-08 152.125p 4.8299230000000002e-08 152.13750000000002p 4.9909230000000001e-08 152.15000000000001p 5.1480790000000002e-08 152.16249999999999p 5.301296e-08 152.17499999999998p 5.4504850000000003e-08 152.1875p 5.59556e-08 152.19999999999999p 5.7364379999999999e-08 152.21250000000001p 5.8730439999999998e-08 152.22500000000002p 6.0053040000000001e-08 152.23749999999998p 6.1331499999999996e-08 152.25p 6.2565169999999999e-08 152.26249999999999p 6.3753439999999997e-08 152.27500000000001p 6.4895749999999994e-08 152.28749999999999p 6.5991560000000005e-08 152.30000000000001p 6.7040400000000005e-08 152.3125p 6.8041809999999994e-08 152.32499999999999p 6.8995380000000005e-08
+ 152.33750000000001p 6.9900720000000002e-08 152.34999999999999p 7.0757479999999997e-08 152.36250000000001p 7.1565360000000002e-08 152.375p 7.2324069999999995e-08 152.38750000000002p 7.3033369999999995e-08 152.40000000000001p 7.3693039999999996e-08 152.41249999999999p 7.4302889999999998e-08 152.42499999999998p 7.4862760000000003e-08 152.4375p 7.5372510000000005e-08 152.44999999999999p 7.5832049999999996e-08 152.46250000000001p 7.6241289999999994e-08 152.47500000000002p 7.6600189999999999e-08 152.48750000000001p 7.6908700000000001e-08 152.5p 7.7166820000000001e-08 152.51249999999999p 7.7374570000000005e-08 152.52500000000001p 7.7531989999999999e-08 152.53749999999999p 7.7639130000000006e-08 152.55000000000001p 7.7696079999999995e-08
+ 152.5625p 7.7702920000000005e-08 152.57499999999999p 7.7659790000000001e-08 152.58749999999998p 7.7566799999999998e-08 152.59999999999999p 7.7424130000000001e-08 152.61250000000001p 7.7231920000000001e-08 152.625p 7.6990390000000002e-08 152.63750000000002p 7.6699719999999995e-08 152.65000000000001p 7.6360129999999999e-08 152.66249999999999p 7.5971870000000005e-08 152.67499999999998p 7.5535179999999999e-08 152.6875p 7.5050330000000006e-08 152.69999999999999p 7.4517599999999998e-08 152.71250000000001p 7.3937280000000005e-08 152.72499999999999p 7.330969e-08 152.73750000000001p 7.2635150000000003e-08 152.75p 7.1913989999999995e-08 152.76249999999999p 7.1146579999999994e-08 152.77500000000001p 7.0333290000000005e-08
+ 152.78749999999999p 6.9474489999999995e-08 152.80000000000001p 6.8570589999999994e-08 152.8125p 6.7621989999999998e-08 152.82500000000002p 6.6629149999999995e-08 152.83749999999998p 6.5592480000000003e-08 152.84999999999999p 6.451247e-08 152.86250000000001p 6.3389589999999996e-08 152.875p 6.2224329999999995e-08 152.88750000000002p 6.101722e-08 152.90000000000001p 5.9768769999999997e-08 152.91249999999999p 5.8479539999999997e-08 152.92499999999998p 5.7150099999999998e-08 152.9375p 5.5781029999999998e-08 152.94999999999999p 5.4372949999999997e-08 152.96250000000001p 5.2926469999999998e-08 152.97499999999999p 5.1442260000000002e-08 152.98750000000001p 4.9920980000000001e-08 153p 4.8363310000000001e-08
+ 153.01249999999999p 4.6769989999999998e-08 153.02500000000001p 4.5141739999999998e-08 153.03749999999999p 4.3479319999999998e-08 153.05000000000001p 4.1783530000000001e-08 153.0625p 4.0055180000000001e-08 153.07500000000002p 3.8295090000000002e-08 153.08749999999998p 3.6504139999999999e-08 153.09999999999999p 3.4683219999999998e-08 153.11250000000001p 3.2833230000000001e-08 153.125p 3.0955130000000003e-08 153.13750000000002p 2.904988e-08 153.15000000000001p 2.7118489999999999e-08 153.16250000000002p 2.5161980000000001e-08 153.17499999999998p 2.3181409999999999e-08 153.1875p 2.1177870000000001e-08 153.19999999999999p 1.9152479999999999e-08 153.21250000000001p 1.710637e-08 153.22499999999999p 1.5040729999999999e-08
+ 153.23750000000001p 1.2956759999999999e-08 153.25p 1.08557e-08 153.26249999999999p 8.7388079999999997e-09 153.27500000000001p 6.6073879999999996e-09 153.28749999999999p 4.462764e-09 153.30000000000001p 2.306289e-09 153.3125p 1.3934829999999999e-10 153.32500000000002p -2.0366440000000001e-09 153.33749999999998p -4.2202459999999997e-09 153.34999999999999p -6.409987e-09 153.36249999999998p -8.6043690000000006e-09 153.375p -1.080187e-08 153.38750000000002p -1.3000929999999999e-08 153.40000000000001p -1.5199980000000001e-08 153.41250000000002p -1.7397419999999998e-08 153.42499999999998p -1.9591629999999999e-08 153.4375p -2.1780939999999999e-08 153.44999999999999p -2.3963699999999999e-08
+ 153.46250000000001p -2.613822e-08 153.47499999999999p -2.8302780000000001e-08 153.48750000000001p -3.0455660000000002e-08 153.5p -3.259512e-08 153.51249999999999p -3.4719400000000003e-08 153.52500000000001p -3.682672e-08 153.53749999999999p -3.8915310000000001e-08 153.55000000000001p -4.0983370000000003e-08 153.5625p -4.30291e-08 153.57500000000002p -4.5050689999999998e-08 153.58749999999998p -4.7046330000000002e-08 153.59999999999999p -4.9014200000000002e-08 153.61249999999998p -5.0952490000000003e-08 153.625p -5.2859390000000002e-08 153.63750000000002p -5.473309e-08 153.65000000000001p -5.6571789999999998e-08 153.66250000000002p -5.8373680000000001e-08 153.67499999999998p -6.0137000000000004e-08
+ 153.6875p -6.185996e-08 153.69999999999999p -6.3540809999999999e-08 153.71250000000001p -6.5177819999999999e-08 153.72499999999999p -6.6769269999999994e-08 153.73750000000001p -6.8313469999999995e-08 153.75p -6.9808760000000003e-08 153.76249999999999p -7.1253480000000004e-08 153.77500000000001p -7.2646049999999997e-08 153.78749999999999p -7.3984870000000002e-08 153.80000000000001p -7.5268419999999998e-08 153.8125p -7.6495189999999999e-08 153.82500000000002p -7.766373e-08 153.83750000000001p -7.8772619999999998e-08 153.84999999999999p -7.982049e-08 153.86249999999998p -8.0806030000000005e-08 153.875p -8.1727950000000006e-08 153.88749999999999p -8.2585060000000001e-08 153.90000000000001p -8.3376190000000006e-08
+ 153.91250000000002p -8.4100240000000002e-08 153.92499999999998p -8.4756160000000006e-08 153.9375p -8.5342990000000002e-08 153.94999999999999p -8.5859810000000002e-08 153.96250000000001p -8.6305780000000001e-08 153.97499999999999p -8.6680120000000004e-08 153.98750000000001p -8.6982120000000003e-08 154p -8.7211150000000001e-08 154.01249999999999p -8.7366669999999998e-08 154.02500000000001p -8.7448169999999998e-08 154.03749999999999p -8.7455269999999998e-08 154.05000000000001p -8.7387640000000006e-08 154.0625p -8.7245020000000004e-08 154.07500000000002p -8.7027270000000002e-08 154.08750000000001p -8.6734300000000004e-08 154.09999999999999p -8.6366120000000006e-08 154.11249999999998p -8.5922809999999994e-08 154.125p -8.5404540000000002e-08
+ 154.13749999999999p -8.4811580000000004e-08 154.15000000000001p -8.4144270000000002e-08 154.16250000000002p -8.3403039999999995e-08 154.17499999999998p -8.2588410000000003e-08 154.1875p -8.1700990000000002e-08 154.19999999999999p -8.0741449999999999e-08 154.21250000000001p -7.971059e-08 154.22499999999999p -7.8609250000000006e-08 154.23750000000001p -7.7438389999999994e-08 154.25p -7.6199029999999996e-08 154.26249999999999p -7.489229e-08 154.27500000000001p -7.3519359999999994e-08 154.28749999999999p -7.2081510000000006e-08 154.30000000000001p -7.0580100000000006e-08 154.3125p -6.9016570000000004e-08 154.32500000000002p -6.7392410000000004e-08 154.33750000000001p -6.5709210000000004e-08 154.34999999999999p -6.3968630000000003e-08
+ 154.36249999999998p -6.2172389999999994e-08 154.375p -6.0322279999999999e-08 154.38749999999999p -5.8420160000000001e-08 154.40000000000001p -5.6467949999999997e-08 154.41249999999999p -5.4467639999999999e-08 154.42500000000001p -5.2421269999999997e-08 154.4375p -5.0330919999999997e-08 154.44999999999999p -4.8198760000000003e-08 154.46250000000001p -4.6026979999999999e-08 154.47499999999999p -4.3817810000000001e-08 154.48750000000001p -4.1573559999999998e-08 154.5p -3.929653e-08 154.51249999999999p -3.6989110000000003e-08 154.52499999999998p -3.4653679999999998e-08 154.53749999999999p -3.2292680000000001e-08 154.55000000000001p -2.9908550000000002e-08 154.5625p -2.7503769999999999e-08 154.57500000000002p -2.508083e-08
+ 154.58750000000001p -2.2642249999999999e-08 154.59999999999999p -2.0190540000000001e-08 154.61249999999998p -1.7728249999999999e-08 154.625p -1.5257890000000001e-08 154.63749999999999p -1.278202e-08 154.65000000000001p -1.030315e-08 154.66249999999999p -7.8238270000000006e-09 154.67500000000001p -5.3465589999999999e-09 154.6875p -2.8738520000000002e-09 154.69999999999999p -4.0819160000000001e-10 154.71250000000001p 2.0479550000000001e-09 154.72499999999999p 4.492146e-09 154.73750000000001p 6.9219650000000003e-09 154.75p 9.3350300000000002e-09 154.76250000000002p 1.172899e-08 154.77499999999998p 1.410153e-08 154.78749999999999p 1.6450370000000001e-08 154.80000000000001p 1.8773299999999998e-08
+ 154.8125p 2.1068119999999999e-08 154.82500000000002p 2.3332689999999998e-08 154.83750000000001p 2.5564950000000002e-08 154.84999999999999p 2.776285e-08 154.86249999999998p 2.9924419999999999e-08 154.875p 3.204776e-08 154.88749999999999p 3.413101e-08 154.90000000000001p 3.6172380000000003e-08 154.91249999999999p 3.8170149999999999e-08 154.92500000000001p 4.0122659999999999e-08 154.9375p 4.2028329999999997e-08 154.94999999999999p 4.3885639999999998e-08 154.96250000000001p 4.5693149999999999e-08 154.97499999999999p 4.7449490000000001e-08 154.98750000000001p 4.9153359999999999e-08 155p 5.0803540000000002e-08 155.01250000000002p 5.2398899999999999e-08 155.02499999999998p 5.3938350000000002e-08
+ 155.03749999999999p 5.5420919999999998e-08 155.04999999999998p 5.6845689999999999e-08 155.0625p 5.8211840000000001e-08 155.07500000000002p 5.9518599999999997e-08 155.08750000000001p 6.0765310000000001e-08 155.10000000000002p 6.1951370000000002e-08 155.11249999999998p 6.3076260000000005e-08 155.125p 6.4139540000000003e-08 155.13749999999999p 6.5140859999999996e-08 155.15000000000001p 6.6079919999999994e-08 155.16249999999999p 6.6956520000000001e-08 155.17500000000001p 6.7770519999999998e-08 155.1875p 6.8521870000000001e-08 155.19999999999999p 6.9210569999999999e-08 155.21250000000001p 6.9836719999999995e-08 155.22499999999999p 7.0400470000000006e-08 155.23750000000001p 7.0902039999999995e-08 155.25p 7.1341730000000004e-08
+ 155.26250000000002p 7.1719889999999994e-08 155.27499999999998p 7.2036950000000002e-08 155.28749999999999p 7.2293389999999996e-08 155.29999999999998p 7.2489759999999999e-08 155.3125p 7.262667e-08 155.32500000000002p 7.2704760000000004e-08 155.33750000000001p 7.2724760000000001e-08 155.35000000000002p 7.2687430000000006e-08 155.36249999999998p 7.2593590000000003e-08 155.375p 7.2444109999999999e-08 155.38749999999999p 7.2239890000000002e-08 155.40000000000001p 7.198189e-08 155.41249999999999p 7.1671099999999999e-08 155.42500000000001p 7.1308550000000002e-08 155.4375p 7.0895319999999997e-08 155.44999999999999p 7.0432510000000002e-08 155.46250000000001p 6.9921240000000005e-08 155.47499999999999p 6.9362689999999998e-08
+ 155.48750000000001p 6.8758039999999999e-08 155.5p 6.8108510000000001e-08 155.51250000000002p 6.7415330000000004e-08 155.52499999999998p 6.6679750000000005e-08 155.53749999999999p 6.5903050000000001e-08 155.54999999999998p 6.5086510000000002e-08 155.5625p 6.4231429999999999e-08 155.57500000000002p 6.3339130000000004e-08 155.58750000000001p 6.2410899999999997e-08 155.60000000000002p 6.1448090000000004e-08 155.61249999999998p 6.0452010000000001e-08 155.625p 5.9423979999999997e-08 155.63749999999999p 5.8365349999999999e-08 155.65000000000001p 5.7277419999999999e-08 155.66249999999999p 5.6161529999999999e-08 155.67500000000001p 5.5018970000000002e-08 155.6875p 5.3851069999999999e-08 155.69999999999999p 5.2659109999999997e-08
+ 155.71250000000001p 5.1444380000000003e-08 155.72499999999999p 5.020814e-08 155.73750000000001p 4.8951659999999998e-08 155.75p 4.7676180000000001e-08 155.76250000000002p 4.638292e-08 155.77500000000001p 4.5073080000000002e-08 155.78749999999999p 4.3747850000000001e-08 155.79999999999998p 4.24084e-08 155.8125p 4.1055860000000002e-08 155.82499999999999p 3.9691359999999997e-08 155.83750000000001p 3.8315999999999997e-08 155.85000000000002p 3.6930839999999997e-08 155.86249999999998p 3.5536940000000003e-08 155.875p 3.413531e-08 155.88749999999999p 3.272696e-08 155.90000000000001p 3.1312850000000002e-08 155.91249999999999p 2.9893919999999997e-08 155.92500000000001p 2.847109e-08
+ 155.9375p 2.7045249999999999e-08 155.94999999999999p 2.5617260000000001e-08 155.96250000000001p 2.4187949999999999e-08 155.97499999999999p 2.275812e-08 155.98750000000001p 2.1328560000000001e-08 156p 1.9900019999999999e-08 156.01250000000002p 1.847322e-08 156.02500000000001p 1.7048860000000001e-08 156.03749999999999p 1.5627610000000001e-08 156.04999999999998p 1.421012e-08 156.0625p 1.279701e-08 156.07499999999999p 1.138887e-08 156.08750000000001p 9.9862769999999998e-09 156.10000000000002p 8.5897840000000001e-09 156.11250000000001p 7.1999139999999998e-09 156.125p 5.8171729999999998e-09 156.13749999999999p 4.4420449999999996e-09 156.15000000000001p 3.0749930000000001e-09
+ 156.16249999999999p 1.716463e-09 156.17500000000001p 3.6687999999999998e-10 156.1875p -9.7334640000000005e-10 156.19999999999999p -2.303824e-09 156.21250000000001p -3.6241749999999998e-09 156.22499999999999p -4.9340359999999996e-09 156.23750000000001p -6.2330590000000001e-09 156.25p -7.5209059999999998e-09 156.26250000000002p -8.7972509999999999e-09 156.27500000000001p -1.006178e-08 156.28749999999999p -1.1314180000000001e-08 156.29999999999998p -1.2554159999999999e-08 156.3125p -1.3781419999999999e-08 156.32499999999999p -1.4995690000000001e-08 156.33750000000001p -1.619667e-08 156.34999999999999p -1.7384100000000001e-08 156.36250000000001p -1.855769e-08 156.375p -1.9717180000000002e-08
+ 156.38749999999999p -2.0862300000000001e-08 156.40000000000001p -2.199278e-08 156.41249999999999p -2.310835e-08 156.42500000000001p -2.4208729999999999e-08 156.4375p -2.5293649999999999e-08 156.45000000000002p -2.6362840000000001e-08 156.46249999999998p -2.7416009999999999e-08 156.47499999999999p -2.8452870000000002e-08 156.48750000000001p -2.947315e-08 156.5p -3.0476549999999998e-08 156.51250000000002p -3.1462750000000002e-08 156.52500000000001p -3.2431460000000002e-08 156.53749999999999p -3.338237e-08 156.54999999999998p -3.4315139999999998e-08 156.5625p -3.5229459999999998e-08 156.57499999999999p -3.6124989999999998e-08 156.58750000000001p -3.700139e-08 156.59999999999999p -3.7858299999999997e-08
+ 156.61250000000001p -3.8695370000000002e-08 156.625p -3.9512229999999997e-08 156.63749999999999p -4.0308510000000003e-08 156.65000000000001p -4.1083829999999998e-08 156.66249999999999p -4.1837800000000003e-08 156.67500000000001p -4.2570040000000003e-08 156.6875p -4.3280130000000003e-08 156.70000000000002p -4.3967679999999998e-08 156.71249999999998p -4.4632280000000002e-08 156.72499999999999p -4.5273499999999998e-08 156.73750000000001p -4.5890939999999998e-08 156.75p -4.6484170000000002e-08 156.76250000000002p -4.7052760000000001e-08 156.77500000000001p -4.7596289999999998e-08 156.78749999999999p -4.8114339999999999e-08 156.79999999999998p -4.8606470000000003e-08 156.8125p -4.9072249999999998e-08 156.82499999999999p -4.9511280000000002e-08
+ 156.83750000000001p -4.9923109999999998e-08 156.84999999999999p -5.0307339999999998e-08 156.86250000000001p -5.0663560000000002e-08 156.875p -5.0991359999999999e-08 156.88749999999999p -5.1290340000000001e-08 156.90000000000001p -5.1560099999999999e-08 156.91249999999999p -5.180029e-08 156.92500000000001p -5.2010509999999998e-08 156.9375p -5.2190420000000001e-08 156.95000000000002p -5.2339680000000001e-08 156.96249999999998p -5.2457950000000003e-08 156.97499999999999p -5.2544919999999999e-08 156.98749999999998p -5.2600310000000001e-08 157p -5.2623819999999997e-08 157.01250000000002p -5.2615209999999999e-08 157.02500000000001p -5.2574240000000002e-08 157.03750000000002p -5.2500690000000002e-08 157.04999999999998p -5.2394369999999998e-08
+ 157.0625p -5.2255119999999999e-08 157.07499999999999p -5.2082790000000003e-08 157.08750000000001p -5.1877270000000002e-08 157.09999999999999p -5.163847e-08 157.11250000000001p -5.1366320000000001e-08 157.125p -5.1060810000000002e-08 157.13749999999999p -5.0721919999999997e-08 157.15000000000001p -5.0349689999999998e-08 157.16249999999999p -4.9944179999999998e-08 157.17500000000001p -4.950548e-08 157.1875p -4.9033730000000001e-08 157.20000000000002p -4.852907e-08 157.21249999999998p -4.7991700000000001e-08 157.22499999999999p -4.7421860000000001e-08 157.23749999999998p -4.6819800000000001e-08 157.25p -4.6185820000000003e-08 157.26250000000002p -4.5520259999999997e-08 157.27500000000001p -4.4823479999999998e-08
+ 157.28750000000002p -4.4095889999999998e-08 157.29999999999998p -4.3337920000000002e-08 157.3125p -4.2550050000000003e-08 157.32499999999999p -4.1732800000000003e-08 157.33750000000001p -4.0886690000000001e-08 157.34999999999999p -4.0012319999999997e-08 157.36250000000001p -3.9110280000000001e-08 157.375p -3.8181229999999997e-08 157.38749999999999p -3.7225840000000001e-08 157.40000000000001p -3.6244829999999997e-08 157.41249999999999p -3.523893e-08 157.42500000000001p -3.4208910000000003e-08 157.4375p -3.3155580000000001e-08 157.45000000000002p -3.2079760000000003e-08 157.46249999999998p -3.0982309999999999e-08 157.47499999999999p -2.986412e-08 157.48749999999998p -2.8726080000000001e-08 157.5p -2.7569139999999999e-08
+ 157.51249999999999p -2.6394250000000002e-08 157.52500000000001p -2.5202380000000002e-08 157.53750000000002p -2.399454e-08 157.54999999999998p -2.277173e-08 157.5625p -2.1534980000000001e-08 157.57499999999999p -2.0285349999999998e-08 157.58750000000001p -1.90239e-08 157.59999999999999p -1.775169e-08 157.61250000000001p -1.646982e-08 157.625p -1.5179369999999999e-08 157.63749999999999p -1.388144e-08 157.65000000000001p -1.2577150000000001e-08 157.66249999999999p -1.12676e-08 157.67500000000001p -9.9539029999999998e-09 157.6875p -8.6371730000000004e-09 157.70000000000002p -7.3185219999999999e-09 157.71250000000001p -5.9990579999999999e-09 157.72499999999999p -4.6798859999999996e-09
+ 157.73749999999998p -3.3621039999999998e-09 157.75p -2.0468019999999998e-09 157.76249999999999p -7.3506090000000002e-10 157.77500000000001p 5.7204929999999999e-10 157.78750000000002p 1.873472e-09 157.79999999999998p 3.1681630000000001e-09 157.8125p 4.4550970000000003e-09 157.82499999999999p 5.7332630000000002e-09 157.83750000000001p 7.001669e-09 157.84999999999999p 8.2593440000000002e-09 157.86250000000001p 9.505338e-09 157.875p 1.0738719999999999e-08 157.88749999999999p 1.195859e-08 157.90000000000001p 1.316407e-08 157.91249999999999p 1.43543e-08 157.92500000000001p 1.552845e-08 157.9375p 1.6685740000000001e-08 157.95000000000002p 1.7825380000000001e-08
+ 157.96250000000001p 1.8946629999999999e-08 157.97499999999999p 2.0048789999999999e-08 157.98749999999998p 2.113117e-08 158p 2.2193130000000001e-08 158.01249999999999p 2.3234040000000001e-08 158.02500000000001p 2.4253330000000001e-08 158.03750000000002p 2.5250449999999999e-08 158.05000000000001p 2.622486e-08 158.0625p 2.717609e-08 158.07499999999999p 2.8103679999999999e-08 158.08750000000001p 2.900721e-08 158.09999999999999p 2.9886299999999997e-08 158.11250000000001p 3.0740580000000002e-08 158.125p 3.1569749999999997e-08 158.13749999999999p 3.2373509999999999e-08 158.15000000000001p 3.3151600000000003e-08 158.16249999999999p 3.3903810000000003e-08 158.17500000000001p 3.4629929999999997e-08
+ 158.1875p 3.5329800000000002e-08 158.20000000000002p 3.6003290000000001e-08 158.21250000000001p 3.665031e-08 158.22499999999999p 3.7270770000000003e-08 158.23749999999998p 3.786462e-08 158.25p 3.8431859999999998e-08 158.26249999999999p 3.8972480000000001e-08 158.27500000000001p 3.9486520000000001e-08 158.28749999999999p 3.9974039999999997e-08 158.30000000000001p 4.043513e-08 158.3125p 4.086987e-08 158.32499999999999p 4.1278400000000003e-08 158.33750000000001p 4.1660870000000003e-08 158.34999999999999p 4.201744e-08 158.36250000000001p 4.2348290000000003e-08 158.375p 4.2653619999999997e-08 158.38750000000002p 4.293365e-08 158.39999999999998p 4.3188609999999999e-08
+ 158.41249999999999p 4.3418740000000003e-08 158.42500000000001p 4.3624299999999997e-08 158.4375p 4.3805560000000001e-08 158.45000000000002p 4.3962790000000001e-08 158.46250000000001p 4.4096280000000003e-08 158.47499999999999p 4.4206320000000002e-08 158.48749999999998p 4.4293220000000002e-08 158.5p 4.4357269999999998e-08 158.51249999999999p 4.4398800000000002e-08 158.52500000000001p 4.44181e-08 158.53749999999999p 4.4415490000000002e-08 158.55000000000001p 4.43913e-08 158.5625p 4.4345829999999998e-08 158.57499999999999p 4.4279399999999997e-08 158.58750000000001p 4.4192319999999999e-08 158.59999999999999p 4.4084900000000002e-08 158.61250000000001p 4.3957449999999999e-08 158.625p 4.3810259999999997e-08
+ 158.63750000000002p 4.3643629999999998e-08 158.64999999999998p 4.3457859999999999e-08 158.66249999999999p 4.3253209999999998e-08 158.67500000000001p 4.3029980000000002e-08 158.6875p 4.2788420000000001e-08 158.70000000000002p 4.2528790000000002e-08 158.71250000000001p 4.2251340000000001e-08 158.72500000000002p 4.1956319999999998e-08 158.73749999999998p 4.1643950000000003e-08 158.75p 4.131445e-08 158.76249999999999p 4.0968039999999999e-08 158.77500000000001p 4.06049e-08 158.78749999999999p 4.0225240000000002e-08 158.80000000000001p 3.9829220000000003e-08 158.8125p 3.9417020000000001e-08 158.82499999999999p 3.8988789999999998e-08 158.83750000000001p 3.8544669999999999e-08 158.84999999999999p 3.8084800000000002e-08
+ 158.86250000000001p 3.7609310000000002e-08 158.875p 3.7118310000000001e-08 158.88750000000002p 3.6611899999999998e-08 158.89999999999998p 3.6090179999999999e-08 158.91249999999999p 3.5553239999999998e-08 158.92499999999998p 3.5001149999999998e-08 158.9375p 3.4433980000000003e-08 158.95000000000002p 3.38518e-08 158.96250000000001p 3.3254670000000003e-08 158.97500000000002p 3.2642620000000001e-08 158.98749999999998p 3.201571e-08 159p 3.137398e-08 159.01249999999999p 3.0717450000000001e-08 159.02500000000001p 3.0046169999999998e-08 159.03749999999999p 2.9360160000000001e-08 159.05000000000001p 2.865945e-08 159.0625p 2.7944070000000001e-08 159.07499999999999p 2.7214050000000001e-08
+ 159.08750000000001p 2.6469409999999999e-08 159.09999999999999p 2.5710200000000001e-08 159.11250000000001p 2.4936430000000001e-08 159.125p 2.414815e-08 159.13750000000002p 2.334541e-08 159.14999999999998p 2.2528259999999998e-08 159.16249999999999p 2.1696749999999999e-08 159.17499999999998p 2.085095e-08 159.1875p 1.9990940000000001e-08 159.20000000000002p 1.9116790000000001e-08 159.21250000000001p 1.8228619999999999e-08 159.22500000000002p 1.7326519999999999e-08 159.23749999999998p 1.6410619999999998e-08 159.25p 1.5481050000000001e-08 159.26249999999999p 1.453797e-08 159.27500000000001p 1.3581539999999999e-08 159.28749999999999p 1.261195e-08 159.30000000000001p 1.1629409999999999e-08
+ 159.3125p 1.063412e-08 159.32499999999999p 9.6263390000000002e-09 159.33750000000001p 8.6063219999999995e-09 159.34999999999999p 7.5743520000000002e-09 159.36250000000001p 6.5307310000000002e-09 159.375p 5.4757869999999996e-09 159.38750000000002p 4.4098680000000004e-09 159.39999999999998p 3.3333470000000002e-09 159.41249999999999p 2.2466220000000001e-09 159.42499999999998p 1.1501120000000001e-09 159.4375p 4.4264119999999998e-11 159.44999999999999p -1.07045e-09 159.46250000000001p -2.193534e-09 159.47500000000002p -3.3244649999999999e-09 159.48749999999998p -4.4626950000000004e-09 159.5p -5.6076499999999998e-09 159.51249999999999p -6.7587279999999997e-09 159.52500000000001p -7.9153030000000007e-09
+ 159.53749999999999p -9.0767240000000005e-09 159.55000000000001p -1.024231e-08 159.5625p -1.1411359999999999e-08 159.57499999999999p -1.2583150000000001e-08 159.58750000000001p -1.375692e-08 159.59999999999999p -1.4931889999999999e-08 159.61250000000001p -1.610727e-08 159.625p -1.7282219999999999e-08 159.63750000000002p -1.8455900000000001e-08 159.65000000000001p -1.9627439999999999e-08 159.66249999999999p -2.079596e-08 159.67499999999998p -2.196053e-08 159.6875p -2.3120229999999998e-08 159.69999999999999p -2.4274110000000001e-08 159.71250000000001p -2.5421200000000001e-08 159.72500000000002p -2.6560530000000001e-08 159.73749999999998p -2.7691099999999998e-08 159.75p -2.8811880000000002e-08
+ 159.76249999999999p -2.9921880000000003e-08 159.77500000000001p -3.1020029999999999e-08 159.78749999999999p -3.2105310000000001e-08 159.80000000000001p -3.3176670000000001e-08 159.8125p -3.4233030000000003e-08 159.82499999999999p -3.527333e-08 159.83750000000001p -3.6296520000000003e-08 159.84999999999999p -3.7301499999999998e-08 159.86250000000001p -3.8287229999999998e-08 159.875p -3.9252610000000002e-08 159.88750000000002p -4.0196590000000001e-08 159.90000000000001p -4.1118099999999997e-08 159.91249999999999p -4.2016089999999999e-08 159.92499999999998p -4.2889500000000002e-08 159.9375p -4.37373e-08 159.94999999999999p -4.4558460000000002e-08 159.96250000000001p -4.5351949999999999e-08 159.97499999999999p -4.6116799999999998e-08
+ 159.98750000000001p -4.6852000000000002e-08 160p -4.7556610000000002e-08 160.01249999999999p -4.822966e-08 160.02500000000001p -4.887025e-08 160.03749999999999p -4.9477469999999998e-08 160.05000000000001p -5.0050460000000003e-08 160.0625p -5.0588359999999998e-08 160.07499999999999p -5.1090359999999999e-08 160.08749999999998p -5.1555679999999999e-08 160.09999999999999p -5.1983560000000003e-08 160.11250000000001p -5.2373279999999998e-08 160.125p -5.2724160000000001e-08 160.13750000000002p -5.3035550000000001e-08 160.15000000000001p -5.3306839999999997e-08 160.16249999999999p -5.3537459999999999e-08 160.17499999999998p -5.3726879999999997e-08 160.1875p -5.3874609999999999e-08 160.19999999999999p -5.3980200000000002e-08
+ 160.21250000000001p -5.4043250000000003e-08 160.22499999999999p -5.4063409999999997e-08 160.23750000000001p -5.4040369999999998e-08 160.25p -5.3973859999999999e-08 160.26249999999999p -5.3863660000000003e-08 160.27500000000001p -5.3709609999999997e-08 160.28749999999999p -5.3511580000000001e-08 160.30000000000001p -5.3269510000000003e-08 160.3125p -5.2983389999999997e-08 160.32500000000002p -5.2653230000000002e-08 160.33749999999998p -5.2279110000000003e-08 160.34999999999999p -5.1861180000000001e-08 160.36250000000001p -5.1399620000000002e-08 160.375p -5.0894650000000001e-08 160.38750000000002p -5.0346559999999999e-08 160.40000000000001p -4.9755680000000003e-08 160.41249999999999p -4.912241e-08 160.42499999999998p -4.8447169999999998e-08
+ 160.4375p -4.7730450000000002e-08 160.44999999999999p -4.6972780000000002e-08 160.46250000000001p -4.6174750000000001e-08 160.47499999999999p -4.5336990000000001e-08 160.48750000000001p -4.4460169999999997e-08 160.5p -4.3545019999999997e-08 160.51249999999999p -4.2592299999999998e-08 160.52500000000001p -4.1602820000000001e-08 160.53749999999999p -4.0577460000000001e-08 160.55000000000001p -3.9517089999999998e-08 160.5625p -3.8422659999999997e-08 160.57500000000002p -3.7295140000000002e-08 160.58749999999998p -3.6135559999999999e-08 160.59999999999999p -3.4944970000000003e-08 160.61250000000001p -3.3724450000000003e-08 160.625p -3.247513e-08 160.63750000000002p -3.1198150000000001e-08 160.65000000000001p -2.9894709999999998e-08
+ 160.66250000000002p -2.8566019999999999e-08 160.67499999999998p -2.721331e-08 160.6875p -2.5837860000000001e-08 160.69999999999999p -2.4440940000000001e-08 160.71250000000001p -2.302388e-08 160.72499999999999p -2.1588000000000001e-08 160.73750000000001p -2.0134649999999999e-08 160.75p -1.866519e-08 160.76249999999999p -1.7181e-08 160.77500000000001p -1.568348e-08 160.78749999999999p -1.417402e-08 160.80000000000001p -1.265403e-08 160.8125p -1.1124939999999999e-08 160.82500000000002p -9.5881449999999995e-09 160.83749999999998p -8.0450849999999992e-09 160.84999999999999p -6.4971790000000002e-09 160.86249999999998p -4.9458500000000002e-09 160.875p -3.3925170000000001e-09
+ 160.88750000000002p -1.8385930000000001e-09 160.90000000000001p -2.8548729999999998e-10 160.91250000000002p 1.265402e-09 160.92499999999998p 2.812687e-09 160.9375p 4.3549889999999998e-09 160.94999999999999p 5.8909470000000001e-09 160.96250000000001p 7.4192110000000004e-09 160.97499999999999p 8.9384510000000002e-09 160.98750000000001p 1.044735e-08 161p 1.194463e-08 161.01249999999999p 1.3429000000000001e-08 161.02500000000001p 1.4899220000000001e-08 161.03749999999999p 1.6354060000000001e-08 161.05000000000001p 1.7792330000000001e-08 161.0625p 1.921286e-08 161.07500000000002p 2.0614489999999999e-08 161.08749999999998p 2.1996109999999999e-08 161.09999999999999p 2.335663e-08
+ 161.11249999999998p 2.4694990000000001e-08 161.125p 2.601018e-08 161.13750000000002p 2.7301200000000002e-08 161.15000000000001p 2.8567089999999999e-08 161.16250000000002p 2.9806919999999998e-08 161.17499999999998p 3.1019799999999998e-08 161.1875p 3.2204879999999998e-08 161.19999999999999p 3.3361339999999999e-08 161.21250000000001p 3.4488390000000003e-08 161.22499999999999p 3.5585280000000001e-08 161.23750000000001p 3.6651299999999998e-08 161.25p 3.768578e-08 161.26249999999999p 3.8688080000000001e-08 161.27500000000001p 3.9657589999999999e-08 161.28749999999999p 4.0593760000000002e-08 161.30000000000001p 4.1496049999999999e-08 161.3125p 4.2363989999999998e-08 161.32500000000002p 4.3197099999999998e-08
+ 161.33750000000001p 4.3994979999999998e-08 161.34999999999999p 4.4757259999999999e-08 161.36249999999998p 4.5483570000000001e-08 161.375p 4.6173619999999998e-08 161.38749999999999p 4.6827139999999998e-08 161.40000000000001p 4.7443890000000003e-08 161.41250000000002p 4.8023650000000001e-08 161.42499999999998p 4.8566280000000003e-08 161.4375p 4.9071620000000002e-08 161.44999999999999p 4.9539579999999997e-08 161.46250000000001p 4.9970089999999999e-08 161.47499999999999p 5.0363099999999998e-08 161.48750000000001p 5.0718619999999997e-08 161.5p 5.103666e-08 161.51249999999999p 5.1317279999999999e-08 161.52500000000001p 5.1560550000000003e-08 161.53749999999999p 5.1766580000000001e-08 161.55000000000001p 5.1935520000000002e-08
+ 161.5625p 5.2067510000000003e-08 161.57500000000002p 5.2162750000000002e-08 161.58750000000001p 5.2221460000000003e-08 161.59999999999999p 5.2243860000000003e-08 161.61249999999998p 5.2230220000000002e-08 161.625p 5.2180810000000002e-08 161.63749999999999p 5.2095939999999999e-08 161.65000000000001p 5.1975929999999999e-08 161.66250000000002p 5.182113e-08 161.67499999999998p 5.163189e-08 161.6875p 5.1408590000000002e-08 161.69999999999999p 5.1151630000000002e-08 161.71250000000001p 5.0861420000000003e-08 161.72499999999999p 5.0538400000000001e-08 161.73750000000001p 5.0182989999999997e-08 161.75p 4.9795660000000002e-08 161.76249999999999p 4.9376869999999998e-08 161.77500000000001p 4.8927119999999997e-08
+ 161.78749999999999p 4.8446890000000002e-08 161.80000000000001p 4.7936679999999998e-08 161.8125p 4.7397019999999997e-08 161.82500000000002p 4.6828420000000002e-08 161.83750000000001p 4.623142e-08 161.84999999999999p 4.5606570000000001e-08 161.86249999999998p 4.4954409999999998e-08 161.875p 4.4275499999999998e-08 161.88749999999999p 4.3570400000000001e-08 161.90000000000001p 4.2839680000000002e-08 161.91249999999999p 4.2083929999999999e-08 161.92500000000001p 4.1303720000000001e-08 161.9375p 4.0499640000000003e-08 161.94999999999999p 3.9672280000000003e-08 161.96250000000001p 3.8822230000000002e-08 161.97499999999999p 3.7950099999999998e-08 161.98750000000001p 3.7056490000000002e-08 162p 3.6142e-08
+ 162.01249999999999p 3.5207249999999999e-08 162.02499999999998p 3.4252850000000001e-08 162.03749999999999p 3.3279410000000001e-08 162.05000000000001p 3.228755e-08 162.0625p 3.1277879999999999e-08 162.07500000000002p 3.0251039999999997e-08 162.08750000000001p 2.920765e-08 162.09999999999999p 2.8148320000000001e-08 162.11249999999998p 2.7073699999999998e-08 162.125p 2.5984410000000001e-08 162.13749999999999p 2.4881079999999999e-08 162.15000000000001p 2.3764349999999999e-08 162.16249999999999p 2.2634849999999999e-08 162.17500000000001p 2.149322e-08 162.1875p 2.0340100000000001e-08 162.19999999999999p 1.9176130000000001e-08 162.21250000000001p 1.8001959999999998e-08 162.22499999999999p 1.6818229999999999e-08
+ 162.23750000000001p 1.5625589999999999e-08 162.25p 1.44247e-08 162.26250000000002p 1.32162e-08 162.27499999999998p 1.2000750000000001e-08 162.28749999999999p 1.077902e-08 162.30000000000001p 9.5516530000000003e-09 162.3125p 8.3193259999999996e-09 162.32500000000002p 7.0827019999999998e-09 162.33750000000001p 5.8424529999999999e-09 162.34999999999999p 4.5992529999999999e-09 162.36249999999998p 3.3537769999999998e-09 162.375p 2.1067069999999999e-09 162.38749999999999p 8.587268e-10 162.40000000000001p -3.8947750000000001e-10 162.41249999999999p -1.6372149999999999e-09 162.42500000000001p -2.8837909999999999e-09 162.4375p -4.1285079999999996e-09 162.44999999999999p -5.3706640000000002e-09
+ 162.46250000000001p -6.609556e-09 162.47499999999999p -7.8444739999999995e-09 162.48750000000001p -9.0747069999999994e-09 162.5p -1.029954e-08 162.51250000000002p -1.1518259999999999e-08 162.52499999999998p -1.2730130000000001e-08 162.53749999999999p -1.393445e-08 162.54999999999998p -1.5130470000000001e-08 162.5625p -1.6317470000000001e-08 162.57500000000002p -1.7494719999999999e-08 162.58750000000001p -1.8661490000000001e-08 162.60000000000002p -1.9817040000000001e-08 162.61249999999998p -2.0960629999999999e-08 162.625p -2.2091529999999999e-08 162.63749999999999p -2.320899e-08 162.65000000000001p -2.4312289999999999e-08 162.66249999999999p -2.5400670000000001e-08 162.67500000000001p -2.647341e-08
+ 162.6875p -2.7529759999999999e-08 162.69999999999999p -2.8568999999999999e-08 162.71250000000001p -2.9590380000000001e-08 162.72499999999999p -3.0593190000000002e-08 162.73750000000001p -3.1576689999999999e-08 162.75p -3.2540159999999997e-08 162.76250000000002p -3.3482890000000001e-08 162.77499999999998p -3.440416e-08 162.78749999999999p -3.5303270000000002e-08 162.79999999999998p -3.6179520000000003e-08 162.8125p -3.7032220000000001e-08 162.82500000000002p -3.7860680000000001e-08 162.83750000000001p -3.8664250000000002e-08 162.85000000000002p -3.944224e-08 162.86249999999998p -4.0194009999999999e-08 162.875p -4.0918930000000002e-08 162.88749999999999p -4.1616360000000002e-08 162.90000000000001p -4.2285680000000003e-08
+ 162.91249999999999p -4.2926319999999999e-08 162.92500000000001p -4.353766e-08 162.9375p -4.4119159999999998e-08 162.94999999999999p -4.4670270000000002e-08 162.96250000000001p -4.5190439999999998e-08 162.97499999999999p -4.5679170000000003e-08 162.98750000000001p -4.6135959999999998e-08 163p -4.6560339999999997e-08 163.01250000000002p -4.6951870000000001e-08 163.02499999999998p -4.731011e-08 163.03749999999999p -4.7634669999999997e-08 163.04999999999998p -4.7925150000000002e-08 163.0625p -4.8181219999999997e-08 163.07500000000002p -4.8402530000000002e-08 163.08750000000001p -4.8588789999999998e-08 163.10000000000002p -4.8739720000000002e-08 163.11249999999998p -4.8855089999999999e-08 163.125p -4.8934659999999999e-08
+ 163.13749999999999p -4.897826e-08 163.15000000000001p -4.8985740000000003e-08 163.16249999999999p -4.895696e-08 163.17500000000001p -4.8891829999999997e-08 163.1875p -4.8790290000000002e-08 163.19999999999999p -4.8652320000000001e-08 163.21250000000001p -4.8477909999999997e-08 163.22499999999999p -4.8267120000000003e-08 163.23750000000001p -4.8020000000000003e-08 163.25p -4.773667e-08 163.26250000000002p -4.7417279999999997e-08 163.27500000000001p -4.7061989999999998e-08 163.28749999999999p -4.6671020000000001e-08 163.29999999999998p -4.6244610000000003e-08 163.3125p -4.578306e-08 163.32499999999999p -4.5286670000000001e-08 163.33750000000001p -4.4755800000000003e-08 163.35000000000002p -4.4190839999999997e-08
+ 163.36249999999998p -4.3592200000000002e-08 163.375p -4.2960359999999998e-08 163.38749999999999p -4.2295790000000003e-08 163.40000000000001p -4.159904e-08 163.41249999999999p -4.0870649999999997e-08 163.42500000000001p -4.0111219999999998e-08 163.4375p -3.9321369999999997e-08 163.44999999999999p -3.8501779999999999e-08 163.46250000000001p -3.7653119999999998e-08 163.47499999999999p -3.677611e-08 163.48750000000001p -3.5871519999999998e-08 163.5p -3.4940110000000003e-08 163.51250000000002p -3.3982710000000001e-08 163.52500000000001p -3.3000140000000003e-08 163.53749999999999p -3.1993270000000001e-08 163.54999999999998p -3.0962999999999997e-08 163.5625p -2.9910230000000002e-08 163.57499999999999p -2.8835899999999999e-08
+ 163.58750000000001p -2.774098e-08 163.60000000000002p -2.6626440000000001e-08 163.61250000000001p -2.5493299999999998e-08 163.625p -2.434257e-08 163.63749999999999p -2.3175280000000001e-08 163.65000000000001p -2.199251e-08 163.66249999999999p -2.0795310000000001e-08 163.67500000000001p -1.9584759999999999e-08 163.6875p -1.8361979999999999e-08 163.69999999999999p -1.7128059999999999e-08 163.71250000000001p -1.588412e-08 163.72499999999999p -1.463128e-08 163.73750000000001p -1.337068e-08 163.75p -1.210345e-08 163.76250000000002p -1.083072e-08 163.77500000000001p -9.5536549999999999e-09 163.78749999999999p -8.2733790000000007e-09 163.79999999999998p -6.9910369999999998e-09
+ 163.8125p -5.7077680000000002e-09 163.82499999999999p -4.424707e-09 163.83750000000001p -3.1429820000000001e-09 163.84999999999999p -1.8637170000000001e-09 163.86250000000001p -5.8802400000000004e-10 163.875p 6.8299109999999997e-10 163.88749999999999p 1.9482359999999998e-09 163.90000000000001p 3.2066279999999999e-09 163.91249999999999p 4.4571020000000001e-09 163.92500000000001p 5.6986060000000004e-09 163.9375p 6.9301029999999996e-09 163.95000000000002p 8.1505749999999998e-09 163.96249999999998p 9.3590249999999993e-09 163.97499999999999p 1.0554470000000001e-08 163.98750000000001p 1.173596e-08 164p 1.290255e-08 164.01250000000002p 1.4053329999999999e-08 164.02500000000001p 1.518742e-08
+ 164.03749999999999p 1.6303939999999999e-08 164.04999999999998p 1.7402069999999998e-08 164.0625p 1.8480999999999999e-08 164.07499999999999p 1.9539929999999999e-08 164.08750000000001p 2.0578119999999999e-08 164.09999999999999p 2.1594850000000001e-08 164.11250000000001p 2.258941e-08 164.125p 2.356115e-08 164.13749999999999p 2.4509429999999999e-08 164.15000000000001p 2.5433639999999999e-08 164.16249999999999p 2.6333219999999999e-08 164.17500000000001p 2.7207629999999999e-08 164.1875p 2.8056359999999999e-08 164.20000000000002p 2.8878930000000001e-08 164.21249999999998p 2.967492e-08 164.22499999999999p 3.0443899999999999e-08 164.23750000000001p 3.1185499999999998e-08 164.25p 3.1899380000000002e-08
+ 164.26250000000002p 3.2585220000000001e-08 164.27500000000001p 3.3242759999999998e-08 164.28749999999999p 3.3871739999999997e-08 164.29999999999998p 3.4471950000000003e-08 164.3125p 3.5043209999999999e-08 164.32499999999999p 3.5585370000000003e-08 164.33750000000001p 3.6098310000000003e-08 164.34999999999999p 3.658195e-08 164.36250000000001p 3.7036210000000002e-08 164.375p 3.7461090000000003e-08 164.38749999999999p 3.7856570000000001e-08 164.40000000000001p 3.8222680000000001e-08 164.41249999999999p 3.8559489999999999e-08 164.42500000000001p 3.8867079999999999e-08 164.4375p 3.9145559999999997e-08 164.45000000000002p 3.9395060000000002e-08 164.46249999999998p 3.9615750000000002e-08 164.47499999999999p 3.980781e-08
+ 164.48749999999998p 3.9971449999999999e-08 164.5p 4.0106910000000001e-08 164.51250000000002p 4.0214429999999997e-08 164.52500000000001p 4.0294290000000003e-08 164.53750000000002p 4.034678e-08 164.54999999999998p 4.0372220000000003e-08 164.5625p 4.0370930000000002e-08 164.57499999999999p 4.0343260000000003e-08 164.58750000000001p 4.0289579999999997e-08 164.59999999999999p 4.0210259999999998e-08 164.61250000000001p 4.0105690000000002e-08 164.625p 3.9976279999999997e-08 164.63749999999999p 3.9822439999999999e-08 164.65000000000001p 3.9644609999999997e-08 164.66249999999999p 3.9443229999999998e-08 164.67500000000001p 3.9218730000000002e-08 164.6875p 3.8971579999999998e-08 164.70000000000002p 3.8702240000000002e-08
+ 164.71249999999998p 3.841117e-08 164.72499999999999p 3.8098870000000001e-08 164.73749999999998p 3.7765790000000001e-08 164.75p 3.7412439999999999e-08 164.76250000000002p 3.7039289999999998e-08 164.77500000000001p 3.6646839999999999e-08 164.78750000000002p 3.6235579999999999e-08 164.79999999999998p 3.5806000000000003e-08 164.8125p 3.5358590000000001e-08 164.82499999999999p 3.4893840000000003e-08 164.83750000000001p 3.4412240000000001e-08 164.84999999999999p 3.3914279999999998e-08 164.86250000000001p 3.3400440000000003e-08 164.875p 3.2871220000000001e-08 164.88749999999999p 3.2327069999999998e-08 164.90000000000001p 3.1768490000000001e-08 164.91249999999999p 3.1195930000000001e-08 164.92500000000001p 3.0609860000000002e-08
+ 164.9375p 3.0010750000000003e-08 164.95000000000002p 2.939904e-08 164.96249999999998p 2.8775169999999999e-08 164.97499999999999p 2.8139600000000001e-08 164.98749999999998p 2.749275e-08 165p 2.6835050000000001e-08 165.01249999999999p 2.616692e-08 165.02500000000001p 2.548876e-08 165.03750000000002p 2.4801000000000002e-08 165.04999999999998p 2.4104009999999999e-08 165.0625p 2.339819e-08 165.07499999999999p 2.2683920000000001e-08 165.08750000000001p 2.196158e-08 165.09999999999999p 2.123153e-08 165.11250000000001p 2.049414e-08 165.125p 1.9749740000000001e-08 165.13749999999999p 1.8998700000000001e-08 165.15000000000001p 1.824134e-08
+ 165.16249999999999p 1.7477999999999999e-08 165.17500000000001p 1.6709010000000001e-08 165.1875p 1.5934670000000001e-08 165.20000000000002p 1.5155309999999999e-08 165.21250000000001p 1.4371230000000001e-08 165.22499999999999p 1.358273e-08 165.23749999999998p 1.2790109999999999e-08 165.25p 1.1993660000000001e-08 165.26249999999999p 1.119367e-08 165.27500000000001p 1.0390420000000001e-08 165.28750000000002p 9.5841990000000006e-09 165.29999999999998p 8.7752750000000008e-09 165.3125p 7.9639260000000006e-09 165.32499999999999p 7.1504250000000002e-09 165.33750000000001p 6.3350440000000001e-09 165.34999999999999p 5.5180500000000004e-09 165.36250000000001p 4.699715e-09 165.375p 3.8803050000000003e-09
+ 165.38749999999999p 3.060089e-09 165.40000000000001p 2.2393370000000001e-09 165.41249999999999p 1.4183179999999999e-09 165.42500000000001p 5.9730349999999997e-10 165.4375p -2.2343270000000001e-10 165.45000000000002p -1.0436159999999999e-09 165.46250000000001p -1.8629670000000001e-09 165.47499999999999p -2.6812060000000001e-09 165.48749999999998p -3.4980480000000001e-09 165.5p -4.313204e-09 165.51249999999999p -5.1263820000000001e-09 165.52500000000001p -5.9372850000000003e-09 165.53750000000002p -6.7456120000000001e-09 165.55000000000001p -7.5510550000000002e-09 165.5625p -8.3533029999999994e-09 165.57499999999999p -9.152037e-09 165.58750000000001p -9.9469350000000005e-09 165.59999999999999p -1.0737670000000001e-08
+ 165.61250000000001p -1.1523900000000001e-08 165.625p -1.230528e-08 165.63749999999999p -1.3081470000000001e-08 165.65000000000001p -1.3852120000000001e-08 165.66249999999999p -1.461686e-08 165.67500000000001p -1.537532e-08 165.6875p -1.6127140000000001e-08 165.70000000000002p -1.6871920000000001e-08 165.71250000000001p -1.7609279999999999e-08 165.72499999999999p -1.8338840000000002e-08 165.73749999999998p -1.9060180000000001e-08 165.75p -1.9772909999999999e-08 165.76249999999999p -2.047661e-08 165.77500000000001p -2.117087e-08 165.78749999999999p -2.185526e-08 165.80000000000001p -2.2529370000000002e-08 165.8125p -2.3192750000000001e-08 165.82499999999999p -2.384498e-08
+ 165.83750000000001p -2.44856e-08 165.84999999999999p -2.51142e-08 165.86250000000001p -2.5730309999999999e-08 165.875p -2.6333489999999999e-08 165.88750000000002p -2.6923289999999999e-08 165.89999999999998p -2.749927e-08 165.91249999999999p -2.8060969999999999e-08 165.92500000000001p -2.8607930000000001e-08 165.9375p -2.9139720000000002e-08 165.95000000000002p -2.9655879999999999e-08 165.96250000000001p -3.0155969999999999e-08 165.97499999999999p -3.0639540000000001e-08 165.98749999999998p -3.1106150000000002e-08 166p -3.1555360000000003e-08 166.01249999999999p -3.1986739999999997e-08 166.02500000000001p -3.2399860000000001e-08 166.03749999999999p -3.2794310000000002e-08 166.05000000000001p -3.3169680000000002e-08
+ 166.0625p -3.3525539999999998e-08 166.07499999999999p -3.3861520000000002e-08 166.08750000000001p -3.4177210000000003e-08 166.09999999999999p -3.447225e-08 166.11250000000001p -3.4746269999999999e-08 166.125p -3.4998909999999999e-08 166.13750000000002p -3.5229829999999997e-08 166.14999999999998p -3.5438700000000001e-08 166.16249999999999p -3.5625209999999997e-08 166.17500000000001p -3.578905e-08 166.1875p -3.5929950000000002e-08 166.20000000000002p -3.6047630000000001e-08 166.21250000000001p -3.6141840000000002e-08 166.22500000000002p -3.6212340000000003e-08 166.23749999999998p -3.6258929999999998e-08 166.25p -3.6281400000000001e-08 166.26249999999999p -3.6279580000000003e-08 166.27500000000001p -3.6253299999999997e-08
+ 166.28749999999999p -3.6202439999999997e-08 166.30000000000001p -3.6126870000000001e-08 166.3125p -3.6026500000000002e-08 166.32499999999999p -3.5901260000000002e-08 166.33750000000001p -3.5751099999999999e-08 166.34999999999999p -3.5576e-08 166.36250000000001p -3.5375939999999999e-08 166.375p -3.5150940000000002e-08 166.38750000000002p -3.4901060000000002e-08 166.39999999999998p -3.4626359999999997e-08 166.41249999999999p -3.4326929999999998e-08 166.42499999999998p -3.4002890000000001e-08 166.4375p -3.365438e-08 166.45000000000002p -3.3281559999999999e-08 166.46250000000001p -3.2884619999999998e-08 166.47500000000002p -3.2463789999999998e-08 166.48749999999998p -3.2019289999999997e-08 166.5p -3.1551390000000001e-08
+ 166.51249999999999p -3.106039e-08 166.52500000000001p -3.0546589999999997e-08 166.53749999999999p -3.0010330000000001e-08 166.55000000000001p -2.9451959999999998e-08 166.5625p -2.887188e-08 166.57499999999999p -2.8270489999999998e-08 166.58750000000001p -2.7648220000000001e-08 166.59999999999999p -2.700551e-08 166.61250000000001p -2.6342840000000002e-08 166.625p -2.5660710000000001e-08 166.63750000000002p -2.4959620000000001e-08 166.64999999999998p -2.4240119999999999e-08 166.66249999999999p -2.3502749999999998e-08 166.67499999999998p -2.2748089999999999e-08 166.6875p -2.1976729999999999e-08 166.70000000000002p -2.1189269999999999e-08 166.71250000000001p -2.038635e-08 166.72500000000002p -1.956859e-08
+ 166.73749999999998p -1.8736659999999998e-08 166.75p -1.7891229999999998e-08 166.76249999999999p -1.7032960000000002e-08 166.77500000000001p -1.6162569999999999e-08 166.78749999999999p -1.5280759999999999e-08 166.80000000000001p -1.438824e-08 166.8125p -1.3485740000000001e-08 166.82499999999999p -1.2574000000000001e-08 166.83750000000001p -1.1653749999999999e-08 166.84999999999999p -1.0725760000000001e-08 166.86250000000001p -9.7907659999999996e-09 166.875p -8.8495419999999994e-09 166.88750000000002p -7.9028479999999992e-09 166.89999999999998p -6.9514530000000001e-09 166.91249999999999p -5.9961270000000003e-09 166.92499999999998p -5.0376409999999999e-09 166.9375p -4.0767670000000001e-09 166.94999999999999p -3.1142739999999999e-09
+ 166.96250000000001p -2.150932e-09 166.97500000000002p -1.187507e-09 166.98749999999998p -2.2476139999999999e-10 167p 7.3654720000000004e-10 167.01249999999999p 1.695666e-09 167.02500000000001p 2.6518479999999999e-09 167.03749999999999p 3.6043539999999999e-09 167.05000000000001p 4.5524520000000002e-09 167.0625p 5.4954209999999999e-09 167.07499999999999p 6.4325450000000001e-09 167.08750000000001p 7.3631229999999998e-09 167.09999999999999p 8.2864620000000006e-09 167.11250000000001p 9.2018810000000004e-09 167.125p 1.010871e-08 167.13750000000002p 1.1006300000000001e-08 167.15000000000001p 1.1894e-08 167.16249999999999p 1.277119e-08 167.17499999999998p 1.363726e-08
+ 167.1875p 1.44916e-08 167.19999999999999p 1.5333630000000001e-08 167.21250000000001p 1.616279e-08 167.22500000000002p 1.6978529999999998e-08 167.23749999999998p 1.778032e-08 167.25p 1.8567629999999999e-08 167.26249999999999p 1.933998e-08 167.27500000000001p 2.0096879999999999e-08 167.28749999999999p 2.0837869999999999e-08 167.30000000000001p 2.1562499999999999e-08 167.3125p 2.2270349999999999e-08 167.32499999999999p 2.2961009999999999e-08 167.33750000000001p 2.3634100000000001e-08 167.34999999999999p 2.428924e-08 167.36250000000001p 2.492607e-08 167.375p 2.554428e-08 167.38750000000002p 2.6143550000000001e-08 167.40000000000001p 2.672357e-08
+ 167.41249999999999p 2.728408e-08 167.42499999999998p 2.7824810000000002e-08 167.4375p 2.834552e-08 167.44999999999999p 2.8845999999999999e-08 167.46250000000001p 2.932603e-08 167.47499999999999p 2.978543e-08 167.48750000000001p 3.0224039999999999e-08 167.5p 3.0641689999999998e-08 167.51249999999999p 3.1038270000000003e-08 167.52500000000001p 3.141363e-08 167.53749999999999p 3.1767689999999997e-08 167.55000000000001p 3.2100359999999999e-08 167.5625p 3.2411559999999998e-08 167.57499999999999p 3.2701250000000003e-08 167.58749999999998p 3.2969370000000001e-08 167.59999999999999p 3.3215910000000002e-08 167.61250000000001p 3.3440860000000003e-08 167.625p 3.3644199999999998e-08
+ 167.63750000000002p 3.3825960000000002e-08 167.65000000000001p 3.3986169999999999e-08 167.66249999999999p 3.4124870000000001e-08 167.67499999999998p 3.4242100000000002e-08 167.6875p 3.4337929999999997e-08 167.69999999999999p 3.4412430000000002e-08 167.71250000000001p 3.4465700000000003e-08 167.72499999999999p 3.4497830000000001e-08 167.73750000000001p 3.4508909999999999e-08 167.75p 3.4499069999999999e-08 167.76249999999999p 3.4468440000000003e-08 167.77500000000001p 3.4417129999999998e-08 167.78749999999999p 3.4345299999999997e-08 167.80000000000001p 3.4253100000000001e-08 167.8125p 3.4140670000000002e-08 167.82500000000002p 3.4008189999999997e-08 167.83749999999998p 3.3855830000000001e-08 167.84999999999999p 3.3683749999999999e-08
+ 167.86250000000001p 3.3492150000000001e-08 167.875p 3.3281220000000003e-08 167.88750000000002p 3.3051140000000001e-08 167.90000000000001p 3.2802119999999997e-08 167.91249999999999p 3.2534369999999998e-08 167.92499999999998p 3.2248090000000001e-08 167.9375p 3.1943510000000001e-08 167.94999999999999p 3.1620830000000001e-08 167.96250000000001p 3.1280280000000003e-08 167.97499999999999p 3.0922089999999999e-08 167.98750000000001p 3.0546500000000002e-08 168p 3.015373e-08 168.01249999999999p 2.9744030000000001e-08 168.02500000000001p 2.9317629999999999e-08 168.03749999999999p 2.8874790000000001e-08 168.05000000000001p 2.8415740000000001e-08 168.0625p 2.7940760000000001e-08 168.07500000000002p 2.745009e-08
+ 168.08749999999998p 2.694398e-08 168.09999999999999p 2.6422710000000001e-08 168.11250000000001p 2.5886540000000001e-08 168.125p 2.5335739999999999e-08 168.13750000000002p 2.4770569999999999e-08 168.15000000000001p 2.4191330000000001e-08 168.16250000000002p 2.3598280000000001e-08 168.17499999999998p 2.2991709999999999e-08 168.1875p 2.2371910000000001e-08 168.19999999999999p 2.1739159999999998e-08 168.21250000000001p 2.109377e-08 168.22499999999999p 2.0436030000000001e-08 168.23750000000001p 1.976624e-08 168.25p 1.9084719999999999e-08 168.26249999999999p 1.839177e-08 168.27500000000001p 1.768771e-08 168.28749999999999p 1.6972860000000001e-08 168.30000000000001p 1.624755e-08
+ 168.3125p 1.5512109999999999e-08 168.32500000000002p 1.4766880000000001e-08 168.33749999999998p 1.4012210000000001e-08 168.34999999999999p 1.324842e-08 168.36249999999998p 1.24759e-08 168.375p 1.169498e-08 168.38750000000002p 1.090605e-08 168.40000000000001p 1.0109460000000001e-08 168.41250000000002p 9.3056079999999999e-09 168.42499999999998p 8.4948709999999995e-09 168.4375p 7.677644e-09 168.44999999999999p 6.8543260000000002e-09 168.46250000000001p 6.0253229999999997e-09 168.47499999999999p 5.1910480000000004e-09 168.48750000000001p 4.3519239999999996e-09 168.5p 3.5083759999999998e-09 168.51249999999999p 2.660841e-09 168.52500000000001p 1.809762e-09
+ 168.53749999999999p 9.5558830000000008e-10 168.55000000000001p 9.8777640000000002e-11 168.5625p -7.6020509999999999e-10 168.57500000000002p -1.620888e-09 168.58749999999998p -2.4827899999999999e-09 168.59999999999999p -3.3454260000000001e-09 168.61249999999998p -4.2083e-09 168.625p -5.0709129999999999e-09 168.63750000000002p -5.9327549999999997e-09 168.65000000000001p -6.7933120000000002e-09 168.66250000000002p -7.6520609999999992e-09 168.67499999999998p -8.5084760000000003e-09 168.6875p -9.3620220000000001e-09 168.69999999999999p -1.021216e-08 168.71250000000001p -1.105834e-08 168.72499999999999p -1.1900010000000001e-08 168.73750000000001p -1.273662e-08 168.75p -1.3567609999999999e-08
+ 168.76249999999999p -1.4392410000000001e-08 168.77500000000001p -1.521044e-08 168.78749999999999p -1.602115e-08 168.80000000000001p -1.682394e-08 168.8125p -1.761825e-08 168.82500000000002p -1.840349e-08 168.83750000000001p -1.9179080000000002e-08 168.84999999999999p -1.9944430000000001e-08 168.86249999999998p -2.0698959999999999e-08 168.875p -2.144209e-08 168.88749999999999p -2.217322e-08 168.90000000000001p -2.289179e-08 168.91250000000002p -2.35972e-08 168.92499999999998p -2.4288880000000001e-08 168.9375p -2.496624e-08 168.94999999999999p -2.5628730000000001e-08 168.96250000000001p -2.6275769999999999e-08 168.97499999999999p -2.69068e-08
+ 168.98750000000001p -2.7521259999999999e-08 169p -2.81186e-08 169.01249999999999p -2.869829e-08 169.02500000000001p -2.9259770000000001e-08 169.03749999999999p -2.9802530000000001e-08 169.05000000000001p -3.0326060000000002e-08 169.0625p -3.0829829999999998e-08 169.07500000000002p -3.1313370000000003e-08 169.08750000000001p -3.1776179999999997e-08 169.09999999999999p -3.2217789999999997e-08 169.11249999999998p -3.2637740000000001e-08 169.125p -3.3035599999999997e-08 169.13749999999999p -3.3410920000000002e-08 169.15000000000001p -3.3763299999999999e-08 169.16250000000002p -3.4092340000000001e-08 169.17500000000001p -3.4397650000000002e-08 169.1875p -3.4678870000000001e-08 169.19999999999999p -3.493566e-08
+ 169.21250000000001p -3.5167679999999998e-08 169.22499999999999p -3.5374640000000002e-08 169.23750000000001p -3.5556240000000001e-08 169.25p -3.5712210000000003e-08 169.26249999999999p -3.5842309999999997e-08 169.27500000000001p -3.5946319999999999e-08 169.28749999999999p -3.6024039999999998e-08 169.30000000000001p -3.607528e-08 169.3125p -3.609988e-08 169.32500000000002p -3.6097729999999997e-08 169.33750000000001p -3.6068700000000001e-08 169.34999999999999p -3.6012720000000003e-08 169.36249999999998p -3.5929729999999998e-08 169.375p -3.581969e-08 169.38749999999999p -3.5682600000000001e-08 169.40000000000001p -3.5518469999999998e-08 169.41249999999999p -3.5327359999999998e-08 169.42500000000001p -3.5109320000000003e-08
+ 169.4375p -3.4864449999999998e-08 169.44999999999999p -3.4592879999999999e-08 169.46250000000001p -3.4294749999999997e-08 169.47499999999999p -3.3970249999999999e-08 169.48750000000001p -3.3619570000000001e-08 169.5p -3.3242929999999999e-08 169.51249999999999p -3.2840600000000001e-08 169.52499999999998p -3.2412849999999999e-08 169.53749999999999p -3.195999e-08 169.55000000000001p -3.1482350000000003e-08 169.5625p -3.098028e-08 169.57500000000002p -3.0454169999999997e-08 169.58750000000001p -2.9904429999999999e-08 169.59999999999999p -2.9331480000000001e-08 169.61249999999998p -2.8735779999999999e-08 169.625p -2.811781e-08 169.63749999999999p -2.7478059999999999e-08 169.65000000000001p -2.681707e-08
+ 169.66249999999999p -2.6135370000000001e-08 169.67500000000001p -2.543354e-08 169.6875p -2.4712160000000001e-08 169.69999999999999p -2.397183e-08 169.71250000000001p -2.3213189999999999e-08 169.72499999999999p -2.2436869999999999e-08 169.73750000000001p -2.1643550000000001e-08 169.75p -2.0833890000000001e-08 169.76250000000002p -2.0008599999999999e-08 169.77499999999998p -1.9168389999999999e-08 169.78749999999999p -1.8313980000000001e-08 169.80000000000001p -1.7446100000000002e-08 169.8125p -1.656552e-08 169.82500000000002p -1.5673000000000001e-08 169.83750000000001p -1.4769299999999999e-08 169.84999999999999p -1.385522e-08 169.86249999999998p -1.293154e-08 169.875p -1.199907e-08
+ 169.88749999999999p -1.105862e-08 169.90000000000001p -1.011099e-08 169.91249999999999p -9.1570160000000007e-09 169.92500000000001p -8.1975130000000003e-09 169.9375p -7.2333079999999999e-09 169.94999999999999p -6.2652290000000004e-09 169.96250000000001p -5.2941049999999997e-09 169.97499999999999p -4.3207660000000001e-09 169.98750000000001p -3.3460410000000001e-09)
R_LOAD OUT 0 10
I_IBIAS 0 IBIAS pwl(0p 0 1p 35u 2p 35u 170p 35u)
.tran 0.0125p 170p
.print P(BJs|XBQ) V(BJs|XBQ) I(BJs|XBQ)
.print P(BJL1|XBQ) V(BJL1|XBQ) I(BJL1|XBQ)
.print P(BJL2|XBQ) V(BJL2|XBQ) I(BJL2|XBQ)
.print V(IN) V(OUT) I(Lin|XBQ) I(L0|XBQ) I(L1|XBQ) I(L2|XBQ)
.print I(RB|XBQ) I(RJ1|XBQ) I(RJ2|XBQ) I(R_LOAD) I(I_IBIAS)
.print I(I_REPLAY)
.end
