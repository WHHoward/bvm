* PASSIVE: BVM array -> COMMON_SL -> JSL1..8; no QB/JTL/terminal.
{{JJ_INCLUDE}}
{{BVM_INCLUDE}}
{{STIMULUS_INCLUDE}}

{{BVM_INSTANCES}}

B_JSL1 COMMON_SL JSL_NODE1 jjmit area=5.0
B_JSL2 JSL_NODE1 JSL_NODE2 jjmit area=5.0
B_JSL3 JSL_NODE2 JSL_NODE3 jjmit area=5.0
B_JSL4 JSL_NODE3 JSL_NODE4 jjmit area=5.0
B_JSL5 JSL_NODE4 JSL_NODE5 jjmit area=5.0
B_JSL6 JSL_NODE5 JSL_NODE6 jjmit area=5.0
B_JSL7 JSL_NODE6 JSL_NODE7 jjmit area=5.0
B_JSL8 JSL_NODE7 0 jjmit area=5.0

{{PROBES}}
.tran {{DT}} {{STOP_TIME}}
.end
