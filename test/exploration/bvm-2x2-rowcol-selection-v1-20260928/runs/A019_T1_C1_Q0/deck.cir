* 2x2 BVM row/column selection platform; two isolated column merge chains; T1 only on C1.
* MERGE_Cn_Lm names are electrical shared nodes, not MERGE subcircuit instances.
* Per column: QB1->MERGE1->sJTL1->CB1->MERGE2; QB2 also feeds MERGE2->sJTL2->CB2->VOUT.
* Canonical component sources are direct includes and remain unchanged.
.include ../../../../../circuits/models/jjmit.cir
.include ../../../../../circuits/bvm/bvm_cell_0923.cir
.include ../../../../../circuits/qb/BQ_0928.cir
.include ../../../../../circuits/sJTL_0923.cir
.include ../../../../../circuits/CB/CB_0928.cir
.include ../../../../../circuits/t1/t1_cell.cir

* One PWL current driver for each independent input line.
.include stimulus.inc

* C1 VOUT connects only to T1 input; C2 retains its 2-ohm termination.
* FINAL READ has zero BL drive.
XBVM_R1C1 WL_R1 BL_C1 SE_R1C1 SL_R1C1 BVM
XBQ_R1C1 SL_R1C1 MERGE_C1_L1 BQ
XSJTL_C1_L1 MERGE_C1_L1 SJTL_OUT_C1_L1 sJTL
XCB_C1_L1 SJTL_OUT_C1_L1 MERGE_C1_L2 CB
XBVM_R2C1 WL_R2 BL_C1 SE_R2C1 SL_R2C1 BVM
XBQ_R2C1 SL_R2C1 MERGE_C1_L2 BQ
XSJTL_C1_L2 MERGE_C1_L2 SJTL_OUT_C1_L2 sJTL
XCB_C1_L2 SJTL_OUT_C1_L2 VOUT_C1 CB
XBVM_R1C2 WL_R1 BL_C2 SE_R1C2 SL_R1C2 BVM
XBQ_R1C2 SL_R1C2 MERGE_C2_L1 BQ
XSJTL_C2_L1 MERGE_C2_L1 SJTL_OUT_C2_L1 sJTL
XCB_C2_L1 SJTL_OUT_C2_L1 MERGE_C2_L2 CB
XBVM_R2C2 WL_R2 BL_C2 SE_R2C2 SL_R2C2 BVM
XBQ_R2C2 SL_R2C2 MERGE_C2_L2 BQ
XSJTL_C2_L2 MERGE_C2_L2 SJTL_OUT_C2_L2 sJTL
XCB_C2_L2 SJTL_OUT_C2_L2 VOUT_C2 CB
R_TERM_C2 VOUT_C2 0 2

* T1 Bias B; canonical T1 source and shared jjmit model.
V_BIAS1 N_BIAS1 0 DC 1.8m
V_BIAS2 N_BIAS2 0 DC 1.8m
V_BIAS3 N_BIAS3 0 DC 1.8m
R_S S 0 12
R_C C 0 12
R_CLK_QUIET CLK 0 5
V_T1_LINK VOUT_C1 T1_I 0
XT1 T1_I CLK S C N_BIAS1 N_BIAS2 N_BIAS3 T1

* Registered raw probes.
.print I(I_WL_R1)
.print I(I_WL_R2)
.print I(I_BL_C1)
.print I(I_BL_C2)
.print I(I_SE_R1C1)
.print I(I_SE_R1C2)
.print I(I_SE_R2C1)
.print I(I_SE_R2C2)
.print I(R_WL|XBVM_R1C1)
.print I(R_BL|XBVM_R1C1)
.print I(R_SE|XBVM_R1C1)
.print V(SL_R1C1)
.print I(L_SL|XBVM_R1C1)
.print P(B_JM1|XBVM_R1C1)
.print V(B_JM1|XBVM_R1C1)
.print P(B_JM2|XBVM_R1C1)
.print V(B_JM2|XBVM_R1C1)
.print P(B_JS1|XBVM_R1C1)
.print V(B_JS1|XBVM_R1C1)
.print P(B_JS2|XBVM_R1C1)
.print V(B_JS2|XBVM_R1C1)
.print P(BJ1|XBQ_R1C1)
.print V(BJ1|XBQ_R1C1)
.print P(BJ2|XBQ_R1C1)
.print V(BJ2|XBQ_R1C1)
.print P(BJ3|XBQ_R1C1)
.print V(BJ3|XBQ_R1C1)
.print I(LIN|XBQ_R1C1)
.print I(L1|XBQ_R1C1)
.print I(L2|XBQ_R1C1)
.print I(L3|XBQ_R1C1)
.print I(IB2|XBQ_R1C1)
.print V(MERGE_C1_L1)
.print I(R_WL|XBVM_R1C2)
.print I(R_BL|XBVM_R1C2)
.print I(R_SE|XBVM_R1C2)
.print V(SL_R1C2)
.print I(L_SL|XBVM_R1C2)
.print P(B_JM1|XBVM_R1C2)
.print V(B_JM1|XBVM_R1C2)
.print P(B_JM2|XBVM_R1C2)
.print V(B_JM2|XBVM_R1C2)
.print P(B_JS1|XBVM_R1C2)
.print V(B_JS1|XBVM_R1C2)
.print P(B_JS2|XBVM_R1C2)
.print V(B_JS2|XBVM_R1C2)
.print I(R_WL|XBVM_R2C1)
.print I(R_BL|XBVM_R2C1)
.print I(R_SE|XBVM_R2C1)
.print V(SL_R2C1)
.print I(L_SL|XBVM_R2C1)
.print P(B_JM1|XBVM_R2C1)
.print V(B_JM1|XBVM_R2C1)
.print P(B_JM2|XBVM_R2C1)
.print V(B_JM2|XBVM_R2C1)
.print P(B_JS1|XBVM_R2C1)
.print V(B_JS1|XBVM_R2C1)
.print P(B_JS2|XBVM_R2C1)
.print V(B_JS2|XBVM_R2C1)
.print P(BJ1|XBQ_R2C1)
.print V(BJ1|XBQ_R2C1)
.print P(BJ2|XBQ_R2C1)
.print V(BJ2|XBQ_R2C1)
.print P(BJ3|XBQ_R2C1)
.print V(BJ3|XBQ_R2C1)
.print I(LIN|XBQ_R2C1)
.print I(L1|XBQ_R2C1)
.print I(L2|XBQ_R2C1)
.print I(L3|XBQ_R2C1)
.print I(IB2|XBQ_R2C1)
.print V(MERGE_C1_L2)
.print I(R_WL|XBVM_R2C2)
.print I(R_BL|XBVM_R2C2)
.print I(R_SE|XBVM_R2C2)
.print V(SL_R2C2)
.print I(L_SL|XBVM_R2C2)
.print P(B_JM1|XBVM_R2C2)
.print V(B_JM1|XBVM_R2C2)
.print P(B_JM2|XBVM_R2C2)
.print V(B_JM2|XBVM_R2C2)
.print P(B_JS1|XBVM_R2C2)
.print V(B_JS1|XBVM_R2C2)
.print P(B_JS2|XBVM_R2C2)
.print V(B_JS2|XBVM_R2C2)
.print V(SJTL_OUT_C1_L1)
.print P(BJ1|XSJTL_C1_L1)
.print V(BJ1|XSJTL_C1_L1)
.print I(L1|XSJTL_C1_L1)
.print I(L2|XSJTL_C1_L1)
.print P(BJ1|XCB_C1_L1)
.print V(BJ1|XCB_C1_L1)
.print P(BJ2|XCB_C1_L1)
.print V(BJ2|XCB_C1_L1)
.print I(L1|XCB_C1_L1)
.print I(L2|XCB_C1_L1)
.print I(L3|XCB_C1_L1)
.print I(L4|XCB_C1_L1)
.print V(SJTL_OUT_C1_L2)
.print P(BJ1|XSJTL_C1_L2)
.print V(BJ1|XSJTL_C1_L2)
.print I(L1|XSJTL_C1_L2)
.print I(L2|XSJTL_C1_L2)
.print P(BJ1|XCB_C1_L2)
.print V(BJ1|XCB_C1_L2)
.print P(BJ2|XCB_C1_L2)
.print V(BJ2|XCB_C1_L2)
.print I(L1|XCB_C1_L2)
.print I(L2|XCB_C1_L2)
.print I(L3|XCB_C1_L2)
.print I(L4|XCB_C1_L2)
.print P(B_J1|XT1)
.print V(B_J1|XT1)
.print P(B_J2|XT1)
.print V(B_J2|XT1)
.print P(B_J3|XT1)
.print V(B_J3|XT1)
.print P(B_J4|XT1)
.print V(B_J4|XT1)
.print P(B_J5|XT1)
.print V(B_J5|XT1)
.print P(B_J6|XT1)
.print V(B_J6|XT1)
.print P(B_J7|XT1)
.print V(B_J7|XT1)
.print P(B_J8|XT1)
.print V(B_J8|XT1)
.print P(B_J9|XT1)
.print V(B_J9|XT1)
.print P(B_J10|XT1)
.print V(B_J10|XT1)
.print P(B_J11|XT1)
.print V(B_J11|XT1)
.print I(L1|XT1)
.print I(L3|XT1)
.print I(L11|XT1)
.print I(L14|XT1)
.print I(L17|XT1)
.print V(T1_I)
.print I(V_T1_LINK)
.print V(VOUT_C1)
.print V(VOUT_C2)
.print V(S)
.print V(C)
.print I(R_S)
.print I(R_C)
.print I(V_BIAS1)
.print I(V_BIAS2)
.print I(V_BIAS3)
.print V(CLK)
.print I(R_CLK_QUIET)
.print I(R_TERM_C2)
.tran 0.01p 250p
.end
