* BVM_READ_SEMANTICS_AUDIT_AND_JSL_WIDTH_BRACKET_V1: 13ps logical1_no_read_control
* exact I(B_LD1) replay from /home/howard/JoSIM/test/exploration/paper-sl-l0-20260824/raw/logical1-read0-control/run-01.csv; no reshape/hold/scale/resample
.include ../../bq_cell.cir
.include ../../qb-jjmit.cir
XBQ IN OUT IBIAS BQ
I_REPLAY 0 IN pwl(0p 0 0.012500000000000001p 0 0.025000000000000001p 0 0.037499999999999999p 0 0.050000000000000003p 0 0.0625p 0 0.074999999999999997p 0 0.087500000000000008p 0 0.10000000000000001p 0 0.1125p 0 0.125p 0 0.13749999999999998p 0 0.14999999999999999p 0 0.16249999999999998p 0 0.17500000000000002p 0 0.1875p 0 0.20000000000000001p 0 0.21249999999999999p 0
+ 0.22500000000000001p 0 0.23749999999999999p 0 0.25p 0 0.26250000000000001p 0 0.27499999999999997p 0 0.28749999999999998p 0 0.29999999999999999p 0 0.3125p 0 0.32499999999999996p 0 0.33749999999999997p 0 0.35000000000000003p 0 0.36250000000000004p 0 0.375p 0 0.38750000000000001p 0 0.40000000000000002p 0 0.41250000000000003p 0 0.42499999999999999p 0 0.4375p 0
+ 0.45000000000000001p 0 0.46250000000000002p 0 0.47499999999999998p 0 0.48749999999999999p 0 0.5p 0 0.51249999999999996p 0 0.52500000000000002p 0 0.53749999999999998p 0 0.54999999999999993p 0 0.5625p 0 0.57499999999999996p 0 0.58750000000000002p 0 0.59999999999999998p 0 0.61249999999999993p 0 0.625p 0 0.63749999999999996p 0 0.64999999999999991p 0 0.66249999999999998p 0
+ 0.67499999999999993p 0 0.6875p 0 0.70000000000000007p 0 0.71250000000000002p 0 0.72500000000000009p 0 0.73750000000000004p 0 0.75p 0 0.76250000000000007p 0 0.77500000000000002p 0 0.78749999999999998p 0 0.80000000000000004p 0 0.8125p 0 0.82500000000000007p 0 0.83750000000000002p 0 0.84999999999999998p 0 0.86250000000000004p 0 0.875p 0 0.88749999999999996p 0
+ 0.90000000000000002p 0 0.91249999999999998p 0 0.92500000000000004p 0 0.9375p 0 0.94999999999999996p 0 0.96250000000000002p 0 0.97499999999999998p 0 0.98749999999999993p 0 1p 0 1.0125p 0 1.0249999999999999p 0 1.0374999999999999p 0 1.05p 0 1.0625p 0 1.075p 0 1.0874999999999999p 0 1.0999999999999999p 0 1.1125p 0
+ 1.125p 0 1.1375p 0 1.1499999999999999p 0 1.1624999999999999p 0 1.175p 0 1.1875p 0 1.2p 0 1.2124999999999999p 0 1.2249999999999999p 0 1.2374999999999998p 0 1.25p 0 1.2625p 0 1.2749999999999999p 0 1.2874999999999999p 0 1.2999999999999998p 0 1.3125p 0 1.325p 0 1.3374999999999999p 0
+ 1.3499999999999999p 0 1.3624999999999998p 0 1.375p 0 1.3875000000000002p 0 1.4000000000000001p 0 1.4125000000000001p 0 1.425p 0 1.4375p 0 1.4500000000000002p 0 1.4625000000000001p 0 1.4750000000000001p 0 1.4875p 0 1.5p 0 1.5125000000000002p 0 1.5250000000000001p 0 1.5375000000000001p 0 1.55p 0 1.5625p 0
+ 1.575p 0 1.5875000000000001p 0 1.6000000000000001p 0 1.6125p 0 1.625p 0 1.6375p 0 1.6500000000000001p 0 1.6625000000000001p 0 1.675p 0 1.6875p 0 1.7p 0 1.7125000000000001p 0 1.7250000000000001p 0 1.7375p 0 1.75p 0 1.7625p 0 1.7749999999999999p 0 1.7875000000000001p 0
+ 1.8p 0 1.8125p 0 1.825p 0 1.8375000000000001p 0 1.8625000000000003p 0 1.875p 0 1.8875000000000002p 0 1.8999999999999999p 0 1.9125000000000001p 0 1.925p 0 1.9375000000000002p 0 1.95p 0 1.9625000000000001p 0 1.9749999999999999p 0 1.9875000000000003p 0 2p 0 2.0125000000000002p 0 2.0249999999999999p 0
+ 2.0375000000000001p 0 2.0499999999999998p 0 2.0625p 0 2.0749999999999997p 0 2.0875000000000004p 0 2.1000000000000001p 0 2.1125000000000003p 0 2.125p 0 2.1375000000000002p 0 2.1499999999999999p 0 2.1625000000000001p 0 2.1749999999999998p 0 2.1875p 0 2.1999999999999997p 0 2.2124999999999999p 0 2.2250000000000001p 0 2.2375000000000003p 0 2.25p 0
+ 2.2625000000000002p 0 2.2749999999999999p 0 2.2875000000000001p 0 2.2999999999999998p 0 2.3125p 0 2.3249999999999997p 0 2.3374999999999999p 0 2.3500000000000001p 0 2.3625000000000003p 0 2.375p 0 2.3875000000000002p 0 2.3999999999999999p 0 2.4125000000000001p 0 2.4249999999999998p 0 2.4375p 0 2.4499999999999997p 0 2.4624999999999999p 0 2.4749999999999996p 0
+ 2.4875000000000003p 0 2.5p 0 2.5125000000000002p 0 2.5249999999999999p 0 2.5375000000000001p 0 2.5499999999999998p 0 2.5625p 0 2.5749999999999997p 0 2.5874999999999999p 0 2.5999999999999996p 0 2.6124999999999998p 0 2.625p 0 2.6375000000000002p 0 2.6499999999999999p 0 2.6625000000000001p 0 2.6749999999999998p 0 2.6875p 0 2.6999999999999997p 0
+ 2.7124999999999999p 0 2.7249999999999996p 0 2.7374999999999998p 0 2.75p 0 2.7625000000000002p 0 2.7750000000000004p 0 2.7875000000000001p 0 2.8000000000000003p 0 2.8125p 0 2.8250000000000002p 0 2.8374999999999999p 0 2.8500000000000001p 0 2.8624999999999998p 0 2.875p 0 2.8875000000000002p 0 2.9000000000000004p 0 2.9125000000000001p 0 2.9250000000000003p 0
+ 2.9375p 0 2.9500000000000002p 0 2.9624999999999999p 0 2.9750000000000001p 0 2.9874999999999998p 0 3p 0 3.0124999999999997p 0 3.0250000000000004p 0 3.0375000000000001p 0 3.0500000000000003p 0 3.0625p 0 3.0750000000000002p 0 3.0874999999999999p 0 3.1000000000000001p 0 3.1124999999999998p 0 3.125p 0 3.1374999999999997p 0 3.1499999999999999p 0
+ 3.1625000000000001p 0 3.1750000000000003p 0 3.1875p 0 3.2000000000000002p 0 3.2124999999999999p 0 3.2250000000000001p 0 3.2374999999999998p 0 3.25p 0 3.2624999999999997p 0 3.2749999999999999p 0 3.2875000000000001p 0 3.3000000000000003p 0 3.3125p 0 3.3250000000000002p 0 3.3374999999999999p 0 3.3500000000000001p 0 3.3624999999999998p 0 3.375p 0
+ 3.3874999999999997p 0 3.3999999999999999p 0 3.4124999999999996p 0 3.4250000000000003p 0 3.4375p 0 3.4500000000000002p 0 3.4624999999999999p 0 3.4750000000000001p 0 3.4874999999999998p 0 3.5p 0 3.5124999999999997p 0 3.5249999999999999p 0 3.5374999999999996p 0 3.5499999999999998p 0 3.5625p 0 3.5750000000000002p 0 3.5874999999999999p 0 3.6000000000000001p 0
+ 3.6124999999999998p 0 3.625p 0 3.6374999999999997p 0 3.6499999999999999p 0 3.6624999999999996p 0 3.6750000000000003p 0 3.6875p 0 3.7000000000000002p 0 3.7124999999999999p 0 3.7250000000000005p 0 3.7375000000000003p 0 3.75p 0 3.7624999999999997p 0 3.7750000000000004p 0 3.7875000000000001p 0 3.7999999999999998p 0 3.8124999999999996p 0 3.8250000000000002p 0
+ 3.8375000000000004p 0 3.8500000000000001p 0 3.8624999999999998p 0 3.8750000000000004p 0 3.8875000000000002p 0 3.8999999999999999p 0 3.9124999999999996p 0 3.9250000000000003p 0 3.9375p 0 3.9499999999999997p 0 3.9624999999999999p 0 3.9750000000000005p 0 3.9875000000000003p 0 4p 0 4.0124999999999993p 0 4.0250000000000004p 0 4.0375000000000005p 0 4.0499999999999998p 0
+ 4.0625p 0 4.0750000000000002p 0 4.0875000000000004p 0 4.0999999999999996p 0 4.1124999999999998p 0 4.125p 0 4.1375000000000002p 0 4.1499999999999995p 0 4.1624999999999996p 0 4.1750000000000007p 0 4.1875p 0 4.2000000000000002p 0 4.2124999999999995p 0 4.2250000000000005p 0 4.2374999999999998p 0 4.25p 0 4.2624999999999993p 0 4.2750000000000004p 0
+ 4.2874999999999996p 0 4.2999999999999998p 0 4.3125p 0 4.3250000000000002p 0 4.3375000000000004p 0 4.3499999999999996p 0 4.3624999999999998p 0 4.375p 0 4.3875000000000002p 0 4.3999999999999995p 0 4.4124999999999996p 0 4.4249999999999998p 0 4.4375p 0 4.4500000000000002p 0 4.4624999999999995p 0 4.4750000000000005p 0 4.4874999999999998p 0 4.5p 0
+ 4.5124999999999993p 0 4.5250000000000004p 0 4.5374999999999996p 0 4.5499999999999998p 0 4.5625p 0 4.5750000000000002p 0 4.5875000000000004p 0 4.5999999999999996p 0 4.6125000000000007p 0 4.625p 0 4.6375000000000002p 0 4.6499999999999995p 0 4.6625000000000005p 0 4.6749999999999998p 0 4.6875p 0 4.7000000000000002p 0 4.7125000000000004p 0 4.7250000000000005p 0
+ 4.7374999999999998p 0 4.75p 0 4.7625000000000002p 0 4.7750000000000004p 0 4.7874999999999996p 0 4.7999999999999998p 0 4.8125p 0 4.8250000000000002p 0 4.8375000000000004p 0 4.8499999999999996p 0 4.8625000000000007p 0 4.875p 0 4.8875000000000002p 0 4.8999999999999995p 0 4.9125000000000005p 0 4.9249999999999998p 0 4.9375p 0 4.9499999999999993p 0
+ 4.9625000000000004p 0 4.9750000000000005p 0 4.9874999999999998p 0 5p 0 5.0125000000000002p 0 5.0250000000000004p 0 5.0374999999999996p 0 5.0499999999999998p 0 5.0625p 0 5.0750000000000002p 0 5.0874999999999995p 0 5.0999999999999996p 0 5.1125000000000007p 0 5.125p 0 5.1375000000000002p 0 5.1499999999999995p 0 5.1625000000000005p 0 5.1749999999999998p 0
+ 5.1875p 0 5.1999999999999993p 0 5.2125000000000004p 0 5.2249999999999996p 0 5.2374999999999998p 0 5.25p 0 5.2625000000000002p 0 5.2750000000000004p 0 5.2874999999999996p 0 5.2999999999999998p 0 5.3125p 0 5.3250000000000002p 0 5.3374999999999995p 0 5.3499999999999996p 0 5.3624999999999998p 0 5.375p 0 5.3875000000000002p 0 5.3999999999999995p 0
+ 5.4125000000000005p 0 5.4249999999999998p 0 5.4375p 0 5.4499999999999993p 0 5.4625000000000004p 0 5.4749999999999996p 0 5.4874999999999998p 0 5.5p 0 5.5125000000000002p 0 5.5250000000000004p 0 5.5374999999999996p 0 5.5500000000000007p 0 5.5625p 0 5.5750000000000002p 0 5.5874999999999995p 0 5.6000000000000005p 0 5.6124999999999998p 0 5.625p 0
+ 5.6375000000000002p 0 5.6500000000000004p 0 5.6625000000000005p 0 5.6749999999999998p 0 5.6875p 0 5.7000000000000002p 0 5.7125000000000004p 0 5.7249999999999996p 0 5.7374999999999998p 0 5.75p 0 5.7625000000000002p 0 5.7750000000000004p 0 5.7874999999999996p 0 5.8000000000000007p 0 5.8125p 0 5.8250000000000002p 0 5.8374999999999995p 0 5.8500000000000005p 0
+ 5.8624999999999998p 0 5.875p 0 5.8874999999999993p 0 5.9000000000000004p 0 5.9125000000000005p 0 5.9249999999999998p 0 5.9375p 0 5.9500000000000002p 0 5.9625000000000004p 0 5.9749999999999996p 0 5.9874999999999998p 0 6p 0 6.0125000000000002p 0 6.0249999999999995p 0 6.0374999999999996p 0 6.0500000000000007p 0 6.0625p 0 6.0750000000000002p 0
+ 6.0874999999999995p 0 6.1000000000000005p 0 6.1124999999999998p 0 6.125p 0 6.1374999999999993p 0 6.1500000000000004p 0 6.1624999999999996p 0 6.1749999999999998p 0 6.1875p 0 6.2000000000000002p 0 6.2125000000000004p 0 6.2249999999999996p 0 6.2374999999999998p 0 6.25p 0 6.2625000000000002p 0 6.2749999999999995p 0 6.2874999999999996p 0 6.2999999999999998p 0
+ 6.3125p 0 6.3250000000000002p 0 6.3374999999999995p 0 6.3500000000000005p 0 6.3624999999999998p 0 6.375p 0 6.3875000000000002p 0 6.4000000000000004p 0 6.4124999999999996p 0 6.4249999999999998p 0 6.4375p 0 6.4500000000000002p 0 6.4625000000000004p 0 6.4749999999999996p 0 6.4875000000000007p 0 6.5p 0 6.5125000000000002p 0 6.5249999999999995p 0
+ 6.5375000000000005p 0 6.5499999999999998p 0 6.5625p 0 6.5750000000000002p 0 6.5875000000000004p 0 6.6000000000000005p 0 6.6124999999999998p 0 6.625p 0 6.6375000000000002p 0 6.6500000000000004p 0 6.6624999999999996p 0 6.6749999999999998p 0 6.6875p 0 6.7000000000000002p 0 6.7125000000000004p 0 6.7249999999999996p 0 6.7375000000000007p 0 6.75p 0
+ 6.7625000000000002p 0 6.7749999999999995p 0 6.7875000000000005p 0 6.7999999999999998p 0 6.8125p 0 6.8249999999999993p 0 6.8375000000000004p 0 6.8500000000000005p 0 6.8624999999999998p 0 6.875p 0 6.8875000000000002p 0 6.9000000000000004p 0 6.9124999999999996p 0 6.9249999999999998p 0 6.9375p 0 6.9500000000000002p 0 6.9624999999999995p 0 6.9749999999999996p 0
+ 6.9874999999999998p 0 7p 0 7.0125000000000002p 0 7.0249999999999995p 0 7.0375000000000005p 0 7.0499999999999998p 0 7.0625p 0 7.0749999999999993p 0 7.0875000000000004p 0 7.0999999999999996p 0 7.1124999999999998p 0 7.125p 0 7.1375000000000002p 0 7.1500000000000004p 0 7.1624999999999996p 0 7.1749999999999998p 0 7.1875p 0 7.2000000000000002p 0
+ 7.2124999999999995p 0 7.2249999999999996p 0 7.2374999999999998p 0 7.25p 0 7.2625000000000002p 0 7.2749999999999995p 0 7.2874999999999996p 0 7.2999999999999998p 0 7.3125000000000009p 0 7.3249999999999993p 0 7.3375000000000004p 0 7.3500000000000005p 0 7.3624999999999998p 0 7.375p 0 7.3874999999999993p 0 7.4000000000000004p 0 7.4125000000000005p 0 7.4249999999999998p 0
+ 7.4375p 0 7.4500000000000011p 0 7.4624999999999995p 0 7.4750000000000005p 0 7.4874999999999989p 0 7.5p 0 7.5125000000000002p 0 7.5249999999999995p 0 7.5375000000000005p 0 7.5500000000000007p 0 7.5625p 0 7.5750000000000002p 0 7.5874999999999995p 0 7.5999999999999996p 0 7.6125000000000007p 0 7.6249999999999991p 0 7.6375000000000002p 0 7.6500000000000004p 0
+ 7.6624999999999996p 0 7.6750000000000007p 0 7.6874999999999991p 0 7.7000000000000002p 0 7.7125000000000004p 0 7.7249999999999996p 0 7.7374999999999998p 0 7.7500000000000009p 0 7.7624999999999993p 0 7.7750000000000004p 0 7.7874999999999996p 0 7.7999999999999998p 0 7.8125000000000009p 0 7.8249999999999993p 0 7.8375000000000004p 0 7.8500000000000005p 0 7.8624999999999998p 0 7.875p 0
+ 7.8874999999999993p 0 7.8999999999999995p 0 7.9125000000000005p 0 7.9249999999999998p 0 7.9375p 0 7.9500000000000011p 0 7.9624999999999995p 0 7.9750000000000005p 0 7.9874999999999989p 0 8p 0 8.0125000000000011p 0 8.0249999999999986p 0 8.0374999999999996p 0 8.0500000000000007p 0 8.0625p 0 8.0750000000000011p 0 8.0874999999999986p 0 8.0999999999999996p 0
+ 8.1125000000000007p 0 8.125p 0 8.1374999999999993p 0 8.1500000000000004p 0 8.1624999999999996p 0 8.1750000000000007p 0 8.1875p 0 8.1999999999999993p 0 8.2125000000000004p 0 8.2249999999999996p 0 8.2375000000000007p 0 8.25p 0 8.2624999999999993p 0 8.2750000000000004p 0 8.2875000000000014p 0 8.2999999999999989p 0 8.3125p 0 8.3249999999999993p 0
+ 8.3375000000000004p 0 8.3500000000000014p 0 8.3624999999999989p 0 8.375p 0 8.3875000000000011p 0 8.4000000000000004p 0 8.4124999999999996p 0 8.4249999999999989p 0 8.4375p 0 8.4500000000000011p 0 8.4625000000000004p 0 8.4749999999999996p 0 8.4875000000000007p 0 8.5p 0 8.5125000000000011p 0 8.5249999999999986p 0 8.5374999999999996p 0 8.5500000000000007p 0
+ 8.5625p 0 8.5749999999999993p 0 8.5875000000000004p 0 8.5999999999999996p 0 8.6125000000000007p 0 8.625p 0 8.6374999999999993p 0 8.6500000000000004p 0 8.6624999999999996p 0 8.6750000000000007p 0 8.6875p 0 8.6999999999999993p 0 8.7125000000000004p 0 8.7249999999999996p 0 8.7375000000000007p 0 8.75p 0 8.7624999999999993p 0 8.7750000000000004p 0
+ 8.7875000000000014p 0 8.7999999999999989p 0 8.8125p 0 8.8249999999999993p 0 8.8375000000000004p 0 8.8499999999999996p 0 8.8624999999999989p 0 8.875p 0 8.8875000000000011p 0 8.9000000000000004p 0 8.9124999999999996p 0 8.9249999999999989p 0 8.9375p 0 8.9500000000000011p 0 8.9624999999999986p 0 8.9749999999999996p 0 8.9875000000000007p 0 9p 0
+ 9.0125000000000011p 0 9.0249999999999986p 0 9.0374999999999996p 0 9.0500000000000007p 0 9.0625p 0 9.0749999999999993p 0 9.0875000000000004p 0 9.0999999999999996p 0 9.1125000000000007p 0 9.125p 0 9.1374999999999993p 0 9.1500000000000004p 0 9.1624999999999996p 0 9.1750000000000007p 0 9.1875p 0 9.1999999999999993p 0 9.2125000000000004p 0 9.2250000000000014p 0
+ 9.2374999999999989p 0 9.25p 0 9.2624999999999993p 0 9.2750000000000004p 0 9.2875000000000014p 0 9.2999999999999989p 0 9.3125p 0 9.3250000000000011p 0 9.3375000000000004p 0 9.3499999999999996p 0 9.3624999999999989p 0 9.375p 0 9.3875000000000011p 0 9.4000000000000004p 0 9.4124999999999996p 0 9.4250000000000007p 0 9.4375p 0 9.4500000000000011p 0
+ 9.4624999999999986p 0 9.4749999999999996p 0 9.4875000000000007p 0 9.5p 0 9.5124999999999993p 0 9.5250000000000004p 0 9.5374999999999996p 0 9.5500000000000007p 0 9.5625p 0 9.5749999999999993p 0 9.5875000000000004p 0 9.5999999999999996p 0 9.6125000000000007p 0 9.625p 0 9.6374999999999993p 0 9.6500000000000004p 0 9.6624999999999996p 0 9.6750000000000007p 0
+ 9.6875p 0 9.6999999999999993p 0 9.7125000000000004p 0 9.7250000000000014p 0 9.7374999999999989p 0 9.75p 0 9.7624999999999993p 0 9.7750000000000004p 0 9.7874999999999996p 0 9.7999999999999989p 0 9.8125p 0 9.8250000000000011p 0 9.8375000000000004p 0 9.8499999999999996p 0 9.8624999999999989p 0 9.875p 0 9.8875000000000011p 0 9.8999999999999986p 0
+ 9.9124999999999996p 0 9.9250000000000007p 0 9.9375p 0 9.9500000000000011p 0 9.9624999999999986p 0 9.9749999999999996p 0 9.9875000000000007p 0 10p 5.0939030000000001e-20 10.012499999999999p 3.9412170000000001e-07 10.025p 7.5903300000000002e-07 10.0375p 1.093568e-06 10.050000000000001p 1.3984240000000001e-06 10.0625p 1.674946e-06 10.074999999999999p 1.9247099999999998e-06 10.0875p 2.1493770000000001e-06 10.1p 2.3506340000000001e-06 10.112500000000001p 2.53017e-06 10.125p 2.6896609999999998e-06
+ 10.137499999999999p 2.8307610000000001e-06 10.15p 2.9550909999999998e-06 10.162500000000001p 3.064236e-06 10.174999999999999p 3.1597340000000001e-06 10.1875p 3.243074e-06 10.199999999999999p 3.3156870000000001e-06 10.2125p 3.378946e-06 10.225000000000001p 3.4341599999999998e-06 10.237499999999999p 3.4825690000000001e-06 10.25p 3.5253450000000001e-06 10.262500000000001p 3.5635880000000002e-06 10.275p 3.598327e-06 10.2875p 3.6305140000000002e-06 10.299999999999999p 3.6610289999999999e-06 10.3125p 3.6906770000000001e-06 10.325000000000001p 3.7201889999999999e-06 10.3375p 3.7502250000000002e-06 10.35p 3.7813710000000002e-06
+ 10.362500000000001p 3.814146e-06 10.375p 3.8489980000000003e-06 10.387500000000001p 3.8863109999999996e-06 10.399999999999999p 3.9264049999999997e-06 10.4125p 3.9695379999999996e-06 10.425000000000001p 4.0159129999999997e-06 10.4375p 4.0656749999999998e-06 10.449999999999999p 4.118919e-06 10.4625p 4.1756899999999998e-06 10.475p 4.235987e-06 10.487500000000001p 4.2997679999999999e-06 10.5p 4.3669529999999996e-06 10.512499999999999p 4.4374250000000001e-06 10.525p 4.5110340000000002e-06 10.5375p 4.587604e-06 10.550000000000001p 4.666931e-06 10.5625p 4.7487909999999997e-06 10.574999999999999p 4.8329389999999999e-06
+ 10.5875p 4.919114e-06 10.6p 5.0070429999999998e-06 10.612500000000001p 5.0964419999999999e-06 10.625p 5.1870200000000002e-06 10.637499999999999p 5.2784789999999996e-06 10.65p 5.3705209999999996e-06 10.662500000000001p 5.4628469999999998e-06 10.674999999999999p 5.5551600000000004e-06 10.6875p 5.6471660000000002e-06 10.699999999999999p 5.7385780000000002e-06 10.7125p 5.8291169999999996e-06 10.725p 5.9185110000000003e-06 10.737499999999999p 6.0065010000000002e-06 10.75p 6.0928390000000004e-06 10.762500000000001p 6.1772900000000003e-06 10.775p 6.2596339999999998e-06 10.7875p 6.3396640000000003e-06 10.799999999999999p 6.4171900000000003e-06
+ 10.8125p 6.4920370000000002e-06 10.825000000000001p 6.5640500000000003e-06 10.837499999999999p 6.6330870000000003e-06 10.85p 6.6990249999999998e-06 10.862500000000001p 6.7617580000000003e-06 10.875p 6.8211989999999998e-06 10.887500000000001p 6.8772760000000004e-06 10.899999999999999p 6.9299359999999996e-06 10.9125p 6.9791410000000003e-06 10.925000000000001p 7.0248720000000004e-06 10.9375p 7.0671240000000003e-06 10.949999999999999p 7.1059089999999996e-06 10.9625p 7.1412520000000001e-06 10.975p 7.1731960000000001e-06 10.987500000000001p 7.2017949999999999e-06 11p 7.2271179999999999e-06 11.012499999999999p 6.8551239999999996e-06 11.025p 6.5092380000000001e-06
+ 11.0375p 6.1907279999999998e-06 11.050000000000001p 5.8990130000000003e-06 11.0625p 5.6328690000000001e-06 11.074999999999999p 5.3908530000000001e-06 11.0875p 5.1714430000000003e-06 11.100000000000001p 4.9730999999999999e-06 11.112499999999999p 4.794286e-06 11.125p 4.6334829999999999e-06 11.137499999999999p 4.4892000000000001e-06 11.15p 4.3599800000000001e-06 11.162500000000001p 4.244409e-06 11.174999999999999p 4.1411190000000004e-06 11.1875p 4.0487919999999999e-06 11.200000000000001p 3.9661699999999998e-06 11.2125p 3.8920530000000002e-06 11.225p 3.8253030000000003e-06 11.237499999999999p 3.7648489999999998e-06 11.25p 3.7096890000000002e-06
+ 11.262500000000001p 3.6588859999999999e-06 11.275p 3.6115749999999998e-06 11.2875p 3.5669620000000001e-06 11.300000000000001p 3.52432e-06 11.3125p 3.482995e-06 11.325000000000001p 3.4423999999999999e-06 11.337499999999999p 3.4020140000000002e-06 11.35p 3.3613840000000001e-06 11.362500000000001p 3.3201199999999999e-06 11.375p 3.2778950000000001e-06 11.387499999999999p 3.2344400000000002e-06 11.4p 3.1895440000000001e-06 11.4125p 3.1430490000000001e-06 11.425000000000001p 3.0948500000000001e-06 11.4375p 3.0448890000000002e-06 11.449999999999999p 2.9931530000000002e-06 11.4625p 2.9396729999999999e-06 11.475p 2.8845169999999999e-06
+ 11.487500000000001p 2.8277890000000002e-06 11.5p 2.769626e-06 11.512499999999999p 2.7101929999999999e-06 11.525p 2.6496820000000002e-06 11.5375p 2.5883069999999998e-06 11.550000000000001p 2.5263019999999999e-06 11.5625p 2.4639190000000001e-06 11.574999999999999p 2.401423e-06 11.5875p 2.3390879999999999e-06 11.600000000000001p 2.2772e-06 11.612499999999999p 2.2160480000000001e-06 11.625p 2.155925e-06 11.637499999999999p 2.0971280000000001e-06 11.65p 2.039947e-06 11.6625p 1.9846750000000002e-06 11.674999999999999p 1.9315960000000002e-06 11.6875p 1.880989e-06 11.700000000000001p 1.8331240000000001e-06
+ 11.7125p 1.7882610000000001e-06 11.725p 1.74665e-06 11.737499999999999p 1.7085259999999999e-06 11.75p 1.674115e-06 11.762500000000001p 1.643623e-06 11.774999999999999p 1.617247e-06 11.7875p 1.595163e-06 11.800000000000001p 1.577534e-06 11.8125p 1.5645049999999999e-06 11.825000000000001p 1.5562039999999999e-06 11.8375p 1.5527420000000001e-06 11.85p 1.554212e-06 11.862500000000001p 1.5606890000000001e-06 11.875p 1.572233e-06 11.887499999999999p 1.5888829999999999e-06 11.9p 1.610665e-06 11.9125p 1.637585e-06 11.925000000000001p 1.6696329999999999e-06
+ 11.9375p 1.7067840000000001e-06 11.949999999999999p 1.748997e-06 11.9625p 1.796214e-06 11.975p 1.848364e-06 11.987500000000001p 1.905362e-06 12p 1.9671089999999998e-06 12.012499999999999p 2.0334899999999998e-06 12.025p 2.1043829999999999e-06 12.037500000000001p 2.1796510000000002e-06 12.049999999999999p 2.2591449999999999e-06 12.0625p 2.342707e-06 12.074999999999999p 2.4301689999999998e-06 12.0875p 2.5213549999999999e-06 12.100000000000001p 2.6160780000000001e-06 12.112499999999999p 2.7141450000000002e-06 12.125p 2.815355e-06 12.137500000000001p 2.919501e-06 12.15p 3.02637e-06
+ 12.1625p 3.1357439999999998e-06 12.174999999999999p 3.2474e-06 12.1875p 3.361111e-06 12.200000000000001p 3.4766470000000001e-06 12.2125p 3.5937750000000002e-06 12.225p 3.712261e-06 12.237500000000001p 3.8318670000000003e-06 12.25p 3.9523560000000001e-06 12.262500000000001p 4.0734900000000002e-06 12.274999999999999p 4.1950289999999998e-06 12.2875p 4.3167370000000001e-06 12.300000000000001p 4.4383749999999997e-06 12.3125p 4.5597090000000002e-06 12.324999999999999p 4.6805049999999998e-06 12.3375p 4.8005299999999996e-06 12.35p 4.9195570000000002e-06 12.362500000000001p 5.0373589999999998e-06 12.375p 5.1537149999999997e-06
+ 12.387499999999999p 5.2684040000000004e-06 12.4p 5.381213e-06 12.4125p 5.4919319999999999e-06 12.425000000000001p 5.6003560000000003e-06 12.4375p 5.7062840000000003e-06 12.449999999999999p 5.809521e-06 12.4625p 5.9098779999999998e-06 12.475p 6.0071709999999997e-06 12.487500000000001p 6.1012239999999999e-06 12.5p 6.1918639999999998e-06 12.512499999999999p 6.2789290000000003e-06 12.525p 6.3622580000000002e-06 12.537500000000001p 6.4417030000000004e-06 12.549999999999999p 6.5171169999999997e-06 12.5625p 6.5883659999999998e-06 12.574999999999999p 6.6553179999999997e-06 12.5875p 6.717852e-06 12.6p 6.7758539999999998e-06
+ 12.612499999999999p 6.8292169999999996e-06 12.625p 6.8778410000000001e-06 12.637500000000001p 6.9216349999999998e-06 12.65p 6.9605160000000001e-06 12.6625p 6.9944070000000003e-06 12.674999999999999p 7.0232419999999998e-06 12.6875p 7.0469619999999998e-06 12.700000000000001p 7.0655130000000001e-06 12.712499999999999p 7.0788529999999999e-06 12.725p 7.0869470000000001e-06 12.737500000000001p 7.0897659999999998e-06 12.75p 7.0872919999999997e-06 12.762500000000001p 7.0795120000000001e-06 12.775p 7.0664239999999996e-06 12.7875p 7.0480309999999999e-06 12.800000000000001p 7.0243459999999998e-06 12.8125p 6.9953879999999996e-06 12.824999999999999p 6.9611860000000004e-06
+ 12.8375p 6.9217740000000001e-06 12.85p 6.8771940000000002e-06 12.862500000000001p 6.8274979999999998e-06 12.875p 6.7727429999999997e-06 12.887499999999999p 6.712993e-06 12.9p 6.6483189999999998e-06 12.9125p 6.5788020000000001e-06 12.925000000000001p 6.5045250000000002e-06 12.9375p 6.4255819999999999e-06 12.949999999999999p 6.3420700000000002e-06 12.9625p 6.2540949999999996e-06 12.975000000000001p 6.161768e-06 12.987499999999999p 6.0652059999999997e-06 13p 5.9645320000000003e-06 13.012499999999999p 5.8598740000000001e-06 13.025p 5.751366e-06 13.037500000000001p 5.6391480000000004e-06 13.049999999999999p 5.523363e-06
+ 13.0625p 5.4041609999999998e-06 13.075000000000001p 5.281694e-06 13.0875p 5.1561209999999996e-06 13.1p 5.0276029999999998e-06 13.112499999999999p 4.8963040000000001e-06 13.125p 4.7623960000000002e-06 13.137500000000001p 4.6260479999999999e-06 13.15p 4.487437e-06 13.1625p 4.3467399999999997e-06 13.175000000000001p 4.2041379999999999e-06 13.1875p 4.059812e-06 13.200000000000001p 3.9139470000000002e-06 13.212499999999999p 3.766729e-06 13.225p 3.6183440000000001e-06 13.237500000000001p 3.4689789999999998e-06 13.25p 3.3188240000000001e-06 13.262499999999999p 3.1680669999999999e-06 13.275p 3.0168960000000002e-06
+ 13.2875p 2.8654999999999999e-06 13.300000000000001p 2.7140659999999999e-06 13.3125p 2.5627800000000001e-06 13.324999999999999p 2.4118290000000001e-06 13.3375p 2.2613950000000001e-06 13.35p 2.111661e-06 13.362500000000001p 1.9628070000000001e-06 13.375p 1.815009e-06 13.387499999999999p 1.6684420000000001e-06 13.4p 1.5232789999999999e-06 13.4125p 1.3796859999999999e-06 13.425000000000001p 1.23783e-06 13.4375p 1.0978699999999999e-06 13.449999999999999p 9.5996460000000004e-07 13.4625p 8.2426589999999996e-07 13.475000000000001p 6.9092239999999997e-07 13.487499999999999p 5.6007779999999998e-07 13.5p 4.3187109999999998e-07
+ 13.512499999999999p 3.0643620000000002e-07 13.525p 1.8390190000000001e-07 13.5375p 6.4391720000000002e-08 13.549999999999999p -5.1976279999999998e-08 13.5625p -1.6508949999999999e-07 13.575000000000001p -2.7484110000000001e-07 13.5875p -3.811297e-07 13.6p -4.8385989999999995e-07 13.612499999999999p -5.829421e-07 13.625p -6.7829239999999999e-07 13.637500000000001p -7.6983310000000003e-07 13.649999999999999p -8.5749209999999998e-07 13.6625p -9.4120329999999999e-07 13.675000000000001p -1.020906e-06 13.6875p -1.096547e-06 13.700000000000001p -1.1680760000000001e-06 13.7125p -1.235452e-06 13.725p -1.2986360000000001e-06
+ 13.737500000000001p -1.3575970000000001e-06 13.75p -1.4123090000000001e-06 13.762499999999999p -1.4627509999999999e-06 13.775p -1.5089070000000001e-06 13.7875p -1.550767e-06 13.800000000000001p -1.588325e-06 13.8125p -1.621582e-06 13.824999999999999p -1.650542e-06 13.8375p -1.675212e-06 13.85p -1.6956079999999999e-06 13.862500000000001p -1.7117470000000001e-06 13.875p -1.72365e-06 13.887499999999999p -1.731345e-06 13.9p -1.7348600000000001e-06 13.912500000000001p -1.7342310000000001e-06 13.924999999999999p -1.729494e-06 13.9375p -1.7206910000000001e-06 13.949999999999999p -1.7078669999999999e-06
+ 13.9625p -1.691069e-06 13.975p -1.6703469999999999e-06 13.987499999999999p -1.6457570000000001e-06 14p -1.617355e-06 14.012500000000001p -1.5852000000000001e-06 14.025p -1.549356e-06 14.0375p -1.509888e-06 14.049999999999999p -1.4668629999999999e-06 14.0625p -1.4203509999999999e-06 14.075000000000001p -1.3704250000000001e-06 14.0875p -1.31716e-06 14.1p -1.2606339999999999e-06 14.112500000000001p -1.2009250000000001e-06 14.125p -1.1381149999999999e-06 14.137500000000001p -1.072289e-06 14.149999999999999p -1.003532e-06 14.1625p -9.3193229999999999e-07 14.175000000000001p -8.5757980000000005e-07
+ 14.1875p -7.8056689999999999e-07 14.199999999999999p -7.009877e-07 14.2125p -6.1893839999999998e-07 14.225p -5.3451719999999995e-07 14.237500000000001p -4.4782440000000002e-07 14.25p -3.5896209999999997e-07 14.262499999999999p -2.6803450000000002e-07 14.275p -1.751477e-07 14.2875p -8.0409679999999994e-08 14.300000000000001p 1.6069480000000001e-08 14.3125p 1.141779e-07 14.324999999999999p 2.1380190000000001e-07 14.3375p 3.1482569999999999e-07 14.35p 4.1713189999999999e-07 14.362500000000001p 5.2060129999999999e-07 14.375p 6.2511289999999995e-07 14.387499999999999p 7.3054390000000004e-07 14.4p 8.3677019999999998e-07
+ 14.412500000000001p 9.4366579999999999e-07 14.424999999999999p 1.0511030000000001e-06 14.4375p 1.158954e-06 14.449999999999999p 1.267088e-06 14.4625p 1.3753739999999999e-06 14.475p 1.48368e-06 14.487499999999999p 1.591871e-06 14.5p 1.699815e-06 14.512500000000001p 1.807376e-06 14.525p 1.9144190000000001e-06 14.5375p 2.020808e-06 14.549999999999999p 2.1264070000000001e-06 14.562500000000002p 2.23108e-06 14.574999999999999p 2.3346909999999998e-06 14.587499999999999p 2.437104e-06 14.6p 2.5381840000000001e-06 14.612500000000001p 2.6377979999999999e-06 14.625000000000002p 2.73581e-06
+ 14.637499999999999p 2.8320900000000001e-06 14.649999999999999p 2.926506e-06 14.6625p 3.0189290000000002e-06 14.675000000000001p 3.1092319999999998e-06 14.687500000000002p 3.197288e-06 14.700000000000001p 3.2829750000000001e-06 14.712499999999999p 3.3661720000000001e-06 14.725p 3.4467610000000002e-06 14.737500000000001p 3.524628e-06 14.75p 3.5996600000000002e-06 14.762500000000001p 3.671748e-06 14.774999999999999p 3.74079e-06 14.7875p 3.8066819999999998e-06 14.800000000000001p 3.8693289999999997e-06 14.8125p 3.928639e-06 14.825000000000001p 3.9845230000000001e-06 14.837499999999999p 4.0368970000000004e-06 14.85p 4.0856840000000001e-06
+ 14.862499999999999p 4.1308089999999999e-06 14.875p 4.1722060000000002e-06 14.887500000000001p 4.2098099999999998e-06 14.900000000000002p 4.2435640000000002e-06 14.9125p 4.273416e-06 14.924999999999999p 4.2993219999999998e-06 14.9375p 4.3212399999999996e-06 14.950000000000001p 4.3391359999999998e-06 14.962500000000002p 4.3529829999999998e-06 14.974999999999998p 4.3627590000000003e-06 14.987499999999999p 4.368448e-06 15p 4.3700410000000002e-06 15.012500000000001p 4.3675339999999998e-06 15.025p 4.3609330000000003e-06 15.037499999999998p 4.3502460000000003e-06 15.049999999999999p 4.3354900000000004e-06 15.0625p 4.316687e-06 15.075000000000001p 4.293866e-06
+ 15.0875p 4.267064e-06 15.100000000000001p 4.2363219999999998e-06 15.112499999999999p 4.2016870000000002e-06 15.125p 4.1632140000000002e-06 15.137499999999999p 4.1209629999999996e-06 15.15p 4.0750010000000002e-06 15.162500000000001p 4.0253999999999996e-06 15.174999999999999p 3.9722379999999996e-06 15.1875p 3.9155979999999998e-06 15.199999999999999p 3.8555709999999998e-06 15.2125p 3.79225e-06 15.225000000000001p 3.7257350000000001e-06 15.237499999999999p 3.6561329999999999e-06 15.249999999999998p 3.5835519999999998e-06 15.262499999999999p 3.5081069999999999e-06 15.275p 3.4299169999999998e-06 15.287500000000001p 3.3491069999999998e-06 15.300000000000001p 3.265803e-06
+ 15.312499999999998p 3.180138e-06 15.324999999999999p 3.0922459999999998e-06 15.3375p 3.0022670000000002e-06 15.350000000000001p 2.910341e-06 15.362500000000001p 2.8166150000000001e-06 15.374999999999998p 2.721236e-06 15.387499999999999p 2.624353e-06 15.4p 2.52612e-06 15.4125p 2.426691e-06 15.425000000000001p 2.3262209999999998e-06 15.437499999999998p 2.2248689999999999e-06 15.449999999999999p 2.122792e-06 15.4625p 2.0201509999999999e-06 15.475p 1.917106e-06 15.487500000000001p 1.8138159999999999e-06 15.500000000000002p 1.7104430000000001e-06 15.512499999999999p 1.6071480000000001e-06 15.524999999999999p 1.5040900000000001e-06
+ 15.5375p 1.4014269999999999e-06 15.550000000000001p 1.2993199999999999e-06 15.562500000000002p 1.1979250000000001e-06 15.574999999999999p 1.097396e-06 15.587499999999999p 9.978887000000001e-07 15.6p 8.9955400000000004e-07 15.612500000000001p 8.0254150000000003e-07 15.625000000000002p 7.069982e-07 15.637500000000001p 6.1306849999999998e-07 15.649999999999999p 5.2089369999999998e-07 15.6625p 4.3061190000000003e-07 15.675000000000001p 3.42358e-07 15.6875p 2.5626320000000001e-07 15.700000000000001p 1.7245510000000001e-07 15.712499999999999p 9.1057149999999994e-08 15.725p 1.218882e-08 15.737500000000001p -6.4034730000000004e-08 15.75p -1.3750270000000001e-07
+ 15.762500000000001p -2.0810909999999999e-07 15.774999999999999p -2.757522e-07 15.7875p -3.4033560000000002e-07 15.799999999999999p -4.0176740000000002e-07 15.8125p -4.5996110000000002e-07 15.825000000000001p -5.148349e-07 15.837500000000002p -5.6631259999999995e-07 15.85p -6.1432310000000003e-07 15.862499999999999p -6.588006e-07 15.875p -6.9968470000000003e-07 15.887500000000001p -7.3692030000000004e-07 15.900000000000002p -7.7045799999999998e-07 15.912499999999998p -8.0025349999999997e-07 15.924999999999999p -8.2626819999999998e-07 15.9375p -8.4846880000000001e-07 15.950000000000001p -8.6682770000000001e-07 15.9625p -8.8132230000000004e-07 15.974999999999998p -8.9193580000000004e-07
+ 15.987499999999999p -8.9865659999999998e-07 16p -9.0147830000000002e-07 16.012499999999999p -9.0039990000000005e-07 16.025000000000002p -8.9542569999999998e-07 16.037500000000001p -8.8656489999999995e-07 16.049999999999997p -8.7383189999999999e-07 16.0625p -8.5724639999999999e-07 16.074999999999999p -8.3683250000000003e-07 16.087500000000002p -8.1261960000000001e-07 16.100000000000001p -7.8464179999999998e-07 16.112499999999997p -7.5293760000000005e-07 16.125p -7.1755039999999998e-07 16.137499999999999p -6.7852799999999997e-07 16.150000000000002p -6.3592269999999999e-07 16.162500000000001p -5.8979100000000002e-07 16.174999999999997p -5.4019349999999996e-07 16.1875p -4.8719509999999998e-07 16.199999999999999p -4.3086469999999998e-07
+ 16.212499999999999p -3.7127499999999999e-07 16.225000000000001p -3.0850250000000001e-07 16.237500000000001p -2.426273e-07 16.25p -1.737332e-07 16.262499999999999p -1.019073e-07 16.274999999999999p -2.724012e-08 16.287500000000001p 5.0174640000000002e-08 16.300000000000001p 1.3024019999999999e-07 16.3125p 2.1285689999999999e-07 16.324999999999999p 2.979221e-07 16.337499999999999p 3.8533059999999998e-07 16.350000000000001p 4.7497449999999999e-07 16.362500000000001p 5.6674359999999999e-07 16.375p 6.6052539999999999e-07 16.387499999999999p 7.5620510000000003e-07 16.399999999999999p 8.5366599999999999e-07 16.412500000000001p 9.5278950000000004e-07 16.425000000000001p 1.053455e-06
+ 16.4375p 1.1555420000000001e-06 16.449999999999999p 1.258925e-06 16.462499999999999p 1.3634820000000001e-06 16.475000000000001p 1.4690850000000001e-06 16.487500000000001p 1.575609e-06 16.5p 1.6829260000000001e-06 16.512499999999999p 1.7909089999999999e-06 16.524999999999999p 1.8994279999999999e-06 16.537500000000001p 2.0083560000000002e-06 16.550000000000001p 2.1175640000000001e-06 16.5625p 2.226924e-06 16.575000000000003p 2.3363060000000001e-06 16.587499999999999p 2.4455819999999999e-06 16.599999999999998p 2.5546270000000002e-06 16.612500000000001p 2.6633119999999999e-06 16.625p 2.7715110000000002e-06 16.637500000000003p 2.8791009999999999e-06 16.649999999999999p 2.9859559999999999e-06
+ 16.662499999999998p 3.0919559999999998e-06 16.675000000000001p 3.1969779999999999e-06 16.6875p 3.3009029999999999e-06 16.700000000000003p 3.4036139999999999e-06 16.712499999999999p 3.5049940000000002e-06 16.724999999999998p 3.60493e-06 16.737500000000001p 3.7033089999999998e-06 16.75p 3.800021e-06 16.762499999999999p 3.8949590000000003e-06 16.775000000000002p 3.9880179999999998e-06 16.787499999999998p 4.0790929999999996e-06 16.800000000000001p 4.1680840000000004e-06 16.8125p 4.254894e-06 16.824999999999999p 4.339427e-06 16.837500000000002p 4.4215890000000001e-06 16.849999999999998p 4.501291e-06 16.862500000000001p 4.5784449999999998e-06 16.875p 4.6529669999999999e-06
+ 16.887499999999999p 4.724775e-06 16.900000000000002p 4.7937899999999999e-06 16.912499999999998p 4.8599370000000002e-06 16.925000000000001p 4.9231439999999999e-06 16.9375p 4.9833399999999996e-06 16.949999999999999p 5.04046e-06 16.962500000000002p 5.0944400000000001e-06 16.975000000000001p 5.1452210000000003e-06 16.987499999999997p 5.1927469999999997e-06 17p 5.2369650000000001e-06 17.012499999999999p 5.277826e-06 17.025000000000002p 5.3152840000000002e-06 17.037500000000001p 5.3492959999999996e-06 17.049999999999997p 5.379826e-06 17.0625p 5.406837e-06 17.074999999999999p 5.4303009999999997e-06 17.087500000000002p 5.4501900000000001e-06 17.100000000000001p 5.4664809999999998e-06
+ 17.112499999999997p 5.4791569999999999e-06 17.125p 5.4882030000000001e-06 17.137499999999999p 5.4936089999999998e-06 17.149999999999999p 5.4953690000000001e-06 17.162500000000001p 5.4934819999999999e-06 17.175000000000001p 5.4879509999999999e-06 17.1875p 5.4787840000000004e-06 17.199999999999999p 5.4659929999999999e-06 17.212499999999999p 5.449595e-06 17.225000000000001p 5.4296100000000003e-06 17.237500000000001p 5.4060660000000001e-06 17.25p 5.378991e-06 17.262499999999999p 5.3484219999999997e-06 17.274999999999999p 5.3143979999999998e-06 17.287500000000001p 5.2769640000000003e-06 17.300000000000001p 5.2361679999999999e-06 17.3125p 5.1920649999999999e-06 17.324999999999999p 5.1447120000000004e-06
+ 17.337499999999999p 5.0941710000000001e-06 17.350000000000001p 5.0405110000000004e-06 17.362500000000001p 4.9838009999999999e-06 17.375p 4.9241169999999998e-06 17.387499999999999p 4.8615400000000002e-06 17.399999999999999p 4.7961510000000001e-06 17.412500000000001p 4.7280390000000003e-06 17.425000000000001p 4.6572960000000002e-06 17.4375p 4.5840139999999996e-06 17.449999999999999p 4.5082939999999999e-06 17.462499999999999p 4.4302350000000003e-06 17.475000000000001p 4.3499429999999998e-06 17.487500000000001p 4.267524e-06 17.5p 4.18309e-06 17.512500000000003p 4.0967519999999998e-06 17.524999999999999p 4.0086260000000003e-06 17.537499999999998p 3.9188280000000004e-06 17.550000000000001p 3.827478e-06
+ 17.5625p 3.7346959999999999e-06 17.575000000000003p 3.6406049999999998e-06 17.587499999999999p 3.545326e-06 17.599999999999998p 3.448986e-06 17.612500000000001p 3.3517079999999998e-06 17.625p 3.2536180000000001e-06 17.637500000000003p 3.154843e-06 17.649999999999999p 3.0555070000000002e-06 17.662499999999998p 2.9557380000000001e-06 17.675000000000001p 2.8556600000000002e-06 17.6875p 2.7553979999999999e-06 17.699999999999999p 2.655076e-06 17.712500000000002p 2.5548169999999999e-06 17.724999999999998p 2.4547430000000001e-06 17.737500000000001p 2.3549749999999998e-06 17.75p 2.25563e-06 17.762499999999999p 2.1568269999999999e-06 17.775000000000002p 2.0586789999999999e-06
+ 17.787499999999998p 1.9613000000000002e-06 17.800000000000001p 1.8647999999999999e-06 17.8125p 1.769288e-06 17.824999999999999p 1.674867e-06 17.837500000000002p 1.5816419999999999e-06 17.849999999999998p 1.489712e-06 17.862500000000001p 1.399173e-06 17.875p 1.3101200000000001e-06 17.887499999999999p 1.2226430000000001e-06 17.900000000000002p 1.136828e-06 17.912500000000001p 1.0527600000000001e-06 17.924999999999997p 9.7051929999999999e-07 17.9375p 8.9018259999999995e-07 17.949999999999999p 8.1182319999999999e-07 17.962500000000002p 7.3551110000000002e-07 17.975000000000001p 6.6131229999999996e-07 17.987499999999997p 5.892894e-07 18p 5.195015e-07
+ 18.012499999999999p 4.5200379999999999e-07 18.025000000000002p 3.8684790000000001e-07 18.037500000000001p 3.2408199999999998e-07 18.049999999999997p 2.6375039999999998e-07 18.0625p 2.058941e-07 18.074999999999999p 1.5055030000000001e-07 18.087499999999999p 9.7752819999999997e-08 18.100000000000001p 4.7532030000000001e-08 18.112500000000001p -8.5157969999999998e-11 18.125p -4.5075220000000002e-08 18.137499999999999p -8.7417919999999997e-08 18.149999999999999p -1.2709629999999999e-07 18.162500000000001p -1.640966e-07 18.175000000000001p -1.984081e-07 18.1875p -2.3002339999999999e-07 18.199999999999999p -2.5893779999999997e-07 18.212499999999999p -2.8514970000000001e-07 18.225000000000001p -3.0866039999999998e-07
+ 18.237500000000001p -3.2947390000000001e-07 18.25p -3.4759689999999999e-07 18.262499999999999p -3.6303900000000003e-07 18.274999999999999p -3.7581199999999998e-07 18.287500000000001p -3.8593070000000001e-07 18.300000000000001p -3.9341189999999998e-07 18.3125p -3.982751e-07 18.324999999999999p -4.005422e-07 18.337499999999999p -4.002372e-07 18.350000000000001p -3.9738630000000001e-07 18.362500000000001p -3.9201799999999998e-07 18.375p -3.8416309999999999e-07 18.387499999999999p -3.7385399999999998e-07 18.399999999999999p -3.6112549999999999e-07 18.412500000000001p -3.4601449999999998e-07 18.425000000000001p -3.2855940000000002e-07 18.4375p -3.0880089999999999e-07 18.450000000000003p -2.8678139999999997e-07
+ 18.462499999999999p -2.6254529999999998e-07 18.474999999999998p -2.3613869999999999e-07 18.487500000000001p -2.0760940000000001e-07 18.5p -1.7700710000000001e-07 18.512500000000003p -1.4438319999999999e-07 18.524999999999999p -1.097909e-07 18.537499999999998p -7.3284950000000001e-08 18.550000000000001p -3.4921789999999999e-08 18.5625p 5.2404440000000002e-09 18.575000000000003p 4.7142019999999999e-08 18.587499999999999p 9.0721579999999995e-08 18.599999999999998p 1.359162e-07 18.612500000000001p 1.8266139999999999e-07 18.625p 2.3089120000000001e-07 18.637499999999999p 2.8053799999999999e-07 18.650000000000002p 3.3153289999999999e-07 18.662499999999998p 3.838052e-07 18.675000000000001p 4.3728330000000002e-07
+ 18.6875p 4.9189359999999998e-07 18.699999999999999p 5.4756170000000004e-07 18.712500000000002p 6.0421160000000002e-07 18.724999999999998p 6.6176590000000003e-07 18.737500000000001p 7.2014630000000002e-07 18.75p 7.7927310000000004e-07 18.762499999999999p 8.3906559999999998e-07 18.775000000000002p 8.9944180000000003e-07 18.787499999999998p 9.6031909999999998e-07 18.800000000000001p 1.0216140000000001e-06 18.8125p 1.0832409999999999e-06 18.824999999999999p 1.145115e-06 18.837500000000002p 1.20715e-06 18.850000000000001p 1.26926e-06 18.862499999999997p 1.3313569999999999e-06 18.875p 1.393353e-06 18.887499999999999p 1.455161e-06 18.900000000000002p 1.516692e-06
+ 18.912500000000001p 1.577857e-06 18.924999999999997p 1.6385690000000001e-06 18.9375p 1.6987389999999999e-06 18.949999999999999p 1.758279e-06 18.962500000000002p 1.817101e-06 18.975000000000001p 1.8751189999999999e-06 18.987499999999997p 1.9322439999999998e-06 19p 1.9883929999999999e-06 19.012499999999999p 2.0434790000000001e-06 19.024999999999999p 2.0974180000000001e-06 19.037500000000001p 2.1501279999999999e-06 19.050000000000001p 2.2015259999999999e-06 19.0625p 2.251534e-06 19.074999999999999p 2.3000710000000001e-06 19.087499999999999p 2.3470620000000002e-06 19.100000000000001p 2.3924300000000001e-06 19.112500000000001p 2.436104e-06 19.125p 2.4780109999999999e-06
+ 19.137499999999999p 2.518082e-06 19.149999999999999p 2.5562530000000002e-06 19.162500000000001p 2.592457e-06 19.175000000000001p 2.6266340000000001e-06 19.1875p 2.6587259999999999e-06 19.199999999999999p 2.688676e-06 19.212499999999999p 2.716432e-06 19.225000000000001p 2.7419439999999999e-06 19.237500000000001p 2.7651649999999999e-06 19.25p 2.7860530000000001e-06 19.262499999999999p 2.8045660000000001e-06 19.274999999999999p 2.8206690000000001e-06 19.287500000000001p 2.8343289999999999e-06 19.300000000000001p 2.8455160000000001e-06 19.3125p 2.8542050000000001e-06 19.324999999999999p 2.8603739999999999e-06 19.337499999999999p 2.8640049999999999e-06 19.350000000000001p 2.8650830000000001e-06
+ 19.362500000000001p 2.8635990000000002e-06 19.375p 2.8595450000000001e-06 19.387500000000003p 2.85292e-06 19.399999999999999p 2.8437239999999998e-06 19.412499999999998p 2.8319630000000002e-06 19.425000000000001p 2.8176459999999999e-06 19.4375p 2.800786e-06 19.450000000000003p 2.781401e-06 19.462499999999999p 2.7595119999999999e-06 19.474999999999998p 2.735143e-06 19.487500000000001p 2.708323e-06 19.5p 2.6790850000000001e-06 19.512500000000003p 2.6474650000000002e-06 19.524999999999999p 2.6135020000000001e-06 19.537499999999998p 2.5772410000000001e-06 19.550000000000001p 2.5387279999999999e-06 19.5625p 2.498012e-06 19.574999999999999p 2.4551489999999999e-06
+ 19.587500000000002p 2.4101949999999999e-06 19.599999999999998p 2.3632090000000001e-06 19.612500000000001p 2.3142549999999998e-06 19.625p 2.2633980000000002e-06 19.637499999999999p 2.210706e-06 19.650000000000002p 2.156252e-06 19.662499999999998p 2.1001079999999998e-06 19.675000000000001p 2.04235e-06 19.6875p 1.9830560000000002e-06 19.699999999999999p 1.9223070000000002e-06 19.712500000000002p 1.860185e-06 19.724999999999998p 1.796772e-06 19.737500000000001p 1.7321549999999999e-06 19.75p 1.66642e-06 19.762499999999999p 1.5996549999999999e-06 19.775000000000002p 1.531949e-06 19.787500000000001p 1.463392e-06 19.799999999999997p 1.3940750000000001e-06
+ 19.8125p 1.324088e-06 19.824999999999999p 1.253524e-06 19.837500000000002p 1.182474e-06 19.850000000000001p 1.11103e-06 19.862499999999997p 1.0392839999999999e-06 19.875p 9.6732860000000002e-07 19.887499999999999p 8.9525389999999999e-07 19.900000000000002p 8.2315080000000005e-07 19.912500000000001p 7.511094e-07 19.924999999999997p 6.7921869999999996e-07 19.9375p 6.0756670000000003e-07 19.949999999999999p 5.362405e-07 19.962499999999999p 4.6532570000000002e-07 19.975000000000001p 3.949064e-07 19.987500000000001p 3.2506529999999998e-07 20p 2.5588349999999998e-07 20.012499999999999p -2.066816e-07 20.024999999999999p -6.3922069999999997e-07
+ 20.037500000000001p -1.0404930000000001e-06 20.050000000000001p -1.4111219999999999e-06 20.0625p -1.7523829999999999e-06 20.074999999999999p -2.065785e-06 20.087499999999999p -2.352923e-06 20.100000000000001p -2.6154220000000002e-06 20.112500000000001p -2.8549119999999999e-06 20.125p -3.073014e-06 20.137499999999999p -3.2713290000000001e-06 20.149999999999999p -3.4514289999999998e-06 20.162500000000001p -3.6148539999999999e-06 20.175000000000001p -3.7631009999999998e-06 20.1875p -3.8976179999999998e-06 20.199999999999999p -4.0198050000000004e-06 20.212499999999999p -4.1310020000000004e-06 20.225000000000001p -4.2324910000000001e-06 20.237500000000001p -4.3254890000000003e-06 20.25p -4.4111510000000003e-06
+ 20.262499999999999p -4.4905590000000002e-06 20.274999999999999p -4.5647279999999996e-06 20.287500000000001p -4.6346039999999997e-06 20.300000000000001p -4.7010609999999997e-06 20.3125p -4.7649020000000004e-06 20.325000000000003p -4.8268579999999996e-06 20.337499999999999p -4.8875939999999998e-06 20.349999999999998p -4.947703e-06 20.362500000000001p -5.0077130000000001e-06 20.375p -5.068083e-06 20.387500000000003p -5.1292129999999997e-06 20.399999999999999p -5.1914379999999997e-06 20.412499999999998p -5.2550350000000004e-06 20.425000000000001p -5.3202250000000004e-06 20.4375p -5.3871749999999998e-06 20.450000000000003p -5.4560010000000002e-06 20.462499999999999p -5.5267699999999998e-06 20.474999999999998p -5.5995060000000001e-06
+ 20.487500000000001p -5.67419e-06 20.5p -5.7507650000000002e-06 20.512499999999999p -5.829136e-06 20.525000000000002p -5.9091790000000002e-06 20.537499999999998p -5.9907379999999999e-06 20.550000000000001p -6.0736310000000004e-06 20.5625p -6.1576540000000004e-06 20.574999999999999p -6.2425820000000001e-06 20.587500000000002p -6.3281700000000003e-06 20.599999999999998p -6.414163e-06 20.612500000000001p -6.5002890000000002e-06 20.625p -6.5862709999999998e-06 20.637499999999999p -6.6718229999999998e-06 20.650000000000002p -6.7566520000000004e-06 20.662499999999998p -6.8404679999999999e-06 20.675000000000001p -6.922977e-06 20.6875p -7.0038870000000003e-06 20.699999999999999p -7.0829119999999999e-06
+ 20.712500000000002p -7.1597700000000001e-06 20.725000000000001p -7.2341849999999999e-06 20.737499999999997p -7.3058929999999998e-06 20.75p -7.374637e-06 20.762499999999999p -7.4401729999999998e-06 20.775000000000002p -7.5022690000000004e-06 20.787500000000001p -7.5607070000000003e-06 20.799999999999997p -7.6152819999999997e-06 20.8125p -7.6658069999999995e-06 20.824999999999999p -7.7121089999999999e-06 20.837500000000002p -7.7540310000000004e-06 20.850000000000001p -7.7914359999999998e-06 20.862499999999997p -7.8242009999999998e-06 20.875p -7.8522219999999993e-06 20.887499999999999p -7.8754159999999996e-06 20.899999999999999p -7.8937140000000003e-06 20.912500000000001p -7.9070659999999996e-06 20.925000000000001p -7.9154429999999998e-06
+ 20.9375p -7.9188299999999999e-06 20.949999999999999p -7.9172340000000007e-06 20.962499999999999p -7.9106780000000002e-06 20.975000000000001p -7.8992000000000005e-06 20.987500000000001p -7.8828589999999999e-06 21p -7.86173e-06 21.012499999999999p -7.4417799999999999e-06 21.024999999999999p -7.0464470000000002e-06 21.037500000000001p -6.6770200000000003e-06 21.050000000000001p -6.3329379999999997e-06 21.0625p -6.013004e-06 21.074999999999999p -5.7158070000000004e-06 21.087499999999999p -5.4398629999999998e-06 21.100000000000001p -5.1836730000000003e-06 21.112500000000001p -4.9457480000000004e-06 21.125p -4.7246219999999998e-06 21.137499999999999p -4.5188629999999997e-06 21.149999999999999p -4.3270780000000003e-06
+ 21.162500000000001p -4.1479219999999999e-06 21.175000000000001p -3.9801030000000001e-06 21.1875p -3.8223839999999996e-06 21.199999999999999p -3.6735929999999999e-06 21.212499999999999p -3.5326209999999998e-06 21.225000000000001p -3.3984310000000002e-06 21.237500000000001p -3.2700520000000002e-06 21.25p -3.1465899999999998e-06 21.262500000000003p -3.0272209999999999e-06 21.274999999999999p -2.9111989999999999e-06 21.287499999999998p -2.7978480000000002e-06 21.300000000000001p -2.6865699999999998e-06 21.3125p -2.5768379999999998e-06 21.325000000000003p -2.4681990000000001e-06 21.337499999999999p -2.360268e-06 21.349999999999998p -2.2527289999999998e-06 21.362500000000001p -2.1453349999999999e-06 21.375p -2.0378970000000001e-06
+ 21.387500000000003p -1.9302920000000002e-06 21.399999999999999p -1.8224530000000001e-06 21.412499999999998p -1.714366e-06 21.425000000000001p -1.606069e-06 21.4375p -1.4976479999999999e-06 21.449999999999999p -1.389233e-06 21.462500000000002p -1.2809939999999999e-06 21.474999999999998p -1.173138e-06 21.487500000000001p -1.0659029999999999e-06 21.5p -9.5955860000000005e-07 21.512499999999999p -8.5439849999999999e-07 21.525000000000002p -7.5073840000000003e-07 21.537499999999998p -6.489121e-07 21.550000000000001p -5.4926809999999998e-07 21.5625p -4.5216609999999999e-07 21.574999999999999p -3.5797379999999999e-07 21.587500000000002p -2.6706359999999999e-07 21.599999999999998p -1.7980980000000001e-07
+ 21.612500000000001p -9.6585260000000004e-08 21.625p -1.7759230000000001e-08 21.637499999999999p 5.6305719999999998e-08 21.650000000000002p 1.252559e-07 21.662500000000001p 1.887486e-07 21.674999999999997p 2.4645479999999998e-07 21.6875p 2.9806019999999999e-07 21.699999999999999p 3.4326760000000001e-07 21.712500000000002p 3.8179840000000001e-07 21.725000000000001p 4.1339360000000001e-07 21.737499999999997p 4.378158e-07 21.75p 4.5484940000000002e-07 21.762499999999999p 4.6430219999999998e-07 21.775000000000002p 4.6600579999999999e-07 21.787500000000001p 4.5981640000000001e-07 21.799999999999997p 4.4561500000000001e-07 21.8125p 4.2330830000000002e-07 21.824999999999999p 3.9282819999999999e-07
+ 21.837499999999999p 3.5413250000000002e-07 21.850000000000001p 3.0720429999999998e-07 21.862500000000001p 2.5205230000000002e-07 21.875p 1.887104e-07 21.887499999999999p 1.1723700000000001e-07 21.899999999999999p 3.7715140000000002e-08 21.912500000000001p -4.9748439999999998e-08 21.925000000000001p -1.450239e-07 21.9375p -2.4795879999999999e-07 21.949999999999999p -3.5837909999999997e-07 21.962499999999999p -4.7608969999999999e-07 21.975000000000001p -6.0087589999999997e-07 21.987500000000001p -7.3250329999999998e-07 22p -8.7072e-07 22.012499999999999p -1.0152569999999999e-06 22.024999999999999p -1.1658280000000001e-06 22.037500000000001p -1.3221330000000001e-06 22.050000000000001p -1.483858e-06
+ 22.0625p -1.6506769999999999e-06 22.074999999999999p -1.82225e-06 22.087499999999999p -1.9982280000000001e-06 22.100000000000001p -2.1782530000000001e-06 22.112500000000001p -2.3619580000000001e-06 22.125p -2.5489689999999999e-06 22.137499999999999p -2.7389059999999999e-06 22.149999999999999p -2.931386e-06 22.162500000000001p -3.1260179999999999e-06 22.175000000000001p -3.3224129999999999e-06 22.1875p -3.520178e-06 22.200000000000003p -3.718921e-06 22.212499999999999p -3.9182479999999997e-06 22.224999999999998p -4.117769e-06 22.237500000000001p -4.3170959999999996e-06 22.25p -4.5158430000000002e-06 22.262500000000003p -4.7136320000000001e-06 22.274999999999999p -4.9100859999999998e-06
+ 22.287499999999998p -5.1048370000000002e-06 22.300000000000001p -5.2975230000000001e-06 22.3125p -5.4877900000000004e-06 22.325000000000003p -5.6752910000000001e-06 22.337499999999999p -5.8596910000000004e-06 22.349999999999998p -6.0406619999999998e-06 22.362500000000001p -6.2178869999999996e-06 22.375p -6.3910600000000003e-06 22.387499999999999p -6.5598880000000002e-06 22.400000000000002p -6.724087e-06 22.412499999999998p -6.8833870000000003e-06 22.425000000000001p -7.0375290000000001e-06 22.4375p -7.1862680000000001e-06 22.449999999999999p -7.329373e-06 22.462500000000002p -7.4666239999999996e-06 22.474999999999998p -7.5978159999999999e-06 22.487500000000001p -7.7227559999999996e-06 22.5p -7.8412670000000004e-06
+ 22.512499999999999p -7.9531830000000005e-06 22.525000000000002p -8.0583539999999998e-06 22.537499999999998p -8.1566409999999996e-06 22.550000000000001p -8.2479210000000002e-06 22.5625p -8.3320820000000002e-06 22.574999999999999p -8.4090280000000002e-06 22.587500000000002p -8.4786720000000007e-06 22.600000000000001p -8.5409440000000002e-06 22.612499999999997p -8.5957830000000001e-06 22.625p -8.6431420000000002e-06 22.637499999999999p -8.6829850000000004e-06 22.650000000000002p -8.7152889999999993e-06 22.662500000000001p -8.7400400000000004e-06 22.674999999999997p -8.7572359999999999e-06 22.6875p -8.7668860000000008e-06 22.699999999999999p -8.7690080000000005e-06 22.712500000000002p -8.7636300000000007e-06 22.725000000000001p -8.7507900000000003e-06
+ 22.737500000000001p -8.7305330000000008e-06 22.75p -8.7029159999999997e-06 22.762499999999999p -8.6680000000000007e-06 22.774999999999999p -8.6258559999999995e-06 22.787500000000001p -8.5765630000000006e-06 22.800000000000001p -8.5202050000000005e-06 22.8125p -8.4568729999999998e-06 22.824999999999999p -8.3866670000000003e-06 22.837499999999999p -8.3096889999999993e-06 22.850000000000001p -8.2260480000000002e-06 22.862500000000001p -8.1358609999999995e-06 22.875p -8.039246e-06 22.887499999999999p -7.9363280000000005e-06 22.899999999999999p -7.8272369999999997e-06 22.912500000000001p -7.7121050000000006e-06 22.925000000000001p -7.5910709999999999e-06 22.9375p -7.4642770000000003e-06 22.949999999999999p -7.3318669999999998e-06
+ 22.962499999999999p -7.1939909999999996e-06 22.975000000000001p -7.050802e-06 22.987500000000001p -6.9024549999999998e-06 23p -6.7491110000000004e-06 23.012499999999999p -6.5909309999999997e-06 23.024999999999999p -6.4280829999999997e-06 23.037500000000001p -6.2607360000000002e-06 23.050000000000001p -6.0890609999999998e-06 23.0625p -5.9132350000000003e-06 23.074999999999999p -5.7334360000000002e-06 23.087499999999999p -5.549847e-06 23.100000000000001p -5.3626519999999999e-06 23.112500000000001p -5.17204e-06 23.125p -4.9782019999999997e-06 23.137500000000003p -4.7813329999999997e-06 23.149999999999999p -4.5816320000000004e-06 23.162499999999998p -4.3792980000000001e-06 23.175000000000001p -4.1745359999999997e-06
+ 23.1875p -3.9675539999999999e-06 23.200000000000003p -3.7585629999999999e-06 23.212499999999999p -3.5477750000000001e-06 23.224999999999998p -3.3354089999999999e-06 23.237500000000001p -3.121682e-06 23.25p -2.9068190000000002e-06 23.262500000000003p -2.6910449999999999e-06 23.274999999999999p -2.4745869999999998e-06 23.287499999999998p -2.2576760000000002e-06 23.300000000000001p -2.0405460000000002e-06 23.3125p -1.823431e-06 23.324999999999999p -1.606569e-06 23.337500000000002p -1.390199e-06 23.349999999999998p -1.1745609999999999e-06 23.362500000000001p -9.5989760000000009e-07 23.375p -7.4645060000000002e-07 23.387499999999999p -5.344638e-07 23.400000000000002p -3.2418100000000001e-07
+ 23.412499999999998p -1.15846e-07 23.425000000000001p 9.0297609999999994e-08 23.4375p 2.9400719999999998e-07 23.449999999999999p 4.9504110000000004e-07 23.462500000000002p 6.9315900000000002e-07 23.474999999999998p 8.8812280000000003e-07 23.487500000000001p 1.0796959999999999e-06 23.5p 1.267647e-06 23.512499999999999p 1.4517429999999999e-06 23.525000000000002p 1.6317599999999999e-06 23.537500000000001p 1.807474e-06 23.549999999999997p 1.9786680000000002e-06 23.5625p 2.1451279999999999e-06 23.574999999999999p 2.3066469999999999e-06 23.587500000000002p 2.4630220000000001e-06 23.600000000000001p 2.614057e-06 23.612499999999997p 2.7595640000000001e-06 23.625p 2.8993579999999998e-06
+ 23.637499999999999p 3.0332660000000002e-06 23.650000000000002p 3.1611199999999998e-06 23.662500000000001p 3.2827599999999999e-06 23.675000000000001p 3.3980349999999998e-06 23.6875p 3.5068020000000001e-06 23.699999999999999p 3.6089279999999998e-06 23.712499999999999p 3.7042890000000002e-06 23.725000000000001p 3.7927690000000001e-06 23.737500000000001p 3.8742640000000002e-06 23.75p 3.9486770000000004e-06 23.762499999999999p 4.015925e-06 23.774999999999999p 4.0759320000000003e-06 23.787500000000001p 4.1286349999999996e-06 23.800000000000001p 4.173978e-06 23.8125p 4.2119189999999997e-06 23.824999999999999p 4.2424259999999997e-06 23.837499999999999p 4.2654769999999996e-06 23.850000000000001p 4.2810610000000004e-06
+ 23.862500000000001p 4.2891789999999996e-06 23.875p 4.2898409999999996e-06 23.887499999999999p 4.2830689999999999e-06 23.899999999999999p 4.2688959999999998e-06 23.912500000000001p 4.2473659999999997e-06 23.925000000000001p 4.2185320000000004e-06 23.9375p 4.1824589999999997e-06 23.949999999999999p 4.1392220000000003e-06 23.962499999999999p 4.0889069999999999e-06 23.975000000000001p 4.0316079999999999e-06 23.987500000000001p 3.9674310000000001e-06 24p 3.8964929999999999e-06 24.012499999999999p 3.8189169999999998e-06 24.024999999999999p 3.734838e-06 24.037500000000001p 3.6444000000000002e-06 24.050000000000001p 3.547755e-06 24.0625p 3.4450640000000001e-06 24.075000000000003p 3.3364969999999999e-06
+ 24.087499999999999p 3.2222319999999999e-06 24.099999999999998p 3.1024550000000002e-06 24.112500000000001p 2.977359e-06 24.125p 2.8471440000000002e-06 24.137500000000003p 2.7120189999999999e-06 24.149999999999999p 2.5721969999999998e-06 24.162499999999998p 2.4278989999999998e-06 24.175000000000001p 2.2793509999999999e-06 24.1875p 2.1267860000000002e-06 24.200000000000003p 1.9704400000000001e-06 24.212499999999999p 1.8105559999999999e-06 24.224999999999998p 1.647381e-06 24.237500000000001p 1.481164e-06 24.25p 1.3121610000000001e-06 24.262499999999999p 1.1406280000000001e-06 24.275000000000002p 9.6682579999999999e-07 24.287499999999998p 7.9101749999999998e-07 24.300000000000001p 6.1346769999999997e-07
+ 24.3125p 4.3444239999999999e-07 24.324999999999999p 2.5420920000000001e-07 24.337500000000002p 7.3036000000000006e-08 24.349999999999998p -1.088089e-07 24.362500000000001p -2.9105730000000001e-07 24.375p -4.7344199999999999e-07 24.387499999999999p -6.5569639999999999e-07 24.400000000000002p -8.3755590000000005e-07 24.412499999999998p -1.018757e-06 24.425000000000001p -1.1990409999999999e-06 24.4375p -1.378148e-06 24.449999999999999p -1.555824e-06 24.462500000000002p -1.73182e-06 24.475000000000001p -1.9058870000000001e-06 24.487499999999997p -2.077783e-06 24.5p -2.2472709999999999e-06 24.512499999999999p -2.4141190000000002e-06 24.525000000000002p -2.5780990000000001e-06
+ 24.537500000000001p -2.7389900000000001e-06 24.549999999999997p -2.8965769999999999e-06 24.5625p -3.0506519999999998e-06 24.574999999999999p -3.2010130000000001e-06 24.587500000000002p -3.347466e-06 24.600000000000001p -3.4898219999999998e-06 24.612500000000001p -3.6279009999999998e-06 24.625p -3.7615319999999999e-06 24.637499999999999p -3.8905500000000004e-06 24.649999999999999p -4.0147970000000002e-06 24.662500000000001p -4.1341269999999996e-06 24.675000000000001p -4.2483989999999996e-06 24.6875p -4.3574809999999999e-06 24.699999999999999p -4.4612510000000001e-06 24.712499999999999p -4.5595930000000004e-06 24.725000000000001p -4.6524020000000002e-06 24.737500000000001p -4.739581e-06 24.75p -4.8210400000000003e-06
+ 24.762499999999999p -4.8966989999999998e-06 24.774999999999999p -4.9664870000000001e-06 24.787500000000001p -5.0303400000000002e-06 24.800000000000001p -5.0882039999999999e-06 24.8125p -5.140032e-06 24.824999999999999p -5.1857859999999996e-06 24.837499999999999p -5.2254349999999999e-06 24.850000000000001p -5.2589590000000003e-06 24.862500000000001p -5.2863410000000002e-06 24.875p -5.3075770000000002e-06 24.887499999999999p -5.3226660000000002e-06 24.899999999999999p -5.331618e-06 24.912500000000001p -5.3344479999999998e-06 24.925000000000001p -5.3311789999999999e-06 24.9375p -5.3218399999999999e-06 24.949999999999999p -5.3064679999999999e-06 24.962499999999999p -5.2851060000000002e-06 24.975000000000001p -5.257804e-06
+ 24.987500000000001p -5.2246160000000004e-06 25p -5.1856050000000003e-06 25.012500000000003p -5.1408379999999998e-06 25.024999999999999p -5.0903880000000001e-06 25.037499999999998p -5.0343339999999999e-06 25.050000000000001p -4.9727599999999998e-06 25.0625p -4.9057560000000002e-06 25.075000000000003p -4.8334159999999998e-06 25.087499999999999p -4.7558399999999997e-06 25.099999999999998p -4.673131e-06 25.112500000000001p -4.5854000000000002e-06 25.125p -4.4927600000000002e-06 25.137500000000003p -4.3953290000000002e-06 25.149999999999999p -4.293229e-06 25.162499999999998p -4.1865870000000001e-06 25.175000000000001p -4.0755350000000001e-06 25.1875p -3.9602069999999998e-06 25.199999999999999p -3.8407420000000002e-06
+ 25.212500000000002p -3.7172839999999999e-06 25.224999999999998p -3.589979e-06 25.237500000000001p -3.4589780000000001e-06 25.25p -3.3244349999999998e-06 25.262499999999999p -3.1865089999999999e-06 25.275000000000002p -3.0453599999999998e-06 25.287499999999998p -2.9011539999999999e-06 25.300000000000001p -2.7540580000000001e-06 25.3125p -2.6042439999999999e-06 25.324999999999999p -2.4518879999999999e-06 25.337500000000002p -2.2971660000000001e-06 25.349999999999998p -2.1402599999999998e-06 25.362500000000001p -1.981353e-06 25.375p -1.820632e-06 25.387499999999999p -1.6582850000000001e-06 25.400000000000002p -1.494505e-06 25.412500000000001p -1.3294849999999999e-06 25.424999999999997p -1.1634219999999999e-06
+ 25.4375p -9.9651270000000002e-07 25.449999999999999p -8.2895850000000004e-07 25.462500000000002p -6.6096069999999996e-07 25.475000000000001p -4.9272250000000005e-07 25.487499999999997p -3.2444820000000001e-07 25.5p -1.5634359999999999e-07 25.512499999999999p 1.1385239999999999e-08 25.525000000000002p 1.785313e-07 25.537500000000001p 3.4488730000000001e-07 25.550000000000001p 5.1024619999999999e-07 25.5625p 6.7440069999999995e-07 25.574999999999999p 8.3714440000000002e-07 25.587499999999999p 9.9827159999999993e-07 25.600000000000001p 1.1575769999999999e-06 25.612500000000001p 1.314859e-06 25.625p 1.4699140000000001e-06 25.637499999999999p 1.6225440000000001e-06 25.649999999999999p 1.7725500000000001e-06
+ 25.662500000000001p 1.9197399999999999e-06 25.675000000000001p 2.06392e-06 25.6875p 2.2049019999999999e-06 25.699999999999999p 2.3425029999999999e-06 25.712499999999999p 2.476541e-06 25.725000000000001p 2.6068390000000002e-06 25.737500000000001p 2.733225e-06 25.75p 2.8555329999999999e-06 25.762499999999999p 2.9736000000000002e-06 25.774999999999999p 3.0872700000000001e-06 25.787500000000001p 3.1963920000000002e-06 25.800000000000001p 3.3008210000000002e-06 25.8125p 3.400419e-06 25.824999999999999p 3.495053e-06 25.837499999999999p 3.5845990000000001e-06 25.850000000000001p 3.6689370000000001e-06 25.862500000000001p 3.7479569999999998e-06 25.875p 3.8215550000000002e-06
+ 25.887499999999999p 3.8896360000000001e-06 25.899999999999999p 3.9521099999999997e-06 25.912500000000001p 4.008897e-06 25.925000000000001p 4.0599249999999999e-06 25.9375p 4.1051300000000003e-06 25.950000000000003p 4.1444560000000004e-06 25.962499999999999p 4.1778559999999999e-06 25.974999999999998p 4.2052900000000004e-06 25.987500000000001p 4.2267279999999996e-06 26p 4.2421490000000003e-06 26.012500000000003p 4.2515389999999999e-06 26.024999999999999p 4.2548929999999997e-06 26.037499999999998p 4.2522170000000004e-06 26.050000000000001p 4.2435229999999997e-06 26.0625p 4.2288320000000001e-06 26.075000000000003p 4.2081740000000003e-06 26.087499999999999p 4.1815889999999998e-06 26.099999999999998p 4.1491230000000002e-06
+ 26.112500000000001p 4.1108319999999997e-06 26.125p 4.0667800000000001e-06 26.137499999999999p 4.0170389999999998e-06 26.150000000000002p 3.9616889999999996e-06 26.162499999999998p 3.9008180000000001e-06 26.175000000000001p 3.8345219999999996e-06 26.1875p 3.7629060000000002e-06 26.199999999999999p 3.6860789999999998e-06 26.212500000000002p 3.6041610000000001e-06 26.224999999999998p 3.5172759999999999e-06 26.237500000000001p 3.4255589999999998e-06 26.25p 3.3291469999999998e-06 26.262499999999999p 3.2281870000000001e-06 26.275000000000002p 3.1228310000000002e-06 26.287499999999998p 3.0132370000000002e-06 26.300000000000001p 2.8995680000000001e-06 26.3125p 2.7819949999999999e-06 26.324999999999999p 2.660692e-06
+ 26.337500000000002p 2.5358380000000001e-06 26.350000000000001p 2.4076180000000001e-06 26.362499999999997p 2.2762220000000001e-06 26.375p 2.141841e-06 26.387499999999999p 2.0046740000000002e-06 26.400000000000002p 1.864919e-06 26.412500000000001p 1.7227809999999999e-06 26.424999999999997p 1.5784659999999999e-06 26.4375p 1.432183e-06 26.449999999999999p 1.2841440000000001e-06 26.462500000000002p 1.1345600000000001e-06 26.475000000000001p 9.8364679999999993e-07 26.487500000000001p 8.3161989999999999e-07 26.5p 6.7869579999999997e-07 26.512499999999999p 5.2509159999999998e-07 26.524999999999999p 3.7102419999999999e-07 26.537500000000001p 2.1671070000000001e-07 26.550000000000001p 6.2367390000000004e-08
+ 26.5625p -9.1790310000000003e-08 26.574999999999999p -2.4554820000000001e-07 26.587499999999999p -3.986938e-07 26.600000000000001p -5.5101630000000004e-07 26.612500000000001p -7.0230750000000003e-07 26.625p -8.5236160000000002e-07 26.637499999999999p -1.000976e-06 26.649999999999999p -1.14795e-06 26.662500000000001p -1.2930890000000001e-06 26.675000000000001p -1.4361990000000001e-06 26.6875p -1.5770939999999999e-06 26.699999999999999p -1.715588e-06 26.712499999999999p -1.8515040000000001e-06 26.725000000000001p -1.9846660000000002e-06 26.737500000000001p -2.1149050000000002e-06 26.75p -2.2420580000000002e-06 26.762499999999999p -2.3659660000000002e-06 26.774999999999999p -2.486476e-06
+ 26.787500000000001p -2.6034430000000001e-06 26.800000000000001p -2.7167260000000001e-06 26.8125p -2.8261890000000001e-06 26.824999999999999p -2.931706e-06 26.837499999999999p -3.0331549999999998e-06 26.850000000000001p -3.1304210000000001e-06 26.862500000000001p -3.2233959999999998e-06 26.875p -3.311978e-06 26.887500000000003p -3.3960720000000001e-06 26.899999999999999p -3.4755910000000002e-06 26.912499999999998p -3.5504540000000001e-06 26.925000000000001p -3.6205860000000002e-06 26.9375p -3.6859210000000001e-06 26.950000000000003p -3.746397e-06 26.962499999999999p -3.801962e-06 26.974999999999998p -3.8525680000000001e-06 26.987500000000001p -3.8981750000000002e-06 27p -3.9387500000000002e-06
+ 27.012500000000003p -3.9742659999999997e-06 27.024999999999999p -4.0047029999999998e-06 27.037499999999998p -4.0300460000000004e-06 27.050000000000001p -4.0502889999999999e-06 27.0625p -4.0654299999999996e-06 27.074999999999999p -4.0754729999999997e-06 27.087500000000002p -4.0804300000000003e-06 27.099999999999998p -4.0803170000000004e-06 27.112500000000001p -4.0751570000000003e-06 27.125p -4.0649779999999999e-06 27.137499999999999p -4.0498139999999997e-06 27.150000000000002p -4.0297039999999998e-06 27.162499999999998p -4.0046919999999997e-06 27.175000000000001p -3.9748280000000004e-06 27.1875p -3.9401669999999997e-06 27.199999999999999p -3.900768e-06 27.212500000000002p -3.8566959999999997e-06 27.224999999999998p -3.8080199999999999e-06
+ 27.237500000000001p -3.7548130000000002e-06 27.25p -3.6971550000000002e-06 27.262499999999999p -3.635126e-06 27.275000000000002p -3.5688149999999998e-06 27.287500000000001p -3.4983119999999999e-06 27.299999999999997p -3.4237130000000001e-06 27.3125p -3.345116e-06 27.324999999999999p -3.2626240000000001e-06 27.337500000000002p -3.1763439999999999e-06 27.350000000000001p -3.0863859999999998e-06 27.362499999999997p -2.992864e-06 27.375p -2.895896e-06 27.387499999999999p -2.7956029999999998e-06 27.400000000000002p -2.6921090000000001e-06 27.412500000000001p -2.5855410000000001e-06 27.425000000000001p -2.4760309999999999e-06 27.4375p -2.3637119999999998e-06 27.449999999999999p -2.2487199999999999e-06
+ 27.462499999999999p -2.1311970000000002e-06 27.475000000000001p -2.0112829999999999e-06 27.487500000000001p -1.8891259999999999e-06 27.5p -1.7648719999999999e-06 27.512499999999999p -1.638673e-06 27.524999999999999p -1.5106810000000001e-06 27.537500000000001p -1.3810509999999999e-06 27.550000000000001p -1.249941e-06 27.5625p -1.117512e-06 27.574999999999999p -9.8392279999999993e-07 27.587499999999999p -8.4933849999999997e-07 27.600000000000001p -7.1392360000000001e-07 27.612500000000001p -5.7784470000000005e-07 27.625p -4.4126939999999997e-07 27.637499999999999p -3.043669e-07 27.649999999999999p -1.673071e-07 27.662500000000001p -3.0260759999999998e-08 27.675000000000001p 1.0660059999999999e-07
+ 27.6875p 2.4310530000000001e-07 27.699999999999999p 3.790811e-07 27.712499999999999p 5.143561e-07 27.725000000000001p 6.4875829999999997e-07 27.737500000000001p 7.8211639999999998e-07 27.75p 9.1425980000000005e-07 27.762499999999999p 1.045018e-06 27.774999999999999p 1.1742239999999999e-06 27.787500000000001p 1.301709e-06 27.800000000000001p 1.4273080000000001e-06 27.8125p 1.5508559999999999e-06 27.825000000000003p 1.6721940000000001e-06 27.837499999999999p 1.7911610000000001e-06 27.849999999999998p 1.907601e-06 27.862500000000001p 2.02136e-06 27.875p 2.132288e-06 27.887500000000003p 2.2402379999999999e-06 27.899999999999999p 2.3450669999999999e-06
+ 27.912499999999998p 2.4466340000000001e-06 27.925000000000001p 2.5448050000000001e-06 27.9375p 2.639449e-06 27.949999999999999p 2.7304390000000002e-06 27.962499999999999p 2.8176540000000001e-06 27.974999999999998p 2.9009769999999998e-06 27.987500000000001p 2.9802970000000002e-06 28p 3.055508e-06 28.012499999999999p 3.1265090000000001e-06 28.025000000000002p 3.1932059999999999e-06 28.037499999999998p 3.2555110000000001e-06 28.050000000000001p 3.3133410000000002e-06 28.0625p 3.3666199999999998e-06 28.074999999999999p 3.4152770000000001e-06 28.087500000000002p 3.4592510000000002e-06 28.099999999999998p 3.4984829999999998e-06 28.112500000000001p 3.5329250000000001e-06 28.125p 3.5625319999999998e-06
+ 28.137499999999999p 3.5872690000000001e-06 28.150000000000002p 3.6071059999999999e-06 28.162499999999998p 3.622022e-06 28.175000000000001p 3.6319989999999999e-06 28.1875p 3.6370309999999999e-06 28.199999999999999p 3.6371159999999999e-06 28.212500000000002p 3.6322600000000001e-06 28.225000000000001p 3.6224759999999998e-06 28.237499999999997p 3.6077830000000002e-06 28.25p 3.5882089999999998e-06 28.262499999999999p 3.5637869999999999e-06 28.275000000000002p 3.5345589999999999e-06 28.287500000000001p 3.5005720000000001e-06 28.299999999999997p 3.4618809999999999e-06 28.3125p 3.4185450000000001e-06 28.324999999999999p 3.3706340000000001e-06 28.337500000000002p 3.31822e-06 28.350000000000001p 3.261385e-06
+ 28.362500000000001p 3.2002150000000001e-06 28.375p 3.1348020000000001e-06 28.387499999999999p 3.0652459999999999e-06 28.399999999999999p 2.99165e-06 28.412500000000001p 2.914124e-06 28.425000000000001p 2.8327840000000002e-06 28.4375p 2.7477509999999999e-06 28.449999999999999p 2.659149e-06 28.462499999999999p 2.5671099999999998e-06 28.475000000000001p 2.4717680000000002e-06 28.487500000000001p 2.3732640000000001e-06 28.5p 2.27174e-06 28.512499999999999p 2.167346e-06 28.524999999999999p 2.060231e-06 28.537500000000001p 1.950552e-06 28.550000000000001p 1.838467e-06 28.5625p 1.7241369999999999e-06 28.574999999999999p 1.607727e-06
+ 28.587499999999999p 1.4894019999999999e-06 28.600000000000001p 1.369333e-06 28.612500000000001p 1.2476900000000001e-06 28.625p 1.124646e-06 28.637499999999999p 1.000376e-06 28.649999999999999p 8.7505360000000003e-07 28.662500000000001p 7.4885639999999996e-07 28.675000000000001p 6.219612e-07 28.6875p 4.9454529999999999e-07 28.699999999999999p 3.667862e-07 28.712499999999999p 2.3886099999999998e-07 28.725000000000001p 1.109466e-07 28.737500000000001p -1.678097e-08 28.75p -1.4414660000000001e-07 28.762500000000003p -2.7097660000000001e-07 28.774999999999999p -3.9709870000000002e-07 28.787499999999998p -5.2234249999999997e-07 28.800000000000001p -6.465395e-07
+ 28.8125p -7.6952389999999998e-07 28.825000000000003p -8.9113199999999996e-07 28.837499999999999p -1.011203e-06 28.849999999999998p -1.12958e-06 28.862500000000001p -1.246108e-06 28.875p -1.3606350000000001e-06 28.887499999999999p -1.4730159999999999e-06 28.899999999999999p -1.5831060000000001e-06 28.912499999999998p -1.6907669999999999e-06 28.925000000000001p -1.7958630000000001e-06 28.9375p -1.8982629999999999e-06 28.949999999999999p -1.9978420000000001e-06 28.962500000000002p -2.0944790000000001e-06 28.974999999999998p -2.1880559999999999e-06 28.987500000000001p -2.2784629999999999e-06 29p -2.3655940000000001e-06 29.012499999999999p -2.4493469999999998e-06 29.025000000000002p -2.529627e-06
+ 29.037499999999998p -2.6063419999999998e-06 29.050000000000001p -2.67941e-06 29.0625p -2.7487489999999999e-06 29.074999999999999p -2.8142859999999999e-06 29.087500000000002p -2.8759540000000001e-06 29.099999999999998p -2.9336900000000001e-06 29.112500000000001p -2.9874360000000001e-06 29.125000000000004p -3.0371410000000002e-06 29.137499999999999p -3.0827600000000001e-06 29.149999999999999p -3.1242539999999999e-06 29.162500000000001p -3.161586e-06 29.174999999999997p -3.1947300000000001e-06 29.187500000000004p -3.2236610000000001e-06 29.199999999999999p -3.2483630000000001e-06 29.212499999999999p -3.2688209999999999e-06 29.225000000000001p -3.2850299999999999e-06 29.237499999999997p -3.2969889999999999e-06 29.250000000000004p -3.3046999999999999e-06
+ 29.262499999999999p -3.308172e-06 29.274999999999999p -3.30742e-06 29.287500000000001p -3.3024610000000001e-06 29.299999999999997p -3.2933209999999998e-06 29.312500000000004p -3.280027e-06 29.324999999999999p -3.262613e-06 29.337499999999999p -3.2411160000000002e-06 29.350000000000001p -3.2155800000000001e-06 29.362499999999997p -3.1860500000000002e-06 29.375000000000004p -3.1525790000000002e-06 29.387499999999999p -3.1152210000000002e-06 29.400000000000002p -3.0740359999999999e-06 29.412500000000001p -3.029088e-06 29.424999999999997p -2.9804450000000001e-06 29.4375p -2.9281770000000002e-06 29.449999999999999p -2.8723590000000002e-06 29.462500000000002p -2.8130719999999999e-06 29.475000000000001p -2.750395e-06
+ 29.487499999999997p -2.6844169999999999e-06 29.5p -2.615225e-06 29.512499999999999p -2.5429120000000002e-06 29.525000000000002p -2.4675730000000002e-06 29.537500000000001p -2.3893079999999999e-06 29.549999999999997p -2.308217e-06 29.5625p -2.2244050000000002e-06 29.574999999999999p -2.1379790000000002e-06 29.587500000000002p -2.0490499999999999e-06 29.600000000000001p -1.9577290000000001e-06 29.612499999999997p -1.8641329999999999e-06 29.625p -1.7683779999999999e-06 29.637499999999999p -1.6705830000000001e-06 29.650000000000002p -1.570873e-06 29.662500000000001p -1.4693690000000001e-06 29.674999999999997p -1.3661989999999999e-06 29.6875p -1.2614910000000001e-06 29.699999999999999p -1.1553749999999999e-06
+ 29.712500000000002p -1.0479810000000001e-06 29.724999999999998p -9.3944389999999996e-07 29.737499999999997p -8.2989759999999996e-07 29.75p -7.1947810000000002e-07 29.762499999999999p -6.0832259999999999e-07 29.775000000000002p -4.9656920000000002e-07 29.787499999999998p -3.8435719999999999e-07 29.800000000000004p -2.7182639999999998e-07 29.8125p -1.591174e-07 29.824999999999999p -4.6371340000000001e-08 29.837500000000002p 6.6270370000000003e-08 29.849999999999998p 1.7866610000000001e-07 29.862500000000004p 2.9067429999999998e-07 29.875p 4.0215339999999998e-07 29.887499999999999p 5.1296209999999995e-07 29.900000000000002p 6.2295999999999996e-07 29.912499999999998p 7.3200680000000004e-07 29.925000000000004p 8.3996340000000001e-07
+ 29.9375p 9.4669170000000004e-07 29.949999999999996p 1.0520550000000001e-06 29.962500000000002p 1.1559170000000001e-06 29.974999999999998p 1.258144e-06 29.987500000000001p 1.3586049999999999e-06 30p 1.457168e-06 30.012499999999996p 1.553706e-06 30.025000000000002p 1.648093e-06 30.037499999999998p 1.740206e-06 30.050000000000001p 1.8299250000000001e-06 30.0625p 1.9171330000000001e-06 30.074999999999996p 2.001713e-06 30.087500000000002p 2.0835570000000001e-06 30.099999999999998p 2.1625559999999999e-06 30.112500000000001p 2.2386059999999998e-06 30.125p 2.311607e-06 30.137500000000003p 2.3814620000000002e-06 30.150000000000002p 2.448081e-06
+ 30.162499999999998p 2.5113750000000002e-06 30.175000000000001p 2.57126e-06 30.1875p 2.627658e-06 30.200000000000003p 2.6804959999999999e-06 30.212500000000002p 2.7297030000000002e-06 30.224999999999998p 2.7752160000000001e-06 30.237500000000001p 2.8169749999999998e-06 30.25p 2.8549270000000001e-06 30.262500000000003p 2.889022e-06 30.274999999999999p 2.919218e-06 30.287499999999998p 2.945477e-06 30.300000000000001p 2.9677649999999999e-06 30.3125p 2.986057e-06 30.325000000000003p 3.0003299999999999e-06 30.337499999999999p 3.01057e-06 30.349999999999998p 3.016766e-06 30.362500000000001p 3.018914e-06 30.375p 3.0170160000000001e-06
+ 30.387500000000003p 3.0110769999999999e-06 30.399999999999999p 3.0011130000000001e-06 30.412499999999998p 2.98714e-06 30.425000000000001p 2.969183e-06 30.4375p 2.947271e-06 30.450000000000003p 2.9214410000000002e-06 30.462499999999999p 2.8917319999999998e-06 30.474999999999998p 2.858191e-06 30.487500000000001p 2.8208690000000002e-06 30.499999999999996p 2.7798239999999999e-06 30.512500000000003p 2.7351179999999999e-06 30.524999999999999p 2.6868170000000001e-06 30.537500000000001p 2.634994e-06 30.550000000000001p 2.5797259999999999e-06 30.562499999999996p 2.521095e-06 30.575000000000003p 2.459187e-06 30.587499999999999p 2.3940939999999999e-06 30.600000000000001p 2.3259090000000001e-06
+ 30.612500000000001p 2.2547339999999999e-06 30.624999999999996p 2.180671e-06 30.637500000000003p 2.103828e-06 30.649999999999999p 2.0243159999999998e-06 30.662500000000001p 1.9422499999999999e-06 30.675000000000001p 1.8577480000000001e-06 30.687499999999996p 1.7709310000000001e-06 30.700000000000003p 1.6819229999999999e-06 30.712499999999999p 1.590851e-06 30.725000000000001p 1.4978460000000001e-06 30.737500000000001p 1.4030379999999999e-06 30.749999999999996p 1.3065619999999999e-06 30.762499999999999p 1.208555e-06 30.774999999999999p 1.1091549999999999e-06 30.787500000000001p 1.0085e-06 30.800000000000001p 9.0673210000000001e-07 30.812499999999996p 8.0399319999999995e-07 30.824999999999999p 7.0042610000000002e-07
+ 30.837499999999999p 5.9617459999999998e-07 30.850000000000001p 4.9138280000000004e-07 30.862500000000001p 3.8619500000000002e-07 30.874999999999996p 2.8075589999999998e-07 30.887499999999999p 1.752095e-07 30.899999999999999p 6.9699940000000003e-08 30.912500000000001p -3.562966e-08 30.925000000000001p -1.4063680000000001e-07 30.937500000000004p -2.4517999999999998e-07 30.949999999999999p -3.491192e-07 30.962499999999999p -4.523155e-07 30.975000000000001p -5.546318e-07 30.987500000000001p -6.5593280000000002e-07 31.000000000000004p -7.5608540000000003e-07 31.012499999999999p -8.5495840000000005e-07 31.024999999999999p -9.5242319999999996e-07 31.037500000000001p -1.048354e-06 31.049999999999997p -1.142627e-06
+ 31.062500000000004p -1.235122e-06 31.074999999999999p -1.325722e-06 31.087499999999999p -1.4143120000000001e-06 31.100000000000001p -1.500782e-06 31.112499999999997p -1.5850249999999999e-06 31.125000000000004p -1.666936e-06 31.137499999999999p -1.746417e-06 31.149999999999999p -1.82337e-06 31.162500000000001p -1.897704e-06 31.174999999999997p -1.9693310000000002e-06 31.187500000000004p -2.0381660000000001e-06 31.199999999999999p -2.1041310000000001e-06 31.212499999999999p -2.1671500000000001e-06 31.225000000000001p -2.2271510000000002e-06 31.237499999999997p -2.2840690000000001e-06 31.250000000000004p -2.337841e-06 31.262499999999999p -2.3884089999999999e-06 31.275000000000002p -2.4357210000000002e-06
+ 31.287500000000001p -2.4797280000000001e-06 31.299999999999997p -2.5203849999999998e-06 31.3125p -2.5576549999999999e-06 31.324999999999999p -2.5915020000000001e-06 31.337500000000002p -2.6218949999999999e-06 31.350000000000001p -2.6488099999999998e-06 31.362499999999997p -2.6722259999999999e-06 31.375p -2.6921250000000001e-06 31.387499999999999p -2.7084970000000001e-06 31.400000000000002p -2.721333e-06 31.412500000000001p -2.730631e-06 31.424999999999997p -2.7363930000000002e-06 31.4375p -2.7386229999999999e-06 31.449999999999999p -2.7373329999999999e-06 31.462500000000002p -2.7325370000000001e-06 31.475000000000001p -2.7242519999999998e-06 31.487499999999997p -2.7125030000000002e-06 31.5p -2.697316e-06
+ 31.512499999999999p -2.6787209999999998e-06 31.525000000000002p -2.6567540000000001e-06 31.537500000000001p -2.6314529999999999e-06 31.549999999999997p -2.6028599999999998e-06 31.5625p -2.5710219999999998e-06 31.574999999999999p -2.5359889999999999e-06 31.587500000000002p -2.4978130000000002e-06 31.599999999999998p -2.4565519999999999e-06 31.612499999999997p -2.4122660000000001e-06 31.625p -2.3650190000000001e-06 31.637499999999999p -2.3148770000000001e-06 31.650000000000002p -2.2619100000000002e-06 31.662499999999998p -2.2061910000000001e-06 31.675000000000004p -2.1477970000000001e-06 31.6875p -2.0868059999999998e-06 31.699999999999999p -2.023301e-06 31.712500000000002p -1.957364e-06 31.724999999999998p -1.8890850000000001e-06
+ 31.737500000000004p -1.818551e-06 31.75p -1.7458559999999999e-06 31.762499999999999p -1.671093e-06 31.775000000000002p -1.5943600000000001e-06 31.787499999999998p -1.515755e-06 31.800000000000004p -1.4353799999999999e-06 31.8125p -1.353336e-06 31.824999999999996p -1.2697290000000001e-06 31.837500000000002p -1.184666e-06 31.849999999999998p -1.0982539999999999e-06 31.862500000000001p -1.010603e-06 31.875p -9.2182389999999999e-07 31.887499999999996p -8.3202980000000004e-07 31.900000000000002p -7.4133410000000003e-07 31.912499999999998p -6.4985149999999995e-07 31.925000000000001p -5.5769769999999999e-07 31.9375p -4.6498919999999999e-07 31.949999999999996p -3.7184329999999998e-07
+ 31.962500000000002p -2.7837789999999999e-07 31.974999999999998p -1.847113e-07 31.987500000000001p -9.0962160000000002e-08 32p 2.7506770000000001e-09 32.012500000000003p 9.6308320000000001e-08 32.024999999999999p 1.895919e-07 32.037500000000001p 2.82483e-07 32.050000000000004p 3.7486320000000002e-07 32.0625p 4.6661490000000001e-07 32.075000000000003p 5.5762100000000001e-07 32.087499999999999p 6.4776529999999998e-07 32.099999999999994p 7.3693259999999998e-07 32.112500000000004p 8.2500870000000005e-07 32.125p 9.1188069999999998e-07 32.137500000000003p 9.9743720000000002e-07 32.149999999999999p 1.0815679999999999e-06 32.162499999999994p 1.1641650000000001e-06 32.175000000000004p 1.2451229999999999e-06
+ 32.1875p 1.3243359999999999e-06 32.200000000000003p 1.4017029999999999e-06 32.212499999999999p 1.477123e-06 32.224999999999994p 1.5505e-06 32.237500000000004p 1.6217380000000001e-06 32.25p 1.690746e-06 32.262500000000003p 1.757435e-06 32.274999999999999p 1.8217179999999999e-06 32.287499999999994p 1.883512e-06 32.300000000000004p 1.9427379999999998e-06 32.3125p 1.9993200000000002e-06 32.325000000000003p 2.0531840000000001e-06 32.337499999999999p 2.1042609999999999e-06 32.349999999999994p 2.152487e-06 32.362499999999997p 2.1977979999999999e-06 32.375p 2.240139e-06 32.387500000000003p 2.2794550000000002e-06 32.399999999999999p 2.315696e-06
+ 32.412500000000001p 2.3488170000000001e-06 32.424999999999997p 2.3787779999999998e-06 32.4375p 2.4055410000000002e-06 32.450000000000003p 2.4290739999999999e-06 32.462499999999999p 2.4493489999999999e-06 32.475000000000001p 2.4663430000000001e-06 32.487499999999997p 2.4800369999999999e-06 32.5p 2.4904159999999999e-06 32.512500000000003p 2.4974719999999999e-06 32.524999999999999p 2.5011979999999998e-06 32.537500000000001p 2.5015940000000002e-06 32.549999999999997p 2.4986640000000002e-06 32.5625p 2.4924180000000001e-06 32.575000000000003p 2.4828679999999999e-06 32.587499999999999p 2.4700320000000001e-06 32.600000000000001p 2.453932e-06 32.612499999999997p 2.4345959999999998e-06 32.625p 2.412055e-06
+ 32.637500000000003p 2.3863450000000001e-06 32.649999999999999p 2.357506e-06 32.662500000000001p 2.3255820000000002e-06 32.674999999999997p 2.2906230000000001e-06 32.6875p 2.2526810000000002e-06 32.700000000000003p 2.2118129999999999e-06 32.712499999999999p 2.1680799999999999e-06 32.725000000000001p 2.121548e-06 32.737499999999997p 2.0722849999999998e-06 32.75p 2.020362e-06 32.762500000000003p 1.9658580000000002e-06 32.774999999999999p 1.9088499999999999e-06 32.787500000000001p 1.849421e-06 32.799999999999997p 1.787659e-06 32.8125p 1.72365e-06 32.825000000000003p 1.6574889999999999e-06 32.837499999999999p 1.589269e-06 32.850000000000001p 1.5190889999999999e-06
+ 32.862499999999997p 1.4470469999999999e-06 32.875p 1.3732470000000001e-06 32.887500000000003p 1.2977929999999999e-06 32.899999999999999p 1.220791e-06 32.912500000000001p 1.14235e-06 32.924999999999997p 1.0625809999999999e-06 32.9375p 9.8159370000000007e-07 32.950000000000003p 8.9950280000000002e-07 32.962499999999999p 8.1642210000000005e-07 32.975000000000001p 7.3246669999999999e-07 32.987499999999997p 6.4775279999999995e-07 33p 5.6239720000000001e-07 33.012500000000003p 4.7651719999999999e-07 33.024999999999999p 3.9023039999999999e-07 33.037500000000001p 3.0365450000000001e-07 33.049999999999997p 2.1690720000000001e-07 33.0625p 1.3010610000000001e-07 33.075000000000003p 4.336837e-08
+ 33.087499999999999p -4.3189490000000001e-08 33.100000000000001p -1.294515e-07 33.112499999999997p -2.1530279999999999e-07 33.125p -3.0062930000000001e-07 33.137500000000003p -3.8531829999999999e-07 33.150000000000006p -4.6925839999999997e-07 33.162500000000001p -5.5233980000000005e-07 33.174999999999997p -6.3445420000000001e-07 33.1875p -7.1549529999999997e-07 33.199999999999996p -7.953586e-07 33.212500000000006p -8.7394189999999996e-07 33.225000000000001p -9.5114499999999996e-07 33.237499999999997p -1.0268700000000001e-06 33.25p -1.1010220000000001e-06 33.262499999999996p -1.1735089999999999e-06 33.275000000000006p -1.2442399999999999e-06 33.287500000000001p -1.3131279999999999e-06 33.299999999999997p -1.380089e-06
+ 33.3125p -1.445042e-06 33.324999999999996p -1.507908e-06 33.337500000000006p -1.5686140000000001e-06 33.350000000000001p -1.6270869999999999e-06 33.362499999999997p -1.683259e-06 33.375p -1.737066e-06 33.387499999999996p -1.7884450000000001e-06 33.400000000000006p -1.837339e-06 33.412500000000001p -1.8836939999999999e-06 33.424999999999997p -1.9274590000000001e-06 33.4375p -1.9685860000000001e-06 33.449999999999996p -2.0070340000000001e-06 33.462499999999999p -2.0427599999999999e-06 33.475000000000001p -2.0757310000000001e-06 33.487499999999997p -2.1059130000000002e-06 33.5p -2.133277e-06 33.512499999999996p -2.1577999999999999e-06 33.524999999999999p -2.179459e-06
+ 33.537500000000001p -2.1982380000000002e-06 33.550000000000004p -2.2141230000000001e-06 33.5625p -2.2271030000000001e-06 33.574999999999996p -2.2371729999999998e-06 33.587499999999999p -2.244329e-06 33.600000000000001p -2.2485740000000001e-06 33.612500000000004p -2.2499100000000001e-06 33.625p -2.248347e-06 33.637499999999996p -2.2438960000000001e-06 33.649999999999999p -2.2365710000000002e-06 33.662500000000001p -2.2263920000000002e-06 33.675000000000004p -2.213381e-06 33.6875p -2.1975620000000002e-06 33.699999999999996p -2.1789640000000001e-06 33.712499999999999p -2.1576190000000002e-06 33.725000000000001p -2.133562e-06 33.737500000000004p -2.1068310000000001e-06 33.75p -2.0774670000000002e-06
+ 33.762499999999996p -2.0455129999999999e-06 33.774999999999999p -2.011018e-06 33.787500000000001p -1.9740309999999999e-06 33.800000000000004p -1.934605e-06 33.8125p -1.892795e-06 33.824999999999996p -1.8486599999999999e-06 33.837499999999999p -1.802259e-06 33.850000000000001p -1.7536569999999999e-06 33.862500000000004p -1.70292e-06 33.875p -1.6501150000000001e-06 33.887500000000003p -1.5953129999999999e-06 33.899999999999999p -1.538586e-06 33.912500000000001p -1.4800100000000001e-06 33.925000000000004p -1.4196609999999999e-06 33.9375p -1.357619e-06 33.950000000000003p -1.2939630000000001e-06 33.962499999999999p -1.228778e-06 33.974999999999994p -1.1621470000000001e-06
+ 33.987500000000004p -1.0941560000000001e-06 34p -1.0248929999999999e-06 34.012500000000003p -9.5444720000000003e-07 34.024999999999999p -8.8290890000000004e-07 34.037499999999994p -8.1036989999999998e-07 34.050000000000004p -7.3692310000000003e-07 34.0625p -6.6266259999999999e-07 34.075000000000003p -5.8768320000000005e-07 34.087499999999999p -5.1208100000000004e-07 34.099999999999994p -4.3595240000000001e-07 34.112500000000004p -3.5939489999999998e-07 34.125p -2.8250619999999999e-07 34.137500000000003p -2.053845e-07 34.149999999999999p -1.281286e-07 34.162499999999994p -5.0837159999999999e-08 34.175000000000004p 2.6390909999999999e-08 34.1875p 1.034568e-07 34.200000000000003p 1.802617e-07
+ 34.212499999999999p 2.5670729999999997e-07 34.224999999999994p 3.3269549999999999e-07 34.237499999999997p 4.0812879999999998e-07 34.25p 4.8291029999999995e-07 34.262500000000003p 5.5694399999999996e-07 34.274999999999999p 6.3013469999999999e-07 34.287500000000001p 7.0238809999999997e-07 34.299999999999997p 7.7361130000000001e-07 34.3125p 8.4371249999999999e-07 34.325000000000003p 9.1260139999999995e-07 34.337499999999999p 9.8018910000000001e-07 34.350000000000001p 1.0463879999999999e-06 34.362499999999997p 1.111114e-06 34.375p 1.1742820000000001e-06 34.387500000000003p 1.235812e-06 34.399999999999999p 1.2956229999999999e-06 34.412500000000001p 1.3536390000000001e-06 34.424999999999997p 1.409784e-06
+ 34.4375p 1.463988e-06 34.450000000000003p 1.516179e-06 34.462499999999999p 1.5662900000000001e-06 34.475000000000001p 1.6142580000000001e-06 34.487499999999997p 1.6600209999999999e-06 34.5p 1.703521e-06 34.512500000000003p 1.7447020000000001e-06 34.524999999999999p 1.783511e-06 34.537500000000001p 1.8198999999999999e-06 34.549999999999997p 1.8538229999999999e-06 34.5625p 1.8852369999999999e-06 34.575000000000003p 1.9141040000000001e-06 34.587499999999999p 1.9403880000000002e-06 34.600000000000001p 1.9640569999999998e-06 34.612499999999997p 1.985083e-06 34.625p 2.0034409999999998e-06 34.637500000000003p 2.0191089999999999e-06 34.649999999999999p 2.0320709999999998e-06
+ 34.662500000000001p 2.0423119999999998e-06 34.674999999999997p 2.0498240000000001e-06 34.6875p 2.054599e-06 34.700000000000003p 2.0566360000000001e-06 34.712499999999999p 2.055935e-06 34.725000000000001p 2.0525030000000001e-06 34.737499999999997p 2.0463479999999998e-06 34.75p 2.0374830000000001e-06 34.762500000000003p 2.0259229999999999e-06 34.774999999999999p 2.0116910000000001e-06 34.787500000000001p 1.994809e-06 34.799999999999997p 1.9753040000000001e-06 34.8125p 1.9532089999999998e-06 34.825000000000003p 1.9285569999999999e-06 34.837499999999999p 1.901386e-06 34.850000000000001p 1.8717400000000001e-06 34.862499999999997p 1.8396609999999999e-06 34.875p 1.8051990000000001e-06
+ 34.887500000000003p 1.768404e-06 34.899999999999999p 1.729333e-06 34.912500000000001p 1.6880420000000001e-06 34.924999999999997p 1.6445910000000001e-06 34.9375p 1.5990460000000001e-06 34.950000000000003p 1.5514709999999999e-06 34.962499999999999p 1.5019359999999999e-06 34.975000000000001p 1.450512e-06 34.987499999999997p 1.3972740000000001e-06 35p 1.342298e-06 35.012500000000003p 1.285662e-06 35.025000000000006p 1.2274479999999999e-06 35.037500000000001p 1.1677380000000001e-06 35.049999999999997p 1.106617e-06 35.0625p 1.0441709999999999e-06 35.074999999999996p 9.8048770000000003e-07 35.087500000000006p 9.1565720000000004e-07 35.100000000000001p 8.4977009999999996e-07
+ 35.112499999999997p 7.8291830000000005e-07 35.125p 7.1519500000000002e-07 35.137499999999996p 6.4669400000000003e-07 35.150000000000006p 5.7751020000000003e-07 35.162500000000001p 5.0773900000000004e-07 35.174999999999997p 4.374763e-07 35.1875p 3.6681850000000001e-07 35.199999999999996p 2.9586190000000001e-07 35.212500000000006p 2.2470320000000001e-07 35.225000000000001p 1.5343890000000001e-07 35.237499999999997p 8.2165320000000004e-08 35.25p 1.0978410000000001e-08 35.262499999999996p -6.002634e-08 35.275000000000006p -1.307541e-07 35.287500000000001p -2.0111060000000001e-07 35.299999999999997p -2.7100280000000002e-07 35.3125p -3.403385e-07 35.324999999999996p -4.0902640000000002e-07
+ 35.337499999999999p -4.769769e-07 35.350000000000001p -5.4410159999999999e-07 35.362499999999997p -6.1031349999999995e-07 35.375p -6.7552729999999996e-07 35.387499999999996p -7.3965950000000003e-07 35.399999999999999p -8.0262849999999999e-07 35.412500000000001p -8.6435450000000005e-07 35.425000000000004p -9.2475979999999999e-07 35.4375p -9.8376879999999991e-07 35.449999999999996p -1.0413080000000001e-06 35.462499999999999p -1.097307e-06 35.475000000000001p -1.151697e-06 35.487500000000004p -1.204412e-06 35.5p -1.255388e-06 35.512499999999996p -1.304564e-06 35.524999999999999p -1.3518820000000001e-06 35.537500000000001p -1.397288e-06 35.550000000000004p -1.4407269999999999e-06
+ 35.5625p -1.4821510000000001e-06 35.574999999999996p -1.5215120000000001e-06 35.587499999999999p -1.5587659999999999e-06 35.600000000000001p -1.593873e-06 35.612500000000004p -1.6267949999999999e-06 35.625p -1.6574959999999999e-06 35.637499999999996p -1.685945e-06 35.649999999999999p -1.712113e-06 35.662500000000001p -1.7359739999999999e-06 35.675000000000004p -1.7575060000000001e-06 35.6875p -1.776688e-06 35.699999999999996p -1.793505e-06 35.712499999999999p -1.807944e-06 35.725000000000001p -1.819993e-06 35.737500000000004p -1.829646e-06 35.75p -1.8368980000000001e-06 35.762500000000003p -1.841749e-06 35.774999999999999p -1.844199e-06
+ 35.787500000000001p -1.8442550000000001e-06 35.800000000000004p -1.8419239999999999e-06 35.8125p -1.837216e-06 35.825000000000003p -1.8301460000000001e-06 35.837499999999999p -1.8207289999999999e-06 35.849999999999994p -1.808986e-06 35.862500000000004p -1.7949369999999999e-06 35.875p -1.778609e-06 35.887500000000003p -1.760028e-06 35.899999999999999p -1.7392250000000001e-06 35.912499999999994p -1.716232e-06 35.925000000000004p -1.691084e-06 35.9375p -1.663821e-06 35.950000000000003p -1.6344810000000001e-06 35.962499999999999p -1.6031069999999999e-06 35.974999999999994p -1.5697439999999999e-06 35.987500000000004p -1.5344399999999999e-06 36p -1.497243e-06
+ 36.012500000000003p -1.458206e-06 36.024999999999999p -1.4173819999999999e-06 36.037499999999994p -1.374826e-06 36.050000000000004p -1.3305969999999999e-06 36.0625p -1.2847529999999999e-06 36.075000000000003p -1.237355e-06 36.087499999999999p -1.1884680000000001e-06 36.099999999999994p -1.138155e-06 36.112499999999997p -1.0864840000000001e-06 36.125p -1.0335200000000001e-06 36.137500000000003p -9.7933509999999994e-07 36.149999999999999p -9.2399850000000003e-07 36.162500000000001p -8.6758239999999996e-07 36.174999999999997p -8.1016009999999999e-07 36.1875p -7.51806e-07 36.200000000000003p -6.925952e-07 36.212499999999999p -6.3260430000000002e-07 36.225000000000001p -5.7191049999999995e-07
+ 36.237499999999997p -5.1059180000000004e-07 36.25p -4.4872709999999998e-07 36.262500000000003p -3.8639569999999998e-07 36.274999999999999p -3.2367749999999998e-07 36.287500000000001p -2.6065300000000002e-07 36.299999999999997p -1.9740300000000001e-07 36.3125p -1.3400850000000001e-07 36.325000000000003p -7.0550569999999996e-08 36.337499999999999p -7.1106060000000001e-09 36.350000000000001p 5.6230190000000002e-08 36.362499999999997p 1.1939070000000001e-07 36.375p 1.8229e-07 36.387500000000003p 2.4484750000000001e-07 36.399999999999999p 3.0698299999999999e-07 36.412500000000001p 3.68617e-07 36.424999999999997p 4.2967029999999999e-07 36.4375p 4.9006459999999999e-07 36.450000000000003p 5.4972249999999999e-07
+ 36.462499999999999p 6.0856739999999999e-07 36.475000000000001p 6.6652380000000004e-07 36.487499999999997p 7.2351719999999996e-07 36.5p 7.794744e-07 36.512500000000003p 8.3432350000000001e-07 36.524999999999999p 8.879941e-07 36.537500000000001p 9.404173e-07 36.549999999999997p 9.9152560000000007e-07 36.5625p 1.0412540000000001e-06 36.575000000000003p 1.0895370000000001e-06 36.587499999999999p 1.136315e-06 36.600000000000001p 1.1815259999999999e-06 36.612499999999997p 1.2251130000000001e-06 36.625p 1.26702e-06 36.637500000000003p 1.307194e-06 36.649999999999999p 1.345583e-06 36.662500000000001p 1.3821390000000001e-06 36.674999999999997p 1.4168140000000001e-06
+ 36.6875p 1.449566e-06 36.700000000000003p 1.480353e-06 36.712499999999999p 1.509136e-06 36.725000000000001p 1.535879e-06 36.737499999999997p 1.560549e-06 36.75p 1.5831159999999999e-06 36.762500000000003p 1.6035519999999999e-06 36.774999999999999p 1.6218329999999999e-06 36.787500000000001p 1.637937e-06 36.799999999999997p 1.651844e-06 36.8125p 1.6635400000000001e-06 36.825000000000003p 1.673012e-06 36.837499999999999p 1.6802490000000001e-06 36.850000000000001p 1.685246e-06 36.862499999999997p 1.6879989999999999e-06 36.875p 1.688507e-06 36.887499999999996p 1.686774e-06 36.900000000000006p 1.6828030000000001e-06
+ 36.912500000000001p 1.6766050000000001e-06 36.924999999999997p 1.668192e-06 36.9375p 1.657577e-06 36.949999999999996p 1.644779e-06 36.962500000000006p 1.6298179999999999e-06 36.975000000000001p 1.6127189999999999e-06 36.987499999999997p 1.5935070000000001e-06 37p 1.5722130000000001e-06 37.012499999999996p 1.5488680000000001e-06 37.025000000000006p 1.5235089999999999e-06 37.037500000000001p 1.496172e-06 37.049999999999997p 1.4668990000000001e-06 37.0625p 1.4357310000000001e-06 37.074999999999996p 1.4027159999999999e-06 37.087500000000006p 1.3679010000000001e-06 37.100000000000001p 1.331336e-06 37.112499999999997p 1.2930749999999999e-06 37.125p 1.253173e-06
+ 37.137499999999996p 1.211686e-06 37.150000000000006p 1.1686740000000001e-06 37.162500000000001p 1.1241979999999999e-06 37.174999999999997p 1.0783220000000001e-06 37.1875p 1.0311110000000001e-06 37.199999999999996p 9.8263010000000005e-07 37.212499999999999p 9.3294890000000003e-07 37.225000000000001p 8.8213670000000003e-07 37.237499999999997p 8.3026469999999997e-07 37.25p 7.7740530000000002e-07 37.262499999999996p 7.2363210000000002e-07 37.274999999999999p 6.6901969999999996e-07 37.287500000000001p 6.1364369999999996e-07 37.300000000000004p 5.5758049999999995e-07 37.3125p 5.009074e-07 37.324999999999996p 4.4370209999999998e-07 37.337499999999999p 3.8604290000000002e-07 37.350000000000001p 3.2800859999999999e-07
+ 37.362500000000004p 2.6967800000000001e-07 37.375p 2.1113040000000001e-07 37.387499999999996p 1.5244489999999999e-07 37.399999999999999p 9.3700520000000006e-08 37.412500000000001p 3.4976330000000001e-08 37.425000000000004p -2.3649080000000001e-08 37.4375p -8.2097440000000005e-08 37.449999999999996p -1.40291e-07 37.462499999999999p -1.9815270000000001e-07 37.475000000000001p -2.5560619999999998e-07 37.487500000000004p -3.1257569999999998e-07 37.5p -3.6898680000000001e-07 37.512499999999996p -4.2476580000000002e-07 37.524999999999999p -4.7984019999999997e-07 37.537500000000001p -5.3413889999999997e-07 37.550000000000004p -5.8759190000000005e-07 37.5625p -6.4013059999999996e-07 37.574999999999996p -6.9168819999999995e-07
+ 37.587499999999999p -7.4219909999999998e-07 37.600000000000001p -7.9159970000000004e-07 37.612500000000004p -8.3982789999999998e-07 37.625p -8.8682359999999998e-07 37.637500000000003p -9.3252839999999997e-07 37.649999999999999p -9.7688620000000004e-07 37.662500000000001p -1.0198430000000001e-06 37.675000000000004p -1.0613450000000001e-06 37.6875p -1.1013440000000001e-06 37.700000000000003p -1.1397920000000001e-06 37.712499999999999p -1.176643e-06 37.724999999999994p -1.211853e-06 37.737500000000004p -1.2453819999999999e-06 37.75p -1.277192e-06 37.762500000000003p -1.3072449999999999e-06 37.774999999999999p -1.335509e-06 37.787499999999994p -1.361952e-06 37.800000000000004p -1.386546e-06
+ 37.8125p -1.4092650000000001e-06 37.825000000000003p -1.4300840000000001e-06 37.837499999999999p -1.448983e-06 37.849999999999994p -1.465944e-06 37.862500000000004p -1.48095e-06 37.875p -1.4939880000000001e-06 37.887500000000003p -1.505048e-06 37.899999999999999p -1.514121e-06 37.912499999999994p -1.521202e-06 37.925000000000004p -1.526287e-06 37.9375p -1.5293769999999999e-06 37.950000000000003p -1.5304739999999999e-06 37.962499999999999p -1.529581e-06 37.974999999999994p -1.5267060000000001e-06 37.987499999999997p -1.5218589999999999e-06 38p -1.5150520000000001e-06 38.012500000000003p -1.5062990000000001e-06 38.024999999999999p -1.4956159999999999e-06
+ 38.037500000000001p -1.4830240000000001e-06 38.049999999999997p -1.4685429999999999e-06 38.0625p -1.452197e-06 38.075000000000003p -1.4340130000000001e-06 38.087499999999999p -1.414019e-06 38.100000000000001p -1.3922439999999999e-06 38.112499999999997p -1.3687220000000001e-06 38.125p -1.343487e-06 38.137500000000003p -1.316575e-06 38.149999999999999p -1.288025e-06 38.162500000000001p -1.2578780000000001e-06 38.174999999999997p -1.226176e-06 38.1875p -1.1929630000000001e-06 38.200000000000003p -1.158285e-06 38.212499999999999p -1.1221889999999999e-06 38.225000000000001p -1.084724e-06 38.237499999999997p -1.0459419999999999e-06 38.25p -1.005895e-06
+ 38.262500000000003p -9.6463609999999992e-07 38.274999999999999p -9.2222069999999995e-07 38.287500000000001p -8.7870519999999996e-07 38.299999999999997p -8.341472e-07 38.3125p -7.8860569999999998e-07 38.325000000000003p -7.4214059999999995e-07 38.337499999999999p -6.9481279999999995e-07 38.350000000000001p -6.4668449999999998e-07 38.362499999999997p -5.9781839999999996e-07 38.375p -5.4827829999999996e-07 38.387500000000003p -4.9812860000000003e-07 38.399999999999999p -4.474344e-07 38.412500000000001p -3.9626140000000003e-07 38.424999999999997p -3.4467599999999998e-07 38.4375p -2.9274480000000001e-07 38.450000000000003p -2.4053479999999999e-07 38.462499999999999p -1.8811329999999999e-07 38.475000000000001p -1.3554799999999999e-07
+ 38.487499999999997p -8.2906469999999999e-08 38.5p -3.0256410000000001e-08 38.512500000000003p 2.233451e-08 38.524999999999999p 7.4798729999999994e-08 38.537500000000001p 1.2706889999999999e-07 38.549999999999997p 1.790781e-07 38.5625p 2.307594e-07 38.575000000000003p 2.820468e-07 38.587499999999999p 3.3287450000000001e-07 38.600000000000001p 3.831775e-07 38.612499999999997p 4.328914e-07 38.625p 4.8195260000000001e-07 38.637500000000003p 5.3029840000000005e-07 38.649999999999999p 5.7786700000000005e-07 38.662500000000001p 6.2459770000000004e-07 38.674999999999997p 6.7043090000000004e-07 38.6875p 7.1530799999999996e-07 38.700000000000003p 7.5917200000000004e-07
+ 38.712499999999999p 8.0196700000000005e-07 38.725000000000001p 8.4363849999999996e-07 38.737499999999997p 8.8413350000000001e-07 38.75p 9.2340079999999996e-07 38.762499999999996p 9.6139060000000001e-07 38.775000000000006p 9.9805470000000002e-07 38.787500000000001p 1.0333469999999999e-06 38.799999999999997p 1.0672229999999999e-06 38.8125p 1.0996400000000001e-06 38.824999999999996p 1.1305569999999999e-06 38.837500000000006p 1.159936e-06 38.850000000000001p 1.1877409999999999e-06 38.862499999999997p 1.2139360000000001e-06 38.875p 1.238489e-06 38.887499999999996p 1.2613709999999999e-06 38.900000000000006p 1.282554e-06 38.912500000000001p 1.3020110000000001e-06 38.924999999999997p 1.319721e-06
+ 38.9375p 1.335661e-06 38.949999999999996p 1.3498129999999999e-06 38.962500000000006p 1.3621620000000001e-06 38.975000000000001p 1.372694e-06 38.987499999999997p 1.3813969999999999e-06 39p 1.3882629999999999e-06 39.012499999999996p 1.3932860000000001e-06 39.025000000000006p 1.3964610000000001e-06 39.037500000000001p 1.3977880000000001e-06 39.049999999999997p 1.3972679999999999e-06 39.0625p 1.3949040000000001e-06 39.074999999999996p 1.390704e-06 39.087499999999999p 1.384675e-06 39.100000000000001p 1.3768290000000001e-06 39.112500000000004p 1.3671790000000001e-06 39.125p 1.3557420000000001e-06 39.137499999999996p 1.342535e-06 39.149999999999999p 1.3275809999999999e-06
+ 39.162500000000001p 1.3109020000000001e-06 39.175000000000004p 1.2925229999999999e-06 39.1875p 1.272473e-06 39.199999999999996p 1.2507810000000001e-06 39.212499999999999p 1.22748e-06 39.225000000000001p 1.202603e-06 39.237500000000004p 1.1761879999999999e-06 39.25p 1.1482719999999999e-06 39.262499999999996p 1.1188969999999999e-06 39.274999999999999p 1.0881039999999999e-06 39.287500000000001p 1.0559379999999999e-06 39.300000000000004p 1.0224440000000001e-06 39.3125p 9.8767010000000005e-07 39.324999999999996p 9.516659e-07 39.337499999999999p 9.1448200000000002e-07 39.350000000000001p 8.7617089999999997e-07 39.362500000000004p 8.367862e-07 39.375p 7.9638310000000001e-07
+ 39.387499999999996p 7.550179e-07 39.399999999999999p 7.1274820000000001e-07 39.412500000000001p 6.6963270000000005e-07 39.425000000000004p 6.2573080000000002e-07 39.4375p 5.811032e-07 39.449999999999996p 5.3581130000000004e-07 39.462499999999999p 4.8991700000000001e-07 39.475000000000001p 4.4348320000000001e-07 39.487500000000004p 3.9657320000000002e-07 39.5p 3.4925080000000002e-07 39.512500000000003p 3.0157999999999998e-07 39.524999999999999p 2.5362540000000002e-07 39.537500000000001p 2.054514e-07 39.550000000000004p 1.57123e-07 39.5625p 1.087047e-07 39.575000000000003p 6.0261220000000003e-08 39.587499999999999p 1.1857060000000001e-08 39.599999999999994p -3.644359e-08
+ 39.612500000000004p -8.4576859999999999e-08 39.625p -1.3247930000000001e-07 39.637500000000003p -1.8008810000000001e-07 39.649999999999999p -2.2734080000000001e-07 39.662499999999994p -2.7417599999999998e-07 39.675000000000004p -3.2053270000000003e-07 39.6875p -3.6635100000000002e-07 39.700000000000003p -4.1157189999999998e-07 39.712499999999999p -4.5613730000000001e-07 39.724999999999994p -4.999902e-07 39.737500000000004p -5.4307490000000005e-07 39.75p -5.8533689999999995e-07 39.762500000000003p -6.2672270000000004e-07 39.774999999999999p -6.6718070000000002e-07 39.787499999999994p -7.0666019999999999e-07 39.800000000000004p -7.4511219999999997e-07 39.8125p -7.8248940000000001e-07 39.825000000000003p -8.1874590000000005e-07
+ 39.837499999999999p -8.5383740000000002e-07 39.849999999999994p -8.8772150000000005e-07 39.862499999999997p -9.2035739999999996e-07 39.875p -9.5170619999999997e-07 39.887500000000003p -9.8173079999999998e-07 39.899999999999999p -1.010396e-06 39.912500000000001p -1.037668e-06 39.924999999999997p -1.0635160000000001e-06 39.9375p -1.0879110000000001e-06 39.950000000000003p -1.110824e-06 39.962499999999999p -1.1322309999999999e-06 39.975000000000001p -1.152108e-06 39.987499999999997p -1.1704339999999999e-06 40p -1.18719e-06 40.012500000000003p -1.2023590000000001e-06 40.024999999999999p -1.2159249999999999e-06 40.037500000000001p -1.2278759999999999e-06 40.049999999999997p -1.2382010000000001e-06
+ 40.0625p -1.2468920000000001e-06 40.075000000000003p -1.253941e-06 40.087499999999999p -1.2593449999999999e-06 40.100000000000001p -1.2631010000000001e-06 40.112499999999997p -1.265208e-06 40.125p -1.26567e-06 40.137500000000003p -1.264489e-06 40.149999999999999p -1.261673e-06 40.162500000000001p -1.2572279999999999e-06 40.174999999999997p -1.2511650000000001e-06 40.1875p -1.2434959999999999e-06 40.200000000000003p -1.2342359999999999e-06 40.212499999999999p -1.2234e-06 40.225000000000001p -1.2110060000000001e-06 40.237499999999997p -1.1970750000000001e-06 40.25p -1.1816269999999999e-06 40.262500000000003p -1.1646869999999999e-06 40.274999999999999p -1.146281e-06
+ 40.287500000000001p -1.126434e-06 40.299999999999997p -1.105177e-06 40.3125p -1.082539e-06 40.325000000000003p -1.0585530000000001e-06 40.337499999999999p -1.0332530000000001e-06 40.350000000000001p -1.006674e-06 40.362499999999997p -9.788536000000001e-07 40.375p -9.4982949999999996e-07 40.387500000000003p -9.1964170000000002e-07 40.399999999999999p -8.8833140000000001e-07 40.412500000000001p -8.55941e-07 40.424999999999997p -8.2251450000000004e-07 40.4375p -7.8809659999999997e-07 40.450000000000003p -7.5273360000000003e-07 40.462499999999999p -7.1647259999999996e-07 40.475000000000001p -6.7936189999999997e-07 40.487499999999997p -6.4145070000000001e-07 40.5p -6.0278930000000001e-07
+ 40.512500000000003p -5.6342859999999996e-07 40.524999999999999p -5.2342040000000003e-07 40.537500000000001p -4.8281739999999997e-07 40.549999999999997p -4.4167270000000001e-07 40.5625p -4.0004020000000001e-07 40.575000000000003p -3.579743e-07 40.587499999999999p -3.1552989999999998e-07 40.600000000000001p -2.727622e-07 40.612499999999997p -2.29727e-07 40.625p -1.8647989999999999e-07 40.637499999999996p -1.4307730000000001e-07 40.650000000000006p -9.957528e-08 40.662500000000001p -5.603021e-08 40.674999999999997p -1.249841e-08 40.6875p 3.0963890000000003e-08 40.699999999999996p 7.4300579999999997e-08 40.712500000000006p 1.1745580000000001e-07 40.725000000000001p 1.6037379999999999e-07
+ 40.737499999999997p 2.0299949999999999e-07 40.75p 2.4527799999999998e-07 40.762499999999996p 2.8715490000000001e-07 40.775000000000006p 3.285765e-07 40.787500000000001p 3.6948959999999999e-07 40.799999999999997p 4.0984179999999999e-07 40.8125p 4.4958129999999998e-07 40.824999999999996p 4.8865740000000003e-07 40.837500000000006p 5.2702009999999996e-07 40.850000000000001p 5.6462030000000001e-07 40.862499999999997p 6.0141020000000002e-07 40.875p 6.373429e-07 40.887499999999996p 6.7237269999999998e-07 40.900000000000006p 7.0645520000000005e-07 40.912500000000001p 7.3954710000000004e-07 40.924999999999997p 7.7160650000000002e-07 40.9375p 8.0259310000000001e-07 40.949999999999996p 8.3246779999999995e-07
+ 40.962499999999999p 8.6119309999999997e-07 40.975000000000001p 8.8873289999999998e-07 40.987500000000004p 9.1505309999999995e-07 41p 9.4012070000000003e-07 41.012499999999996p 9.6390489999999998e-07 41.024999999999999p 9.8637629999999999e-07 41.037500000000001p 1.0075070000000001e-06 41.050000000000004p 1.027272e-06 41.0625p 1.045648e-06 41.074999999999996p 1.0626110000000001e-06 41.087499999999999p 1.078143e-06 41.100000000000001p 1.0922239999999999e-06 41.112500000000004p 1.104839e-06 41.125p 1.1159739999999999e-06 41.137499999999996p 1.1256160000000001e-06 41.149999999999999p 1.1337559999999999e-06 41.162500000000001p 1.1403849999999999e-06 41.175000000000004p 1.145497e-06
+ 41.1875p 1.149087e-06 41.199999999999996p 1.1511549999999999e-06 41.212499999999999p 1.1516999999999999e-06 41.225000000000001p 1.1507249999999999e-06 41.237500000000004p 1.1482319999999999e-06 41.25p 1.14423e-06 41.262499999999996p 1.1387250000000001e-06 41.274999999999999p 1.131728e-06 41.287500000000001p 1.1232520000000001e-06 41.300000000000004p 1.1133110000000001e-06 41.3125p 1.1019199999999999e-06 41.324999999999996p 1.0890990000000001e-06 41.337499999999999p 1.074866e-06 41.350000000000001p 1.0592449999999999e-06 41.362500000000004p 1.0422580000000001e-06 41.375p 1.0239320000000001e-06 41.387500000000003p 1.0042930000000001e-06 41.399999999999999p 9.8337179999999996e-07
+ 41.412500000000001p 9.6119769999999992e-07 41.425000000000004p 9.3780350000000004e-07 41.4375p 9.1322319999999998e-07 41.450000000000003p 8.8749240000000004e-07 41.462499999999999p 8.6064809999999996e-07 41.474999999999994p 8.3272859999999997e-07 41.487500000000004p 8.0377370000000003e-07 41.5p 7.7382459999999999e-07 41.512500000000003p 7.4292370000000001e-07 41.524999999999999p 7.1111439999999999e-07 41.537499999999994p 6.7844150000000002e-07 41.550000000000004p 6.4495069999999996e-07 41.5625p 6.1068879999999996e-07 41.575000000000003p 5.7570329999999995e-07 41.587499999999999p 5.4004279999999995e-07 41.599999999999994p 5.0375659999999995e-07 41.612500000000004p 4.6689459999999998e-07 41.625p 4.2950760000000002e-07
+ 41.637500000000003p 3.9164669999999998e-07 41.649999999999999p 3.5336370000000001e-07 41.662499999999994p 3.147106e-07 41.675000000000004p 2.7574000000000001e-07 41.6875p 2.365045e-07 41.700000000000003p 1.970572e-07 41.712499999999999p 1.5745109999999999e-07 41.724999999999994p 1.177393e-07 41.737499999999997p 7.7974849999999994e-08 41.75p 3.8210790000000003e-08 41.762500000000003p -1.5000690000000001e-09 41.774999999999999p -4.1105169999999998e-08 41.787500000000001p -8.0552270000000006e-08 41.799999999999997p -1.197895e-07 41.8125p -1.587654e-07 41.825000000000003p -1.974292e-07 41.837499999999999p -2.3573060000000001e-07 41.850000000000001p -2.736198e-07
+ 41.862499999999997p -3.1104810000000001e-07 41.875p -3.479674e-07 41.887500000000003p -3.8433019999999999e-07 41.899999999999999p -4.2009040000000002e-07 41.912500000000001p -4.5520260000000001e-07 41.924999999999997p -4.8962230000000004e-07 41.9375p -5.2330639999999996e-07 41.950000000000003p -5.5621260000000004e-07 41.962499999999999p -5.8830009999999999e-07 41.975000000000001p -6.1952909999999995e-07 41.987499999999997p -6.4986119999999998e-07 42p -6.7925929999999996e-07 42.012500000000003p -7.0768760000000004e-07 42.024999999999999p -7.3511190000000003e-07 42.037500000000001p -7.6149930000000004e-07 42.049999999999997p -7.8681830000000003e-07 42.0625p -8.1103899999999996e-07 42.075000000000003p -8.3413329999999997e-07
+ 42.087499999999999p -8.5607419999999995e-07 42.100000000000001p -8.7683669999999995e-07 42.112499999999997p -8.9639720000000001e-07 42.125p -9.1473380000000001e-07 42.137500000000003p -9.3182639999999996e-07 42.149999999999999p -9.4765650000000001e-07 42.162500000000001p -9.622071e-07 42.174999999999997p -9.7546319999999994e-07 42.1875p -9.8741150000000007e-07 42.200000000000003p -9.9804019999999994e-07 42.212499999999999p -1.0073390000000001e-06 42.225000000000001p -1.0153010000000001e-06 42.237499999999997p -1.021919e-06 42.25p -1.0271869999999999e-06 42.262500000000003p -1.0311050000000001e-06 42.274999999999999p -1.0336689999999999e-06 42.287500000000001p -1.0348809999999999e-06 42.299999999999997p -1.0347419999999999e-06
+ 42.3125p -1.033257e-06 42.325000000000003p -1.0304319999999999e-06 42.337499999999999p -1.0262739999999999e-06 42.350000000000001p -1.020791e-06 42.362499999999997p -1.013994e-06 42.375p -1.0058960000000001e-06 42.387500000000003p -9.965103e-07 42.399999999999999p -9.8585229999999993e-07 42.412500000000001p -9.7393920000000001e-07 42.424999999999997p -9.6078940000000006e-07 42.4375p -9.4642299999999995e-07 42.450000000000003p -9.3086140000000001e-07 42.462499999999999p -9.1412760000000002e-07 42.475000000000001p -8.9624590000000005e-07 42.487499999999997p -8.7724209999999998e-07 42.5p -8.5714320000000003e-07 42.512499999999996p -8.3597770000000002e-07 42.525000000000006p -8.1377510000000004e-07
+ 42.537500000000001p -7.9056639999999998e-07 42.549999999999997p -7.6638359999999999e-07 42.5625p -7.4125990000000002e-07 42.574999999999996p -7.1522980000000005e-07 42.587500000000006p -6.8832840000000004e-07 42.600000000000001p -6.6059240000000004e-07 42.612499999999997p -6.3205910000000003e-07 42.625p -6.0276669999999998e-07 42.637499999999996p -5.727546e-07 42.650000000000006p -5.4206269999999997e-07 42.662500000000001p -5.1073179999999999e-07 42.674999999999997p -4.7880360000000001e-07 42.6875p -4.4632030000000002e-07 42.699999999999996p -4.133247e-07 42.712500000000006p -3.7986029999999999e-07 42.725000000000001p -3.4597119999999998e-07 42.737499999999997p -3.117016e-07 42.75p -2.7709670000000001e-07
+ 42.762499999999996p -2.4220150000000003e-07 42.775000000000006p -2.0706160000000001e-07 42.787500000000001p -1.7172289999999999e-07 42.799999999999997p -1.3623139999999999e-07 42.8125p -1.006331e-07 42.824999999999996p -6.4974459999999998e-08 42.837499999999999p -2.9301579999999998e-08 42.850000000000001p 6.339276e-09 42.862500000000004p 4.1901960000000001e-08 42.875p 7.7340470000000001e-08 42.887499999999996p 1.12609e-07 42.899999999999999p 1.4766210000000001e-07 42.912500000000001p 1.8245449999999999e-07 42.925000000000004p 2.1694140000000001e-07 42.9375p 2.5107830000000002e-07 42.949999999999996p 2.8482139999999998e-07 42.962499999999999p 3.181274e-07 42.975000000000001p 3.509534e-07
+ 42.987500000000004p 3.832574e-07 43p 4.149979e-07 43.012499999999996p 4.461345e-07 43.024999999999999p 4.7662720000000001e-07 43.037500000000001p 5.0643719999999998e-07 43.050000000000004p 5.3552640000000005e-07 43.0625p 5.6385789999999997e-07 43.074999999999996p 5.9139570000000003e-07 43.087499999999999p 6.181048e-07 43.100000000000001p 6.4395139999999999e-07 43.112500000000004p 6.689029e-07 43.125p 6.9292789999999995e-07 43.137499999999996p 7.1599619999999999e-07 43.149999999999999p 7.3807889999999998e-07 43.162500000000001p 7.5914839999999998e-07 43.175000000000004p 7.7917850000000003e-07 43.1875p 7.9814449999999999e-07 43.199999999999996p 8.16023e-07
+ 43.212499999999999p 8.3279219999999997e-07 43.225000000000001p 8.4843159999999996e-07 43.237500000000004p 8.6292239999999997e-07 43.25p 8.7624730000000003e-07 43.262500000000003p 8.8839049999999999e-07 43.274999999999999p 8.99338e-07 43.287499999999994p 9.0907709999999995e-07 43.300000000000004p 9.1759709999999997e-07 43.3125p 9.2488870000000001e-07 43.325000000000003p 9.3094430000000003e-07 43.337499999999999p 9.3575800000000001e-07 43.349999999999994p 9.3932550000000002e-07 43.362500000000004p 9.4164429999999999e-07 43.375p 9.4271359999999999e-07 43.387500000000003p 9.4253410000000001e-07 43.399999999999999p 9.4110830000000002e-07 43.412499999999994p 9.384404e-07 43.425000000000004p 9.3453620000000004e-07
+ 43.4375p 9.2940329999999995e-07 43.450000000000003p 9.230507e-07 43.462499999999999p 9.1548919999999996e-07 43.474999999999994p 9.0673129999999997e-07 43.487500000000004p 8.9679089999999995e-07 43.5p 8.8568359999999996e-07 43.512500000000003p 8.7342649999999996e-07 43.524999999999999p 8.600382e-07 43.537499999999994p 8.4553889999999997e-07 43.550000000000004p 8.2995019999999997e-07 43.5625p 8.1329510000000002e-07 43.575000000000003p 7.95598e-07 43.587499999999999p 7.7688479999999995e-07 43.599999999999994p 7.5718260000000002e-07 43.612499999999997p 7.365198e-07 43.625p 7.1492610000000005e-07 43.637500000000003p 6.9243229999999999e-07 43.649999999999999p 6.6907050000000001e-07
+ 43.662500000000001p 6.4487369999999995e-07 43.674999999999997p 6.1987620000000005e-07 43.6875p 5.9411299999999999e-07 43.700000000000003p 5.6762050000000001e-07 43.712499999999999p 5.4043549999999997e-07 43.725000000000001p 5.1259610000000001e-07 43.737499999999997p 4.8414089999999998e-07 43.75p 4.5510930000000001e-07 43.762500000000003p 4.2554150000000003e-07 43.774999999999999p 3.9547809999999998e-07 43.787500000000001p 3.6496060000000001e-07 43.799999999999997p 3.3403069999999998e-07 43.8125p 3.0273070000000001e-07 43.825000000000003p 2.7110329999999999e-07 43.837499999999999p 2.3919130000000002e-07 43.850000000000001p 2.070381e-07 43.862499999999997p 1.7468719999999999e-07 43.875p 1.42182e-07
+ 43.887500000000003p 1.0956630000000001e-07 43.899999999999999p 7.6883880000000004e-08 43.912500000000001p 4.4178279999999997e-08 43.924999999999997p 1.1493109999999999e-08 43.9375p -2.11282e-08 43.950000000000003p -5.3642470000000002e-08 43.962499999999999p -8.6006780000000006e-08 43.975000000000001p -1.181785e-07 43.987499999999997p -1.5011550000000001e-07 44p -1.81776e-07 44.012500000000003p -2.1311869999999999e-07 44.024999999999999p -2.44103e-07 44.037500000000001p -2.7468880000000002e-07 44.049999999999997p -3.0483660000000002e-07 44.0625p -3.3450770000000002e-07 44.075000000000003p -3.636642e-07 44.087499999999999p -3.9226899999999998e-07 44.100000000000001p -4.2028580000000002e-07
+ 44.112499999999997p -4.4767920000000001e-07 44.125p -4.7441469999999997e-07 44.137500000000003p -5.0045900000000005e-07 44.149999999999999p -5.2577969999999996e-07 44.162500000000001p -5.5034530000000005e-07 44.174999999999997p -5.7412580000000003e-07 44.1875p -5.9709190000000002e-07 44.200000000000003p -6.1921570000000003e-07 44.212499999999999p -6.4047060000000002e-07 44.225000000000001p -6.6083110000000004e-07 44.237499999999997p -6.8027290000000003e-07 44.25p -6.9877319999999996e-07 44.262500000000003p -7.1631030000000002e-07 44.274999999999999p -7.3286399999999996e-07 44.287500000000001p -7.4841530000000002e-07 44.299999999999997p -7.6294679999999997e-07 44.3125p -7.7644219999999997e-07 44.325000000000003p -7.888869e-07
+ 44.337499999999999p -8.0026750000000004e-07 44.350000000000001p -8.1057210000000003e-07 44.362499999999997p -8.1979030000000004e-07 44.375p -8.2791310000000003e-07 44.387499999999996p -8.3493289999999996e-07 44.400000000000006p -8.4084349999999999e-07 44.412500000000001p -8.4564040000000002e-07 44.424999999999997p -8.4932039999999995e-07 44.4375p -8.5188169999999995e-07 44.449999999999996p -8.5332399999999997e-07 44.462500000000006p -8.5364850000000004e-07 44.475000000000001p -8.5285759999999995e-07 44.487499999999997p -8.5095550000000003e-07 44.5p -8.479475e-07 44.512499999999996p -8.4384050000000003e-07 44.525000000000006p -8.3864259999999995e-07 44.537500000000001p -8.3236339999999997e-07 44.549999999999997p -8.2501380000000002e-07
+ 44.5625p -8.1660610000000005e-07 44.574999999999996p -8.0715379999999999e-07 44.587500000000006p -7.9667180000000002e-07 44.600000000000001p -7.8517630000000002e-07 44.612499999999997p -7.7268459999999997e-07 44.625p -7.5921520000000005e-07 44.637499999999996p -7.4478800000000004e-07 44.650000000000006p -7.2942399999999998e-07 44.662500000000001p -7.1314510000000002e-07 44.674999999999997p -6.9597470000000001e-07 44.6875p -6.7793690000000003e-07 44.699999999999996p -6.5905700000000005e-07 44.712499999999999p -6.3936140000000003e-07 44.725000000000001p -6.1887730000000005e-07 44.737500000000004p -5.9763290000000002e-07 44.75p -5.756574e-07 44.762499999999996p -5.5298070000000002e-07 44.774999999999999p -5.2963359999999999e-07
+ 44.787500000000001p -5.056477e-07 44.800000000000004p -4.8105529999999999e-07 44.8125p -4.5588929999999999e-07 44.824999999999996p -4.3018359999999999e-07 44.837499999999999p -4.0397240000000001e-07 44.850000000000001p -3.7729050000000003e-07 44.862500000000004p -3.5017350000000001e-07 44.875p -3.2265699999999998e-07 44.887499999999996p -2.9477760000000003e-07 44.899999999999999p -2.6657189999999999e-07 44.912500000000001p -2.38077e-07 44.925000000000004p -2.0933030000000001e-07 44.9375p -1.8036950000000001e-07 44.949999999999996p -1.5123229999999999e-07 44.962499999999999p -1.2195689999999999e-07 44.975000000000001p -9.2581380000000002e-08 44.987500000000004p -6.3143929999999997e-08 45p -3.36828e-08
+ 45.012499999999996p -4.2362129999999999e-09 45.024999999999999p 2.51577e-08 45.037500000000001p 5.4460920000000001e-08 45.050000000000004p 8.3635579999999994e-08 45.0625p 1.126441e-07 45.074999999999996p 1.4144900000000001e-07 45.087499999999999p 1.700133e-07 45.100000000000001p 1.983003e-07 45.112500000000004p 2.2627360000000001e-07 45.125p 2.538975e-07 45.137500000000003p 2.811365e-07 45.149999999999999p 3.0795590000000002e-07 45.162499999999994p 3.343213e-07 45.175000000000004p 3.6019920000000002e-07 45.1875p 3.8555670000000001e-07 45.200000000000003p 4.1036160000000001e-07 45.212499999999999p 4.345823e-07 45.224999999999994p 4.5818819999999998e-07
+ 45.237500000000004p 4.8114950000000003e-07 45.25p 5.0343719999999997e-07 45.262500000000003p 5.2502329999999998e-07 45.274999999999999p 5.4588059999999997e-07 45.287499999999994p 5.6598309999999996e-07 45.300000000000004p 5.8530569999999996e-07 45.3125p 6.038243e-07 45.325000000000003p 6.2151600000000002e-07 45.337499999999999p 6.3835889999999999e-07 45.349999999999994p 6.5433229999999999e-07 45.362500000000004p 6.6941670000000002e-07 45.375p 6.8359379999999996e-07 45.387500000000003p 6.9684640000000001e-07 45.399999999999999p 7.0915859999999998e-07 45.412499999999994p 7.205159e-07 45.425000000000004p 7.3090489999999995e-07 45.4375p 7.4031360000000003e-07 45.450000000000003p 7.4873129999999996e-07
+ 45.462499999999999p 7.5614850000000002e-07 45.475000000000001p 7.6255719999999997e-07 45.487499999999997p 7.6795069999999999e-07 45.5p 7.7232359999999995e-07 45.512500000000003p 7.7567209999999995e-07 45.524999999999999p 7.7799339999999999e-07 45.537500000000001p 7.7928629999999996e-07 45.549999999999997p 7.7955100000000004e-07 45.5625p 7.7878890000000003e-07 45.575000000000003p 7.7700300000000001e-07 45.587499999999999p 7.7419749999999997e-07 45.600000000000001p 7.7037790000000005e-07 45.612499999999997p 7.6555109999999999e-07 45.625p 7.5972560000000001e-07 45.637500000000003p 7.5291069999999998e-07 45.649999999999999p 7.4511759999999997e-07 45.662500000000001p 7.3635820000000005e-07 45.674999999999997p 7.266461e-07
+ 45.6875p 7.1599610000000005e-07 45.700000000000003p 7.0442400000000001e-07 45.712499999999999p 6.9194700000000002e-07 45.725000000000001p 6.7858339999999998e-07 45.737499999999997p 6.6435269999999999e-07 45.75p 6.4927559999999998e-07 45.762500000000003p 6.3337379999999998e-07 45.774999999999999p 6.1666990000000004e-07 45.787500000000001p 5.9918780000000002e-07 45.799999999999997p 5.8095240000000005e-07 45.8125p 5.6198939999999996e-07 45.825000000000003p 5.4232529999999996e-07 45.837499999999999p 5.2198800000000003e-07 45.850000000000001p 5.0100560000000004e-07 45.862499999999997p 4.7940750000000001e-07 45.875p 4.572236e-07 45.887500000000003p 4.3448460000000002e-07 45.899999999999999p 4.1122190000000001e-07
+ 45.912500000000001p 3.8746740000000001e-07 45.924999999999997p 3.6325379999999999e-07 45.9375p 3.3861430000000002e-07 45.950000000000003p 3.1358230000000001e-07 45.962499999999999p 2.881919e-07 45.975000000000001p 2.6247770000000003e-07 45.987499999999997p 2.364744e-07 46p 2.102171e-07 46.012500000000003p 1.8374119999999999e-07 46.024999999999999p 1.5708219999999999e-07 46.037500000000001p 1.302759e-07 46.049999999999997p 1.03358e-07 46.0625p 7.6364459999999996e-08 46.075000000000003p 4.9331119999999999e-08 46.087499999999999p 2.229381e-08 46.100000000000001p -4.7117339999999999e-09 46.112499999999997p -3.1649899999999997e-08 46.125p -5.8485289999999997e-08
+ 46.137500000000003p -8.5182730000000002e-08 46.149999999999999p -1.117073e-07 46.162500000000001p -1.3802450000000001e-07 46.174999999999997p -1.6410010000000001e-07 46.1875p -1.899003e-07 46.200000000000003p -2.1539179999999999e-07 46.212499999999999p -2.4054180000000003e-07 46.225000000000001p -2.6531809999999999e-07 46.237499999999997p -2.8968900000000002e-07 46.25p -3.1362350000000002e-07 46.262499999999996p -3.3709120000000002e-07 46.275000000000006p -3.6006239999999998e-07 46.287500000000001p -3.8250829999999998e-07 46.299999999999997p -4.0440069999999999e-07 46.3125p -4.257122e-07 46.324999999999996p -4.4641650000000001e-07 46.337500000000006p -4.664879e-07 46.350000000000001p -4.8590180000000005e-07
+ 46.362499999999997p -5.0463439999999996e-07 46.375p -5.2266289999999998e-07 46.387499999999996p -5.3996550000000002e-07 46.400000000000006p -5.5652159999999999e-07 46.412500000000001p -5.7231130000000002e-07 46.424999999999997p -5.8731599999999999e-07 46.4375p -6.0151820000000004e-07 46.449999999999996p -6.1490129999999998e-07 46.462500000000006p -6.2745000000000002e-07 46.475000000000001p -6.3914999999999995e-07 46.487499999999997p -6.4998839999999998e-07 46.5p -6.5995310000000005e-07 46.512499999999996p -6.6903350000000005e-07 46.525000000000006p -6.7721999999999997e-07 46.537500000000001p -6.8450410000000002e-07 46.549999999999997p -6.9087879999999999e-07 46.5625p -6.9633810000000004e-07 46.574999999999996p -7.0087709999999998e-07
+ 46.587499999999999p -7.0449230000000001e-07 46.600000000000001p -7.0718130000000001e-07 46.612500000000004p -7.0894300000000002e-07 46.625p -7.0977740000000004e-07 46.637499999999996p -7.0968580000000001e-07 46.649999999999999p -7.0867050000000002e-07 46.662500000000001p -7.067351e-07 46.675000000000004p -7.0388450000000005e-07 46.6875p -7.0012450000000002e-07 46.699999999999996p -6.9546229999999999e-07 46.712499999999999p -6.8990609999999995e-07 46.725000000000001p -6.8346530000000002e-07 46.737500000000004p -6.7615019999999996e-07 46.75p -6.6797260000000003e-07 46.762499999999996p -6.5894500000000003e-07 46.774999999999999p -6.4908110000000001e-07 46.787500000000001p -6.3839560000000003e-07 46.800000000000004p -6.2690439999999996e-07
+ 46.8125p -6.1462409999999998e-07 46.824999999999996p -6.0157240000000003e-07 46.837499999999999p -5.8776799999999997e-07 46.850000000000001p -5.7323049999999997e-07 46.862500000000004p -5.579803e-07 46.875p -5.4203879999999999e-07 46.887499999999996p -5.2542800000000001e-07 46.899999999999999p -5.0817110000000005e-07 46.912500000000001p -4.9029169999999995e-07 46.925000000000004p -4.7181430000000002e-07 46.9375p -4.5276409999999998e-07 46.949999999999996p -4.3316699999999998e-07 46.962499999999999p -4.130495e-07 46.975000000000001p -3.9243869999999998e-07 46.987500000000004p -3.7136239999999998e-07 47p -3.4984880000000001e-07 47.012500000000003p -3.2792669999999999e-07 47.024999999999999p -3.0562520000000002e-07
+ 47.037499999999994p -2.829741e-07 47.050000000000004p -2.600034e-07 47.0625p -2.3674340000000001e-07 47.075000000000003p -2.1322500000000001e-07 47.087499999999999p -1.89479e-07 47.099999999999994p -1.655368e-07 47.112500000000004p -1.4142969999999999e-07 47.125p -1.1718929999999999e-07 47.137500000000003p -9.284738e-08 47.149999999999999p -6.8435660000000002e-08 47.162499999999994p -4.3985969999999998e-08 47.175000000000004p -1.9530119999999999e-08 47.1875p 4.9001150000000003e-09 47.200000000000003p 2.9273059999999999e-08 47.212499999999999p 5.3557139999999999e-08 47.224999999999994p 7.7720969999999995e-08 47.237500000000004p 1.017333e-07 47.25p 1.255633e-07
+ 47.262500000000003p 1.4918029999999999e-07 47.274999999999999p 1.7255379999999999e-07 47.287499999999994p 1.9565389999999999e-07 47.300000000000004p 2.1845109999999999e-07 47.3125p 2.409161e-07 47.325000000000003p 2.630204e-07 47.337499999999999p 2.8473580000000001e-07 47.350000000000001p 3.0603460000000001e-07 47.362499999999997p 3.268898e-07 47.375p 3.4727509999999998e-07 47.387500000000003p 3.6716460000000002e-07 47.399999999999999p 3.8653330000000001e-07 47.412500000000001p 4.053569e-07 47.424999999999997p 4.2361169999999999e-07 47.4375p 4.4127500000000001e-07 47.450000000000003p 4.583246e-07 47.462499999999999p 4.7473950000000001e-07 47.475000000000001p 4.9049940000000005e-07
+ 47.487499999999997p 5.0558469999999995e-07 47.5p 5.19977e-07 47.512500000000003p 5.3365869999999997e-07 47.524999999999999p 5.4661329999999995e-07 47.537500000000001p 5.5882510000000005e-07 47.549999999999997p 5.7027939999999999e-07 47.5625p 5.8096279999999997e-07 47.575000000000003p 5.9086259999999999e-07 47.587499999999999p 5.9996730000000004e-07 47.600000000000001p 6.0826660000000003e-07 47.612499999999997p 6.1575100000000002e-07 47.625p 6.224123e-07 47.637500000000003p 6.2824330000000003e-07 47.649999999999999p 6.3323809999999996e-07 47.662500000000001p 6.3739169999999999e-07 47.674999999999997p 6.4070020000000005e-07 47.6875p 6.4316100000000002e-07 47.700000000000003p 6.4477270000000002e-07
+ 47.712499999999999p 6.4553469999999999e-07 47.725000000000001p 6.4544779999999996e-07 47.737499999999997p 6.4451389999999995e-07 47.75p 6.4273579999999996e-07 47.762500000000003p 6.401178e-07 47.774999999999999p 6.3666499999999996e-07 47.787500000000001p 6.3238370000000003e-07 47.799999999999997p 6.2728130000000005e-07 47.8125p 6.2136630000000004e-07 47.825000000000003p 6.146481e-07 47.837499999999999p 6.071376e-07 47.850000000000001p 5.9884610000000003e-07 47.862499999999997p 5.8978639999999995e-07 47.875p 5.7997220000000001e-07 47.887500000000003p 5.6941799999999997e-07 47.899999999999999p 5.5813939999999999e-07 47.912500000000001p 5.4615300000000003e-07 47.924999999999997p 5.3347609999999997e-07
+ 47.9375p 5.2012719999999999e-07 47.950000000000003p 5.0612520000000005e-07 47.962499999999999p 4.9149030000000005e-07 47.975000000000001p 4.762432e-07 47.987499999999997p 4.6040550000000001e-07 48p 4.4399949999999999e-07 48.012500000000003p 4.2704819999999998e-07 48.024999999999999p 4.0957529999999999e-07 48.037500000000001p 3.9160500000000002e-07 48.049999999999997p 3.7316240000000001e-07 48.0625p 3.542728e-07 48.075000000000003p 3.3496249999999999e-07 48.087499999999999p 3.1525779999999999e-07 48.100000000000001p 2.951857e-07 48.112499999999997p 2.7477369999999999e-07 48.125p 2.5404950000000001e-07 48.137499999999996p 2.3304130000000001e-07 48.150000000000006p 2.1177760000000001e-07
+ 48.162500000000001p 1.902869e-07 48.174999999999997p 1.6859829999999999e-07 48.1875p 1.4674079999999999e-07 48.199999999999996p 1.2474369999999999e-07 48.212500000000006p 1.0263649999999999e-07 48.225000000000001p 8.0448379999999996e-08 48.237499999999997p 5.8208949999999999e-08 48.25p 3.5947620000000003e-08 48.262499999999996p 1.3693779999999999e-08 48.275000000000006p -8.5232780000000006e-09 48.287500000000001p -3.0674400000000002e-08 48.299999999999997p -5.2730580000000003e-08 48.3125p -7.4663060000000004e-08 48.324999999999996p -9.6443290000000005e-08 48.337500000000006p -1.1804299999999999e-07 48.350000000000001p -1.3943430000000001e-07 48.362499999999997p -1.6058970000000001e-07 48.375p -1.8148189999999999e-07
+ 48.387499999999996p -2.0208409999999999e-07 48.400000000000006p -2.2237020000000001e-07 48.412500000000001p -2.4231429999999998e-07 48.424999999999997p -2.6189109999999999e-07 48.4375p -2.8107600000000002e-07 48.449999999999996p -2.998449e-07 48.462499999999999p -3.1817419999999999e-07 48.475000000000001p -3.360411e-07 48.487500000000004p -3.5342349999999999e-07 48.5p -3.7029979999999999e-07 48.512499999999996p -3.8664939999999998e-07 48.524999999999999p -4.0245229999999999e-07 48.537500000000001p -4.1768929999999998e-07 48.550000000000004p -4.3234189999999998e-07 48.5625p -4.4639249999999998e-07 48.574999999999996p -4.5982450000000002e-07 48.587499999999999p -4.7262200000000001e-07 48.600000000000001p -4.8476980000000003e-07
+ 48.612500000000004p -4.9625400000000002e-07 48.625p -5.0706119999999995e-07 48.637499999999996p -5.1717920000000004e-07 48.649999999999999p -5.2659660000000002e-07 48.662500000000001p -5.3530299999999996e-07 48.675000000000004p -5.4328890000000002e-07 48.6875p -5.5054590000000002e-07 48.699999999999996p -5.5706629999999997e-07 48.712499999999999p -5.6284360000000001e-07 48.725000000000001p -5.6787229999999999e-07 48.737500000000004p -5.7214770000000002e-07 48.75p -5.7566629999999999e-07 48.762499999999996p -5.7842530000000002e-07 48.774999999999999p -5.8042319999999997e-07 48.787500000000001p -5.8165930000000004e-07 48.800000000000004p -5.8213399999999999e-07 48.8125p -5.8184850000000005e-07 48.824999999999996p -5.8080509999999998e-07
+ 48.837499999999999p -5.7900710000000001e-07 48.850000000000001p -5.7645879999999995e-07 48.862500000000004p -5.7316520000000005e-07 48.875p -5.6913259999999997e-07 48.887500000000003p -5.6436780000000003e-07 48.899999999999999p -5.5887900000000001e-07 48.912499999999994p -5.5267490000000003e-07 48.925000000000004p -5.4576539999999999e-07 48.9375p -5.3816110000000002e-07 48.950000000000003p -5.2987350000000001e-07 48.962499999999999p -5.2091499999999995e-07 48.974999999999994p -5.1129870000000003e-07 48.987500000000004p -5.0103879999999998e-07 49p -4.9014979999999999e-07 49.012500000000003p -4.786475e-07 49.024999999999999p -4.6654819999999999e-07 49.037499999999994p -4.5386880000000001e-07 49.050000000000004p -4.406272e-07
+ 49.0625p -4.268417e-07 49.075000000000003p -4.1253149999999999e-07 49.087499999999999p -3.9771620000000002e-07 49.099999999999994p -3.8241619999999999e-07 49.112500000000004p -3.6665239999999999e-07 49.125p -3.504462e-07 49.137500000000003p -3.3381969999999998e-07 49.149999999999999p -3.1679519999999998e-07 49.162499999999994p -2.9939570000000001e-07 49.175000000000004p -2.8164459999999998e-07 49.1875p -2.6356569999999999e-07 49.200000000000003p -2.4518319999999999e-07 49.212499999999999p -2.2652139999999999e-07 49.225000000000001p -2.0760529999999999e-07 49.237499999999997p -1.8845989999999999e-07 49.25p -1.6911059999999999e-07 49.262500000000003p -1.49583e-07 49.274999999999999p -1.2990280000000001e-07
+ 49.287500000000001p -1.100958e-07 49.299999999999997p -9.0188190000000001e-08 49.3125p -7.0205990000000004e-08 49.325000000000003p -5.017538e-08 49.337499999999999p -3.0122539999999997e-08 49.350000000000001p -1.0073619999999999e-08 49.362499999999997p 9.9452540000000006e-09 49.375p 2.9908050000000002e-08 49.387500000000003p 4.9788839999999999e-08 49.399999999999999p 6.9561849999999996e-08 49.412500000000001p 8.9201489999999997e-08 49.424999999999997p 1.086824e-07 49.4375p 1.2797940000000001e-07 49.450000000000003p 1.470677e-07 49.462499999999999p 1.659226e-07 49.475000000000001p 1.8452010000000001e-07 49.487499999999997p 2.0283630000000001e-07 49.5p 2.208476e-07
+ 49.512500000000003p 2.3853130000000001e-07 49.524999999999999p 2.5586459999999997e-07 49.537500000000001p 2.7282560000000002e-07 49.549999999999997p 2.8939280000000002e-07 49.5625p 3.0554519999999999e-07 49.575000000000003p 3.2126229999999998e-07 49.587499999999999p 3.3652440000000002e-07 49.600000000000001p 3.5131240000000001e-07 49.612499999999997p 3.6560770000000002e-07 49.625p 3.7939239999999998e-07 49.637500000000003p 3.926495e-07 49.649999999999999p 4.053624e-07 49.662500000000001p 4.1751570000000001e-07 49.674999999999997p 4.2909419999999998e-07 49.6875p 4.4008400000000001e-07 49.700000000000003p 4.5047160000000002e-07 49.712499999999999p 4.6024460000000001e-07 49.725000000000001p 4.693913e-07
+ 49.737499999999997p 4.7790079999999995e-07 49.75p 4.8576319999999999e-07 49.762500000000003p 4.929693e-07 49.774999999999999p 4.9951100000000003e-07 49.787500000000001p 5.0538099999999996e-07 49.799999999999997p 5.1057280000000004e-07 49.8125p 5.1508090000000001e-07 49.825000000000003p 5.1890079999999996e-07 49.837499999999999p 5.2202880000000001e-07 49.850000000000001p 5.2446209999999997e-07 49.862499999999997p 5.2619900000000001e-07 49.875p 5.2723850000000001e-07 49.887500000000003p 5.2758079999999995e-07 49.899999999999999p 5.2722669999999998e-07 49.912500000000001p 5.2617829999999999e-07 49.924999999999997p 5.2443839999999997e-07 49.9375p 5.220107e-07 49.950000000000003p 5.1889980000000004e-07
+ 49.962499999999999p 5.1511140000000001e-07 49.975000000000001p 5.1065190000000005e-07 49.987499999999997p 5.055287e-07 50p 4.9974979999999997e-07 50.012499999999996p 4.9332459999999998e-07 50.025000000000006p 4.8626279999999995e-07 50.037500000000001p 4.7857509999999995e-07 50.049999999999997p 4.7027329999999999e-07 50.0625p 4.6136959999999999e-07 50.074999999999996p 4.518772e-07 50.087500000000006p 4.4180990000000002e-07 50.100000000000001p 4.3118249999999999e-07 50.112499999999997p 4.2001029999999999e-07 50.125p 4.0830929999999998e-07 50.137499999999996p 3.9609619999999999e-07 50.150000000000006p 3.8338850000000001e-07 50.162500000000001p 3.7020420000000001e-07 50.174999999999997p 3.5656169999999998e-07
+ 50.1875p 3.424804e-07 50.199999999999996p 3.2797980000000002e-07 50.212500000000006p 3.1308019999999998e-07 50.225000000000001p 2.978024e-07 50.237499999999997p 2.8216739999999998e-07 50.25p 2.6619690000000002e-07 50.262499999999996p 2.4991279999999999e-07 50.275000000000006p 2.3333750000000001e-07 50.287500000000001p 2.1649360000000001e-07 50.299999999999997p 1.9940419999999999e-07 50.3125p 1.820925e-07 50.324999999999996p 1.6458200000000001e-07 50.337499999999999p 1.468963e-07 50.350000000000001p 1.2905940000000001e-07 50.362500000000004p 1.110952e-07 50.375p 9.3027799999999993e-08 50.387499999999996p 7.4881449999999998e-08 50.399999999999999p 5.6680350000000001e-08
+ 50.412500000000001p 3.8448710000000003e-08 50.425000000000004p 2.0210750000000001e-08 50.4375p 1.990593e-09 50.449999999999996p -1.6187699999999999e-08 50.462499999999999p -3.4300189999999997e-08 50.475000000000001p -5.2323120000000003e-08 50.487500000000004p -7.0232890000000002e-08 50.5p -8.8006140000000006e-08 50.512499999999996p -1.056197e-07 50.524999999999999p -1.230508e-07 50.537500000000001p -1.4027689999999999e-07 50.550000000000004p -1.5727570000000001e-07 50.5625p -1.7402550000000001e-07 50.574999999999996p -1.9050480000000001e-07 50.587499999999999p -2.066925e-07 50.600000000000001p -2.225682e-07 50.612500000000004p -2.3811170000000001e-07 50.625p -2.5330329999999998e-07
+ 50.637499999999996p -2.6812409999999999e-07 50.649999999999999p -2.8255549999999999e-07 50.662500000000001p -2.965796e-07 50.675000000000004p -3.1017879999999998e-07 50.6875p -3.2333659999999998e-07 50.699999999999996p -3.3603680000000002e-07 50.712499999999999p -3.4826379999999999e-07 50.725000000000001p -3.6000300000000002e-07 50.737500000000004p -3.7123999999999998e-07 50.75p -3.8196159999999999e-07 50.762500000000003p -3.9215500000000001e-07 50.774999999999999p -4.018082e-07 50.787499999999994p -4.1091000000000002e-07 50.800000000000004p -4.1944990000000002e-07 50.8125p -4.2741819999999998e-07 50.825000000000003p -4.3480590000000002e-07 50.837499999999999p -4.4160490000000002e-07 50.849999999999994p -4.478078e-07
+ 50.862500000000004p -4.5340810000000002e-07 50.875p -4.5839989999999998e-07 50.887500000000003p -4.6277839999999999e-07 50.899999999999999p -4.665393e-07 50.912499999999994p -4.696794e-07 50.925000000000004p -4.7219609999999999e-07 50.9375p -4.740877e-07 50.950000000000003p -4.7535339999999998e-07 50.962499999999999p -4.7599309999999998e-07 50.974999999999994p -4.7600760000000001e-07 50.987500000000004p -4.7539830000000001e-07 51p -4.7416769999999999e-07 51.012500000000003p -4.7231880000000002e-07 51.024999999999999p -4.6985570000000002e-07 51.037499999999994p -4.6678310000000002e-07 51.050000000000004p -4.6310639999999999e-07 51.0625p -4.5883199999999999e-07 51.075000000000003p -4.5396680000000002e-07
+ 51.087499999999999p -4.485186e-07 51.100000000000001p -4.424959e-07 51.112499999999997p -4.3590799999999999e-07 51.125p -4.2876469999999999e-07 51.137500000000003p -4.2107660000000001e-07 51.149999999999999p -4.1285510000000002e-07 51.162500000000001p -4.0411209999999998e-07 51.174999999999997p -3.9486010000000002e-07 51.1875p -3.851125e-07 51.200000000000003p -3.7488290000000002e-07 51.212499999999999p -3.6418579999999999e-07 51.225000000000001p -3.5303609999999998e-07 51.237499999999997p -3.4144950000000002e-07 51.25p -3.2944189999999997e-07 51.262500000000003p -3.1702989999999998e-07 51.274999999999999p -3.0423049999999998e-07 51.287500000000001p -2.9106120000000003e-07 51.299999999999997p -2.7753999999999998e-07
+ 51.3125p -2.6368510000000001e-07 51.325000000000003p -2.4951540000000002e-07 51.337499999999999p -2.3504990000000001e-07 51.350000000000001p -2.203082e-07 51.362499999999997p -2.0530979999999999e-07 51.375p -1.9007500000000001e-07 51.387500000000003p -1.7462399999999999e-07 51.399999999999999p -1.5897730000000001e-07 51.412500000000001p -1.431558e-07 51.424999999999997p -1.271804e-07 51.4375p -1.110722e-07 51.450000000000003p -9.4852440000000003e-08 51.462499999999999p -7.8542479999999997e-08 51.475000000000001p -6.2163750000000006e-08 51.487499999999997p -4.5737719999999999e-08 51.5p -2.928589e-08 51.512500000000003p -1.2829769999999999e-08 51.524999999999999p 3.6091890000000001e-09
+ 51.537500000000001p 2.000958e-08 51.549999999999997p 3.635009e-08 51.5625p 5.2609499999999999e-08 51.575000000000003p 6.8766759999999999e-08 51.587499999999999p 8.480098e-08 51.600000000000001p 1.0069140000000001e-07 51.612499999999997p 1.164177e-07 51.625p 1.3195939999999999e-07 51.637500000000003p 1.472967e-07 51.649999999999999p 1.6241000000000001e-07 51.662500000000001p 1.7727970000000001e-07 51.674999999999997p 1.918871e-07 51.6875p 2.0621339999999999e-07 51.700000000000003p 2.2024039999999999e-07 51.712499999999999p 2.339503e-07 51.725000000000001p 2.4732579999999999e-07 51.737499999999997p 2.6034989999999998e-07 51.75p 2.7300630000000001e-07
+ 51.762500000000003p 2.852789e-07 51.774999999999999p 2.971525e-07 51.787500000000001p 3.086122e-07 51.799999999999997p 3.196437e-07 51.8125p 3.3023340000000001e-07 51.825000000000003p 3.4036810000000001e-07 51.837500000000006p 3.5003529999999997e-07 51.850000000000001p 3.5922330000000002e-07 51.862499999999997p 3.6792090000000001e-07 51.875p 3.7611749999999999e-07 51.887499999999996p 3.8380329999999999e-07 51.900000000000006p 3.9096909999999998e-07 51.912500000000001p 3.9760649999999998e-07 51.924999999999997p 4.0370769999999997e-07 51.9375p 4.0926559999999999e-07 51.949999999999996p 4.1427410000000001e-07 51.962500000000006p 4.1872739999999998e-07 51.975000000000001p 4.226208e-07
+ 51.987499999999997p 4.259503e-07 52p 4.287124e-07 52.012499999999996p 4.3090459999999998e-07 52.025000000000006p 4.3252509999999998e-07 52.037500000000001p 4.3357279999999998e-07 52.049999999999997p 4.3404749999999998e-07 52.0625p 4.3394970000000001e-07 52.074999999999996p 4.3328049999999999e-07 52.087500000000006p 4.3204190000000001e-07 52.100000000000001p 4.3023670000000001e-07 52.112499999999997p 4.278684e-07 52.125p 4.2494110000000001e-07 52.137499999999996p 4.2145990000000002e-07 52.150000000000006p 4.1743040000000002e-07 52.162500000000001p 4.1285910000000002e-07 52.174999999999997p 4.0775300000000001e-07 52.1875p 4.0211990000000001e-07 52.199999999999996p 3.9596839999999998e-07
+ 52.212499999999999p 3.8930760000000001e-07 52.225000000000001p 3.8214730000000002e-07 52.237500000000004p 3.7449810000000001e-07 52.25p 3.6637099999999999e-07 52.262499999999996p 3.5777769999999999e-07 52.274999999999999p 3.4873059999999998e-07 52.287500000000001p 3.3924249999999998e-07 52.300000000000004p 3.2932689999999998e-07 52.3125p 3.1899789999999999e-07 52.324999999999996p 3.082699e-07 52.337499999999999p 2.971579e-07 52.350000000000001p 2.8567739999999999e-07 52.362500000000004p 2.7384449999999999e-07 52.375p 2.6167549999999998e-07 52.387499999999996p 2.4918709999999999e-07 52.399999999999999p 2.3639669999999999e-07 52.412500000000001p 2.2332169999999999e-07 52.425000000000004p 2.0998e-07
+ 52.4375p 1.9638990000000001e-07 52.449999999999996p 1.8256990000000001e-07 52.462499999999999p 1.6853869999999999e-07 52.475000000000001p 1.5431529999999999e-07 52.487500000000004p 1.399189e-07 52.5p 1.2536910000000001e-07 52.512499999999996p 1.106852e-07 52.524999999999999p 9.5887019999999997e-08 52.537500000000001p 8.0994350000000003e-08 52.550000000000004p 6.6027049999999996e-08 52.5625p 5.1005059999999998e-08 52.574999999999996p 3.5948320000000001e-08 52.587499999999999p 2.0876780000000002e-08 52.600000000000001p 5.8103650000000001e-09 52.612500000000004p -9.2310630000000003e-09 52.625p -2.422772e-08 52.637500000000003p -3.9159940000000002e-08 52.649999999999999p -5.4008180000000001e-08
+ 52.662499999999994p -6.875306e-08 52.675000000000004p -8.3375390000000002e-08 52.6875p -9.7856190000000001e-08 52.700000000000003p -1.121767e-07 52.712499999999999p -1.2631849999999999e-07 52.724999999999994p -1.4026329999999999e-07 52.737500000000004p -1.5399320000000001e-07 52.75p -1.674907e-07 52.762500000000003p -1.8073859999999999e-07 52.774999999999999p -1.9372010000000001e-07 52.787499999999994p -2.064186e-07 52.800000000000004p -2.1881820000000001e-07 52.8125p -2.309032e-07 52.825000000000003p -2.4265859999999998e-07 52.837499999999999p -2.5406970000000002e-07 52.849999999999994p -2.6512240000000001e-07 52.862500000000004p -2.7580280000000001e-07 52.875p -2.8609809999999999e-07
+ 52.887500000000003p -2.9599539999999999e-07 52.899999999999999p -3.0548289999999999e-07 52.912499999999994p -3.1454899999999999e-07 52.925000000000004p -3.231829e-07 52.9375p -3.3137420000000002e-07 52.950000000000003p -3.3911329999999998e-07 52.962499999999999p -3.4639119999999998e-07 52.975000000000001p -3.5319940000000001e-07 52.987499999999997p -3.5953009999999998e-07 53p -3.6537609999999999e-07 53.012500000000003p -3.7073100000000001e-07 53.024999999999999p -3.7558890000000002e-07 53.037500000000001p -3.799447e-07 53.049999999999997p -3.8379379999999999e-07 53.0625p -3.8713240000000002e-07 53.075000000000003p -3.8995729999999998e-07 53.087499999999999p -3.9226609999999999e-07 53.100000000000001p -3.9405699999999999e-07
+ 53.112499999999997p -3.9532890000000001e-07 53.125p -3.960812e-07 53.137500000000003p -3.9631430000000001e-07 53.149999999999999p -3.9602900000000001e-07 53.162500000000001p -3.95227e-07 53.174999999999997p -3.9391039999999998e-07 53.1875p -3.9208219999999999e-07 53.200000000000003p -3.89746e-07 53.212499999999999p -3.8690590000000002e-07 53.225000000000001p -3.8356680000000003e-07 53.237499999999997p -3.7973430000000001e-07 53.25p -3.7541440000000002e-07 53.262500000000003p -3.7061390000000002e-07 53.274999999999999p -3.6534010000000001e-07 53.287500000000001p -3.5960099999999999e-07 53.299999999999997p -3.534051e-07 53.3125p -3.4676140000000001e-07 53.325000000000003p -3.3967970000000001e-07
+ 53.337499999999999p -3.3217019999999997e-07 53.350000000000001p -3.242434e-07 53.362499999999997p -3.1591080000000002e-07 53.375p -3.0718399999999998e-07 53.387500000000003p -2.9807529999999998e-07 53.399999999999999p -2.8859740000000002e-07 53.412500000000001p -2.787633e-07 53.424999999999997p -2.6858669999999999e-07 53.4375p -2.5808149999999998e-07 53.450000000000003p -2.4726219999999999e-07 53.462499999999999p -2.3614339999999999e-07 53.475000000000001p -2.2474029999999999e-07 53.487499999999997p -2.1306840000000001e-07 53.5p -2.0114329999999999e-07 53.512500000000003p -1.8898110000000001e-07 53.524999999999999p -1.7659819999999999e-07 53.537500000000001p -1.6401120000000001e-07 53.549999999999997p -1.5123680000000001e-07
+ 53.5625p -1.3829200000000001e-07 53.575000000000003p -1.2519409999999999e-07 53.587499999999999p -1.119604e-07 53.600000000000001p -9.86084e-08 53.612499999999997p -8.5155760000000001e-08 53.625p -7.1620180000000007e-08 53.637500000000003p -5.8019450000000003e-08 53.649999999999999p -4.4371409999999999e-08 53.662500000000001p -3.0693930000000001e-08 53.674999999999997p -1.700489e-08 53.6875p -3.3221219999999999e-09 53.700000000000003p 1.0336550000000001e-08 53.712500000000006p 2.3953380000000002e-08 53.725000000000001p 3.7510709999999998e-08 53.737499999999997p 5.0991000000000003e-08 53.75p 6.437683e-08 53.762499999999996p 7.7650940000000006e-08 53.775000000000006p 9.0796249999999995e-08
+ 53.787500000000001p 1.0379590000000001e-07 53.799999999999997p 1.166331e-07 53.8125p 1.292916e-07 53.824999999999996p 1.417552e-07 53.837500000000006p 1.5400789999999999e-07 53.850000000000001p 1.6603429999999999e-07 53.862499999999997p 1.7781900000000001e-07 53.875p 1.8934719999999999e-07 53.887499999999996p 2.0060429999999999e-07 53.900000000000006p 2.1157610000000001e-07 53.912500000000001p 2.222489e-07 53.924999999999997p 2.3260929999999999e-07 53.9375p 2.4264439999999998e-07 53.949999999999996p 2.5234180000000001e-07 53.962500000000006p 2.6168930000000001e-07 53.975000000000001p 2.7067550000000002e-07 53.987499999999997p 2.792894e-07 54p 2.8752039999999999e-07
+ 54.012499999999996p 2.9535849999999998e-07 54.025000000000006p 3.0279420000000002e-07 54.037500000000001p 3.0981860000000001e-07 54.049999999999997p 3.1642340000000002e-07 54.0625p 3.226006e-07 54.074999999999996p 3.2834310000000001e-07 54.087499999999999p 3.336443e-07 54.100000000000001p 3.3849800000000002e-07 54.112500000000004p 3.4289880000000002e-07 54.125p 3.4684190000000001e-07 54.137499999999996p 3.5032300000000001e-07 54.149999999999999p 3.5333839999999998e-07 54.162500000000001p 3.558852e-07 54.175000000000004p 3.5796099999999999e-07 54.1875p 3.5956399999999998e-07 54.199999999999996p 3.606931e-07 54.212499999999999p 3.6134770000000001e-07 54.225000000000001p 3.6152810000000003e-07
+ 54.237500000000004p 3.612349e-07 54.25p 3.6046939999999999e-07 54.262499999999996p 3.5923379999999999e-07 54.274999999999999p 3.5753050000000001e-07 54.287500000000001p 3.5536280000000002e-07 54.300000000000004p 3.5273460000000002e-07 54.3125p 3.496501e-07 54.324999999999996p 3.4611459999999998e-07 54.337499999999999p 3.4213340000000001e-07 54.350000000000001p 3.3771290000000001e-07 54.362500000000004p 3.328597e-07 54.375p 3.2758119999999998e-07 54.387499999999996p 3.2188509999999999e-07 54.399999999999999p 3.1577999999999999e-07 54.412500000000001p 3.0927470000000002e-07 54.425000000000004p 3.023785e-07 54.4375p 2.9510149999999998e-07 54.449999999999996p 2.87454e-07
+ 54.462499999999999p 2.7944690000000001e-07 54.475000000000001p 2.7109140000000002e-07 54.487500000000004p 2.6239940000000001e-07 54.5p 2.5338299999999999e-07 54.512500000000003p 2.4405470000000002e-07 54.524999999999999p 2.344275e-07 54.537499999999994p 2.2451480000000001e-07 54.550000000000004p 2.143302e-07 54.5625p 2.0388760000000001e-07 54.575000000000003p 1.932015e-07 54.587499999999999p 1.822863e-07 54.599999999999994p 1.7115690000000001e-07 54.612500000000004p 1.5982850000000001e-07 54.625p 1.4831640000000001e-07 54.637500000000003p 1.366361e-07 54.649999999999999p 1.2480330000000001e-07 54.662499999999994p 1.128339e-07 54.675000000000004p 1.0074400000000001e-07
+ 54.6875p 8.8549719999999999e-08 54.700000000000003p 7.6267270000000004e-08 54.712499999999999p 6.3913009999999995e-08 54.724999999999994p 5.1503310000000001e-08 54.737500000000004p 3.905458e-08 54.75p 2.6583240000000001e-08 54.762500000000003p 1.4105709999999999e-08 54.774999999999999p 1.6383580000000001e-09 54.787499999999994p -1.0802480000000001e-08 54.800000000000004p -2.3200559999999999e-08 54.8125p -3.5539740000000002e-08 54.825000000000003p -4.7803969999999999e-08 54.837499999999999p -5.9977379999999997e-08 54.850000000000001p -7.2044219999999997e-08 54.862499999999997p -8.3988950000000002e-08 54.875p -9.5796200000000004e-08 54.887500000000003p -1.074509e-07 54.899999999999999p -1.18938e-07
+ 54.912500000000001p -1.302431e-07 54.924999999999997p -1.4135160000000001e-07 54.9375p -1.522497e-07 54.950000000000003p -1.629234e-07 54.962499999999999p -1.7335940000000001e-07 54.975000000000001p -1.8354469999999999e-07 54.987499999999997p -1.9346650000000001e-07 55p -2.0311239999999999e-07 55.012500000000003p -2.124706e-07 55.024999999999999p -2.2152950000000001e-07 55.037500000000001p -2.3027799999999999e-07 55.049999999999997p -2.3870539999999999e-07 55.0625p -2.4680159999999999e-07 55.075000000000003p -2.5455660000000003e-07 55.087499999999999p -2.619613e-07 55.100000000000001p -2.6900689999999998e-07 55.112499999999997p -2.7568489999999998e-07 55.125p -2.8198770000000002e-07
+ 55.137500000000003p -2.879078e-07 55.149999999999999p -2.9343839999999998e-07 55.162500000000001p -2.985734e-07 55.174999999999997p -3.0330690000000001e-07 55.1875p -3.0763379999999998e-07 55.200000000000003p -3.1154949999999999e-07 55.212499999999999p -3.1504969999999998e-07 55.225000000000001p -3.1813089999999999e-07 55.237499999999997p -3.2079019999999999e-07 55.25p -3.2302500000000002e-07 55.262500000000003p -3.2483360000000001e-07 55.274999999999999p -3.2621450000000003e-07 55.287500000000001p -3.2716690000000002e-07 55.299999999999997p -3.2769069999999999e-07 55.3125p -3.2778619999999998e-07 55.325000000000003p -3.2745430000000002e-07 55.337499999999999p -3.266964e-07 55.350000000000001p -3.2551460000000002e-07
+ 55.362499999999997p -3.239113e-07 55.375p -3.2188960000000001e-07 55.387500000000003p -3.1945319999999998e-07 55.399999999999999p -3.1660620000000001e-07 55.412500000000001p -3.1335329999999999e-07 55.424999999999997p -3.0969960000000001e-07 55.4375p -3.0565079999999998e-07 55.450000000000003p -3.012131e-07 55.462499999999999p -2.9639329999999998e-07 55.475000000000001p -2.9119829999999999e-07 55.487499999999997p -2.8563590000000001e-07 55.5p -2.797142e-07 55.512500000000003p -2.7344149999999998e-07 55.524999999999999p -2.6682709999999998e-07 55.537500000000001p -2.5988010000000001e-07 55.549999999999997p -2.5261040000000001e-07 55.5625p -2.450282e-07 55.575000000000003p -2.3714409999999999e-07
+ 55.587500000000006p -2.289689e-07 55.600000000000001p -2.2051400000000001e-07 55.612499999999997p -2.1179110000000001e-07 55.625p -2.02812e-07 55.637499999999996p -1.93589e-07 55.650000000000006p -1.8413460000000001e-07 55.662500000000001p -1.7446180000000001e-07 55.674999999999997p -1.645835e-07 55.6875p -1.5451309999999999e-07 55.699999999999996p -1.4426409999999999e-07 55.712500000000006p -1.3385020000000001e-07 55.725000000000001p -1.232854e-07 55.737499999999997p -1.125838e-07 55.75p -1.017596e-07 55.762499999999996p -9.0827100000000002e-08 55.775000000000006p -7.9800889999999999e-08 55.787500000000001p -6.8695520000000001e-08 55.799999999999997p -5.752562e-08
+ 55.8125p -4.6305899999999999e-08 55.824999999999996p -3.5051099999999999e-08 55.837500000000006p -2.3775980000000001e-08 55.850000000000001p -1.249528e-08 55.862499999999997p -1.2237450000000001e-09 55.875p 1.002394e-08 55.887499999999996p 2.123315e-08 55.899999999999999p 3.2389329999999999e-08 55.912500000000001p 4.3478009999999997e-08 55.924999999999997p 5.4484869999999999e-08 55.9375p 6.5395699999999996e-08 55.949999999999996p 7.6196449999999994e-08 55.962499999999999p 8.6873220000000004e-08 55.975000000000001p 9.7412340000000002e-08 55.987500000000004p 1.078003e-07 56p 1.1802390000000001e-07 56.012499999999996p 1.2807000000000001e-07 56.024999999999999p 1.3792589999999999e-07
+ 56.037500000000001p 1.4757909999999999e-07 56.050000000000004p 1.570175e-07 56.0625p 1.66229e-07 56.074999999999996p 1.752021e-07 56.087499999999999p 1.8392560000000001e-07 56.100000000000001p 1.9238859999999999e-07 56.112500000000004p 2.0058059999999999e-07 56.125p 2.0849129999999999e-07 56.137499999999996p 2.16111e-07 56.149999999999999p 2.234304e-07 56.162500000000001p 2.3044040000000001e-07 56.175000000000004p 2.3713259999999999e-07 56.1875p 2.4349890000000001e-07 56.199999999999996p 2.4953149999999997e-07 56.212499999999999p 2.5522339999999998e-07 56.225000000000001p 2.6056780000000002e-07 56.237500000000004p 2.6555829999999998e-07 56.25p 2.7018920000000002e-07
+ 56.262499999999996p 2.7445529999999998e-07 56.274999999999999p 2.7835159999999998e-07 56.287500000000001p 2.8187399999999997e-07 56.300000000000004p 2.8501850000000001e-07 56.3125p 2.8778180000000002e-07 56.324999999999996p 2.901613e-07 56.337499999999999p 2.921545e-07 56.350000000000001p 2.9375969999999998e-07 56.362500000000004p 2.9497569999999998e-07 56.375p 2.9580170000000001e-07 56.387500000000003p 2.9623749999999999e-07 56.399999999999999p 2.962834e-07 56.412499999999994p 2.9594030000000002e-07 56.425000000000004p 2.9520930000000001e-07 56.4375p 2.9409250000000002e-07 56.450000000000003p 2.92592e-07 56.462499999999999p 2.9071079999999998e-07 56.474999999999994p 2.8845220000000001e-07
+ 56.487500000000004p 2.8582009999999999e-07 56.5p 2.8281869999999998e-07 56.512500000000003p 2.7945280000000002e-07 56.524999999999999p 2.7572780000000001e-07 56.537499999999994p 2.7164940000000002e-07 56.550000000000004p 2.6722370000000001e-07 56.5625p 2.6245739999999997e-07 56.575000000000003p 2.5735750000000001e-07 56.587499999999999p 2.5193159999999999e-07 56.599999999999994p 2.4618759999999999e-07 56.612500000000004p 2.4013379999999999e-07 56.625p 2.337789e-07 56.637500000000003p 2.27132e-07 56.649999999999999p 2.2020249999999999e-07 56.662499999999994p 2.1300029999999999e-07 56.675000000000004p 2.0553550000000001e-07 56.6875p 1.9781860000000001e-07 56.700000000000003p 1.8986030000000001e-07
+ 56.712499999999999p 1.8167170000000001e-07 56.725000000000001p 1.732641e-07 56.737499999999997p 1.6464930000000001e-07 56.75p 1.558389e-07 56.762500000000003p 1.468452e-07 56.774999999999999p 1.3768039999999999e-07 56.787500000000001p 1.2835699999999999e-07 56.799999999999997p 1.188877e-07 56.8125p 1.0928530000000001e-07 56.825000000000003p 9.9562789999999995e-08 56.837499999999999p 8.973331e-08 56.850000000000001p 7.9810039999999998e-08 56.862499999999997p 6.98063e-08 56.875p 5.973546e-08 56.887500000000003p 4.9610949999999997e-08 56.899999999999999p 3.9446230000000002e-08 56.912500000000001p 2.9254799999999999e-08 56.924999999999997p 1.905014e-08
+ 56.9375p 8.8457079999999998e-09 56.950000000000003p -1.345059e-09 56.962499999999999p -1.150878e-08 56.975000000000001p -2.1632159999999999e-08 56.987499999999997p -3.1701969999999999e-08 57p -4.1705100000000001e-08 57.012500000000003p -5.1628570000000001e-08 57.024999999999999p -6.1459510000000005e-08 57.037500000000001p -7.1185250000000005e-08 57.049999999999997p -8.0793260000000004e-08 57.0625p -9.0271209999999996e-08 57.075000000000003p -9.9606979999999993e-08 57.087499999999999p -1.087886e-07 57.100000000000001p -1.1780460000000001e-07 57.112499999999997p -1.2664330000000001e-07 57.125p -1.352936e-07 57.137500000000003p -1.4374480000000001e-07 57.149999999999999p -1.5198609999999999e-07
+ 57.162500000000001p -1.6000740000000001e-07 57.174999999999997p -1.6779849999999999e-07 57.1875p -1.7534999999999999e-07 57.200000000000003p -1.8265240000000001e-07 57.212499999999999p -1.8969689999999999e-07 57.225000000000001p -1.964749e-07 57.237499999999997p -2.029781e-07 57.25p -2.0919880000000001e-07 57.262500000000003p -2.1512939999999999e-07 57.274999999999999p -2.20763e-07 57.287500000000001p -2.2609289999999999e-07 57.299999999999997p -2.3111289999999999e-07 57.3125p -2.3581720000000001e-07 57.325000000000003p -2.4020040000000002e-07 57.337499999999999p -2.4425770000000001e-07 57.350000000000001p -2.4798449999999999e-07 57.362499999999997p -2.5137670000000001e-07 57.375p -2.5443080000000003e-07
+ 57.387500000000003p -2.5714360000000002e-07 57.399999999999999p -2.595124e-07 57.412500000000001p -2.6153489999999997e-07 57.424999999999997p -2.6320950000000003e-07 57.4375p -2.645347e-07 57.450000000000003p -2.6550959999999998e-07 57.462500000000006p -2.6613400000000002e-07 57.475000000000001p -2.6640769999999998e-07 57.487499999999997p -2.6633140000000003e-07 57.5p -2.6590589999999998e-07 57.512499999999996p -2.6513269999999999e-07 57.525000000000006p -2.6401359999999998e-07 57.537500000000001p -2.6255100000000001e-07 57.549999999999997p -2.6074749999999999e-07 57.5625p -2.5860639999999998e-07 57.574999999999996p -2.5613120000000002e-07 57.587500000000006p -2.53326e-07 57.600000000000001p -2.5019520000000001e-07
+ 57.612499999999997p -2.4674370000000003e-07 57.625p -2.4297680000000001e-07 57.637499999999996p -2.3890009999999999e-07 57.650000000000006p -2.3451970000000001e-07 57.662500000000001p -2.29842e-07 57.674999999999997p -2.2487379999999999e-07 57.6875p -2.1962230000000001e-07 57.699999999999996p -2.1409489999999999e-07 57.712500000000006p -2.082997e-07 57.725000000000001p -2.022446e-07 57.737499999999997p -1.9593829999999999e-07 57.75p -1.8938949999999999e-07 57.762499999999996p -1.8260729999999999e-07 57.774999999999999p -1.756012e-07 57.787500000000001p -1.6838079999999999e-07 57.799999999999997p -1.60956e-07 57.8125p -1.533369e-07 57.824999999999996p -1.4553400000000001e-07
+ 57.837499999999999p -1.375579e-07 57.850000000000001p -1.2941930000000001e-07 57.862500000000004p -1.2112920000000001e-07 57.875p -1.126989e-07 57.887499999999996p -1.041396e-07 57.899999999999999p -9.5462779999999995e-08 57.912500000000001p -8.6680109999999995e-08 57.925000000000004p -7.7803260000000002e-08 57.9375p -6.884405e-08 57.949999999999996p -5.9814379999999998e-08 57.962499999999999p -5.0726199999999998e-08 57.975000000000001p -4.1591530000000002e-08 57.987500000000004p -3.2422419999999999e-08 58p -2.3230949999999999e-08 58.012499999999996p -1.402919e-08 58.024999999999999p -4.8292070000000004e-09 58.037500000000001p 4.3569500000000003e-09 58.050000000000004p 1.3517289999999999e-08
+ 58.0625p 2.2639850000000001e-08 58.074999999999996p 3.1712779999999997e-08 58.087499999999999p 4.0724279999999998e-08 58.100000000000001p 4.9662680000000003e-08 58.112500000000004p 5.8516409999999998e-08 58.125p 6.727403e-08 58.137499999999996p 7.5924269999999999e-08 58.149999999999999p 8.4455990000000002e-08 58.162500000000001p 9.285826e-08 58.175000000000004p 1.011203e-07 58.1875p 1.092316e-07 58.199999999999996p 1.1718169999999999e-07 58.212499999999991p 1.249607e-07 58.225000000000001p 1.325585e-07 58.237500000000004p 1.3996569999999999e-07 58.250000000000007p 1.4717280000000001e-07 58.262499999999996p 1.5417089999999999e-07 58.274999999999999p 1.60951e-07
+ 58.287500000000001p 1.6750480000000001e-07 58.299999999999997p 1.7382419999999999e-07 58.3125p 1.799012e-07 58.325000000000003p 1.8572830000000001e-07 58.337499999999991p 1.9129850000000001e-07 58.349999999999994p 1.9660489999999999e-07 58.362500000000004p 2.01641e-07 58.375000000000007p 2.0640080000000001e-07 58.387499999999996p 2.108786e-07 58.399999999999999p 2.15069e-07 58.412500000000001p 2.1896719999999999e-07 58.424999999999997p 2.225685e-07 58.4375p 2.2586880000000001e-07 58.450000000000003p 2.2886449999999999e-07 58.462500000000006p 2.315521e-07 58.474999999999994p 2.3392879999999999e-07 58.487500000000004p 2.3599200000000001e-07 58.500000000000007p 2.3773970000000001e-07
+ 58.512499999999996p 2.3917019999999997e-07 58.524999999999999p 2.4028230000000001e-07 58.537500000000001p 2.410751e-07 58.549999999999997p 2.4154840000000001e-07 58.5625p 2.41702e-07 58.575000000000003p 2.4153659999999998e-07 58.587500000000006p 2.410528e-07 58.599999999999994p 2.4025209999999999e-07 58.612499999999997p 2.3913619999999999e-07 58.625000000000007p 2.3770720000000001e-07 58.637499999999996p 2.359675e-07 58.649999999999999p 2.339203e-07 58.662500000000001p 2.315687e-07 58.674999999999997p 2.2891670000000001e-07 58.6875p 2.2596820000000001e-07 58.700000000000003p 2.227278e-07 58.712500000000006p 2.192004e-07 58.724999999999994p 2.153913e-07
+ 58.737499999999997p 2.1130609999999999e-07 58.750000000000007p 2.069508e-07 58.762499999999996p 2.0233170000000001e-07 58.774999999999999p 1.974555e-07 58.787500000000001p 1.9232920000000001e-07 58.800000000000004p 1.8696e-07 58.8125p 1.813557e-07 58.825000000000003p 1.75524e-07 58.837500000000006p 1.694733e-07 58.849999999999994p 1.632119e-07 58.862499999999997p 1.5674869999999999e-07 58.875p 1.5009250000000001e-07 58.887499999999996p 1.4325269999999999e-07 58.899999999999999p 1.3623860000000001e-07 58.912500000000001p 1.290599e-07 58.925000000000004p 1.2172640000000001e-07 58.9375p 1.142482e-07 58.950000000000003p 1.066355e-07
+ 58.962500000000006p 9.8898580000000003e-08 58.974999999999994p 9.1047989999999999e-08 58.987499999999997p 8.3094350000000002e-08 59p 7.504838e-08 59.012499999999996p 6.6920930000000005e-08 59.024999999999999p 5.872289e-08 59.037500000000001p 5.0465259999999999e-08 59.050000000000004p 4.215908e-08 59.062499999999993p 3.3815419999999997e-08 59.075000000000003p 2.5445369999999999e-08 59.087500000000006p 1.7060060000000001e-08 59.099999999999994p 8.6705669999999996e-09 59.112499999999997p 2.8798630000000001e-10 59.125p -8.0766399999999995e-09 59.13750000000001p -1.6412320000000001e-08 59.149999999999999p -2.470812e-08 59.162500000000001p -3.2953180000000002e-08 59.175000000000004p -4.1136760000000003e-08
+ 59.187499999999993p -4.9248200000000003e-08 59.200000000000003p -5.7276970000000001e-08 59.212500000000006p -6.5212679999999994e-08 59.224999999999994p -7.3045070000000006e-08 59.237499999999997p -8.0764069999999997e-08 59.25p -8.8359770000000005e-08 59.262500000000003p -9.5822440000000004e-08 59.274999999999999p -1.031426e-07 59.287500000000001p -1.103108e-07 59.300000000000004p -1.173181e-07 59.312499999999993p -1.241556e-07 59.325000000000003p -1.3081469999999999e-07 59.337500000000006p -1.37287e-07 59.349999999999994p -1.4356449999999999e-07 59.362499999999997p -1.4963930000000001e-07 59.375p -1.555039e-07 59.387500000000003p -1.611511e-07 59.399999999999999p -1.665739e-07
+ 59.412500000000001p -1.7176590000000001e-07 59.425000000000004p -1.767205e-07 59.437499999999993p -1.8143200000000001e-07 59.449999999999996p -1.8589470000000001e-07 59.462500000000006p -1.901032e-07 59.474999999999994p -1.9405269999999999e-07 59.487499999999997p -1.9773850000000001e-07 59.5p -2.0115649999999999e-07 59.512500000000003p -2.043027e-07 59.524999999999999p -2.071736e-07 59.537500000000001p -2.0976609999999999e-07 59.550000000000004p -2.1207749999999999e-07 59.562499999999993p -2.141053e-07 59.574999999999996p -2.1584759999999999e-07 59.587500000000006p -2.1730269999999999e-07 59.600000000000009p -2.184693e-07 59.612499999999997p -2.1934670000000001e-07 59.625p -2.199342e-07
+ 59.637500000000003p -2.202318e-07 59.649999999999999p -2.2023980000000001e-07 59.662500000000001p -2.1995869999999999e-07 59.675000000000004p -2.193897e-07 59.687499999999993p -2.1853410000000001e-07 59.699999999999996p -2.173936e-07 59.712499999999999p -2.1597050000000001e-07 59.725000000000009p -2.1426720000000001e-07 59.737499999999997p -2.1228650000000001e-07 59.75p -2.1003170000000001e-07 59.762500000000003p -2.075064e-07 59.774999999999999p -2.0471440000000001e-07 59.787500000000001p -2.016599e-07 59.800000000000004p -1.983476e-07 59.812499999999993p -1.947824e-07 59.824999999999996p -1.9096950000000001e-07 59.837499999999999p -1.8691430000000001e-07 59.850000000000009p -1.826228e-07
+ 59.862499999999997p -1.7810110000000001e-07 59.875p -1.7335549999999999e-07 59.887500000000003p -1.683929e-07 59.899999999999991p -1.6322e-07 59.912500000000001p -1.578442e-07 59.925000000000004p -1.5227290000000001e-07 59.937500000000007p -1.465138e-07 59.949999999999996p -1.4057479999999999e-07 59.962499999999999p -1.344641e-07 59.975000000000001p -1.2819000000000001e-07 59.987499999999997p -1.2176120000000001e-07 60p -1.1518619999999999e-07 60.012500000000003p -1.08474e-07 60.024999999999991p -1.0163370000000001e-07 60.037500000000001p -9.4674409999999996e-08 60.050000000000004p -8.7605560000000002e-08 60.062500000000007p -8.0436580000000006e-08 60.074999999999996p -7.317706e-08
+ 60.087499999999999p -6.5836649999999997e-08 60.100000000000001p -5.8425120000000001e-08 60.112499999999997p -5.0952300000000002e-08 60.125p -4.3428080000000003e-08 60.137500000000003p -3.5862389999999999e-08 60.149999999999991p -2.8265209999999999e-08 60.162499999999994p -2.0646519999999999e-08 60.175000000000004p -1.301632e-08 60.187500000000007p -5.3846149999999996e-09 60.199999999999996p 2.2386289999999998e-09 60.212499999999999p 9.8434669999999992e-09 60.225000000000001p 1.742e-08 60.237499999999997p 2.495837e-08 60.25p 3.2448819999999997e-08 60.262500000000003p 3.988165e-08 60.275000000000006p 4.7247260000000003e-08 60.287499999999994p 5.4536159999999998e-08 60.300000000000004p 6.1738970000000005e-08
+ 60.312500000000007p 6.8846449999999998e-08 60.324999999999996p 7.5849499999999994e-08 60.337499999999999p 8.2739170000000005e-08 60.350000000000001p 8.9506670000000003e-08 60.362499999999997p 9.6143409999999994e-08 60.375p 1.02641e-07 60.387500000000003p 1.0899110000000001e-07 60.400000000000006p 1.151858e-07 60.412499999999994p 1.212173e-07 60.425000000000004p 1.2707809999999999e-07 60.437500000000007p 1.327607e-07 60.449999999999996p 1.3825810000000001e-07 60.462499999999999p 1.4356349999999999e-07 60.475000000000001p 1.4867039999999999e-07 60.487499999999997p 1.535723e-07 60.5p 1.5826339999999999e-07 60.512500000000003p 1.6273789999999999e-07 60.525000000000006p 1.6699040000000001e-07
+ 60.537499999999994p 1.710157e-07 60.549999999999997p 1.7480910000000001e-07 60.562500000000007p 1.7836590000000001e-07 60.574999999999996p 1.8168209999999999e-07 60.587499999999999p 1.847538e-07 60.600000000000001p 1.8757740000000001e-07 60.612499999999997p 1.9014969999999999e-07 60.625p 1.9246790000000001e-07 60.637500000000003p 1.945295e-07 60.650000000000006p 1.9633210000000001e-07 60.662499999999994p 1.9787410000000001e-07 60.674999999999997p 1.9915389999999999e-07 60.687500000000007p 2.001703e-07 60.699999999999996p 2.0092260000000001e-07 60.712499999999999p 2.0141020000000001e-07 60.725000000000001p 2.016332e-07 60.737500000000004p 2.0159169999999999e-07 60.75p 2.012863e-07
+ 60.762500000000003p 2.0071789999999999e-07 60.775000000000006p 1.998879e-07 60.787499999999994p 1.9879779999999999e-07 60.799999999999997p 1.9744959999999999e-07 60.8125p 1.958456e-07 60.824999999999996p 1.939884e-07 60.837499999999999p 1.91881e-07 60.850000000000001p 1.8952660000000001e-07 60.862500000000004p 1.869289e-07 60.875p 1.8409179999999999e-07 60.887500000000003p 1.8101940000000001e-07 60.900000000000006p 1.777163e-07 60.912499999999994p 1.7418720000000001e-07 60.924999999999997p 1.704374e-07 60.9375p 1.664721e-07 60.949999999999996p 1.6229699999999999e-07 60.962499999999999p 1.5791809999999999e-07 60.975000000000001p 1.5334139999999999e-07
+ 60.987500000000004p 1.4857340000000001e-07 60.999999999999993p 1.436208e-07 61.012500000000003p 1.3849050000000001e-07 61.025000000000006p 1.331895e-07 61.037499999999994p 1.2772510000000001e-07 61.049999999999997p 1.2210499999999999e-07 61.0625p 1.163366e-07 61.075000000000003p 1.1042809999999999e-07 61.087499999999999p 1.043873e-07 61.100000000000001p 9.8222559999999998e-08 61.112500000000004p 9.1942139999999995e-08 61.124999999999993p 8.5554549999999996e-08 61.137500000000003p 7.9068380000000006e-08 61.150000000000006p 7.2492370000000004e-08 61.162499999999994p 6.5835310000000006e-08 61.174999999999997p 5.9106119999999999e-08 61.1875p 5.2313759999999997e-08 61.200000000000003p 4.5467269999999999e-08
+ 61.212499999999999p 3.8575750000000001e-08 61.225000000000001p 3.1648320000000003e-08 61.237500000000004p 2.4694140000000001e-08 61.249999999999993p 1.772238e-08 61.262499999999996p 1.07422e-08 61.275000000000006p 3.7627770000000004e-09 61.287499999999994p -3.206758e-09 61.299999999999997p -1.0157299999999999e-08 61.3125p -1.7079780000000001e-08 61.325000000000003p -2.3965200000000001e-08 61.337499999999999p -3.0804629999999998e-08 61.350000000000001p -3.7589219999999997e-08 61.362500000000004p -4.4310200000000002e-08 61.374999999999993p -5.0958929999999997e-08 61.387499999999996p -5.7526850000000001e-08 61.400000000000006p -6.4005560000000003e-08 61.412500000000009p -7.0386780000000003e-08 61.424999999999997p -7.6662369999999994e-08
+ 61.4375p -8.2824359999999997e-08 61.450000000000003p -8.8864949999999999e-08 61.462499999999999p -9.4776509999999998e-08 61.475000000000001p -1.005516e-07 61.487500000000004p -1.0618300000000001e-07 61.499999999999993p -1.116636e-07 61.512499999999996p -1.1698660000000001e-07 61.524999999999999p -1.2214540000000001e-07 61.537500000000009p -1.271337e-07 61.549999999999997p -1.3194530000000001e-07 61.5625p -1.365742e-07 61.575000000000003p -1.41015e-07 61.587499999999999p -1.452622e-07 61.600000000000001p -1.4931060000000001e-07 61.612500000000004p -1.5315550000000001e-07 61.624999999999993p -1.567923e-07 61.637499999999996p -1.6021670000000001e-07 61.649999999999999p -1.6342469999999999e-07
+ 61.662500000000009p -1.664126e-07 61.674999999999997p -1.691771e-07 61.6875p -1.7171490000000001e-07 61.700000000000003p -1.7402339999999999e-07 61.712499999999991p -1.760999e-07 61.725000000000001p -1.7794239999999999e-07 61.737500000000004p -1.7954899999999999e-07 61.749999999999993p -1.8091800000000001e-07 61.762499999999996p -1.820482e-07 61.774999999999999p -1.8293880000000001e-07 61.787500000000009p -1.8358899999999999e-07 61.799999999999997p -1.8399860000000001e-07 61.8125p -1.8416759999999999e-07 61.825000000000003p -1.8409630000000001e-07 61.837499999999991p -1.837853e-07 61.850000000000001p -1.8323559999999999e-07 61.862500000000004p -1.8244839999999999e-07 61.875000000000007p -1.814253e-07
+ 61.887499999999996p -1.8016809999999999e-07 61.899999999999999p -1.786791e-07 61.912500000000001p -1.769606e-07 61.924999999999997p -1.750154e-07 61.9375p -1.7284659999999999e-07 61.950000000000003p -1.7045749999999999e-07 61.962499999999991p -1.6785170000000001e-07 61.975000000000001p -1.6503299999999999e-07 61.987500000000004p -1.620057e-07 62.000000000000007p -1.5877399999999999e-07 62.012499999999996p -1.5534280000000001e-07 62.024999999999999p -1.5171689999999999e-07 62.037500000000001p -1.4790139999999999e-07 62.049999999999997p -1.439018e-07 62.0625p -1.3972370000000001e-07 62.075000000000003p -1.3537279999999999e-07 62.087499999999991p -1.3085529999999999e-07 62.099999999999994p -1.2617749999999999e-07
+ 62.112500000000004p -1.213457e-07 62.125000000000007p -1.163665e-07 62.137499999999996p -1.112469e-07 62.149999999999999p -1.0599380000000001e-07 62.162500000000001p -1.006142e-07 62.174999999999997p -9.5115639999999994e-08 62.1875p -8.9505360000000002e-08 62.200000000000003p -8.3790969999999996e-08 62.212500000000006p -7.7980140000000006e-08 62.224999999999994p -7.2080660000000006e-08 62.237500000000004p -6.6100409999999995e-08 62.250000000000007p -6.0047360000000004e-08 62.262499999999996p -5.3929550000000003e-08 62.274999999999999p -4.7755099999999999e-08 62.287500000000001p -4.1532189999999999e-08 62.299999999999997p -3.5269040000000003e-08 62.3125p -2.897388e-08 62.325000000000003p -2.265501e-08
+ 62.337500000000006p -1.6320700000000001e-08 62.349999999999994p -9.9792649999999997e-09 62.362499999999997p -3.6389739999999999e-09 62.375000000000007p 2.6919029999999999e-09 62.387499999999996p 9.0051300000000003e-09 62.399999999999999p 1.5292509999999999e-08 62.412500000000001p 2.1545900000000001e-08 62.424999999999997p 2.7757219999999999e-08 62.4375p 3.3918449999999998e-08 62.450000000000003p 4.0021659999999997e-08 62.462500000000006p 4.6059020000000002e-08 62.474999999999994p 5.2022790000000001e-08 62.487499999999997p 5.790535e-08 62.500000000000007p 6.3699200000000004e-08 62.512499999999996p 6.9396970000000006e-08 62.524999999999999p 7.4991429999999998e-08 62.537500000000001p 8.0475499999999998e-08 62.550000000000004p 8.5842259999999999e-08
+ 62.5625p 9.1084959999999999e-08 62.575000000000003p 9.6197030000000001e-08 62.587500000000006p 1.0117210000000001e-07 62.599999999999994p 1.060039e-07 62.612499999999997p 1.106865e-07 62.625p 1.1521409999999999e-07 62.637499999999996p 1.1958110000000001e-07 62.649999999999999p 1.2378210000000001e-07 62.662500000000001p 1.278121e-07 62.675000000000004p 1.3166619999999999e-07 62.6875p 1.353396e-07 62.700000000000003p 1.38828e-07 62.712500000000006p 1.4212729999999999e-07 62.724999999999994p 1.452335e-07 62.737499999999997p 1.4814300000000001e-07 62.75p 1.5085249999999999e-07 62.762499999999996p 1.5335880000000001e-07 62.774999999999999p 1.556591e-07
+ 62.787500000000001p 1.5775099999999999e-07 62.800000000000004p 1.5963200000000001e-07 62.812499999999993p 1.6130020000000001e-07 62.825000000000003p 1.6275390000000001e-07 62.837500000000006p 1.6399179999999999e-07 62.849999999999994p 1.650126e-07 62.862499999999997p 1.6581549999999999e-07 62.875p 1.6639989999999999e-07 62.88750000000001p 1.667656e-07 62.899999999999999p 1.669127e-07 62.912500000000001p 1.6684130000000001e-07 62.925000000000004p 1.6655220000000001e-07 62.937499999999993p 1.660461e-07 62.950000000000003p 1.6532419999999999e-07 62.962500000000006p 1.64388e-07 62.974999999999994p 1.6323920000000001e-07 62.987499999999997p 1.6187980000000001e-07 63p 1.6031200000000001e-07
+ 63.012500000000003p 1.585385e-07 63.024999999999999p 1.565619e-07 63.037500000000001p 1.5438529999999999e-07 63.050000000000004p 1.5201209999999999e-07 63.062499999999993p 1.4944590000000001e-07 63.075000000000003p 1.4669039999999999e-07 63.087500000000006p 1.437497e-07 63.099999999999994p 1.406281e-07 63.112499999999997p 1.3733e-07 63.125p 1.338604e-07 63.137500000000003p 1.3022399999999999e-07 63.149999999999999p 1.26426e-07 63.162500000000001p 1.2247189999999999e-07 63.175000000000004p 1.183671e-07 63.187499999999993p 1.141175e-07 63.199999999999996p 1.0972880000000001e-07 63.212500000000006p 1.0520719999999999e-07 63.224999999999994p 1.0055899999999999e-07
+ 63.237499999999997p 9.5790509999999997e-08 63.25p 9.0908290000000002e-08 63.262500000000003p 8.591901e-08 63.274999999999999p 8.082947e-08 63.287500000000001p 7.5646580000000001e-08 63.300000000000004p 7.0377360000000004e-08 63.312499999999993p 6.5028930000000004e-08 63.324999999999996p 5.9608469999999998e-08 63.337500000000006p 5.4123279999999998e-08 63.350000000000009p 4.8580689999999997e-08 63.362499999999997p 4.2988110000000003e-08 63.375p 3.7352979999999997e-08 63.387500000000003p 3.1682800000000002e-08 63.399999999999999p 2.598508e-08 63.412500000000001p 2.0267350000000001e-08 63.425000000000004p 1.453715e-08 63.437499999999993p 8.8020170000000005e-09 63.449999999999996p 3.0694769999999999e-09
+ 63.462499999999999p -2.652968e-09 63.475000000000009p -8.357846e-09 63.487499999999997p -1.403773e-08 63.5p -1.9685240000000001e-08 63.512500000000003p -2.529306e-08 63.524999999999999p -3.0853949999999997e-08 63.537500000000001p -3.636074e-08 63.550000000000004p -4.180634e-08 63.562499999999993p -4.7183800000000003e-08 63.574999999999996p -5.2486220000000002e-08 63.587499999999999p -5.770685e-08 63.600000000000009p -6.283907e-08 63.612499999999997p -6.7876369999999997e-08 63.625p -7.2812399999999999e-08 63.637500000000003p -7.7640939999999994e-08 63.649999999999991p -8.2355939999999994e-08 63.662500000000001p -8.6951510000000006e-08 63.675000000000004p -9.1421929999999994e-08
+ 63.687500000000007p -9.5761670000000001e-08 63.699999999999996p -9.9965370000000001e-08 63.712499999999999p -1.040279e-07 63.725000000000001p -1.079442e-07 63.737499999999997p -1.117096e-07 63.75p -1.153195e-07 63.762500000000003p -1.187695e-07 63.774999999999991p -1.2205569999999999e-07 63.787500000000001p -1.2517400000000001e-07 63.800000000000004p -1.281208e-07 63.812500000000007p -1.3089260000000001e-07 63.824999999999996p -1.334864e-07 63.837499999999999p -1.3589910000000001e-07 63.850000000000001p -1.3812790000000001e-07 63.862499999999997p -1.401706e-07 63.875p -1.420247e-07 63.887500000000003p -1.436885e-07 63.899999999999991p -1.451601e-07
+ 63.912499999999994p -1.464381e-07 63.925000000000004p -1.4752129999999999e-07 63.937500000000007p -1.484088e-07 63.949999999999996p -1.4909990000000001e-07 63.962499999999999p -1.495941e-07 63.975000000000001p -1.498914e-07 63.987499999999997p -1.4999170000000001e-07 64p -1.4989549999999999e-07 64.012500000000003p -1.496033e-07 64.025000000000006p -1.491159e-07 64.037499999999994p -1.484346e-07 64.049999999999997p -1.475607e-07 64.0625p -1.464956e-07 64.075000000000003p -1.4524139999999999e-07 64.087500000000006p -1.4380019999999999e-07 64.100000000000009p -1.4217410000000001e-07 64.112499999999997p -1.4036579999999999e-07 64.125p -1.3837820000000001e-07
+ 64.137500000000003p -1.362141e-07 64.150000000000006p -1.33877e-07 64.162499999999994p -1.313702e-07 64.174999999999997p -1.286974e-07 64.1875p -1.2586250000000001e-07 64.199999999999989p -1.228695e-07 64.212500000000006p -1.197229e-07 64.225000000000009p -1.16427e-07 64.237499999999997p -1.129866e-07 64.25p -1.094064e-07 64.262500000000003p -1.056914e-07 64.275000000000006p -1.0184690000000001e-07 64.287499999999994p -9.7878170000000006e-08 64.299999999999997p -9.3790670000000003e-08 64.3125p -8.9590039999999996e-08 64.324999999999989p -8.5282029999999999e-08 64.337500000000006p -8.0872530000000001e-08 64.350000000000009p -7.6367549999999995e-08
+ 64.362499999999997p -7.1773209999999998e-08 64.375p -6.7095710000000001e-08 64.387500000000003p -6.2341369999999994e-08 64.400000000000006p -5.7516600000000003e-08 64.412499999999994p -5.2627869999999998e-08 64.424999999999997p -4.7681730000000003e-08 64.4375p -4.2684779999999997e-08 64.449999999999989p -3.76437e-08 64.462499999999991p -3.2565170000000002e-08 64.475000000000009p -2.7455939999999999e-08 64.487500000000011p -2.232278e-08 64.5p -1.7172450000000001e-08 64.512500000000003p -1.201176e-08 64.525000000000006p -6.847485e-09 64.537499999999994p -1.686405e-09 64.549999999999997p 3.4647209999999999e-09 64.5625p 8.5991599999999995e-09 64.574999999999989p 1.3710220000000001e-08
+ 64.587499999999991p 1.879124e-08 64.600000000000009p 2.383563e-08 64.612500000000011p 2.883686e-08 64.625p 3.3788459999999999e-08 64.637500000000003p 3.868403e-08 64.650000000000006p 4.3517289999999998e-08 64.662499999999994p 4.8282029999999998e-08 64.674999999999997p 5.2972130000000001e-08 64.6875p 5.7581619999999997e-08 64.699999999999989p 6.2104610000000001e-08 64.712499999999991p 6.6535369999999999e-08 64.724999999999994p 7.0868269999999996e-08 64.737500000000011p 7.5097840000000004e-08 64.75p 7.9218749999999996e-08 64.762500000000003p 8.3225829999999999e-08 64.775000000000006p 8.7114060000000001e-08 64.787499999999994p 9.0878599999999994e-08 64.799999999999997p 9.4514769999999996e-08
+ 64.8125p 9.8018079999999997e-08 64.825000000000003p 1.013842e-07 64.837499999999991p 1.0460899999999999e-07 64.849999999999994p 1.076887e-07 64.862500000000011p 1.106193e-07 64.875p 1.1339749999999999e-07 64.887500000000003p 1.160199e-07 64.900000000000006p 1.1848330000000001e-07 64.912499999999994p 1.2078500000000001e-07 64.924999999999997p 1.229223e-07 64.9375p 1.2489260000000001e-07 64.950000000000003p 1.266938e-07 64.962499999999991p 1.2832379999999999e-07 64.974999999999994p 1.2978099999999999e-07 64.987500000000011p 1.310638e-07 65p 1.3217079999999999e-07 65.012500000000003p 1.33101e-07 65.025000000000006p 1.338537e-07
+ 65.037499999999994p 1.3442810000000001e-07 65.049999999999997p 1.348239e-07 65.0625p 1.3504109999999999e-07 65.075000000000003p 1.3507970000000001e-07 65.087499999999991p 1.3493999999999999e-07 65.099999999999994p 1.346227e-07 65.112499999999997p 1.3412869999999999e-07 65.125p 1.3345879999999999e-07 65.137500000000003p 1.3261439999999999e-07 65.150000000000006p 1.315971e-07 65.162500000000009p 1.3040859999999999e-07 65.174999999999997p 1.2905070000000001e-07 65.1875p 1.275257e-07 65.200000000000003p 1.2583610000000001e-07 65.212499999999991p 1.2398430000000001e-07 65.224999999999994p 1.2197319999999999e-07 65.237499999999997p 1.198058e-07 65.25p 1.174853e-07
+ 65.262500000000003p 1.150152e-07 65.275000000000006p 1.123991e-07 65.287500000000009p 1.096406e-07 65.299999999999997p 1.067439e-07 65.3125p 1.03713e-07 65.325000000000003p 1.005523e-07 65.337499999999991p 9.7266240000000003e-08 65.349999999999994p 9.3859409999999999e-08 65.362499999999997p 9.0336600000000002e-08 65.375p 8.6702740000000002e-08 65.387500000000003p 8.2962889999999998e-08 65.400000000000006p 7.9122220000000003e-08 65.412500000000009p 7.5186039999999995e-08 65.424999999999997p 7.1159769999999996e-08 65.4375p 6.7048930000000005e-08 65.450000000000003p 6.2859139999999999e-08 65.462499999999991p 5.8596129999999999e-08 65.474999999999994p 5.4265680000000002e-08
+ 65.487499999999997p 4.9873679999999998e-08 65.5p 4.5426070000000002e-08 65.512500000000003p 4.0928839999999997e-08 65.525000000000006p 3.6388040000000001e-08 65.537500000000009p 3.1809780000000001e-08 65.549999999999997p 2.720019e-08 65.5625p 2.2565409999999999e-08 65.575000000000003p 1.791163e-08 65.587499999999991p 1.324503e-08 65.599999999999994p 8.571806e-09 65.612499999999997p 3.8981329999999998e-09 65.625p -7.6981919999999999e-10 65.637500000000003p -5.4259050000000004e-09 65.650000000000006p -1.006401e-08 65.662500000000009p -1.467806e-08 65.674999999999997p -1.926202e-08 65.6875p -2.3809910000000001e-08 65.700000000000003p -2.8315829999999999e-08
+ 65.712499999999991p -3.2773929999999997e-08 65.724999999999994p -3.7178450000000002e-08 65.737499999999997p -4.1523690000000002e-08 65.75p -4.5804079999999997e-08 65.762500000000003p -5.0014119999999999e-08 65.775000000000006p -5.4148430000000001e-08 65.787500000000009p -5.8201730000000001e-08 65.799999999999997p -6.2168879999999994e-08 65.8125p -6.6044850000000005e-08 65.825000000000003p -6.9824749999999998e-08 65.837499999999991p -7.3503820000000003e-08 65.849999999999994p -7.707745e-08 65.862499999999997p -8.0541179999999998e-08 65.875p -8.389071e-08 65.887500000000003p -8.7121890000000002e-08 65.900000000000006p -9.0230750000000002e-08 65.912500000000009p -9.3213479999999996e-08 65.924999999999997p -9.6066440000000003e-08
+ 65.9375p -9.8786189999999996e-08 65.950000000000003p -1.013695e-07 65.962500000000006p -1.038132e-07 65.974999999999994p -1.061144e-07 65.987499999999997p -1.082705e-07 66p -1.102789e-07 66.012499999999989p -1.121374e-07 66.025000000000006p -1.138438e-07 66.037500000000009p -1.153963e-07 66.049999999999997p -1.167932e-07 66.0625p -1.18033e-07 66.075000000000003p -1.191144e-07 66.087500000000006p -1.200364e-07 66.099999999999994p -1.2079810000000001e-07 66.112499999999997p -1.213989e-07 66.125p -1.218384e-07 66.137499999999989p -1.2211630000000001e-07 66.150000000000006p -1.222327e-07
+ 66.162500000000009p -1.221878e-07 66.174999999999997p -1.2198199999999999e-07 66.1875p -1.21616e-07 66.200000000000003p -1.2109059999999999e-07 66.212500000000006p -1.2040679999999999e-07 66.224999999999994p -1.1956590000000001e-07 66.237499999999997p -1.185693e-07 66.25p -1.174188e-07 66.262499999999989p -1.161162e-07 66.275000000000006p -1.146635e-07 66.287500000000009p -1.13063e-07 66.300000000000011p -1.113171e-07 66.3125p -1.094284e-07 66.325000000000003p -1.0739970000000001e-07 66.337500000000006p -1.05234e-07 66.349999999999994p -1.029344e-07 66.362499999999997p -1.005043e-07 66.375p -9.7947170000000005e-08
+ 66.387499999999989p -9.5266570000000004e-08 66.399999999999991p -9.2466310000000002e-08 66.412500000000009p -8.9550339999999994e-08 66.425000000000011p -8.6522739999999996e-08 66.4375p -8.3387730000000005e-08 66.450000000000003p -8.0149640000000004e-08 66.462500000000006p -7.6812960000000001e-08 66.474999999999994p -7.3382260000000005e-08 66.487499999999997p -6.9862269999999994e-08 66.5p -6.6257790000000003e-08 66.512499999999989p -6.2573720000000005e-08 66.524999999999991p -5.8815069999999997e-08 66.537500000000009p -5.4986940000000002e-08 66.550000000000011p -5.1094489999999998e-08 66.5625p -4.7142960000000001e-08 66.575000000000003p -4.313767e-08 66.587500000000006p -3.9083980000000001e-08 66.599999999999994p -3.498731e-08
+ 66.612499999999997p -3.085313e-08 66.625p -2.668694e-08 66.637500000000003p -2.2494279999999999e-08 66.649999999999991p -1.828069e-08 66.662499999999994p -1.405176e-08 66.675000000000011p -9.8130530000000003e-09 66.6875p -5.5701609999999996e-09 66.700000000000003p -1.328656e-09 66.712500000000006p 2.9058990000000002e-09 66.724999999999994p 7.127963e-09 66.737499999999997p 1.133202e-08 66.75p 1.55126e-08 66.762500000000003p 1.966425e-08 66.774999999999991p 2.3781589999999999e-08 66.787499999999994p 2.7859290000000001e-08 66.800000000000011p 3.1892070000000001e-08 66.8125p 3.5874750000000002e-08 66.825000000000003p 3.9802179999999999e-08
+ 66.837500000000006p 4.3669329999999998e-08 66.849999999999994p 4.7471250000000002e-08 66.862499999999997p 5.1203079999999998e-08 66.875p 5.4860049999999999e-08 66.887500000000003p 5.8437529999999999e-08 66.899999999999991p 6.1930979999999994e-08 66.912499999999994p 6.5335980000000004e-08 66.924999999999997p 6.8648240000000004e-08 66.9375p 7.1863589999999996e-08 66.950000000000003p 7.4978009999999995e-08 66.962500000000006p 7.7987609999999998e-08 66.974999999999994p 8.0888660000000001e-08 66.987499999999997p 8.3677559999999995e-08 67p 8.6350869999999995e-08 67.012500000000003p 8.8905310000000001e-08 67.024999999999991p 9.1337759999999997e-08 67.037499999999994p 9.3645289999999996e-08 67.049999999999997p 9.5825089999999995e-08
+ 67.0625p 9.7874569999999997e-08 67.075000000000003p 9.97913e-08 67.087500000000006p 1.0157300000000001e-07 67.100000000000009p 1.032176e-07 67.112499999999997p 1.0472329999999999e-07 67.125p 1.0608830000000001e-07 67.137500000000003p 1.0731110000000001e-07 67.149999999999991p 1.083904e-07 67.162499999999994p 1.093251e-07 67.174999999999997p 1.101142e-07 67.1875p 1.10757e-07 67.200000000000003p 1.112529e-07 67.212500000000006p 1.116015e-07 67.225000000000009p 1.118028e-07 67.237499999999997p 1.118566e-07 67.25p 1.117634e-07 67.262500000000003p 1.1152339999999999e-07 67.274999999999991p 1.111373e-07
+ 67.287499999999994p 1.1060579999999999e-07 67.299999999999997p 1.0993000000000001e-07 67.3125p 1.091111e-07 67.325000000000003p 1.081503e-07 67.337500000000006p 1.070493e-07 67.350000000000009p 1.0580979999999999e-07 67.362499999999997p 1.044337e-07 67.375p 1.02923e-07 67.387500000000003p 1.0128e-07 67.399999999999991p 9.9507230000000006e-08 67.412499999999994p 9.7607160000000006e-08 67.424999999999997p 9.5582570000000005e-08 67.4375p 9.3436390000000002e-08 67.450000000000003p 9.1171669999999998e-08 67.462500000000006p 8.879163e-08 67.475000000000009p 8.6299630000000006e-08 67.487499999999997p 8.3699180000000005e-08 67.5p 8.0993899999999998e-08
+ 67.512500000000003p 7.818757e-08 67.524999999999991p 7.528408e-08 67.537499999999994p 7.2287430000000002e-08 67.549999999999997p 6.9201760000000003e-08 67.5625p 6.6031299999999994e-08 67.575000000000003p 6.2780389999999996e-08 67.587500000000006p 5.9453459999999997e-08 67.600000000000009p 5.6055040000000001e-08 67.612499999999997p 5.258974e-08 67.625p 4.906225e-08 67.637500000000003p 4.547732e-08 67.649999999999991p 4.1839779999999999e-08 67.662499999999994p 3.8154519999999999e-08 67.674999999999997p 3.4426480000000001e-08 67.6875p 3.0660639999999997e-08 67.700000000000003p 2.6862009999999999e-08 67.712500000000006p 2.3035659999999999e-08 67.725000000000009p 1.9186669999999999e-08
+ 67.737499999999997p 1.5320139999999999e-08 67.75p 1.1441169999999999e-08 67.762500000000003p 7.5548819999999993e-09 67.775000000000006p 3.6663969999999999e-09 67.787499999999994p -2.1918120000000001e-10 67.799999999999997p -4.0967590000000003e-09 67.8125p -7.9612659999999997e-09 67.825000000000003p -1.180766e-08 67.837500000000006p -1.563093e-08 67.850000000000009p -1.942611e-08 67.862499999999997p -2.3188279999999999e-08 67.875p -2.6912579999999999e-08 67.887500000000003p -3.05942e-08 67.900000000000006p -3.4228400000000002e-08 67.912499999999994p -3.7810519999999999e-08 67.924999999999997p -4.1335969999999997e-08 67.9375p -4.4800249999999998e-08 67.949999999999989p -4.8198940000000001e-08
+ 67.962500000000006p -5.1527730000000003e-08 67.975000000000009p -5.4782400000000002e-08 67.987499999999997p -5.7958850000000002e-08 68p -6.105307e-08 68.012500000000003p -6.4061189999999995e-08 68.025000000000006p -6.6979440000000002e-08 68.037499999999994p -6.9804200000000005e-08 68.049999999999997p -7.2531960000000004e-08 68.0625p -7.5159350000000004e-08 68.074999999999989p -7.7683149999999996e-08 68.087500000000006p -8.0100269999999996e-08 68.100000000000009p -8.2407759999999995e-08 68.112499999999997p -8.4602850000000005e-08 68.125p -8.6682900000000004e-08 68.137500000000003p -8.8645429999999995e-08 68.150000000000006p -9.0488109999999998e-08 68.162499999999994p -9.2208789999999995e-08 68.174999999999997p -9.3805490000000003e-08
+ 68.1875p -9.5276359999999995e-08 68.199999999999989p -9.6619760000000004e-08 68.212499999999991p -9.7834190000000002e-08 68.225000000000009p -9.8918349999999998e-08 68.237500000000011p -9.9871090000000004e-08 68.25p -1.0069140000000001e-07 68.262500000000003p -1.013786e-07 68.275000000000006p -1.01932e-07 68.287499999999994p -1.0235110000000001e-07 68.299999999999997p -1.026358e-07 68.3125p -1.0278579999999999e-07 68.324999999999989p -1.028014e-07 68.337499999999991p -1.026827e-07 68.350000000000009p -1.024303e-07 68.362500000000011p -1.020446e-07 68.375p -1.015266e-07 68.387500000000003p -1.008771e-07 68.400000000000006p -1.0009739999999999e-07
+ 68.412499999999994p -9.9188570000000004e-08 68.424999999999997p -9.8152230000000005e-08 68.4375p -9.6989950000000001e-08 68.449999999999989p -9.5703529999999997e-08 68.462499999999991p -9.4294900000000006e-08 68.474999999999994p -9.2766159999999996e-08 68.487500000000011p -9.1119560000000003e-08 68.5p -8.9357509999999995e-08 68.512500000000003p -8.7482530000000006e-08 68.525000000000006p -8.5497329999999994e-08 68.537499999999994p -8.3404720000000001e-08 68.549999999999997p -8.1207660000000006e-08 68.5625p -7.8909240000000006e-08 68.575000000000003p -7.6512669999999999e-08 68.587499999999991p -7.4021290000000005e-08 68.599999999999994p -7.1438539999999994e-08 68.612500000000011p -6.8767990000000001e-08 68.625p -6.60133e-08
+ 68.637500000000003p -6.3178260000000002e-08 68.650000000000006p -6.0266719999999996e-08 68.662499999999994p -5.7282640000000002e-08 68.674999999999997p -5.4230080000000002e-08 68.6875p -5.1113149999999997e-08 68.700000000000003p -4.7936050000000003e-08 68.712499999999991p -4.4703070000000002e-08 68.724999999999994p -4.1418520000000001e-08 68.737500000000011p -3.8086810000000001e-08 68.75p -3.4712380000000002e-08 68.762500000000003p -3.1299710000000003e-08 68.775000000000006p -2.7853340000000001e-08 68.787499999999994p -2.437784e-08 68.799999999999997p -2.0877789999999999e-08 68.8125p -1.7357820000000001e-08 68.825000000000003p -1.382255e-08 68.837499999999991p -1.0276629999999999e-08 68.849999999999994p -6.7247009999999996e-09
+ 68.862499999999997p -3.1714109999999998e-09 68.875p 3.786058e-10 68.887500000000003p 3.9207260000000003e-09 68.900000000000006p 7.4503490000000001e-09 68.912500000000009p 1.09629e-08 68.924999999999997p 1.445383e-08 68.9375p 1.7918630000000001e-08 68.950000000000003p 2.1352850000000001e-08 68.962499999999991p 2.4752070000000001e-08 68.974999999999994p 2.8111930000000001e-08 68.987499999999997p 3.1428129999999997e-08 69p 3.4696440000000003e-08 69.012500000000003p 3.79127e-08 69.025000000000006p 4.1072820000000002e-08 69.037500000000009p 4.417281e-08 69.049999999999997p 4.7208739999999999e-08 69.0625p 5.0176800000000002e-08 69.075000000000003p 5.3073259999999998e-08
+ 69.087499999999991p 5.5894490000000001e-08 69.099999999999994p 5.8636970000000001e-08 69.112499999999997p 6.1297290000000003e-08 69.125p 6.3872160000000002e-08 69.137500000000003p 6.6358409999999996e-08 69.150000000000006p 6.8752970000000004e-08 69.162500000000009p 7.1052919999999995e-08 69.174999999999997p 7.3255460000000004e-08 69.1875p 7.5357930000000003e-08 69.200000000000003p 7.7357799999999999e-08 69.212499999999991p 7.9252680000000006e-08 69.224999999999994p 8.1040319999999999e-08 69.237499999999997p 8.2718619999999999e-08 69.25p 8.4285620000000002e-08 69.262500000000003p 8.5739530000000001e-08 69.275000000000006p 8.7078689999999996e-08 69.287500000000009p 8.8301590000000001e-08 69.299999999999997p 8.9406889999999999e-08
+ 69.3125p 9.0393419999999996e-08 69.325000000000003p 9.1260119999999996e-08 69.337499999999991p 9.2006140000000002e-08 69.349999999999994p 9.2630759999999994e-08 69.362499999999997p 9.3133430000000002e-08 69.375p 9.3513760000000002e-08 69.387500000000003p 9.3771530000000003e-08 69.400000000000006p 9.3906649999999996e-08 69.412500000000009p 9.3919219999999999e-08 69.424999999999997p 9.3809500000000004e-08 69.4375p 9.3577890000000004e-08 69.450000000000003p 9.322497e-08 69.462499999999991p 9.2751459999999996e-08 69.474999999999994p 9.2158239999999994e-08 69.487499999999997p 9.1446360000000006e-08 69.5p 9.061699e-08 69.512500000000003p 8.9671499999999997e-08 69.525000000000006p 8.8611359999999994e-08
+ 69.537500000000009p 8.7438209999999999e-08 69.549999999999997p 8.6153839999999994e-08 69.5625p 8.4760169999999994e-08 69.575000000000003p 8.3259249999999998e-08 69.587499999999991p 8.16533e-08 69.599999999999994p 7.9944639999999997e-08 69.612499999999997p 7.8135730000000006e-08 69.625p 7.6229150000000002e-08 69.637500000000003p 7.4227609999999996e-08 69.650000000000006p 7.2133950000000006e-08 69.662500000000009p 6.9951089999999998e-08 69.674999999999997p 6.7682090000000006e-08 69.6875p 6.5330099999999995e-08 69.700000000000003p 6.2898389999999997e-08 69.712500000000006p 6.0390300000000003e-08 69.724999999999994p 5.7809280000000002e-08 69.737499999999997p 5.5158870000000003e-08 69.75p 5.2442679999999999e-08
+ 69.762499999999989p 4.9664409999999999e-08 69.775000000000006p 4.6827820000000003e-08 69.787500000000009p 4.3936760000000001e-08 69.799999999999997p 4.0995109999999999e-08 69.8125p 3.8006830000000003e-08 69.825000000000003p 3.4975940000000002e-08 69.837500000000006p 3.1906469999999999e-08 69.849999999999994p 2.8802539999999999e-08 69.862499999999997p 2.5668259999999999e-08 69.875p 2.2507800000000001e-08 69.887499999999989p 1.9325339999999999e-08 69.900000000000006p 1.6125079999999999e-08 69.912500000000009p 1.2911249999999999e-08 69.924999999999997p 9.6880610000000001e-09 69.9375p 6.4597489999999998e-09 69.950000000000003p 3.2305359999999999e-09 69.962500000000006p 4.6365290000000001e-12 69.974999999999994p -3.2137480000000002e-09
+ 69.987499999999997p -6.4204350000000003e-09 70p -9.6112690000000006e-09 70.012499999999989p -1.278212e-08 70.025000000000006p -1.5928910000000001e-08 70.037500000000009p -1.9047580000000001e-08 70.050000000000011p -2.213413e-08 70.0625p -2.5184599999999998e-08 70.075000000000003p -2.8195110000000001e-08 70.087500000000006p -3.116182e-08 70.099999999999994p -3.408096e-08 70.112499999999997p -3.6948839999999997e-08 70.125p -3.9761839999999998e-08 70.137499999999989p -4.251641e-08 70.149999999999991p -4.520911e-08 70.162500000000009p -4.7836559999999999e-08 70.175000000000011p -5.0395500000000003e-08 70.1875p -5.2882740000000001e-08 70.200000000000003p -5.5295219999999997e-08
+ 70.212500000000006p -5.7629960000000001e-08 70.224999999999994p -5.9884100000000001e-08 70.237499999999997p -6.2054889999999994e-08 70.25p -6.4139709999999997e-08 70.262499999999989p -6.6136029999999994e-08 70.274999999999991p -6.8041459999999995e-08 70.287500000000009p -6.9853729999999998e-08 70.300000000000011p -7.1570699999999996e-08 70.3125p -7.3190349999999995e-08 70.325000000000003p -7.4710809999999999e-08 70.337500000000006p -7.613033e-08 70.349999999999994p -7.7447289999999998e-08 70.362499999999997p -7.8660230000000005e-08 70.375p -7.9767800000000006e-08 70.387500000000003p -8.0768809999999999e-08 70.399999999999991p -8.1662219999999998e-08 70.412499999999994p -8.2447109999999999e-08 70.425000000000011p -8.3122710000000003e-08
+ 70.4375p -8.3688410000000006e-08 70.450000000000003p -8.4143730000000002e-08 70.462500000000006p -8.4488330000000001e-08 70.474999999999994p -8.4722029999999999e-08 70.487499999999997p -8.4844789999999996e-08 70.5p -8.4856719999999994e-08 70.512500000000003p -8.4758050000000006e-08 70.524999999999991p -8.4549189999999999e-08 70.537499999999994p -8.4230660000000006e-08 70.550000000000011p -8.3803150000000001e-08 70.5625p -8.3267460000000001e-08 70.575000000000003p -8.2624560000000006e-08 70.587500000000006p -8.187553e-08 70.599999999999994p -8.1021609999999997e-08 70.612499999999997p -8.0064160000000006e-08 70.625p -7.9004670000000006e-08 70.637500000000003p -7.7844770000000006e-08 70.649999999999991p -7.6586210000000002e-08
+ 70.662499999999994p -7.5230869999999999e-08 70.674999999999997p -7.3780740000000001e-08 70.6875p -7.2237939999999995e-08 70.700000000000003p -7.06047e-08 70.712500000000006p -6.8883370000000001e-08 70.724999999999994p -6.7076410000000003e-08 70.737499999999997p -6.5186370000000004e-08 70.75p -6.3215920000000003e-08 70.762500000000003p -6.1167820000000004e-08 70.774999999999991p -5.9044930000000001e-08 70.787499999999994p -5.68502e-08 70.799999999999997p -5.4586660000000002e-08 70.8125p -5.2257430000000001e-08 70.825000000000003p -4.9865709999999998e-08 70.837500000000006p -4.7414760000000001e-08 70.850000000000009p -4.4907940000000002e-08 70.862499999999997p -4.2348640000000002e-08 70.875p -3.9740330000000003e-08
+ 70.887500000000003p -3.7086539999999999e-08 70.899999999999991p -3.4390829999999999e-08 70.912499999999994p -3.1656839999999999e-08 70.924999999999997p -2.8888220000000001e-08 70.9375p -2.608867e-08 70.950000000000003p -2.3261930000000001e-08 70.962500000000006p -2.0411750000000001e-08 70.975000000000009p -1.754192e-08 70.987499999999997p -1.465622e-08 71p -1.1758479999999999e-08 71.012500000000003p -8.8525069999999999e-09 71.024999999999991p -5.9421220000000004e-09 71.037499999999994p -3.0311409999999998e-09 71.049999999999997p -1.2337390000000001e-10 71.0625p 2.7773839999999998e-09 71.075000000000003p 5.6673559999999997e-09 71.087500000000006p 8.5427850000000001e-09 71.100000000000009p 1.139994e-08
+ 71.112499999999997p 1.423514e-08 71.125p 1.7044699999999998e-08 71.137500000000003p 1.982503e-08 71.149999999999991p 2.2572549999999999e-08 71.162499999999994p 2.528373e-08 71.174999999999997p 2.795513e-08 71.1875p 3.0583319999999999e-08 71.200000000000003p 3.316498e-08 71.212500000000006p 3.5696820000000001e-08 71.225000000000009p 3.8175669999999998e-08 71.237499999999997p 4.0598379999999999e-08 71.25p 4.2961919999999999e-08 71.262500000000003p 4.5263340000000002e-08 71.274999999999991p 4.7499759999999998e-08 71.287499999999994p 4.966842e-08 71.299999999999997p 5.1766620000000001e-08 71.3125p 5.3791779999999999e-08 71.325000000000003p 5.5741430000000001e-08
+ 71.337500000000006p 5.7613190000000002e-08 71.350000000000009p 5.9404779999999998e-08 71.362499999999997p 6.1114060000000006e-08 71.375p 6.2738970000000001e-08 71.387500000000003p 6.427758e-08 71.399999999999991p 6.5728080000000004e-08 71.412499999999994p 6.7088779999999995e-08 71.424999999999997p 6.8358109999999998e-08 71.4375p 6.9534620000000005e-08 71.450000000000003p 7.0616990000000006e-08 71.462500000000006p 7.1604020000000004e-08 71.475000000000009p 7.2494650000000003e-08 71.487499999999997p 7.3287939999999995e-08 71.5p 7.3983069999999997e-08 71.512500000000003p 7.4579389999999994e-08 71.525000000000006p 7.5076329999999996e-08 71.537499999999994p 7.5473479999999998e-08 71.549999999999997p 7.5770569999999999e-08
+ 71.5625p 7.5967440000000003e-08 71.575000000000003p 7.6064089999999994e-08 71.587500000000006p 7.6060609999999997e-08 71.600000000000009p 7.595726e-08 71.612499999999997p 7.5754420000000006e-08 71.625p 7.5452590000000002e-08 71.637500000000003p 7.5052409999999994e-08 71.650000000000006p 7.4554649999999996e-08 71.662499999999994p 7.3960189999999996e-08 71.674999999999997p 7.327006e-08 71.6875p 7.2485380000000006e-08 71.699999999999989p 7.1607420000000002e-08 71.712500000000006p 7.0637570000000002e-08 71.725000000000009p 6.9577329999999994e-08 71.737499999999997p 6.8428290000000002e-08 71.75p 6.7192210000000004e-08 71.762500000000003p 6.5870900000000003e-08 71.775000000000006p 6.4466329999999996e-08
+ 71.787499999999994p 6.2980530000000002e-08 71.799999999999997p 6.1415670000000006e-08 71.8125p 5.9773990000000006e-08 71.824999999999989p 5.8057839999999998e-08 71.837500000000006p 5.6269659999999998e-08 71.850000000000009p 5.4411990000000001e-08 71.862500000000011p 5.2487429999999997e-08 71.875p 5.0498679999999998e-08 71.887500000000003p 4.8448519999999998e-08 71.900000000000006p 4.6339790000000003e-08 71.912499999999994p 4.4175419999999998e-08 71.924999999999997p 4.195838e-08 71.9375p 3.9691739999999999e-08 71.949999999999989p 3.7378579999999999e-08 71.962499999999991p 3.5022069999999997e-08 71.975000000000009p 3.2625419999999998e-08 71.987500000000011p 3.0191879999999998e-08 72p 2.7724740000000002e-08
+ 72.012500000000003p 2.5227340000000001e-08 72.025000000000006p 2.2703040000000001e-08 72.037499999999994p 2.0155220000000001e-08 72.049999999999997p 1.758729e-08 72.0625p 1.5002689999999999e-08 72.074999999999989p 1.2404859999999999e-08 72.087499999999991p 9.7972560000000005e-09 72.100000000000009p 7.1833240000000004e-09 72.112500000000011p 4.5665259999999999e-09 72.125p 1.9503119999999999e-09 72.137500000000003p -6.618758e-10 72.150000000000006p -3.2666079999999999e-09 72.162499999999994p -5.8604760000000004e-09 72.174999999999997p -8.4400910000000007e-09 72.1875p -1.100209e-08 72.199999999999989p -1.3543160000000001e-08 72.212499999999991p -1.605999e-08 72.224999999999994p -1.8549329999999999e-08
+ 72.237500000000011p -2.1007979999999999e-08 72.25p -2.3432770000000002e-08 72.262500000000003p -2.5820600000000002e-08 72.275000000000006p -2.816841e-08 72.287499999999994p -3.0473220000000002e-08 72.299999999999997p -3.2732099999999997e-08 72.3125p -3.4942180000000001e-08 72.325000000000003p -3.710068e-08 72.337499999999991p -3.9204889999999997e-08 72.349999999999994p -4.1252160000000002e-08 72.362500000000011p -4.3239949999999999e-08 72.375p -4.5165790000000001e-08 72.387500000000003p -4.7027290000000001e-08 72.400000000000006p -4.882215e-08 72.412499999999994p -5.0548189999999998e-08 72.424999999999997p -5.2203299999999997e-08 72.4375p -5.3785480000000002e-08 72.450000000000003p -5.5292810000000003e-08
+ 72.462499999999991p -5.6723510000000002e-08 72.474999999999994p -5.8075870000000002e-08 72.487500000000011p -5.9348299999999999e-08 72.5p -6.0539330000000003e-08 72.512500000000003p -6.1647590000000005e-08 72.525000000000006p -6.2671810000000006e-08 72.537499999999994p -6.3610859999999995e-08 72.549999999999997p -6.4463709999999994e-08 72.5625p -6.5229440000000003e-08 72.575000000000003p -6.5907250000000003e-08 72.587499999999991p -6.649647e-08 72.599999999999994p -6.6996530000000003e-08 72.612499999999997p -6.7406990000000006e-08 72.625p -6.7727529999999998e-08 72.637500000000003p -6.7957930000000003e-08 72.650000000000006p -6.8098109999999994e-08 72.662500000000009p -6.8148109999999998e-08 72.674999999999997p -6.8108059999999996e-08
+ 72.6875p -6.7978249999999995e-08 72.700000000000003p -6.7759040000000004e-08 72.712499999999991p -6.7450950000000004e-08 72.724999999999994p -6.7054589999999996e-08 72.737499999999997p -6.6570679999999998e-08 72.75p -6.6000079999999994e-08 72.762500000000003p -6.5343730000000006e-08 72.775000000000006p -6.4602699999999997e-08 72.787500000000009p -6.3778169999999998e-08 72.799999999999997p -6.2871419999999996e-08 72.8125p -6.1883819999999996e-08 72.825000000000003p -6.0816869999999999e-08 72.837499999999991p -5.9672160000000005e-08 72.849999999999994p -5.8451369999999997e-08 72.862499999999997p -5.7156289999999999e-08 72.875p -5.5788789999999997e-08 72.887500000000003p -5.4350839999999997e-08 72.900000000000006p -5.2844489999999997e-08
+ 72.912500000000009p -5.1271879999999999e-08 72.924999999999997p -4.9635239999999998e-08 72.9375p -4.7936860000000003e-08 72.950000000000003p -4.6179110000000001e-08 72.962499999999991p -4.436446e-08 72.974999999999994p -4.2495410000000003e-08 72.987499999999997p -4.057455e-08 73p -3.860452e-08 73.012500000000003p -3.6588020000000003e-08 73.025000000000006p -3.4527830000000002e-08 73.037500000000009p -3.242674e-08 73.049999999999997p -3.0287610000000001e-08 73.0625p -2.8113340000000001e-08 73.075000000000003p -2.590688e-08 73.087499999999991p -2.3671200000000002e-08 73.099999999999994p -2.140931e-08 73.112499999999997p -1.912424e-08 73.125p -1.6819059999999999e-08
+ 73.137500000000003p -1.4496829999999999e-08 73.150000000000006p -1.216067e-08 73.162500000000009p -9.8136710000000004e-09 73.174999999999997p -7.4589499999999998e-09 73.1875p -5.0996240000000003e-09 73.200000000000003p -2.7388109999999999e-09 73.212499999999991p -3.7962290000000002e-10 73.224999999999994p 1.974838e-09 73.237499999999997p 4.3214800000000003e-09 73.25p 6.6572309999999997e-09 73.262500000000003p 8.9790379999999994e-09 73.275000000000006p 1.128387e-08 73.287500000000009p 1.356874e-08 73.299999999999997p 1.5830659999999999e-08 73.3125p 1.8066719999999999e-08 73.325000000000003p 2.027402e-08 73.337499999999991p 2.2449709999999999e-08 73.349999999999994p 2.4591010000000002e-08
+ 73.362499999999997p 2.669515e-08 73.375p 2.8759450000000001e-08 73.387500000000003p 3.0781270000000003e-08 73.400000000000006p 3.2758040000000001e-08 73.412500000000009p 3.4687249999999998e-08 73.424999999999997p 3.6566459999999999e-08 73.4375p 3.8393300000000001e-08 73.450000000000003p 4.0165459999999997e-08 73.462500000000006p 4.1880739999999999e-08 73.474999999999994p 4.3536989999999998e-08 73.487499999999997p 4.5132160000000001e-08 73.5p 4.6664259999999997e-08 73.512499999999989p 4.8131410000000001e-08 73.525000000000006p 4.9531819999999999e-08 73.537500000000009p 5.0863780000000001e-08 73.549999999999997p 5.212567e-08 73.5625p 5.3315979999999999e-08 73.575000000000003p 5.4433299999999998e-08
+ 73.587500000000006p 5.5476300000000003e-08 73.599999999999994p 5.6443749999999999e-08 73.612499999999997p 5.7334560000000002e-08 73.625p 5.8147689999999999e-08 73.637499999999989p 5.8882240000000001e-08 73.650000000000006p 5.9537400000000001e-08 73.662500000000009p 6.0112479999999997e-08 73.674999999999997p 6.0606890000000006e-08 73.6875p 6.1020140000000005e-08 73.700000000000003p 6.1351850000000004e-08 73.712500000000006p 6.1601760000000001e-08 73.724999999999994p 6.1769709999999997e-08 73.737499999999997p 6.1855649999999996e-08 73.75p 6.1859629999999994e-08 73.762499999999989p 6.1781819999999999e-08 73.774999999999991p 6.1622489999999998e-08 73.787500000000009p 6.1382020000000006e-08 73.800000000000011p 6.1060909999999998e-08
+ 73.8125p 6.0659730000000002e-08 73.825000000000003p 6.0179180000000004e-08 73.837500000000006p 5.9620070000000003e-08 73.849999999999994p 5.8983289999999999e-08 73.862499999999997p 5.8269849999999997e-08 73.875p 5.7480839999999999e-08 73.887499999999989p 5.6617470000000001e-08 73.899999999999991p 5.5681020000000001e-08 73.912500000000009p 5.4672879999999997e-08 73.925000000000011p 5.359453e-08 73.9375p 5.2447550000000003e-08 73.950000000000003p 5.1233579999999999e-08 73.962500000000006p 4.9954360000000001e-08 73.974999999999994p 4.8611729999999999e-08 73.987499999999997p 4.7207569999999997e-08 74p 4.5743879999999997e-08 74.012499999999989p 4.4222700000000002e-08 74.024999999999991p 4.2646169999999998e-08
+ 74.037500000000009p 4.1016460000000003e-08 74.050000000000011p 3.9335859999999997e-08 74.0625p 3.7606670000000001e-08 74.075000000000003p 3.5831280000000002e-08 74.087500000000006p 3.4012130000000002e-08 74.099999999999994p 3.2151710000000002e-08 74.112499999999997p 3.0252550000000002e-08 74.125p 2.8317239999999998e-08 74.137500000000003p 2.634841e-08 74.149999999999991p 2.4348729999999998e-08 74.162499999999994p 2.232089e-08 74.175000000000011p 2.0267630000000001e-08 74.1875p 1.8191709999999999e-08 74.200000000000003p 1.6095909999999998e-08 74.212500000000006p 1.398304e-08 74.224999999999994p 1.185591e-08 74.237499999999997p 9.7173650000000008e-09 74.25p 7.5702449999999996e-09
+ 74.262500000000003p 5.4173960000000003e-09 74.274999999999991p 3.2616680000000002e-09 74.287499999999994p 1.10591e-09 74.300000000000011p -1.047039e-09 74.3125p -3.1943459999999998e-09 74.325000000000003p -5.3331949999999998e-09 74.337500000000006p -7.4607840000000004e-09 74.349999999999994p -9.5743330000000005e-09 74.362499999999997p -1.167109e-08 74.375p -1.374832e-08 74.387500000000003p -1.5803329999999999e-08 74.399999999999991p -1.7833469999999999e-08 74.412499999999994p -1.9836099999999999e-08 74.424999999999997p -2.1808650000000001e-08 74.4375p -2.3748590000000001e-08 74.450000000000003p -2.565342e-08 74.462500000000006p -2.7520719999999999e-08 74.474999999999994p -2.9348090000000001e-08
+ 74.487499999999997p -3.1133220000000002e-08 74.5p -3.2873849999999999e-08 74.512500000000003p -3.4567779999999998e-08 74.524999999999991p -3.621287e-08 74.537499999999994p -3.7807060000000002e-08 74.549999999999997p -3.9348359999999998e-08 74.5625p -4.0834840000000003e-08 74.575000000000003p -4.2264679999999999e-08 74.587500000000006p -4.3636089999999997e-08 74.600000000000009p -4.4947409999999997e-08 74.612499999999997p -4.6197030000000003e-08 74.625p -4.738343e-08 74.637500000000003p -4.8505180000000001e-08 74.649999999999991p -4.9560939999999997e-08 74.662499999999994p -5.0549470000000002e-08 74.674999999999997p -5.1469589999999999e-08 74.6875p -5.2320239999999998e-08 74.700000000000003p -5.3100449999999997e-08
+ 74.712500000000006p -5.3809330000000002e-08 74.725000000000009p -5.4446100000000002e-08 74.737499999999997p -5.5010069999999997e-08 74.75p -5.550064e-08 74.762500000000003p -5.5917330000000003e-08 74.774999999999991p -5.6259739999999999e-08 74.787499999999994p -5.6527569999999997e-08 74.799999999999997p -5.6720630000000003e-08 74.8125p -5.6838799999999999e-08 74.825000000000003p -5.6882090000000002e-08 74.837500000000006p -5.6850589999999999e-08 74.850000000000009p -5.6744500000000002e-08 74.862499999999997p -5.6564109999999998e-08 74.875p -5.6309809999999998e-08 74.887500000000003p -5.5982079999999997e-08 74.899999999999991p -5.55815e-08 74.912499999999994p -5.5108739999999997e-08 74.924999999999997p -5.4564570000000001e-08
+ 74.9375p -5.3949850000000002e-08 74.950000000000003p -5.3265529999999998e-08 74.962500000000006p -5.251264e-08 74.975000000000009p -5.169232e-08 74.987499999999997p -5.0805769999999998e-08 75p -4.9854289999999997e-08 75.012500000000003p -4.8839249999999998e-08 75.024999999999991p -4.776212e-08 75.037499999999994p -4.6624440000000002e-08 75.049999999999997p -4.5427810000000001e-08 75.0625p -4.4173919999999997e-08 75.075000000000003p -4.2864530000000003e-08 75.087500000000006p -4.150147e-08 75.100000000000009p -4.0086630000000001e-08 75.112499999999997p -3.862196e-08 75.125p -3.7109499999999999e-08 75.137500000000003p -3.5551300000000002e-08 75.149999999999991p -3.3949509999999999e-08
+ 75.162499999999994p -3.2306300000000001e-08 75.174999999999997p -3.0623919999999998e-08 75.1875p -2.8904640000000001e-08 75.200000000000003p -2.7150779999999999e-08 75.212500000000006p -2.5364719999999999e-08 75.225000000000009p -2.354885e-08 75.237499999999997p -2.1705620000000001e-08 75.25p -1.9837469999999998e-08 75.262500000000003p -1.7946919999999999e-08 75.275000000000006p -1.603648e-08 75.287499999999994p -1.410868e-08 75.299999999999997p -1.216609e-08 75.3125p -1.021127e-08 75.325000000000003p -8.2468010000000004e-09 75.337500000000006p -6.2752799999999999e-09 75.350000000000009p -4.2992949999999999e-09 75.362499999999997p -2.3214389999999999e-09 75.375p -3.4430250000000001e-10
+ 75.387500000000003p 1.629531e-09 75.400000000000006p 3.5974879999999999e-09 75.412499999999994p 5.5570070000000003e-09 75.424999999999997p 7.5055420000000008e-09 75.4375p 9.4405679999999996e-09 75.449999999999989p 1.1359580000000001e-08 75.462500000000006p 1.326011e-08 75.475000000000009p 1.5139699999999999e-08 75.487499999999997p 1.699594e-08 75.5p 1.882646e-08 75.512500000000003p 2.06289e-08 75.525000000000006p 2.240097e-08 75.537499999999994p 2.4140410000000001e-08 75.549999999999997p 2.5845020000000001e-08 75.5625p 2.7512630000000001e-08 75.574999999999989p 2.9141150000000001e-08 75.587500000000006p 3.0728520000000003e-08 75.600000000000009p 3.2272759999999997e-08
+ 75.612500000000011p 3.3771920000000001e-08 75.625p 3.5224140000000003e-08 75.637500000000003p 3.6627609999999997e-08 75.650000000000006p 3.7980610000000002e-08 75.662499999999994p 3.9281449999999997e-08 75.674999999999997p 4.0528559999999997e-08 75.6875p 4.1720400000000001e-08 75.699999999999989p 4.2855529999999999e-08 75.712499999999991p 4.3932579999999999e-08 75.725000000000009p 4.4950259999999999e-08 75.737500000000011p 4.5907359999999998e-08 75.75p 4.6802749999999999e-08 75.762500000000003p 4.7635379999999998e-08 75.775000000000006p 4.8404290000000001e-08 75.787499999999994p 4.9108610000000001e-08 75.799999999999997p 4.9747540000000002e-08 75.8125p 5.0320379999999999e-08 75.824999999999989p 5.0826520000000002e-08
+ 75.837499999999991p 5.1265430000000001e-08 75.850000000000009p 5.1636670000000002e-08 75.862500000000011p 5.1939889999999999e-08 75.875p 5.2174830000000001e-08 75.887500000000003p 5.2341329999999998e-08 75.900000000000006p 5.24393e-08 75.912499999999994p 5.2468749999999998e-08 75.924999999999997p 5.242979e-08 75.9375p 5.2322600000000003e-08 75.949999999999989p 5.2147459999999998e-08 75.962499999999991p 5.1904739999999997e-08 75.974999999999994p 5.1594880000000001e-08 75.987500000000011p 5.1218439999999997e-08 76p 5.077603e-08 76.012500000000003p 5.0268370000000003e-08 76.025000000000006p 4.9696249999999997e-08 76.037499999999994p 4.9060550000000001e-08 76.049999999999997p 4.836223e-08
+ 76.0625p 4.7602320000000001e-08 76.075000000000003p 4.6781960000000002e-08 76.087499999999991p 4.5902310000000003e-08 76.099999999999994p 4.496467e-08 76.112500000000011p 4.3970370000000001e-08 76.125p 4.2920810000000003e-08 76.137500000000003p 4.1817490000000001e-08 76.150000000000006p 4.0661959999999998e-08 76.162499999999994p 3.9455820000000002e-08 76.174999999999997p 3.8200760000000002e-08 76.1875p 3.6898510000000001e-08 76.200000000000003p 3.5550869999999997e-08 76.212499999999991p 3.4159690000000003e-08 76.224999999999994p 3.2726880000000001e-08 76.237500000000011p 3.1254379999999999e-08 76.25p 2.9744209999999999e-08 76.262500000000003p 2.8198400000000001e-08 76.275000000000006p 2.6619050000000001e-08
+ 76.287499999999994p 2.5008290000000001e-08 76.299999999999997p 2.3368280000000001e-08 76.3125p 2.1701220000000001e-08 76.325000000000003p 2.000934e-08 76.337499999999991p 1.8294900000000001e-08 76.349999999999994p 1.6560169999999999e-08 76.362499999999997p 1.4807470000000001e-08 76.375p 1.303912e-08 76.387500000000003p 1.1257450000000001e-08 76.400000000000006p 9.4648049999999998e-09 76.412500000000009p 7.6635560000000007e-09 76.424999999999997p 5.8560620000000004e-09 76.4375p 4.0446940000000001e-09 76.450000000000003p 2.231818e-09 76.462499999999991p 4.1979919999999999e-10 76.474999999999994p -1.389003e-09 76.487499999999997p -3.1922389999999998e-09 76.5p -4.9875719999999998e-09
+ 76.512500000000003p -6.7726809999999997e-09 76.525000000000006p -8.5452620000000006e-09 76.537500000000009p -1.0303029999999999e-08 76.549999999999997p -1.204374e-08 76.5625p -1.3765149999999999e-08 76.575000000000003p -1.5465049999999999e-08 76.587499999999991p -1.7141300000000001e-08 76.599999999999994p -1.879175e-08 76.612499999999997p -2.041431e-08 76.625p -2.2006920000000001e-08 76.637500000000003p -2.3567590000000001e-08 76.650000000000006p -2.5094339999999999e-08 76.662500000000009p -2.658526e-08 76.674999999999997p -2.803849e-08 76.6875p -2.9452219999999999e-08 76.700000000000003p -3.0824699999999997e-08 76.712499999999991p -3.2154220000000002e-08 76.724999999999994p -3.3439159999999997e-08
+ 76.737499999999997p -3.4677929999999999e-08 76.75p -3.5869029999999998e-08 76.762500000000003p -3.7011010000000003e-08 76.775000000000006p -3.8102489999999997e-08 76.787500000000009p -3.9142159999999999e-08 76.799999999999997p -4.0128779999999998e-08 76.8125p -4.1061190000000001e-08 76.825000000000003p -4.1938279999999998e-08 76.837499999999991p -4.2759050000000002e-08 76.849999999999994p -4.3522550000000001e-08 76.862499999999997p -4.4227910000000002e-08 76.875p -4.4874339999999998e-08 76.887500000000003p -4.5461139999999998e-08 76.900000000000006p -4.5987659999999999e-08 76.912500000000009p -4.6453360000000001e-08 76.924999999999997p -4.6857770000000001e-08 76.9375p -4.72005e-08 76.950000000000003p -4.7481230000000001e-08
+ 76.962499999999991p -4.7699749999999997e-08 76.974999999999994p -4.785591e-08 76.987499999999997p -4.794964e-08 77p -4.7980959999999998e-08 77.012500000000003p -4.794997e-08 77.025000000000006p -4.7856850000000001e-08 77.037500000000009p -4.7701860000000001e-08 77.049999999999997p -4.7485340000000001e-08 77.0625p -4.7207710000000002e-08 77.075000000000003p -4.6869460000000002e-08 77.087499999999991p -4.6471179999999998e-08 77.099999999999994p -4.6013519999999997e-08 77.112499999999997p -4.5497210000000001e-08 77.125p -4.4923050000000001e-08 77.137500000000003p -4.4291910000000002e-08 77.150000000000006p -4.3604760000000002e-08 77.162500000000009p -4.2862600000000003e-08 77.174999999999997p -4.2066529999999998e-08
+ 77.1875p -4.1217709999999999e-08 77.200000000000003p -4.0317359999999999e-08 77.212500000000006p -3.9366760000000001e-08 77.224999999999994p -3.8367279999999999e-08 77.237499999999997p -3.7320320000000002e-08 77.25p -3.6227350000000003e-08 77.262499999999989p -3.5089890000000003e-08 77.275000000000006p -3.3909540000000003e-08 77.287500000000009p -3.2687920000000002e-08 77.299999999999997p -3.1426710000000001e-08 77.3125p -3.0127649999999998e-08 77.325000000000003p -2.8792520000000001e-08 77.337500000000006p -2.7423129999999999e-08 77.349999999999994p -2.6021340000000001e-08 77.362499999999997p -2.4589059999999999e-08 77.375p -2.3128220000000001e-08 77.387499999999989p -2.1640780000000001e-08 77.400000000000006p -2.0128740000000001e-08
+ 77.412500000000009p -1.8594119999999999e-08 77.424999999999997p -1.7038980000000001e-08 77.4375p -1.5465389999999998e-08 77.450000000000003p -1.387543e-08 77.462500000000006p -1.227121e-08 77.474999999999994p -1.065486e-08 77.487499999999997p -9.0285110000000006e-09 77.5p -7.3942940000000001e-09 77.512499999999989p -5.7543609999999999e-09 77.524999999999991p -4.1108590000000001e-09 77.537500000000009p -2.4659359999999998e-09 77.550000000000011p -8.2173669999999998e-10 77.5625p 8.195989e-10 77.575000000000003p 2.455941e-09 77.587500000000006p 4.0851700000000003e-09 77.599999999999994p 5.7051799999999999e-09 77.612499999999997p 7.3138849999999999e-09 77.625p 8.9092149999999996e-09
+ 77.637499999999989p 1.0489120000000001e-08 77.649999999999991p 1.2051589999999999e-08 77.662500000000009p 1.359462e-08 77.675000000000011p 1.5116240000000002e-08 77.6875p 1.6614539999999999e-08 77.700000000000003p 1.8087600000000001e-08 77.712500000000006p 1.953357e-08 77.724999999999994p 2.0950640000000001e-08 77.737499999999997p 2.233701e-08 77.75p 2.3690960000000001e-08 77.762499999999989p 2.5010800000000001e-08 77.774999999999991p 2.6294899999999999e-08 77.787500000000009p 2.754165e-08 77.800000000000011p 2.8749540000000002e-08 77.8125p 2.9917060000000002e-08 77.825000000000003p 3.1042810000000001e-08 77.837500000000006p 3.21254e-08 77.849999999999994p 3.3163539999999997e-08
+ 77.862499999999997p 3.4155970000000002e-08 77.875p 3.5101519999999998e-08 77.887500000000003p 3.599905e-08 77.899999999999991p 3.6847519999999999e-08 77.912499999999994p 3.7645939999999999e-08 77.925000000000011p 3.839338e-08 77.9375p 3.9088989999999997e-08 77.950000000000003p 3.9732000000000001e-08 77.962500000000006p 4.0321690000000002e-08 77.974999999999994p 4.0857409999999998e-08 77.987499999999997p 4.1338609999999999e-08 78p 4.176478e-08 78.012500000000003p 4.2135509999999997e-08 78.024999999999991p 4.2450440000000001e-08 78.037499999999994p 4.2709299999999999e-08 78.050000000000011p 4.2911880000000002e-08 78.0625p 4.3058070000000003e-08 78.075000000000003p 4.3147810000000003e-08
+ 78.087500000000006p 4.3181110000000003e-08 78.099999999999994p 4.3158080000000001e-08 78.112499999999997p 4.307888e-08 78.125p 4.2943749999999997e-08 78.137500000000003p 4.2753010000000002e-08 78.149999999999991p 4.2507039999999998e-08 78.162499999999994p 4.220631e-08 78.174999999999997p 4.1851330000000001e-08 78.1875p 4.1442710000000003e-08 78.200000000000003p 4.0981109999999997e-08 78.212500000000006p 4.0467259999999998e-08 78.225000000000009p 3.9901969999999999e-08 78.237499999999997p 3.9286110000000001e-08 78.25p 3.8620599999999997e-08 78.262500000000003p 3.790643e-08 78.274999999999991p 3.714467e-08 78.287499999999994p 3.6336419999999997e-08 78.299999999999997p 3.5482860000000003e-08
+ 78.3125p 3.4585210000000002e-08 78.325000000000003p 3.3644759999999997e-08 78.337500000000006p 3.2662849999999998e-08 78.350000000000009p 3.164086e-08 78.362499999999997p 3.058023e-08 78.375p 2.948244e-08 78.387500000000003p 2.8349020000000001e-08 78.399999999999991p 2.718154e-08 78.412499999999994p 2.5981619999999999e-08 78.424999999999997p 2.4750909999999999e-08 78.4375p 2.3491080000000001e-08 78.450000000000003p 2.220387e-08 78.462500000000006p 2.0891030000000001e-08 78.475000000000009p 1.955433e-08 78.487499999999997p 1.8195590000000001e-08 78.5p 1.6816639999999999e-08 78.512500000000003p 1.541933e-08 78.524999999999991p 1.400555e-08
+ 78.537499999999994p 1.257717e-08 78.549999999999997p 1.113611e-08 78.5625p 9.6842859999999994e-09 78.575000000000003p 8.223622e-09 78.587500000000006p 6.7560529999999998e-09 78.600000000000009p 5.2835179999999997e-09 78.612499999999997p 3.8079560000000001e-09 78.625p 2.3313070000000002e-09 78.637500000000003p 8.555052e-10 78.649999999999991p -6.1751890000000001e-10 78.662499999999994p -2.0858439999999999e-09 78.674999999999997p -3.547561e-09 78.6875p -5.0007710000000002e-09 78.700000000000003p -6.4435949999999996e-09 78.712500000000006p -7.8741680000000005e-09 78.725000000000009p -9.2906509999999999e-09 78.737499999999997p -1.069122e-08 78.75p -1.207409e-08
+ 78.762500000000003p -1.3437490000000001e-08 78.774999999999991p -1.477968e-08 78.787499999999994p -1.6098960000000001e-08 78.799999999999997p -1.7393660000000001e-08 78.8125p -1.866215e-08 78.825000000000003p -1.9902829999999998e-08 78.837500000000006p -2.1114150000000001e-08 78.850000000000009p -2.229459e-08 78.862499999999997p -2.3442690000000001e-08 78.875p -2.4557019999999999e-08 78.887500000000003p -2.5636219999999999e-08 78.899999999999991p -2.6678950000000001e-08 78.912499999999994p -2.7683949999999999e-08 78.924999999999997p -2.8649989999999999e-08 78.9375p -2.9575900000000001e-08 78.950000000000003p -3.0460569999999999e-08 78.962500000000006p -3.130296e-08 78.975000000000009p -3.2102050000000001e-08
+ 78.987499999999997p -3.2856920000000002e-08 79p -3.3566689999999999e-08 79.012500000000003p -3.423053e-08 79.025000000000006p -3.4847699999999999e-08 79.037499999999994p -3.5417510000000003e-08 79.049999999999997p -3.5939330000000001e-08 79.0625p -3.6412589999999998e-08 79.075000000000003p -3.6836799999999997e-08 79.087500000000006p -3.7211520000000002e-08 79.100000000000009p -3.7536400000000001e-08 79.112499999999997p -3.7811119999999999e-08 79.125p -3.8035459999999997e-08 79.137500000000003p -3.8209239999999999e-08 79.150000000000006p -3.8332379999999997e-08 79.162499999999994p -3.8404820000000001e-08 79.174999999999997p -3.8426609999999999e-08 79.1875p -3.8397850000000003e-08 79.199999999999989p -3.8318699999999998e-08
+ 79.212500000000006p -3.8189380000000001e-08 79.225000000000009p -3.8010210000000002e-08 79.237499999999997p -3.778152e-08 79.25p -3.7503759999999999e-08 79.262500000000003p -3.7177410000000001e-08 79.275000000000006p -3.6803009999999999e-08 79.287499999999994p -3.6381190000000001e-08 79.299999999999997p -3.5912599999999997e-08 79.3125p -3.5397990000000001e-08 79.324999999999989p -3.4838140000000002e-08 79.337500000000006p -3.4233909999999998e-08 79.350000000000009p -3.3586190000000001e-08 79.362500000000011p -3.2895950000000003e-08 79.375p -3.21642e-08 79.387500000000003p -3.1391989999999998e-08 79.400000000000006p -3.0580460000000001e-08 79.412499999999994p -2.973076e-08 79.424999999999997p -2.8844099999999999e-08
+ 79.4375p -2.792173e-08 79.449999999999989p -2.6964970000000001e-08 79.462499999999991p -2.5975150000000001e-08 79.475000000000009p -2.495366e-08 79.487500000000011p -2.3901909999999999e-08 79.5p -2.2821359999999999e-08 79.512500000000003p -2.1713510000000001e-08 79.525000000000006p -2.0579880000000001e-08 79.537499999999994p -1.942202e-08 79.549999999999997p -1.8241520000000001e-08 79.5625p -1.7039989999999999e-08 79.574999999999989p -1.581905e-08 79.587499999999991p -1.4580359999999999e-08 79.600000000000009p -1.332559e-08 79.612500000000011p -1.205644e-08 79.625p -1.077461e-08 79.637500000000003p -9.481823e-09 79.650000000000006p -8.1797989999999999e-09
+ 79.662499999999994p -6.8702790000000001e-09 79.674999999999997p -5.5550060000000002e-09 79.6875p -4.2357249999999999e-09 79.699999999999989p -2.914184e-09 79.712499999999991p -1.5921290000000001e-09 79.724999999999994p -2.7130339999999998e-10 79.737500000000011p 1.0465559999999999e-09 79.75p 2.3597200000000002e-09 79.762500000000003p 3.6664700000000001e-09 79.775000000000006p 4.9650979999999999e-09 79.787499999999994p 6.2539120000000002e-09 79.799999999999997p 7.5312369999999992e-09 79.8125p 8.7954169999999993e-09 79.825000000000003p 1.004482e-08 79.837499999999991p 1.1277820000000001e-08 79.849999999999994p 1.249285e-08 79.862500000000011p 1.3688329999999999e-08 79.875p 1.486275e-08
+ 79.887500000000003p 1.60146e-08 79.900000000000006p 1.7142410000000001e-08 79.912499999999994p 1.8244759999999999e-08 79.924999999999997p 1.9320250000000001e-08 79.9375p 2.036752e-08 79.950000000000003p 2.1385259999999999e-08 79.962499999999991p 2.2372200000000001e-08 79.974999999999994p 2.33271e-08 79.987499999999997p 2.424878e-08 80p 2.51361e-08 80.012500000000003p 2.5987980000000001e-08 80.025000000000006p 2.6803360000000001e-08 80.037499999999994p 2.7581260000000001e-08 80.049999999999997p 2.8320749999999999e-08 80.0625p 2.902092e-08 80.075000000000003p 2.968095e-08 80.087499999999991p 3.0300070000000002e-08 80.099999999999994p 3.0877539999999999e-08
+ 80.112499999999997p 3.1412709999999998e-08 80.125p 3.1904969999999997e-08 80.137500000000003p 3.2353749999999999e-08 80.150000000000006p 3.2758589999999997e-08 80.162500000000009p 3.3119030000000003e-08 80.174999999999997p 3.3434710000000001e-08 80.1875p 3.3705310000000003e-08 80.200000000000003p 3.393058e-08 80.212499999999991p 3.4110329999999998e-08 80.224999999999994p 3.4244429999999997e-08 80.237499999999997p 3.4332800000000003e-08 80.25p 3.4375440000000003e-08 80.262500000000003p 3.4372389999999997e-08 80.275000000000006p 3.432376e-08 80.287500000000009p 3.422972e-08 80.299999999999997p 3.409051e-08 80.3125p 3.3906400000000001e-08 80.325000000000003p 3.3677749999999999e-08
+ 80.337499999999991p 3.3404960000000001e-08 80.349999999999994p 3.3088499999999999e-08 80.362499999999997p 3.272887e-08 80.375p 3.2326670000000003e-08 80.387500000000003p 3.1882509999999998e-08 80.400000000000006p 3.1397079999999999e-08 80.412500000000009p 3.0871130000000001e-08 80.424999999999997p 3.0305420000000001e-08 80.4375p 2.9700820000000001e-08 80.450000000000003p 2.9058199999999999e-08 80.462499999999991p 2.8378500000000002e-08 80.474999999999994p 2.7662710000000001e-08 80.487499999999997p 2.6911850000000002e-08 80.5p 2.6127e-08 80.512500000000003p 2.5309279999999998e-08 80.525000000000006p 2.4459840000000001e-08 80.537500000000009p 2.3579880000000002e-08 80.549999999999997p 2.2670639999999999e-08
+ 80.5625p 2.1733369999999999e-08 80.575000000000003p 2.0769400000000001e-08 80.587499999999991p 1.9780039999999999e-08 80.599999999999994p 1.8766679999999999e-08 80.612499999999997p 1.7730699999999999e-08 80.625p 1.667353e-08 80.637500000000003p 1.5596609999999999e-08 80.650000000000006p 1.450142e-08 80.662500000000009p 1.338945e-08 80.674999999999997p 1.22622e-08 80.6875p 1.11212e-08 80.700000000000003p 9.9679929999999997e-09 80.712499999999991p 8.8041350000000006e-09 80.724999999999994p 7.6311870000000007e-09 80.737499999999997p 6.4507220000000001e-09 80.75p 5.2643200000000003e-09 80.762500000000003p 4.0735650000000001e-09 80.775000000000006p 2.8800409999999998e-09
+ 80.787500000000009p 1.685335e-09 80.799999999999997p 4.9102970000000002e-10 80.8125p -7.0129459999999998e-10 80.825000000000003p -1.8900649999999999e-09 80.837499999999991p -3.0737150000000001e-09 80.849999999999994p -4.2506919999999997e-09 80.862499999999997p -5.4194519999999997e-09 80.875p -6.5784659999999999e-09 80.887500000000003p -7.7262239999999994e-09 80.900000000000006p -8.8612309999999999e-09 80.912500000000009p -9.9820140000000008e-09 80.924999999999997p -1.108712e-08 80.9375p -1.217513e-08 80.950000000000003p -1.324463e-08 80.962500000000006p -1.4294250000000001e-08 80.974999999999994p -1.5322649999999999e-08 80.987499999999997p -1.6328509999999999e-08 81p -1.7310550000000001e-08
+ 81.012499999999989p -1.8267530000000001e-08 81.025000000000006p -1.9198230000000001e-08 81.037500000000009p -2.010149e-08 81.049999999999997p -2.097616e-08 81.0625p -2.1821149999999999e-08 81.075000000000003p -2.2635409999999999e-08 81.087500000000006p -2.3417929999999999e-08 81.099999999999994p -2.4167750000000001e-08 81.112499999999997p -2.488394e-08 81.125p -2.556562e-08 81.137499999999989p -2.621198e-08 81.150000000000006p -2.6822240000000001e-08 81.162500000000009p -2.739566e-08 81.174999999999997p -2.793156e-08 81.1875p -2.8429329999999999e-08 81.200000000000003p -2.8888369999999999e-08 81.212500000000006p -2.9308180000000001e-08 81.224999999999994p -2.9688270000000001e-08
+ 81.237499999999997p -3.002824e-08 81.25p -3.0327709999999999e-08 81.262499999999989p -3.0586380000000002e-08 81.274999999999991p -3.0803989999999999e-08 81.287500000000009p -3.0980339999999999e-08 81.300000000000011p -3.1115280000000001e-08 81.3125p -3.1208729999999998e-08 81.325000000000003p -3.1260649999999999e-08 81.337500000000006p -3.1271060000000002e-08 81.349999999999994p -3.124002e-08 81.362499999999997p -3.1167680000000002e-08 81.375p -3.1054199999999999e-08 81.387499999999989p -3.0899829999999998e-08 81.399999999999991p -3.0704859999999998e-08 81.412500000000009p -3.0469619999999999e-08 81.425000000000011p -3.0194510000000003e-08 81.4375p -2.9879969999999997e-08 81.450000000000003p -2.952651e-08
+ 81.462500000000006p -2.913466e-08 81.474999999999994p -2.8705030000000001e-08 81.487499999999997p -2.8238260000000001e-08 81.5p -2.7735039999999999e-08 81.512499999999989p -2.7196109999999999e-08 81.524999999999991p -2.6622259999999999e-08 81.537500000000009p -2.60143e-08 81.550000000000011p -2.537311e-08 81.5625p -2.4699610000000001e-08 81.575000000000003p -2.3994750000000001e-08 81.587500000000006p -2.325952e-08 81.599999999999994p -2.2494950000000001e-08 81.612499999999997p -2.170211e-08 81.625p -2.08821e-08 81.637500000000003p -2.0036060000000001e-08 81.649999999999991p -1.9165150000000001e-08 81.662499999999994p -1.8270570000000001e-08 81.675000000000011p -1.735354e-08
+ 81.6875p -1.6415320000000001e-08 81.700000000000003p -1.5457189999999998e-08 81.712500000000006p -1.4480450000000001e-08 81.724999999999994p -1.3486430000000001e-08 81.737499999999997p -1.247645e-08 81.75p -1.14519e-08 81.762500000000003p -1.041414e-08 81.774999999999991p -9.3645620000000008e-09 81.787499999999994p -8.3045809999999994e-09 81.800000000000011p -7.2356080000000002e-09 81.8125p -6.1590689999999996e-09 81.825000000000003p -5.0763949999999996e-09 81.837500000000006p -3.9890230000000001e-09 81.849999999999994p -2.8983930000000001e-09 81.862499999999997p -1.8059479999999999e-09 81.875p -7.1312669999999998e-10 81.887500000000003p 3.7863069999999998e-10 81.899999999999991p 1.46789e-09
+ 81.912499999999994p 2.553224e-09 81.924999999999997p 3.633211e-09 81.9375p 4.7064420000000004e-09 81.950000000000003p 5.771519e-09 81.962500000000006p 6.8270549999999999e-09 81.975000000000009p 7.8716820000000005e-09 81.987499999999997p 8.9040459999999996e-09 82p 9.9228139999999992e-09 82.012500000000003p 1.092667e-08 82.024999999999991p 1.1914329999999999e-08 82.037499999999994p 1.288452e-08 82.049999999999997p 1.3836000000000001e-08 82.0625p 1.4767550000000001e-08 82.075000000000003p 1.5678e-08 82.087500000000006p 1.6566169999999999e-08 82.100000000000009p 1.743096e-08 82.112499999999997p 1.8271259999999999e-08 82.125p 1.908601e-08
+ 82.137500000000003p 1.9874210000000001e-08 82.149999999999991p 2.0634850000000001e-08 82.162499999999994p 2.1366999999999999e-08 82.174999999999997p 2.2069740000000002e-08 82.1875p 2.274222e-08 82.200000000000003p 2.3383590000000001e-08 82.212500000000006p 2.3993090000000001e-08 82.225000000000009p 2.4569970000000001e-08 82.237499999999997p 2.5113520000000002e-08 82.25p 2.5623109999999999e-08 82.262500000000003p 2.6098130000000002e-08 82.274999999999991p 2.6538019999999999e-08 82.287499999999994p 2.6942260000000001e-08 82.299999999999997p 2.7310399999999999e-08 82.3125p 2.764201e-08 82.325000000000003p 2.793674e-08 82.337500000000006p 2.8194260000000001e-08 82.350000000000009p 2.8414299999999999e-08
+ 82.362499999999997p 2.8596659999999999e-08 82.375p 2.8741150000000001e-08 82.387500000000003p 2.8847659999999999e-08 82.399999999999991p 2.8916130000000001e-08 82.412499999999994p 2.894652e-08 82.424999999999997p 2.893889e-08 82.4375p 2.8893289999999999e-08 82.450000000000003p 2.8809879999999999e-08 82.462500000000006p 2.8688819999999999e-08 82.475000000000009p 2.853035e-08 82.487499999999997p 2.8334739999999998e-08 82.5p 2.8102329999999998e-08 82.512500000000003p 2.7833469999999999e-08 82.524999999999991p 2.7528599999999999e-08 82.537499999999994p 2.7188179999999999e-08 82.549999999999997p 2.681273e-08 82.5625p 2.6402790000000001e-08 82.575000000000003p 2.5958980000000001e-08
+ 82.587500000000006p 2.548194e-08 82.600000000000009p 2.4972349999999999e-08 82.612499999999997p 2.4430949999999999e-08 82.625p 2.3858500000000002e-08 82.637500000000003p 2.3255809999999999e-08 82.649999999999991p 2.2623730000000001e-08 82.662499999999994p 2.1963130000000001e-08 82.674999999999997p 2.1274950000000001e-08 82.6875p 2.0560119999999999e-08 82.700000000000003p 1.9819649999999999e-08 82.712500000000006p 1.905454e-08 82.725000000000009p 1.8265840000000002e-08 82.737499999999997p 1.7454630000000001e-08 82.75p 1.6622010000000001e-08 82.762500000000003p 1.5769119999999999e-08 82.775000000000006p 1.48971e-08 82.787499999999994p 1.4007139999999999e-08 82.799999999999997p 1.310043e-08
+ 82.8125p 1.2178189999999999e-08 82.825000000000003p 1.124166e-08 82.837500000000006p 1.0292089999999999e-08 82.850000000000009p 9.3307400000000008e-09 82.862499999999997p 8.3588960000000005e-09 82.875p 7.3778459999999997e-09 82.887500000000003p 6.3888919999999997e-09 82.900000000000006p 5.3933399999999999e-09 82.912499999999994p 4.3925050000000002e-09 82.924999999999997p 3.3877050000000001e-09 82.9375p 2.3802610000000001e-09 82.949999999999989p 1.371494e-09 82.962500000000006p 3.6272570000000002e-10 82.975000000000009p -6.4472669999999999e-10 82.987499999999997p -1.649549e-09 83p -2.6504339999999999e-09 83.012500000000003p -3.6460820000000001e-09 83.025000000000006p -4.6352019999999997e-09
+ 83.037499999999994p -5.616515e-09 83.049999999999997p -6.5887539999999996e-09 83.0625p -7.5506679999999993e-09 83.074999999999989p -8.5010199999999992e-09 83.087500000000006p -9.438592e-09 83.100000000000009p -1.036219e-08 83.112500000000011p -1.127062e-08 83.125p -1.2162739999999999e-08 83.137500000000003p -1.3037419999999999e-08 83.150000000000006p -1.3893540000000001e-08 83.162499999999994p -1.473002e-08 83.174999999999997p -1.5545810000000001e-08 83.1875p -1.6339900000000001e-08 83.199999999999989p -1.711127e-08 83.212499999999991p -1.7858980000000002e-08 83.225000000000009p -1.8582089999999999e-08 83.237500000000011p -1.9279710000000001e-08 83.25p -1.9950970000000001e-08
+ 83.262500000000003p -2.0595059999999999e-08 83.275000000000006p -2.1211190000000001e-08 83.287499999999994p -2.17986e-08 83.299999999999997p -2.2356600000000001e-08 83.3125p -2.2884499999999999e-08 83.324999999999989p -2.3381690000000001e-08 83.337499999999991p -2.3847570000000001e-08 83.350000000000009p -2.428159e-08 83.362500000000011p -2.468327e-08 83.375p -2.505212e-08 83.387500000000003p -2.5387749999999998e-08 83.400000000000006p -2.568978e-08 83.412499999999994p -2.5957880000000001e-08 83.424999999999997p -2.619177e-08 83.4375p -2.6391209999999999e-08 83.449999999999989p -2.6556019999999999e-08 83.462499999999991p -2.6686040000000001e-08 83.474999999999994p -2.6781180000000001e-08
+ 83.487500000000011p -2.6841380000000001e-08 83.5p -2.6866629999999999e-08 83.512500000000003p -2.685698e-08 83.525000000000006p -2.681249e-08 83.537499999999994p -2.6733310000000001e-08 83.549999999999997p -2.6619600000000001e-08 83.5625p -2.6471579999999999e-08 83.575000000000003p -2.6289519999999998e-08 83.587499999999991p -2.6073709999999999e-08 83.599999999999994p -2.5824500000000001e-08 83.612500000000011p -2.5542290000000001e-08 83.625p -2.5227519999999999e-08 83.637500000000003p -2.4880650000000001e-08 83.650000000000006p -2.4502200000000001e-08 83.662499999999994p -2.4092739999999999e-08 83.674999999999997p -2.3652839999999999e-08 83.6875p -2.3183160000000001e-08 83.700000000000003p -2.2684349999999999e-08
+ 83.712499999999991p -2.215713e-08 83.724999999999994p -2.1602240000000001e-08 83.737499999999997p -2.102046e-08 83.75p -2.04126e-08 83.762500000000003p -1.9779499999999999e-08 83.775000000000006p -1.912204e-08 83.787499999999994p -1.8441120000000001e-08 83.799999999999997p -1.773768e-08 83.8125p -1.7012669999999999e-08 83.825000000000003p -1.6267079999999998e-08 83.837499999999991p -1.550192e-08 83.849999999999994p -1.471824e-08 83.862499999999997p -1.3917070000000001e-08 83.875p -1.3099510000000001e-08 83.887500000000003p -1.2266649999999999e-08 83.900000000000006p -1.1419590000000001e-08 83.912500000000009p -1.055948e-08 83.924999999999997p -9.6874529999999998e-09
+ 83.9375p -8.8046669999999998e-09 83.950000000000003p -7.9122920000000004e-09 83.962499999999991p -7.0115070000000002e-09 83.974999999999994p -6.1034999999999999e-09 83.987499999999997p -5.189464e-09 84p -4.2705999999999997e-09 84.012500000000003p -3.3481099999999999e-09 84.025000000000006p -2.423201e-09 84.037500000000009p -1.4970759999999999e-09 84.049999999999997p -5.7094319999999998e-10 84.0625p 3.5399710000000002e-10 84.075000000000003p 1.2765460000000001e-09 84.087499999999991p 2.1955109999999999e-09 84.099999999999994p 3.1097069999999999e-09 84.112499999999997p 4.0179579999999998e-09 84.125p 4.9190970000000004e-09 84.137500000000003p 5.8119699999999997e-09 84.150000000000006p 6.6954350000000003e-09
+ 84.162500000000009p 7.5683669999999999e-09 84.174999999999997p 8.4296540000000006e-09 84.1875p 9.2782049999999996e-09 84.200000000000003p 1.011294e-08 84.212499999999991p 1.093282e-08 84.224999999999994p 1.17368e-08 84.237499999999997p 1.252388e-08 84.25p 1.329306e-08 84.262500000000003p 1.4043400000000001e-08 84.275000000000006p 1.4773949999999999e-08 84.287500000000009p 1.548382e-08 84.299999999999997p 1.6172129999999999e-08 84.3125p 1.6838030000000001e-08 84.325000000000003p 1.748071e-08 84.337499999999991p 1.8099380000000001e-08 84.349999999999994p 1.869329e-08 84.362499999999997p 1.9261740000000001e-08 84.375p 1.9804029999999999e-08
+ 84.387500000000003p 2.0319519999999999e-08 84.400000000000006p 2.0807610000000002e-08 84.412500000000009p 2.1267709999999999e-08 84.424999999999997p 2.1699300000000001e-08 84.4375p 2.210188e-08 84.450000000000003p 2.2474980000000001e-08 84.462499999999991p 2.281821e-08 84.474999999999994p 2.3131159999999999e-08 84.487499999999997p 2.341351e-08 84.5p 2.3664970000000001e-08 84.512500000000003p 2.3885259999999999e-08 84.525000000000006p 2.4074179999999999e-08 84.537500000000009p 2.423155e-08 84.549999999999997p 2.4357250000000001e-08 84.5625p 2.445117e-08 84.575000000000003p 2.4513269999999999e-08 84.587500000000006p 2.454355e-08 84.599999999999994p 2.4542029999999999e-08
+ 84.612499999999997p 2.4508780000000001e-08 84.625p 2.4443940000000001e-08 84.637500000000003p 2.4347650000000002e-08 84.650000000000006p 2.42201e-08 84.662500000000009p 2.4061549999999999e-08 84.674999999999997p 2.3872250000000001e-08 84.6875p 2.3652539999999999e-08 84.700000000000003p 2.3402770000000001e-08 84.712500000000006p 2.3123330000000001e-08 84.724999999999994p 2.281465e-08 84.737499999999997p 2.2477200000000001e-08 84.75p 2.2111489999999999e-08 84.762499999999989p 2.1718059999999999e-08 84.775000000000006p 2.129748e-08 84.787500000000009p 2.085036e-08 84.799999999999997p 2.037735e-08 84.8125p 1.9879120000000001e-08 84.825000000000003p 1.935638e-08
+ 84.837500000000006p 1.8809859999999999e-08 84.849999999999994p 1.8240329999999999e-08 84.862499999999997p 1.764858e-08 84.875p 1.7035440000000001e-08 84.887499999999989p 1.640175e-08 84.900000000000006p 1.5748379999999999e-08 84.912500000000009p 1.5076229999999999e-08 84.924999999999997p 1.438622e-08 84.9375p 1.367928e-08 84.950000000000003p 1.2956380000000001e-08 84.962500000000006p 1.221849e-08 84.974999999999994p 1.1466599999999999e-08 84.987499999999997p 1.070173e-08 85p 9.9249040000000004e-09 85.012499999999989p 9.1371540000000005e-09 85.024999999999991p 8.3395320000000003e-09 85.037500000000009p 7.5330980000000002e-09 85.050000000000011p 6.7189219999999996e-09
+ 85.0625p 5.89808e-09 85.075000000000003p 5.0716549999999999e-09 85.087500000000006p 4.2407340000000001e-09 85.099999999999994p 3.4064079999999998e-09 85.112499999999997p 2.5697699999999999e-09 85.125p 1.731911e-09 85.137499999999989p 8.9392480000000003e-10 85.149999999999991p 5.68998e-11 85.162500000000009p -7.7807830000000004e-10 85.175000000000011p -1.6099289999999999e-09 85.1875p -2.4375789999999999e-09 85.200000000000003p -3.2599630000000001e-09 85.212500000000006p -4.0760250000000001e-09 85.224999999999994p -4.8847179999999998e-09 85.237499999999997p -5.6850110000000003e-09 85.25p -6.4758839999999998e-09 85.262499999999989p -7.2563310000000002e-09 85.274999999999991p -8.0253639999999993e-09
+ 85.287500000000009p -8.7820100000000004e-09 85.300000000000011p -9.5253169999999994e-09 85.3125p -1.0254349999999999e-08 85.325000000000003p -1.09682e-08 85.337500000000006p -1.166597e-08 85.349999999999994p -1.23468e-08 85.362499999999997p -1.3009840000000001e-08 85.375p -1.3654279999999999e-08 85.387500000000003p -1.4279319999999999e-08 85.399999999999991p -1.48842e-08 85.412499999999994p -1.5468180000000001e-08 85.425000000000011p -1.6030559999999998e-08 85.4375p -1.6570650000000001e-08 85.450000000000003p -1.708781e-08 85.462500000000006p -1.7581429999999999e-08 85.474999999999994p -1.8050920000000002e-08 85.487499999999997p -1.8495729999999999e-08 85.5p -1.891535e-08
+ 85.512500000000003p -1.9309290000000001e-08 85.524999999999991p -1.967711e-08 85.537499999999994p -2.001838e-08 85.550000000000011p -2.0332740000000001e-08 85.5625p -2.0619850000000001e-08 85.575000000000003p -2.087939e-08 85.587500000000006p -2.1111099999999998e-08 85.599999999999994p -2.1314749999999999e-08 85.612499999999997p -2.1490150000000001e-08 85.625p -2.1637139999999999e-08 85.637500000000003p -2.1755600000000001e-08 85.649999999999991p -2.1845449999999999e-08 85.662499999999994p -2.190664e-08 85.674999999999997p -2.193917e-08 85.6875p -2.1943069999999999e-08 85.700000000000003p -2.191841e-08 85.712500000000006p -2.1865290000000001e-08 85.725000000000009p -2.178385e-08
+ 85.737499999999997p -2.1674279999999999e-08 85.75p -2.1536779999999999e-08 85.762500000000003p -2.1371619999999999e-08 85.774999999999991p -2.117907e-08 85.787499999999994p -2.095946e-08 85.799999999999997p -2.071314e-08 85.8125p -2.044051e-08 85.825000000000003p -2.0141989999999999e-08 85.837500000000006p -1.9818019999999999e-08 85.850000000000009p -1.9469119999999999e-08 85.862499999999997p -1.909578e-08 85.875p -1.8698569999999999e-08 85.887500000000003p -1.8278049999999999e-08 85.899999999999991p -1.7834859999999999e-08 85.912499999999994p -1.7369610000000001e-08 85.924999999999997p -1.688297e-08 85.9375p -1.6375640000000002e-08 85.950000000000003p -1.584833e-08
+ 85.962500000000006p -1.530179e-08 85.975000000000009p -1.4736769999999999e-08 85.987499999999997p -1.415406e-08 86p -1.3554479999999999e-08 86.012500000000003p -1.293884e-08 86.024999999999991p -1.2308e-08 86.037499999999994p -1.1662810000000001e-08 86.049999999999997p -1.100417e-08 86.0625p -1.0332959999999999e-08 86.075000000000003p -9.6500969999999999e-09 86.087500000000006p -8.9565049999999998e-09 86.100000000000009p -8.2531199999999997e-09 86.112499999999997p -7.5408859999999996e-09 86.125p -6.8207580000000001e-09 86.137500000000003p -6.0937009999999997e-09 86.149999999999991p -5.3606840000000002e-09 86.162499999999994p -4.6226819999999998e-09 86.174999999999997p -3.8806739999999996e-09
+ 86.1875p -3.1356429999999999e-09 86.200000000000003p -2.388572e-09 86.212500000000006p -1.640446e-09 86.225000000000009p -8.9224720000000003e-10 86.237499999999997p -1.4495610000000001e-10 86.25p 6.0045009999999996e-10 86.262500000000003p 1.3429989999999999e-09 86.274999999999991p 2.081726e-09 86.287499999999994p 2.815671e-09 86.299999999999997p 3.543884e-09 86.3125p 4.2654259999999998e-09 86.325000000000003p 4.9793680000000001e-09 86.337500000000006p 5.6847930000000003e-09 86.350000000000009p 6.3807980000000003e-09 86.362499999999997p 7.0664930000000002e-09 86.375p 7.7410070000000002e-09 86.387500000000003p 8.4034829999999993e-09 86.399999999999991p 9.0530819999999997e-09
+ 86.412499999999994p 9.6889860000000004e-09 86.424999999999997p 1.0310399999999999e-08 86.4375p 1.091653e-08 86.450000000000003p 1.1506639999999999e-08 86.462500000000006p 1.207999e-08 86.475000000000009p 1.263586e-08 86.487499999999997p 1.317358e-08 86.5p 1.369248e-08 86.512500000000003p 1.419193e-08 86.525000000000006p 1.467133e-08 86.537499999999994p 1.5130099999999999e-08 86.549999999999997p 1.5567680000000001e-08 86.5625p 1.5983560000000001e-08 86.574999999999989p 1.6377259999999999e-08 86.587500000000006p 1.6748299999999999e-08 86.600000000000009p 1.709626e-08 86.612499999999997p 1.7420740000000001e-08 86.625p 1.7721369999999999e-08
+ 86.637500000000003p 1.7997829999999999e-08 86.650000000000006p 1.824981e-08 86.662499999999994p 1.847705e-08 86.674999999999997p 1.8679300000000001e-08 86.6875p 1.8856379999999999e-08 86.699999999999989p 1.9008099999999999e-08 86.712500000000006p 1.913434e-08 86.725000000000009p 1.9235e-08 86.737499999999997p 1.9310009999999999e-08 86.75p 1.9359340000000001e-08 86.762500000000003p 1.9382989999999999e-08 86.775000000000006p 1.938099e-08 86.787499999999994p 1.935342e-08 86.799999999999997p 1.9300379999999999e-08 86.8125p 1.9222010000000002e-08 86.824999999999989p 1.911847e-08 86.837500000000006p 1.898997e-08 86.850000000000009p 1.8836729999999998e-08
+ 86.862500000000011p 1.8659040000000001e-08 86.875p 1.8457179999999999e-08 86.887500000000003p 1.823148e-08 86.900000000000006p 1.7982300000000001e-08 86.912499999999994p 1.7710040000000001e-08 86.924999999999997p 1.7415109999999999e-08 86.9375p 1.7097969999999999e-08 86.949999999999989p 1.6759070000000001e-08 86.962499999999991p 1.6398940000000001e-08 86.975000000000009p 1.60181e-08 86.987500000000011p 1.5617099999999999e-08 87p 1.5196529999999999e-08 87.012500000000003p 1.475699e-08 87.025000000000006p 1.429912e-08 87.037499999999994p 1.382357e-08 87.049999999999997p 1.3331e-08 87.0625p 1.2822109999999999e-08 87.074999999999989p 1.229763e-08
+ 87.087499999999991p 1.175827e-08 87.100000000000009p 1.1204789999999999e-08 87.112500000000011p 1.0637969999999999e-08 87.125p 1.005857e-08 87.137500000000003p 9.467411e-09 87.150000000000006p 8.8652900000000001e-09 87.162499999999994p 8.2530350000000008e-09 87.174999999999997p 7.6314810000000001e-09 87.1875p 7.0014730000000004e-09 87.199999999999989p 6.3638669999999997e-09 87.212499999999991p 5.7195239999999997e-09 87.224999999999994p 5.0693150000000001e-09 87.237500000000011p 4.414112e-09 87.25p 3.7547970000000002e-09 87.262500000000003p 3.0922509999999999e-09 87.275000000000006p 2.4273589999999999e-09 87.287499999999994p 1.7610060000000001e-09 87.299999999999997p 1.094078e-09
+ 87.3125p 4.2745819999999998e-10 87.325000000000003p -2.379721e-10 87.337499999999991p -9.0133539999999999e-10 87.349999999999994p -1.5617590000000001e-09 87.362500000000011p -2.2183769999999998e-09 87.375p -2.870329e-09 87.387500000000003p -3.5167640000000002e-09 87.400000000000006p -4.1568410000000002e-09 87.412499999999994p -4.7897289999999998e-09 87.424999999999997p -5.4146069999999996e-09 87.4375p -6.0306689999999999e-09 87.450000000000003p -6.6371200000000003e-09 87.462499999999991p -7.2331820000000003e-09 87.474999999999994p -7.8180930000000008e-09 87.487499999999997p -8.3911040000000006e-09 87.5p -8.9514859999999996e-09 87.512500000000003p -9.4985300000000003e-09 87.525000000000006p -1.0031540000000001e-08
+ 87.537499999999994p -1.054985e-08 87.549999999999997p -1.105281e-08 87.5625p -1.153979e-08 87.575000000000003p -1.2010190000000001e-08 87.587499999999991p -1.246341e-08 87.599999999999994p -1.289891e-08 87.612499999999997p -1.331615e-08 87.625p -1.371462e-08 87.637500000000003p -1.4093840000000001e-08 87.650000000000006p -1.4453359999999999e-08 87.662500000000009p -1.479274e-08 87.674999999999997p -1.5111579999999998e-08 87.6875p -1.540952e-08 87.700000000000003p -1.56862e-08 87.712499999999991p -1.594132e-08 87.724999999999994p -1.6174579999999999e-08 87.737499999999997p -1.6385739999999998e-08 87.75p -1.657455e-08
+ 87.762500000000003p -1.674083e-08 87.775000000000006p -1.6884409999999999e-08 87.787500000000009p -1.7005150000000001e-08 87.799999999999997p -1.7102950000000002e-08 87.8125p -1.717774e-08 87.825000000000003p -1.7229449999999999e-08 87.837499999999991p -1.72581e-08 87.849999999999994p -1.7263679999999999e-08 87.862499999999997p -1.7246240000000001e-08 87.875p -1.720587e-08 87.887500000000003p -1.7142670000000001e-08 87.900000000000006p -1.7056780000000001e-08 87.912500000000009p -1.694836e-08 87.924999999999997p -1.681761e-08 87.9375p -1.666476e-08 87.950000000000003p -1.649005e-08 87.962499999999991p -1.629378e-08 87.974999999999994p -1.6076240000000002e-08
+ 87.987499999999997p -1.5837779999999999e-08 88p -1.557877e-08 88.012500000000003p -1.529958e-08 88.025000000000006p -1.5000650000000001e-08 88.037500000000009p -1.4682400000000001e-08 88.049999999999997p -1.43453e-08 88.0625p -1.398985e-08 88.075000000000003p -1.3616560000000001e-08 88.087499999999991p -1.3225959999999999e-08 88.099999999999994p -1.28186e-08 88.112499999999997p -1.239508e-08 88.125p -1.195597e-08 88.137500000000003p -1.150191e-08 88.150000000000006p -1.1033520000000001e-08 88.162500000000009p -1.0551450000000001e-08 88.174999999999997p -1.0056389999999999e-08 88.1875p -9.5490039999999996e-09 88.200000000000003p -9.0300019999999994e-09
+ 88.212499999999991p -8.5000950000000005e-09 88.224999999999994p -7.9600099999999997e-09 88.237499999999997p -7.4104840000000003e-09 88.25p -6.8522669999999998e-09 88.262500000000003p -6.2861180000000004e-09 88.275000000000006p -5.7128029999999997e-09 88.287500000000009p -5.1330989999999997e-09 88.299999999999997p -4.5477879999999998e-09 88.3125p -3.9576579999999999e-09 88.325000000000003p -3.3635010000000001e-09 88.337500000000006p -2.7661130000000002e-09 88.349999999999994p -2.1662930000000001e-09 88.362499999999997p -1.5648430000000001e-09 88.375p -9.6256070000000005e-10 88.387500000000003p -3.6024820000000002e-10 88.400000000000006p 2.4129670000000002e-10 88.412500000000009p 8.4127829999999999e-10 88.424999999999997p 1.438905e-09
+ 88.4375p 2.0333879999999999e-09 88.450000000000003p 2.623948e-09 88.462500000000006p 3.2098100000000001e-09 88.474999999999994p 3.7902059999999998e-09 88.487499999999997p 4.3643799999999998e-09 88.5p 4.9315830000000002e-09 88.512499999999989p 5.4910769999999999e-09 88.525000000000006p 6.0421370000000003e-09 88.537500000000009p 6.5840510000000001e-09 88.549999999999997p 7.1161180000000002e-09 88.5625p 7.6376539999999992e-09 88.575000000000003p 8.1479889999999994e-09 88.587500000000006p 8.6464699999999994e-09 88.599999999999994p 9.1324589999999994e-09 88.612499999999997p 9.6053399999999998e-09 88.625p 1.006451e-08 88.637499999999989p 1.050939e-08 88.650000000000006p 1.0939419999999999e-08
+ 88.662500000000009p 1.135406e-08 88.674999999999997p 1.175279e-08 88.6875p 1.2135109999999999e-08 88.700000000000003p 1.2500559999999999e-08 88.712500000000006p 1.284867e-08 88.724999999999994p 1.317902e-08 88.737499999999997p 1.349122e-08 88.75p 1.378488e-08 88.762499999999989p 1.4059650000000001e-08 88.774999999999991p 1.43152e-08 88.787500000000009p 1.4551239999999999e-08 88.800000000000011p 1.476748e-08 88.8125p 1.4963680000000001e-08 88.825000000000003p 1.513963e-08 88.837500000000006p 1.5295120000000001e-08 88.849999999999994p 1.542998e-08 88.862499999999997p 1.5544089999999999e-08 88.875p 1.5637339999999999e-08
+ 88.887499999999989p 1.5709620000000001e-08 88.899999999999991p 1.5760899999999999e-08 88.912500000000009p 1.5791140000000001e-08 88.925000000000011p 1.5800350000000002e-08 88.9375p 1.5788549999999999e-08 88.950000000000003p 1.5755790000000001e-08 88.962500000000006p 1.5702169999999999e-08 88.974999999999994p 1.5627789999999999e-08 88.987499999999997p 1.553279e-08 89p 1.5417330000000001e-08 89.012499999999989p 1.5281609999999999e-08 89.024999999999991p 1.5125840000000001e-08 89.037500000000009p 1.4950259999999998e-08 89.050000000000011p 1.475515e-08 89.0625p 1.454081e-08 89.075000000000003p 1.430754e-08 89.087500000000006p 1.4055700000000001e-08 89.099999999999994p 1.3785649999999999e-08
+ 89.112499999999997p 1.3497780000000001e-08 89.125p 1.319251e-08 89.137500000000003p 1.287027e-08 89.149999999999991p 1.253152e-08 89.162499999999994p 1.217674e-08 89.175000000000011p 1.180642e-08 89.1875p 1.1421090000000001e-08 89.200000000000003p 1.102127e-08 89.212500000000006p 1.060754e-08 89.224999999999994p 1.018045e-08 89.237499999999997p 9.740592e-09 89.25p 9.2885789999999995e-09 89.262500000000003p 8.8250249999999993e-09 89.274999999999991p 8.3505639999999998e-09 89.287499999999994p 7.8658409999999997e-09 89.300000000000011p 7.3715160000000002e-09 89.3125p 6.8682580000000002e-09 89.325000000000003p 6.3567480000000002e-09
+ 89.337500000000006p 5.8376749999999997e-09 89.349999999999994p 5.3117379999999999e-09 89.362499999999997p 4.7796449999999998e-09 89.375p 4.2421059999999999e-09 89.387500000000003p 3.699843e-09 89.399999999999991p 3.1535770000000001e-09 89.412499999999994p 2.6040369999999999e-09 89.424999999999997p 2.0519529999999999e-09 89.4375p 1.498057e-09 89.450000000000003p 9.430835000000001e-10 89.462500000000006p 3.8776520000000002e-10 89.475000000000009p -1.6716549999999999e-10 89.487499999999997p -7.2097789999999998e-10 89.5p -1.272944e-09 89.512500000000003p -1.822341e-09 89.524999999999991p -2.36845e-09 89.537499999999994p -2.9105559999999999e-09 89.549999999999997p -3.4479539999999999e-09
+ 89.5625p -3.9799440000000003e-09 89.575000000000003p -4.5058350000000003e-09 89.587500000000006p -5.0249459999999997e-09 89.600000000000009p -5.5366069999999998e-09 89.612499999999997p -6.0401570000000002e-09 89.625p -6.5349480000000003e-09 89.637500000000003p -7.0203439999999998e-09 89.649999999999991p -7.4957239999999995e-09 89.662499999999994p -7.9604809999999993e-09 89.674999999999997p -8.4140230000000008e-09 89.6875p -8.8557720000000001e-09 89.700000000000003p -9.2851689999999994e-09 89.712500000000006p -9.7016719999999995e-09 89.725000000000009p -1.010476e-08 89.737499999999997p -1.0493920000000001e-08 89.75p -1.086866e-08 89.762500000000003p -1.122853e-08 89.774999999999991p -1.1573079999999999e-08
+ 89.787499999999994p -1.1901879999999999e-08 89.799999999999997p -1.221452e-08 89.8125p -1.251062e-08 89.825000000000003p -1.2789839999999999e-08 89.837500000000006p -1.3051820000000001e-08 89.850000000000009p -1.3296250000000001e-08 89.862499999999997p -1.352286e-08 89.875p -1.373136e-08 89.887500000000003p -1.392152e-08 89.899999999999991p -1.4093119999999999e-08 89.912499999999994p -1.4245969999999999e-08 89.924999999999997p -1.437991e-08 89.9375p -1.4494779999999999e-08 89.950000000000003p -1.459047e-08 89.962500000000006p -1.4666899999999999e-08 89.975000000000009p -1.4724e-08 89.987499999999997p -1.476172e-08 90p -1.478004e-08
+ 90.012500000000003p -1.477899e-08 90.024999999999991p -1.47586e-08 90.037499999999994p -1.471892e-08 90.049999999999997p -1.466004e-08 90.0625p -1.458208e-08 90.075000000000003p -1.448517e-08 90.087500000000006p -1.436947e-08 90.100000000000009p -1.4235159999999999e-08 90.112499999999997p -1.4082459999999999e-08 90.125p -1.3911600000000001e-08 90.137500000000003p -1.372282e-08 90.149999999999991p -1.351642e-08 90.162499999999994p -1.3292690000000001e-08 90.174999999999997p -1.3051950000000001e-08 90.1875p -1.279455e-08 90.200000000000003p -1.252086e-08 90.212500000000006p -1.2231260000000001e-08 90.225000000000009p -1.192616e-08
+ 90.237499999999997p -1.160599e-08 90.25p -1.127118e-08 90.262500000000003p -1.0922209999999999e-08 90.275000000000006p -1.055956e-08 90.287499999999994p -1.0183710000000001e-08 90.299999999999997p -9.7951989999999999e-09 90.3125p -9.394541e-09 90.324999999999989p -8.9822840000000002e-09 90.337500000000006p -8.5589869999999999e-09 90.350000000000009p -8.1252219999999996e-09 90.362499999999997p -7.6815740000000004e-09 90.375p -7.2286389999999997e-09 90.387500000000003p -6.767025e-09 90.400000000000006p -6.29735e-09 90.412499999999994p -5.8202390000000003e-09 90.424999999999997p -5.3363299999999999e-09 90.4375p -4.8462630000000003e-09 90.449999999999989p -4.3506910000000003e-09
+ 90.462500000000006p -3.850268e-09 90.475000000000009p -3.345654e-09 90.487499999999997p -2.8375159999999999e-09 90.5p -2.3265220000000002e-09 90.512500000000003p -1.8133420000000001e-09 90.525000000000006p -1.298648e-09 90.537499999999994p -7.8311449999999998e-10 90.549999999999997p -2.6741310000000002e-10 90.5625p 2.4778430000000002e-10 90.574999999999989p 7.6180769999999997e-10 90.587500000000006p 1.2739900000000001e-09 90.600000000000009p 1.783669e-09 90.612500000000011p 2.290185e-09 90.625p 2.7928849999999999e-09 90.637500000000003p 3.2911219999999999e-09 90.650000000000006p 3.7842570000000002e-09 90.662499999999994p 4.2716559999999997e-09 90.674999999999997p 4.7526969999999998e-09
+ 90.6875p 5.2267660000000001e-09 90.699999999999989p 5.6932600000000003e-09 90.712499999999991p 6.1515850000000003e-09 90.725000000000009p 6.6011620000000002e-09 90.737500000000011p 7.0414219999999997e-09 90.75p 7.4718099999999997e-09 90.762500000000003p 7.8917849999999998e-09 90.775000000000006p 8.3008220000000005e-09 90.787499999999994p 8.6984080000000006e-09 90.799999999999997p 9.0840489999999996e-09 90.8125p 9.4572660000000003e-09 90.824999999999989p 9.8175969999999996e-09 90.837499999999991p 1.01646e-08 90.850000000000009p 1.0497849999999999e-08 90.862500000000011p 1.0816929999999999e-08 90.875p 1.112147e-08 90.887500000000003p 1.1411089999999999e-08 90.900000000000006p 1.168545e-08
+ 90.912499999999994p 1.194421e-08 90.924999999999997p 1.2187079999999999e-08 90.9375p 1.2413760000000001e-08 90.950000000000003p 1.262399e-08 90.962499999999991p 1.281754e-08 90.974999999999994p 1.299418e-08 90.987500000000011p 1.315372e-08 91p 1.3295980000000001e-08 91.012500000000003p 1.3420810000000001e-08 91.025000000000006p 1.3528089999999999e-08 91.037499999999994p 1.36177e-08 91.049999999999997p 1.3689559999999999e-08 91.0625p 1.374363e-08 91.075000000000003p 1.377985e-08 91.087499999999991p 1.379822e-08 91.099999999999994p 1.379876e-08 91.112500000000011p 1.378148e-08 91.125p 1.3746460000000001e-08
+ 91.137500000000003p 1.369377e-08 91.150000000000006p 1.3623509999999999e-08 91.162499999999994p 1.353582e-08 91.174999999999997p 1.343083e-08 91.1875p 1.330872e-08 91.200000000000003p 1.316968e-08 91.212499999999991p 1.3013919999999999e-08 91.224999999999994p 1.2841680000000001e-08 91.237499999999997p 1.265322e-08 91.25p 1.244881e-08 91.262500000000003p 1.222875e-08 91.275000000000006p 1.1993349999999999e-08 91.287499999999994p 1.174296e-08 91.299999999999997p 1.147791e-08 91.3125p 1.11986e-08 91.325000000000003p 1.0905400000000001e-08 91.337499999999991p 1.0598729999999999e-08 91.349999999999994p 1.027901e-08
+ 91.362499999999997p 9.9466750000000003e-09 91.375p 9.6021889999999996e-09 91.387500000000003p 9.2460210000000006e-09 91.400000000000006p 8.8786550000000005e-09 91.412500000000009p 8.5005890000000008e-09 91.424999999999997p 8.1123349999999994e-09 91.4375p 7.7144150000000004e-09 91.450000000000003p 7.3073659999999997e-09 91.462499999999991p 6.8917320000000004e-09 91.474999999999994p 6.4680690000000001e-09 91.487499999999997p 6.0369429999999998e-09 91.5p 5.5989250000000003e-09 91.512500000000003p 5.1545979999999997e-09 91.525000000000006p 4.7045489999999999e-09 91.537500000000009p 4.249372e-09 91.549999999999997p 3.7896670000000001e-09 91.5625p 3.3260389999999999e-09 91.575000000000003p 2.8590939999999999e-09
+ 91.587499999999991p 2.389444e-09 91.599999999999994p 1.9177029999999998e-09 91.612499999999997p 1.4444830000000001e-09 91.625p 9.7040180000000004e-10 91.637500000000003p 4.9607269999999996e-10 91.650000000000006p 2.2109849999999999e-11 91.662500000000009p -4.5087459999999998e-10 91.674999999999997p -9.2227129999999996e-10 91.6875p -1.391474e-09 91.700000000000003p -1.8578809999999999e-09 91.712499999999991p -2.3208960000000001e-09 91.724999999999994p -2.7799269999999998e-09 91.737499999999997p -3.2343890000000001e-09 91.75p -3.6837049999999999e-09 91.762500000000003p -4.1273060000000003e-09 91.775000000000006p -4.5646300000000002e-09 91.787500000000009p -4.9951259999999999e-09 91.799999999999997p -5.4182529999999997e-09
+ 91.8125p -5.83348e-09 91.825000000000003p -6.2402879999999999e-09 91.837499999999991p -6.63817e-09 91.849999999999994p -7.0266309999999997e-09 91.862499999999997p -7.4051900000000002e-09 91.875p -7.7733799999999999e-09 91.887500000000003p -8.1307489999999995e-09 91.900000000000006p -8.4768590000000001e-09 91.912500000000009p -8.8112870000000008e-09 91.924999999999997p -9.1336290000000001e-09 91.9375p -9.4434949999999996e-09 91.950000000000003p -9.7405119999999993e-09 91.962499999999991p -1.002433e-08 91.974999999999994p -1.02946e-08 91.987499999999997p -1.0551019999999999e-08 92p -1.0793279999999999e-08 92.012500000000003p -1.10211e-08 92.025000000000006p -1.1234220000000001e-08
+ 92.037500000000009p -1.14324e-08 92.049999999999997p -1.161541e-08 92.0625p -1.178307e-08 92.075000000000003p -1.193517e-08 92.087500000000006p -1.2071580000000001e-08 92.099999999999994p -1.2192129999999999e-08 92.112499999999997p -1.2296719999999999e-08 92.125p -1.238526e-08 92.137500000000003p -1.2457650000000001e-08 92.150000000000006p -1.2513840000000001e-08 92.162500000000009p -1.255381e-08 92.174999999999997p -1.2577540000000001e-08 92.1875p -1.258503e-08 92.200000000000003p -1.2576320000000001e-08 92.212500000000006p -1.2551450000000001e-08 92.224999999999994p -1.25105e-08 92.237499999999997p -1.2453550000000001e-08 92.25p -1.238072e-08
+ 92.262499999999989p -1.229215e-08 92.275000000000006p -1.218797e-08 92.287500000000009p -1.206838e-08 92.299999999999997p -1.193355e-08 92.3125p -1.17837e-08 92.325000000000003p -1.1619060000000001e-08 92.337500000000006p -1.143987e-08 92.349999999999994p -1.124642e-08 92.362499999999997p -1.1038970000000001e-08 92.375p -1.081784e-08 92.387499999999989p -1.058334e-08 92.400000000000006p -1.033581e-08 92.412500000000009p -1.00756e-08 92.424999999999997p -9.8030799999999992e-09 92.4375p -9.5186350000000002e-09 92.450000000000003p -9.2226600000000001e-09 92.462500000000006p -8.9155679999999998e-09 92.474999999999994p -8.5977839999999993e-09
+ 92.487499999999997p -8.2697460000000007e-09 92.5p -7.9319040000000003e-09 92.512499999999989p -7.5847199999999998e-09 92.524999999999991p -7.2286679999999998e-09 92.537500000000009p -6.86423e-09 92.550000000000011p -6.4919010000000002e-09 92.5625p -6.1121810000000002e-09 92.575000000000003p -5.7255820000000002e-09 92.587500000000006p -5.332622e-09 92.599999999999994p -4.9338259999999997e-09 92.612499999999997p -4.5297249999999999e-09 92.625p -4.1208580000000004e-09 92.637499999999989p -3.7077659999999999e-09 92.649999999999991p -3.290995e-09 92.662500000000009p -2.8710950000000002e-09 92.675000000000011p -2.4486179999999999e-09 92.6875p -2.0241189999999999e-09 92.700000000000003p -1.598153e-09
+ 92.712500000000006p -1.171277e-09 92.724999999999994p -7.4404629999999999e-10 92.737499999999997p -3.1701619999999999e-10 92.75p 1.0925979999999999e-10 92.762499999999989p 5.3423079999999997e-10 92.774999999999991p 9.5734859999999998e-10 92.787499999999994p 1.3780690000000001e-09 92.800000000000011p 1.795852e-09 92.8125p 2.2101640000000002e-09 92.825000000000003p 2.6204750000000001e-09 92.837500000000006p 3.026263e-09 92.849999999999994p 3.4270140000000002e-09 92.862499999999997p 3.8222200000000001e-09 92.875p 4.2113819999999998e-09 92.887500000000003p 4.5940109999999998e-09 92.899999999999991p 4.9696279999999997e-09 92.912499999999994p 5.3377619999999998e-09 92.925000000000011p 5.6979549999999997e-09
+ 92.9375p 6.04976e-09 92.950000000000003p 6.3927429999999997e-09 92.962500000000006p 6.7264800000000001e-09 92.974999999999994p 7.0505630000000002e-09 92.987499999999997p 7.3645960000000004e-09 93p 7.6681979999999998e-09 93.012500000000003p 7.9610009999999996e-09 93.024999999999991p 8.242653e-09 93.037499999999994p 8.5128190000000001e-09 93.050000000000011p 8.7711769999999998e-09 93.0625p 9.0174229999999998e-09 93.075000000000003p 9.2512699999999996e-09 93.087500000000006p 9.472445e-09 93.099999999999994p 9.6806959999999998e-09 93.112499999999997p 9.8757870000000002e-09 93.125p 1.0057499999999999e-08 93.137500000000003p 1.022563e-08 93.149999999999991p 1.0379999999999999e-08
+ 93.162499999999994p 1.0520440000000001e-08 93.174999999999997p 1.064682e-08 93.1875p 1.0759000000000001e-08 93.200000000000003p 1.0856870000000001e-08 93.212500000000006p 1.094035e-08 93.225000000000009p 1.100936e-08 93.237499999999997p 1.1063870000000001e-08 93.25p 1.110383e-08 93.262500000000003p 1.112923e-08 93.274999999999991p 1.114008e-08 93.287499999999994p 1.113641e-08 93.299999999999997p 1.1118259999999999e-08 93.3125p 1.108569e-08 93.325000000000003p 1.103879e-08 93.337500000000006p 1.097766e-08 93.350000000000009p 1.0902410000000001e-08 93.362499999999997p 1.081318e-08 93.375p 1.071013e-08
+ 93.387500000000003p 1.0593430000000001e-08 93.399999999999991p 1.0463270000000001e-08 93.412499999999994p 1.0319860000000001e-08 93.424999999999997p 1.016342e-08 93.4375p 9.9941949999999993e-09 93.450000000000003p 9.8124370000000008e-09 93.462500000000006p 9.6184200000000004e-09 93.475000000000009p 9.4124310000000003e-09 93.487499999999997p 9.1947739999999997e-09 93.5p 8.9657650000000002e-09 93.512500000000003p 8.7257360000000001e-09 93.524999999999991p 8.4750299999999994e-09 93.537499999999994p 8.2140049999999999e-09 93.549999999999997p 7.9430320000000007e-09 93.5625p 7.6624929999999994e-09 93.575000000000003p 7.3727809999999998e-09 93.587500000000006p 7.0743019999999997e-09 93.600000000000009p 6.7674700000000004e-09
+ 93.612499999999997p 6.4527109999999996e-09 93.625p 6.130459e-09 93.637500000000003p 5.8011569999999997e-09 93.649999999999991p 5.4652549999999999e-09 93.662499999999994p 5.1232129999999999e-09 93.674999999999997p 4.7754950000000004e-09 93.6875p 4.4225729999999997e-09 93.700000000000003p 4.0649240000000001e-09 93.712500000000006p 3.7030310000000001e-09 93.725000000000009p 3.3373780000000001e-09 93.737499999999997p 2.9684580000000001e-09 93.75p 2.5967609999999999e-09 93.762500000000003p 2.2227840000000001e-09 93.774999999999991p 1.847023e-09 93.787499999999994p 1.469977e-09 93.799999999999997p 1.0921439999999999e-09 93.8125p 7.1402170000000001e-10 93.825000000000003p 3.3610719999999998e-10
+ 93.837500000000006p -4.1103890000000002e-11 93.850000000000009p -4.171182e-10 93.862499999999997p -7.9144539999999997e-10 93.875p -1.1635990000000001e-09 93.887500000000003p -1.5330950000000001e-09 93.899999999999991p -1.8994559999999999e-09 93.912499999999994p -2.2622110000000001e-09 93.924999999999997p -2.6208909999999999e-09 93.9375p -2.975037e-09 93.950000000000003p -3.3241960000000001e-09 93.962500000000006p -3.6679239999999999e-09 93.975000000000009p -4.0057819999999996e-09 93.987499999999997p -4.3373439999999999e-09 94p -4.66219e-09 94.012500000000003p -4.9799130000000002e-09 94.025000000000006p -5.2901130000000002e-09 94.037499999999994p -5.5924049999999998e-09 94.049999999999997p -5.8864110000000001e-09
+ 94.0625p -6.171767e-09 94.074999999999989p -6.4481239999999999e-09 94.087500000000006p -6.71514e-09 94.100000000000009p -6.9724909999999997e-09 94.112499999999997p -7.2198650000000003e-09 94.125p -7.4569640000000003e-09 94.137500000000003p -7.6835019999999996e-09 94.150000000000006p -7.8992130000000002e-09 94.162499999999994p -8.1038399999999996e-09 94.174999999999997p -8.2971439999999994e-09 94.1875p -8.4789040000000002e-09 94.199999999999989p -8.6489099999999997e-09 94.212500000000006p -8.8069699999999994e-09 94.225000000000009p -8.9529100000000003e-09 94.237499999999997p -9.0865700000000008e-09 94.25p -9.2078080000000005e-09 94.262500000000003p -9.3164970000000001e-09 94.275000000000006p -9.4125290000000001e-09
+ 94.287499999999994p -9.4958120000000008e-09 94.299999999999997p -9.5662709999999998e-09 94.3125p -9.6238469999999999e-09 94.324999999999989p -9.6685010000000002e-09 94.337500000000006p -9.7002079999999993e-09 94.350000000000009p -9.718961e-09 94.362500000000011p -9.7247719999999995e-09 94.375p -9.7176679999999998e-09 94.387500000000003p -9.697693e-09 94.400000000000006p -9.664909e-09 94.412499999999994p -9.6193939999999998e-09 94.424999999999997p -9.5612419999999998e-09 94.4375p -9.4905650000000007e-09 94.449999999999989p -9.4074889999999998e-09 94.462499999999991p -9.3121590000000003e-09 94.475000000000009p -9.2047329999999996e-09 94.487500000000011p -9.0853860000000006e-09 94.5p -8.9543070000000006e-09
+ 94.512500000000003p -8.8117029999999994e-09 94.525000000000006p -8.6577910000000001e-09 94.537499999999994p -8.492807e-09 94.549999999999997p -8.3169990000000006e-09 94.5625p -8.1306270000000004e-09 94.574999999999989p -7.9339679999999998e-09 94.587499999999991p -7.7273079999999992e-09 94.600000000000009p -7.5109490000000005e-09 94.612500000000011p -7.2852020000000003e-09 94.625p -7.050391e-09 94.637500000000003p -6.8068520000000001e-09 94.650000000000006p -6.5549299999999998e-09 94.662499999999994p -6.2949820000000003e-09 94.674999999999997p -6.0273720000000003e-09 94.6875p -5.7524769999999998e-09 94.700000000000003p -5.4706790000000001e-09 94.712499999999991p -5.1823709999999997e-09 94.724999999999994p -4.8879520000000001e-09
+ 94.737500000000011p -4.5878290000000004e-09 94.75p -4.2824140000000003e-09 94.762500000000003p -3.9721260000000004e-09 94.775000000000006p -3.6573909999999998e-09 94.787499999999994p -3.3386359999999999e-09 94.799999999999997p -3.0162969999999999e-09 94.8125p -2.6908100000000001e-09 94.825000000000003p -2.3626149999999999e-09 94.837499999999991p -2.0321560000000001e-09 94.849999999999994p -1.699877e-09 94.862500000000011p -1.3662240000000001e-09 94.875p -1.0316430000000001e-09 94.887500000000003p -6.9658310000000004e-10 94.900000000000006p -3.6148920000000001e-10 94.912499999999994p -2.6807260000000001e-11 94.924999999999997p 3.070189e-10 94.9375p 6.3954770000000002e-10 94.950000000000003p 9.7034010000000001e-10
+ 94.962499999999991p 1.2989609999999999e-09 94.974999999999994p 1.6249780000000001e-09 94.987499999999997p 1.947964e-09 95p 2.2674980000000001e-09 95.012500000000003p 2.5831619999999998e-09 95.025000000000006p 2.894547e-09 95.037499999999994p 3.2012480000000001e-09 95.049999999999997p 3.5028699999999999e-09 95.0625p 3.7990220000000002e-09 95.075000000000003p 4.0893240000000001e-09 95.087499999999991p 4.3734040000000003e-09 95.099999999999994p 4.6509000000000001e-09 95.112499999999997p 4.9214559999999996e-09 95.125p 5.1847310000000001e-09 95.137500000000003p 5.4403920000000003e-09 95.150000000000006p 5.6881149999999996e-09 95.162500000000009p 5.9275900000000002e-09 95.174999999999997p 6.1585189999999996e-09
+ 95.1875p 6.3806130000000001e-09 95.200000000000003p 6.5935989999999997e-09 95.212499999999991p 6.7972129999999997e-09 95.224999999999994p 6.9912079999999997e-09 95.237499999999997p 7.1753470000000003e-09 95.25p 7.3494089999999998e-09 95.262500000000003p 7.5131839999999999e-09 95.275000000000006p 7.6664799999999998e-09 95.287500000000009p 7.8091159999999996e-09 95.299999999999997p 7.9409269999999997e-09 95.3125p 8.0617630000000002e-09 95.325000000000003p 8.1714879999999992e-09 95.337499999999991p 8.2699809999999995e-09 95.349999999999994p 8.3571379999999993e-09 95.362499999999997p 8.4328679999999994e-09 95.375p 8.4970969999999994e-09 95.387500000000003p 8.549765e-09 95.400000000000006p 8.5908290000000007e-09
+ 95.412500000000009p 8.6202600000000006e-09 95.424999999999997p 8.6380460000000008e-09 95.4375p 8.6441890000000002e-09 95.450000000000003p 8.638708e-09 95.462499999999991p 8.6216350000000005e-09 95.474999999999994p 8.5930209999999997e-09 95.487499999999997p 8.5529289999999994e-09 95.5p 8.5014380000000001e-09 95.512500000000003p 8.4386420000000004e-09 95.525000000000006p 8.3646500000000001e-09 95.537500000000009p 8.2795860000000007e-09 95.549999999999997p 8.1835890000000004e-09 95.5625p 8.0768090000000005e-09 95.575000000000003p 7.9594129999999996e-09 95.587499999999991p 7.8315819999999994e-09 95.599999999999994p 7.6935069999999993e-09 95.612499999999997p 7.5453969999999999e-09 95.625p 7.3874709999999998e-09
+ 95.637500000000003p 7.21996e-09 95.650000000000006p 7.0431080000000003e-09 95.662500000000009p 6.857172e-09 95.674999999999997p 6.6624200000000002e-09 95.6875p 6.4591289999999999e-09 95.700000000000003p 6.2475899999999999e-09 95.712499999999991p 6.0281019999999997e-09 95.724999999999994p 5.8009740000000001e-09 95.737499999999997p 5.5665270000000001e-09 95.75p 5.3250879999999996e-09 95.762500000000003p 5.0769940000000003e-09 95.775000000000006p 4.8225900000000004e-09 95.787500000000009p 4.5622279999999996e-09 95.799999999999997p 4.2962680000000003e-09 95.8125p 4.0250770000000002e-09 95.825000000000003p 3.7490260000000002e-09 95.837500000000006p 3.4684939999999999e-09 95.849999999999994p 3.1838650000000002e-09
+ 95.862499999999997p 2.8955260000000002e-09 95.875p 2.60387e-09 95.887500000000003p 2.3092919999999998e-09 95.900000000000006p 2.0121899999999999e-09 95.912500000000009p 1.7129660000000001e-09 95.924999999999997p 1.4120240000000001e-09 95.9375p 1.1097670000000001e-09 95.950000000000003p 8.0660089999999996e-10 95.962500000000006p 5.0293239999999998e-10 95.974999999999994p 1.991666e-10 95.987499999999997p -1.042913e-10 96p -4.0703770000000001e-10 96.012499999999989p -7.0867059999999998e-10 96.025000000000006p -1.00879e-09 96.037500000000009p -1.3069999999999999e-09 96.049999999999997p -1.602906e-09 96.0625p -1.8961199999999999e-09 96.075000000000003p -2.186254e-09
+ 96.087500000000006p -2.472931e-09 96.099999999999994p -2.755773e-09 96.112499999999997p -3.0344119999999999e-09 96.125p -3.308486e-09 96.137499999999989p -3.5776379999999998e-09 96.150000000000006p -3.8415199999999998e-09 96.162500000000009p -4.0997890000000001e-09 96.174999999999997p -4.3521139999999998e-09 96.1875p -4.5981699999999996e-09 96.200000000000003p -4.8376409999999998e-09 96.212500000000006p -5.0702210000000002e-09 96.224999999999994p -5.2956140000000001e-09 96.237499999999997p -5.5135340000000001e-09 96.25p -5.7237039999999996e-09 96.262499999999989p -5.925861e-09 96.274999999999991p -6.1197489999999998e-09 96.287500000000009p -6.305127e-09 96.300000000000011p -6.4817630000000003e-09
+ 96.3125p -6.6494400000000001e-09 96.325000000000003p -6.8079509999999997e-09 96.337500000000006p -6.9571020000000001e-09 96.349999999999994p -7.0967119999999998e-09 96.362499999999997p -7.2266140000000002e-09 96.375p -7.346651e-09 96.387499999999989p -7.4566840000000004e-09 96.399999999999991p -7.5565830000000005e-09 96.412500000000009p -7.6462349999999999e-09 96.425000000000011p -7.7255389999999995e-09 96.4375p -7.7944079999999995e-09 96.450000000000003p -7.8527690000000001e-09 96.462500000000006p -7.9005640000000007e-09 96.474999999999994p -7.9377490000000007e-09 96.487499999999997p -7.9642930000000001e-09 96.5p -7.9801790000000001e-09 96.512499999999989p -7.9854050000000001e-09 96.524999999999991p -7.9799830000000005e-09
+ 96.537499999999994p -7.9639400000000001e-09 96.550000000000011p -7.9373139999999994e-09 96.5625p -7.9001599999999993e-09 96.575000000000003p -7.8525449999999998e-09 96.587500000000006p -7.7945510000000005e-09 96.599999999999994p -7.7262730000000002e-09 96.612499999999997p -7.6478169999999996e-09 96.625p -7.5593070000000003e-09 96.637500000000003p -7.4608770000000003e-09 96.649999999999991p -7.352674e-09 96.662499999999994p -7.2348569999999998e-09 96.675000000000011p -7.1075999999999997e-09 96.6875p -6.9710869999999996e-09 96.700000000000003p -6.8255129999999997e-09 96.712500000000006p -6.6710879999999997e-09 96.724999999999994p -6.5080299999999999e-09 96.737499999999997p -6.3365700000000002e-09 96.75p -6.1569480000000001e-09
+ 96.762500000000003p -5.9694150000000003e-09 96.774999999999991p -5.7742329999999999e-09 96.787499999999994p -5.5716730000000002e-09 96.800000000000011p -5.3620130000000003e-09 96.8125p -5.1455439999999996e-09 96.825000000000003p -4.9225619999999998e-09 96.837500000000006p -4.693373e-09 96.849999999999994p -4.4582889999999996e-09 96.862499999999997p -4.2176299999999996e-09 96.875p -3.9717239999999996e-09 96.887500000000003p -3.720903e-09 96.899999999999991p -3.4655069999999998e-09 96.912499999999994p -3.2058800000000001e-09 96.924999999999997p -2.94237e-09 96.9375p -2.6753329999999998e-09 96.950000000000003p -2.405125e-09 96.962500000000006p -2.1321090000000001e-09 96.975000000000009p -1.856648e-09
+ 96.987499999999997p -1.579109e-09 97p -1.2998619999999999e-09 97.012500000000003p -1.0192770000000001e-09 97.024999999999991p -7.3772530000000005e-10 97.037499999999994p -4.5557979999999998e-10 97.049999999999997p -1.7321250000000001e-10 97.0625p 1.0900440000000001e-10 97.075000000000003p 3.9069990000000003e-10 97.087500000000006p 6.7150409999999997e-10 97.100000000000009p 9.5104900000000003e-10 97.112499999999997p 1.228969e-09 97.125p 1.504901e-09 97.137500000000003p 1.7784860000000001e-09 97.149999999999991p 2.0493680000000001e-09 97.162499999999994p 2.3171949999999999e-09 97.174999999999997p 2.58162e-09 97.1875p 2.8423009999999999e-09 97.200000000000003p 3.098901e-09
+ 97.212500000000006p 3.3510910000000002e-09 97.225000000000009p 3.5985449999999998e-09 97.237499999999997p 3.8409469999999999e-09 97.25p 4.0779859999999999e-09 97.262500000000003p 4.3093599999999997e-09 97.274999999999991p 4.534775e-09 97.287499999999994p 4.7539429999999999e-09 97.299999999999997p 4.9665880000000001e-09 97.3125p 5.1724400000000004e-09 97.325000000000003p 5.3712409999999997e-09 97.337500000000006p 5.5627410000000001e-09 97.350000000000009p 5.7467009999999999e-09 97.362499999999997p 5.9228910000000003e-09 97.375p 6.0910939999999999e-09 97.387500000000003p 6.2510999999999996e-09 97.399999999999991p 6.4027140000000001e-09 97.412499999999994p 6.5457500000000001e-09 97.424999999999997p 6.6800349999999997e-09
+ 97.4375p 6.8054059999999999e-09 97.450000000000003p 6.9217139999999997e-09 97.462500000000006p 7.0288200000000001e-09 97.475000000000009p 7.1265990000000003e-09 97.487499999999997p 7.2149379999999997e-09 97.5p 7.2937360000000001e-09 97.512500000000003p 7.3629049999999998e-09 97.524999999999991p 7.4223699999999999e-09 97.537499999999994p 7.4720679999999992e-09 97.549999999999997p 7.5119510000000006e-09 97.5625p 7.5419799999999992e-09 97.575000000000003p 7.5621329999999995e-09 97.587500000000006p 7.5724e-09 97.600000000000009p 7.5727810000000007e-09 97.612499999999997p 7.5632920000000001e-09 97.625p 7.5439620000000007e-09 97.637500000000003p 7.5148310000000005e-09 97.649999999999991p 7.4759519999999998e-09
+ 97.662499999999994p 7.4273920000000002e-09 97.674999999999997p 7.3692300000000002e-09 97.6875p 7.3015559999999997e-09 97.700000000000003p 7.2244739999999996e-09 97.712500000000006p 7.1381000000000004e-09 97.725000000000009p 7.0425600000000001e-09 97.737499999999997p 6.9379940000000004e-09 97.75p 6.8245529999999997e-09 97.762500000000003p 6.702399e-09 97.775000000000006p 6.571704e-09 97.787499999999994p 6.4326520000000003e-09 97.799999999999997p 6.2854389999999998e-09 97.8125p 6.1302680000000004e-09 97.824999999999989p 5.9673549999999996e-09 97.837500000000006p 5.796923e-09 97.850000000000009p 5.6192079999999999e-09 97.862499999999997p 5.4344509999999999e-09 97.875p 5.2429040000000002e-09
+ 97.887500000000003p 5.0448289999999999e-09 97.900000000000006p 4.8404920000000003e-09 97.912499999999994p 4.630169e-09 97.924999999999997p 4.4141440000000003e-09 97.9375p 4.192707e-09 97.949999999999989p 3.966154e-09 97.962500000000006p 3.7347880000000003e-09 97.975000000000009p 3.4989179999999999e-09 97.987499999999997p 3.258856e-09 98p 3.014922e-09 98.012500000000003p 2.7674389999999998e-09 98.025000000000006p 2.5167339999999999e-09 98.037499999999994p 2.263137e-09 98.049999999999997p 2.0069830000000002e-09 98.0625p 1.7486070000000001e-09 98.074999999999989p 1.488349e-09 98.087500000000006p 1.2265500000000001e-09 98.100000000000009p 9.635518e-10
+ 98.112500000000011p 6.9969669999999995e-10 98.125p 4.3532869999999998e-10 98.137500000000003p 1.707911e-10 98.150000000000006p -9.357281e-11 98.162499999999994p -3.5742090000000002e-10 98.174999999999997p -6.2041230000000004e-10 98.1875p -8.8220769999999999e-10 98.199999999999989p -1.1424700000000001e-09 98.212499999999991p -1.400865e-09 98.225000000000009p -1.6570620000000001e-09 98.237500000000011p -1.9107319999999999e-09 98.25p -2.1615520000000001e-09 98.262500000000003p -2.4092009999999998e-09 98.275000000000006p -2.6533659999999999e-09 98.287499999999994p -2.8937359999999999e-09 98.299999999999997p -3.1300069999999999e-09 98.3125p -3.36188e-09 98.324999999999989p -3.589064e-09
+ 98.337499999999991p -3.811272e-09 98.350000000000009p -4.0282270000000001e-09 98.362500000000011p -4.2396579999999996e-09 98.375p -4.4452999999999999e-09 98.387500000000003p -4.6448989999999996e-09 98.400000000000006p -4.8382069999999999e-09 98.412499999999994p -5.024986e-09 98.424999999999997p -5.2050060000000004e-09 98.4375p -5.3780470000000003e-09 98.450000000000003p -5.5438989999999999e-09 98.462499999999991p -5.7023600000000001e-09 98.474999999999994p -5.8532380000000001e-09 98.487500000000011p -5.9963539999999999e-09 98.5p -6.1315360000000001e-09 98.512500000000003p -6.2586250000000004e-09 98.525000000000006p -6.3774719999999997e-09 98.537499999999994p -6.4879369999999997e-09 98.549999999999997p -6.5898959999999997e-09
+ 98.5625p -6.6832310000000002e-09 98.575000000000003p -6.7678380000000003e-09 98.587499999999991p -6.8436250000000003e-09 98.599999999999994p -6.9105110000000003e-09 98.612500000000011p -6.9684260000000001e-09 98.625p -7.0173120000000003e-09 98.637500000000003p -7.0571230000000003e-09 98.650000000000006p -7.0878260000000003e-09 98.662499999999994p -7.1093979999999996e-09 98.674999999999997p -7.1218290000000001e-09 98.6875p -7.1251200000000003e-09 98.700000000000003p -7.1192849999999998e-09 98.712499999999991p -7.1043489999999999e-09 98.724999999999994p -7.0803489999999999e-09 98.737499999999997p -7.0473329999999996e-09 98.75p -7.0053620000000001e-09 98.762500000000003p -6.9545059999999998e-09 98.775000000000006p -6.89485e-09
+ 98.787499999999994p -6.8264880000000003e-09 98.799999999999997p -6.7495239999999997e-09 98.8125p -6.6640739999999997e-09 98.825000000000003p -6.5702670000000002e-09 98.837499999999991p -6.4682380000000002e-09 98.849999999999994p -6.3581360000000001e-09 98.862499999999997p -6.2401200000000002e-09 98.875p -6.1143560000000003e-09 98.887500000000003p -5.9810220000000003e-09 98.900000000000006p -5.8403059999999996e-09 98.912500000000009p -5.692403e-09 98.924999999999997p -5.5375190000000002e-09 98.9375p -5.3758670000000003e-09 98.950000000000003p -5.2076689999999998e-09 98.962499999999991p -5.0331550000000001e-09 98.974999999999994p -4.8525630000000002e-09 98.987499999999997p -4.6661370000000001e-09 99p -4.4741300000000001e-09
+ 99.012500000000003p -4.2768e-09 99.025000000000006p -4.0744119999999996e-09 99.037500000000009p -3.8672370000000003e-09 99.049999999999997p -3.655553e-09 99.0625p -3.4396399999999999e-09 99.075000000000003p -3.2197850000000002e-09 99.087499999999991p -2.9962799999999999e-09 99.099999999999994p -2.7694200000000001e-09 99.112499999999997p -2.5395029999999999e-09 99.125p -2.3068330000000001e-09 99.137500000000003p -2.0717130000000002e-09 99.150000000000006p -1.8344529999999999e-09 99.162500000000009p -1.5953610000000001e-09 99.174999999999997p -1.3547480000000001e-09 99.1875p -1.1129290000000001e-09 99.200000000000003p -8.7021569999999999e-10 99.212499999999991p -6.2692290000000004e-10 99.224999999999994p -3.8336449999999999e-10
+ 99.237499999999997p -1.3985420000000001e-10 99.25p 1.032948e-10 99.262500000000003p 3.4577090000000001e-10 99.275000000000006p 5.8726379999999997e-10 99.287500000000009p 8.2746510000000003e-10 99.299999999999997p 1.0660689999999999e-09 99.3125p 1.3027720000000001e-09 99.325000000000003p 1.5372749999999999e-09 99.337499999999991p 1.7692799999999999e-09 99.349999999999994p 1.998496e-09 99.362499999999997p 2.2246330000000001e-09 99.375p 2.447409e-09 99.387500000000003p 2.6665439999999998e-09 99.400000000000006p 2.881766e-09 99.412500000000009p 3.0928049999999998e-09 99.424999999999997p 3.2994019999999998e-09 99.4375p 3.5012999999999999e-09 99.450000000000003p 3.698251e-09
+ 99.462499999999991p 3.8900139999999999e-09 99.474999999999994p 4.0763529999999996e-09 99.487499999999997p 4.2570419999999998e-09 99.5p 4.4318620000000003e-09 99.512500000000003p 4.6006019999999998e-09 99.525000000000006p 4.7630600000000003e-09 99.537500000000009p 4.9190409999999999e-09 99.549999999999997p 5.0683610000000004e-09 99.5625p 5.2108429999999999e-09 99.575000000000003p 5.3463210000000001e-09 99.587500000000006p 5.4746370000000003e-09 99.599999999999994p 5.5956429999999996e-09 99.612499999999997p 5.7092030000000002e-09 99.625p 5.815186e-09 99.637500000000003p 5.9134769999999996e-09 99.650000000000006p 6.0039669999999998e-09 99.662500000000009p 6.0865579999999999e-09 99.674999999999997p 6.1611650000000002e-09
+ 99.6875p 6.2277110000000001e-09 99.700000000000003p 6.2861300000000001e-09 99.712500000000006p 6.336367e-09 99.724999999999994p 6.3783770000000003e-09 99.737499999999997p 6.4121290000000004e-09 99.75p 6.4375980000000004e-09 99.762499999999989p 6.4547719999999998e-09 99.775000000000006p 6.4636509999999996e-09 99.787500000000009p 6.464244e-09 99.799999999999997p 6.4565710000000001e-09 99.8125p 6.440664e-09 99.825000000000003p 6.4165619999999998e-09 99.837500000000006p 6.3843199999999997e-09 99.849999999999994p 6.3439979999999998e-09 99.862499999999997p 6.2956690000000001e-09 99.875p 6.2394170000000002e-09 99.887499999999989p 6.175335e-09 99.900000000000006p 6.1035240000000001e-09
+ 99.912500000000009p 6.024099e-09 99.924999999999997p 5.93718e-09 99.9375p 5.8429000000000002e-09 99.950000000000003p 5.7413980000000002e-09 99.962500000000006p 5.6328259999999998e-09 99.974999999999994p 5.5173419999999997e-09 99.987499999999997p 5.3951119999999998e-09 100p 5.266312e-09 100.01249999999999p 5.1311249999999999e-09 100.02499999999999p 4.9897430000000003e-09 100.03750000000001p 4.8423650000000002e-09 100.05000000000001p 4.6891969999999998e-09 100.0625p 4.5304509999999997e-09 100.075p 4.3663489999999996e-09 100.08750000000001p 4.1971140000000002e-09 100.09999999999999p 4.0229809999999996e-09 100.1125p 3.8441869999999996e-09 100.125p 3.660975e-09
+ 100.13749999999999p 3.4735939999999998e-09 100.14999999999999p 3.282297e-09 100.16250000000001p 3.087342e-09 100.17500000000001p 2.88899e-09 100.1875p 2.6875080000000001e-09 100.2p 2.483164e-09 100.21250000000001p 2.2762290000000002e-09 100.22499999999999p 2.0669789999999999e-09 100.2375p 1.85569e-09 100.25p 1.6426409999999999e-09 100.26249999999999p 1.4281130000000001e-09 100.27499999999999p 1.212386e-09 100.28749999999999p 9.9574389999999992e-10 100.30000000000001p 7.7846840000000001e-10 100.3125p 5.608426e-10 100.325p 3.4314910000000002e-10 100.33750000000001p 1.256698e-10 100.34999999999999p -9.131449e-11
+ 100.3625p -3.0752419999999998e-10 100.375p -5.2268159999999999e-10 100.3875p -7.3651110000000001e-10 100.39999999999999p -9.4873950000000002e-10 100.41249999999999p -1.159096e-09 100.42500000000001p -1.367315e-09 100.4375p -1.573131e-09 100.45p -1.776284e-09 100.46250000000001p -1.9765200000000001e-09 100.47499999999999p -2.1735860000000001e-09 100.4875p -2.3672360000000002e-09 100.5p -2.557229e-09 100.5125p -2.7433299999999999e-09 100.52499999999999p -2.9253060000000001e-09 100.53749999999999p -3.102936e-09 100.55000000000001p -3.2759989999999999e-09 100.5625p -3.444285e-09 100.575p -3.6075899999999999e-09
+ 100.58750000000001p -3.7657149999999997e-09 100.59999999999999p -3.91847e-09 100.6125p -4.0656729999999998e-09 100.625p -4.2071480000000001e-09 100.6375p -4.3427270000000002e-09 100.64999999999999p -4.4722529999999999e-09 100.66249999999999p -4.5955729999999998e-09 100.675p -4.7125470000000001e-09 100.6875p -4.8230389999999996e-09 100.7p -4.9269259999999996e-09 100.71250000000001p -5.0240920000000004e-09 100.72500000000001p -5.1144300000000001e-09 100.7375p -5.1978419999999997e-09 100.75p -5.2742400000000002e-09 100.7625p -5.3435450000000003e-09 100.77499999999999p -5.4056880000000004e-09 100.78749999999999p -5.4606090000000003e-09 100.8p -5.5082579999999999e-09
+ 100.8125p -5.5485940000000002e-09 100.825p -5.581585e-09 100.83750000000001p -5.6072119999999999e-09 100.85000000000001p -5.6254619999999999e-09 100.8625p -5.6363319999999999e-09 100.875p -5.6398319999999998e-09 100.8875p -5.6359770000000001e-09 100.89999999999999p -5.6247960000000002e-09 100.91249999999999p -5.6063239999999998e-09 100.925p -5.5806070000000001e-09 100.9375p -5.5476999999999998e-09 100.95p -5.5076679999999996e-09 100.96250000000001p -5.4605839999999998e-09 100.97500000000001p -5.4065299999999999e-09 100.9875p -5.3455989999999999e-09 101p -5.2778890000000004e-09 101.0125p -5.2035110000000003e-09 101.02499999999999p -5.1225810000000002e-09
+ 101.03749999999999p -5.0352249999999998e-09 101.05p -4.9415749999999999e-09 101.0625p -4.8417749999999999e-09 101.075p -4.7359720000000004e-09 101.08750000000001p -4.6243230000000001e-09 101.10000000000001p -4.5069920000000002e-09 101.1125p -4.3841490000000001e-09 101.125p -4.2559729999999999e-09 101.1375p -4.1226469999999999e-09 101.14999999999999p -3.9843610000000004e-09 101.16249999999999p -3.8413110000000002e-09 101.175p -3.6937000000000002e-09 101.1875p -3.5417349999999999e-09 101.2p -3.3856279999999998e-09 101.21250000000001p -3.2255960000000001e-09 101.22500000000001p -3.0618619999999998e-09 101.2375p -2.894651e-09 101.25p -2.7241939999999999e-09
+ 101.2625p -2.5507240000000001e-09 101.27499999999999p -2.374478e-09 101.28749999999999p -2.1956970000000001e-09 101.3p -2.0146229999999999e-09 101.3125p -1.8314999999999999e-09 101.325p -1.646577e-09 101.33750000000001p -1.4601010000000001e-09 101.35000000000001p -1.272322e-09 101.3625p -1.0834930000000001e-09 101.375p -8.9386389999999995e-10 101.3875p -7.0368760000000004e-10 101.39999999999999p -5.1321610000000001e-10 101.41249999999999p -3.2270129999999998e-10 101.425p -1.323943e-10 101.4375p 5.7454509999999998e-11 101.45p 2.4659630000000002e-10 101.46250000000001p 4.3478370000000001e-10 101.47500000000001p 6.2177140000000005e-10
+ 101.4875p 8.0731609999999996e-10 101.5p 9.9117730000000005e-10 101.5125p 1.1731170000000001e-09 101.52500000000001p 1.352902e-09 101.53749999999999p 1.5302990000000001e-09 101.55p 1.705083e-09 101.5625p 1.8770300000000001e-09 101.57499999999999p 2.0459209999999998e-09 101.58750000000001p 2.2115409999999999e-09 101.60000000000001p 2.3736830000000001e-09 101.6125p 2.5321409999999998e-09 101.625p 2.686716e-09 101.6375p 2.8372170000000001e-09 101.65000000000001p 2.983455e-09 101.66249999999999p 3.1252500000000001e-09 101.675p 3.2624270000000002e-09 101.6875p 3.3948179999999998e-09 101.69999999999999p 3.522262e-09
+ 101.71250000000001p 3.644604e-09 101.72500000000001p 3.7616979999999997e-09 101.7375p 3.8734029999999996e-09 101.75p 3.9795880000000001e-09 101.7625p 4.0801269999999999e-09 101.77500000000001p 4.1749049999999997e-09 101.78749999999999p 4.2638110000000003e-09 101.8p 4.3467460000000001e-09 101.8125p 4.4236159999999996e-09 101.82499999999999p 4.4943370000000003e-09 101.83750000000001p 4.5588330000000002e-09 101.85000000000001p 4.6170370000000003e-09 101.86250000000001p 4.66889e-09 101.875p 4.7143410000000004e-09 101.8875p 4.7533479999999997e-09 101.90000000000001p 4.7858779999999998e-09 101.91249999999999p 4.8119069999999996e-09 101.925p 4.8314179999999996e-09
+ 101.9375p 4.8444050000000003e-09 101.94999999999999p 4.850868e-09 101.96249999999999p 4.8508190000000001e-09 101.97500000000001p 4.8442750000000002e-09 101.98750000000001p 4.8312649999999997e-09 102p 4.8118230000000002e-09 102.0125p 4.7859940000000004e-09 102.02500000000001p 4.7538309999999998e-09 102.03749999999999p 4.7153949999999997e-09 102.05p 4.6707540000000003e-09 102.0625p 4.6199850000000004e-09 102.07499999999999p 4.5631740000000001e-09 102.08749999999999p 4.5004129999999999e-09 102.10000000000001p 4.4318029999999997e-09 102.11250000000001p 4.3574519999999999e-09 102.125p 4.2774750000000001e-09 102.1375p 4.1919929999999998e-09 102.15000000000001p 4.1011379999999999e-09
+ 102.16249999999999p 4.0050450000000004e-09 102.175p 3.9038560000000002e-09 102.1875p 3.7977209999999999e-09 102.2p 3.6867960000000001e-09 102.21249999999999p 3.571242e-09 102.22499999999999p 3.4512249999999999e-09 102.23750000000001p 3.326919e-09 102.25p 3.198501e-09 102.2625p 3.0661550000000002e-09 102.27500000000001p 2.9300669999999999e-09 102.28749999999999p 2.7904299999999998e-09 102.3p 2.6474400000000001e-09 102.3125p 2.5012969999999999e-09 102.325p 2.3522060000000001e-09 102.33749999999999p 2.200374e-09 102.34999999999999p 2.046011e-09 102.36250000000001p 1.8893300000000001e-09 102.375p 1.730548e-09
+ 102.3875p 1.569882e-09 102.40000000000001p 1.4075530000000001e-09 102.41249999999999p 1.243782e-09 102.425p 1.078792e-09 102.4375p 9.1280720000000001e-10 102.45p 7.4605290000000002e-10 102.46249999999999p 5.7875409999999995e-10 102.47499999999999p 4.1113650000000001e-10 102.4875p 2.4342530000000001e-10 102.5p 7.5845440000000006e-11 102.5125p -9.1378800000000004e-11 102.52500000000001p -2.5802429999999998e-10 102.53749999999999p -4.2386920000000001e-10 102.55p -5.8869329999999998e-10 102.5625p -7.5227819999999996e-10 102.575p -9.144079e-10 102.58749999999999p -1.0748689999999999e-09 102.59999999999999p -1.233449e-09
+ 102.6125p -1.3899420000000001e-09 102.625p -1.5441429999999999e-09 102.6375p -1.6958500000000001e-09 102.65000000000001p -1.844866e-09 102.66250000000001p -1.9909989999999999e-09 102.675p -2.1340580000000002e-09 102.6875p -2.2738599999999998e-09 102.7p -2.4102259999999998e-09 102.71249999999999p -2.5429799999999998e-09 102.72499999999999p -2.6719530000000002e-09 102.7375p -2.7969819999999998e-09 102.75p -2.9179080000000001e-09 102.7625p -3.0345790000000002e-09 102.77500000000001p -3.1468479999999999e-09 102.78750000000001p -3.2545749999999998e-09 102.8p -3.357627e-09 102.8125p -3.4558759999999998e-09 102.825p -3.549201e-09
+ 102.83749999999999p -3.63749e-09 102.84999999999999p -3.7206339999999998e-09 102.8625p -3.7985349999999996e-09 102.875p -3.8711010000000003e-09 102.8875p -3.9382449999999998e-09 102.90000000000001p -3.9998899999999999e-09 102.91250000000001p -4.0559670000000003e-09 102.925p -4.1064129999999998e-09 102.9375p -4.1511719999999997e-09 102.95p -4.1901969999999997e-09 102.96249999999999p -4.2234500000000003e-09 102.97499999999999p -4.2508969999999997e-09 102.9875p -4.272516e-09 103p -4.2882899999999999e-09 103.0125p -4.2982110000000001e-09 103.02500000000001p -4.3022789999999998e-09 103.03750000000001p -4.3005009999999997e-09 103.05p -4.292891e-09
+ 103.0625p -4.279473e-09 103.075p -4.2602779999999999e-09 103.08749999999999p -4.235344e-09 103.09999999999999p -4.2047150000000004e-09 103.1125p -4.1684469999999999e-09 103.125p -4.1265980000000004e-09 103.1375p -4.0792380000000003e-09 103.15000000000001p -4.0264409999999999e-09 103.16250000000001p -3.9682889999999998e-09 103.175p -3.9048730000000001e-09 103.1875p -3.8362870000000001e-09 103.2p -3.7626340000000003e-09 103.21249999999999p -3.6840239999999999e-09 103.22499999999999p -3.6005719999999999e-09 103.2375p -3.5124e-09 103.25p -3.4196350000000001e-09 103.2625p -3.3224120000000001e-09 103.27500000000001p -3.2208699999999999e-09
+ 103.28750000000001p -3.115154e-09 103.3p -3.005413e-09 103.3125p -2.891803e-09 103.325p -2.7744829999999998e-09 103.33750000000001p -2.6536189999999999e-09 103.34999999999999p -2.529378e-09 103.3625p -2.4019350000000001e-09 103.375p -2.2714660000000002e-09 103.3875p -2.1381519999999999e-09 103.40000000000001p -2.0021770000000001e-09 103.41250000000001p -1.8637289999999998e-09 103.425p -1.7229959999999999e-09 103.4375p -1.5801730000000001e-09 103.45p -1.435455e-09 103.46250000000001p -1.2890379999999999e-09 103.47499999999999p -1.1411219999999999e-09 103.4875p -9.9190879999999997e-10 103.5p -8.4159950000000002e-10
+ 103.51249999999999p -6.9039770000000001e-10 103.52500000000001p -5.3850740000000003e-10 103.53750000000001p -3.8613319999999998e-10 103.55p -2.3347990000000002e-10 103.5625p -8.0752390000000002e-11 103.575p 7.1844859999999995e-11 103.58750000000001p 2.2410789999999999e-10 103.59999999999999p 3.7583359999999999e-10 103.6125p 5.2682000000000005e-10 103.625p 6.7686630000000002e-10 103.63749999999999p 8.2577350000000001e-10 103.65000000000001p 9.7334460000000009e-10 103.66250000000001p 1.1193839999999999e-09 103.67500000000001p 1.2637000000000001e-09 103.6875p 1.4061030000000001e-09 103.7p 1.546404e-09 103.71250000000001p 1.6844200000000001e-09 103.72499999999999p 1.819971e-09
+ 103.7375p 1.95288e-09 103.75p 2.082973e-09 103.76249999999999p 2.2100820000000001e-09 103.77499999999999p 2.3340409999999998e-09 103.78750000000001p 2.4546909999999998e-09 103.80000000000001p 2.5718750000000001e-09 103.8125p 2.685442e-09 103.825p 2.795248e-09 103.83750000000001p 2.9011519999999999e-09 103.84999999999999p 3.003018e-09 103.8625p 3.1007169999999999e-09 103.875p 3.194126e-09 103.88749999999999p 3.283126e-09 103.89999999999999p 3.367607e-09 103.91250000000001p 3.4474609999999999e-09 103.92500000000001p 3.5225909999999998e-09 103.9375p 3.592903e-09 103.95p 3.6583109999999999e-09
+ 103.96250000000001p 3.7187359999999999e-09 103.97499999999999p 3.7741039999999996e-09 103.9875p 3.8243499999999999e-09 104p 3.8694140000000002e-09 104.01249999999999p 3.9092439999999997e-09 104.02499999999999p 3.9437959999999999e-09 104.03749999999999p 3.9730299999999999e-09 104.05000000000001p 3.9969170000000002e-09 104.0625p 4.015431e-09 104.075p 4.0285570000000003e-09 104.08750000000001p 4.0362850000000004e-09 104.09999999999999p 4.0386120000000002e-09 104.1125p 4.0355429999999996e-09 104.125p 4.0270910000000003e-09 104.1375p 4.0132730000000003e-09 104.14999999999999p 3.9941170000000001e-09 104.16249999999999p 3.9696550000000002e-09 104.17500000000001p 3.9399269999999999e-09
+ 104.1875p 3.9049800000000003e-09 104.2p 3.8648680000000003e-09 104.21250000000001p 3.819651e-09 104.22499999999999p 3.7693969999999997e-09 104.2375p 3.7141790000000002e-09 104.25p 3.6540770000000001e-09 104.2625p 3.5891770000000001e-09 104.27499999999999p 3.5195729999999998e-09 104.28749999999999p 3.445362e-09 104.30000000000001p 3.3666500000000002e-09 104.3125p 3.2835470000000002e-09 104.325p 3.1961679999999999e-09 104.33750000000001p 3.1046360000000001e-09 104.34999999999999p 3.0090760000000001e-09 104.3625p 2.909621e-09 104.375p 2.8064079999999998e-09 104.3875p 2.6995780000000001e-09 104.39999999999999p 2.5892759999999999e-09
+ 104.41249999999999p 2.4756539999999999e-09 104.425p 2.3588649999999998e-09 104.4375p 2.2390689999999999e-09 104.45p 2.1164270000000002e-09 104.46250000000001p 1.9911049999999998e-09 104.47500000000001p 1.8632709999999998e-09 104.4875p 1.733099e-09 104.5p 1.600762e-09 104.5125p 1.466437e-09 104.52499999999999p 1.330305e-09 104.53749999999999p 1.1925470000000001e-09 104.55p 1.053347e-09 104.5625p 9.1288909999999996e-10 104.575p 7.7136089999999999e-10 104.58750000000001p 6.2894980000000002e-10 104.60000000000001p 4.8584410000000001e-10 104.6125p 3.422332e-10 104.625p 1.983064e-10
+ 104.6375p 5.4253350000000002e-11 104.64999999999999p -8.9736420000000006e-11 104.66249999999999p -2.3347379999999999e-10 104.675p -3.7677040000000001e-10 104.6875p -5.1943859999999999e-10 104.7p -6.6129189999999998e-10 104.71250000000001p -8.0214519999999999e-10 104.72500000000001p -9.4181500000000002e-10 104.7375p -1.08012e-09 104.75p -1.2168789999999999e-09 104.7625p -1.3519170000000001e-09 104.77499999999999p -1.485058e-09 104.78749999999999p -1.616131e-09 104.8p -1.7449650000000001e-09 104.8125p -1.8713959999999999e-09 104.825p -1.9952609999999999e-09 104.83750000000001p -2.1164010000000002e-09 104.85000000000001p -2.2346610000000001e-09
+ 104.8625p -2.3498909999999999e-09 104.875p -2.4619439999999999e-09 104.8875p -2.570676e-09 104.89999999999999p -2.675951e-09 104.91249999999999p -2.7776359999999999e-09 104.925p -2.8756020000000001e-09 104.9375p -2.9697259999999998e-09 104.95p -3.0598910000000002e-09 104.96250000000001p -3.1459830000000001e-09 104.97500000000001p -3.2278969999999999e-09 104.9875p -3.3055299999999999e-09 105p -3.3787869999999999e-09 105.0125p -3.447578e-09 105.02499999999999p -3.51182e-09 105.03749999999999p -3.571434e-09 105.05p -3.62635e-09 105.0625p -3.6765020000000001e-09 105.075p -3.7218310000000001e-09
+ 105.08750000000001p -3.7622849999999999e-09 105.10000000000001p -3.7978169999999999e-09 105.1125p -3.8283869999999997e-09 105.125p -3.8539640000000002e-09 105.1375p -3.87452e-09 105.14999999999999p -3.8900339999999997e-09 105.16249999999999p -3.900495e-09 105.175p -3.905895e-09 105.1875p -3.906235e-09 105.2p -3.9015189999999997e-09 105.21250000000001p -3.8917629999999999e-09 105.22500000000001p -3.8769839999999996e-09 105.2375p -3.8572100000000002e-09 105.25p -3.8324730000000002e-09 105.2625p -3.8028110000000003e-09 105.27500000000001p -3.7682709999999998e-09 105.28749999999999p -3.7289030000000004e-09 105.3p -3.6847659999999998e-09
+ 105.3125p -3.635924e-09 105.32499999999999p -3.5824449999999998e-09 105.33750000000001p -3.5244070000000001e-09 105.35000000000001p -3.4618899999999999e-09 105.3625p -3.3949829999999999e-09 105.375p -3.3237770000000002e-09 105.3875p -3.2483719999999998e-09 105.40000000000001p -3.16887e-09 105.41249999999999p -3.0853809999999999e-09 105.425p -2.9980180000000001e-09 105.4375p -2.9069e-09 105.44999999999999p -2.8121500000000001e-09 105.46250000000001p -2.7138959999999999e-09 105.47500000000001p -2.6122689999999998e-09 105.4875p -2.507407e-09 105.5p -2.3994490000000001e-09 105.5125p -2.28854e-09 105.52500000000001p -2.174826e-09
+ 105.53749999999999p -2.058459e-09 105.55p -1.939593e-09 105.5625p -1.8183859999999999e-09 105.57499999999999p -1.694996e-09 105.58749999999999p -1.569587e-09 105.60000000000001p -1.4423220000000001e-09 105.61250000000001p -1.31337e-09 105.625p -1.182899e-09 105.6375p -1.0510789999999999e-09 105.65000000000001p -9.1808219999999998e-10 105.66249999999999p -7.8408169999999997e-10 105.675p -6.4925179999999996e-10 105.6875p -5.1376730000000004e-10 105.69999999999999p -3.7780350000000001e-10 105.71249999999999p -2.4153640000000002e-10 105.72500000000001p -1.051416e-10 105.73750000000001p 3.1205040000000001e-11 105.75p 1.6732830000000001e-10
+ 105.7625p 3.030534e-10 105.77500000000001p 4.382065e-10 105.78749999999999p 5.726147e-10 105.8p 7.0610649999999997e-10 105.8125p 8.3851190000000002e-10 105.82499999999999p 9.6966240000000008e-10 105.83749999999999p 1.0993920000000001e-09 105.85000000000001p 1.2275349999999999e-09 105.86250000000001p 1.353931e-09 105.875p 1.4784199999999999e-09 105.8875p 1.6008460000000001e-09 105.90000000000001p 1.721054e-09 105.91249999999999p 1.838895e-09 105.925p 1.9542199999999999e-09 105.9375p 2.066887e-09 105.95p 2.1767549999999999e-09 105.96249999999999p 2.2836880000000002e-09 105.97499999999999p 2.3875540000000001e-09
+ 105.98750000000001p 2.4882249999999999e-09 106p 2.5855779999999999e-09 106.0125p 2.6794939999999998e-09 106.02500000000001p 2.769858e-09 106.03749999999999p 2.8565609999999998e-09 106.05p 2.9394979999999998e-09 106.0625p 3.0185689999999999e-09 106.075p 3.0936809999999999e-09 106.08749999999999p 3.164744e-09 106.09999999999999p 3.2316739999999999e-09 106.11250000000001p 3.2943939999999999e-09 106.125p 3.3528299999999999e-09 106.1375p 3.4069150000000001e-09 106.15000000000001p 3.456589e-09 106.16249999999999p 3.501796e-09 106.175p 3.5424859999999998e-09 106.1875p 3.5786160000000002e-09 106.2p 3.6101469999999999e-09
+ 106.21249999999999p 3.6370490000000001e-09 106.22499999999999p 3.659295e-09 106.2375p 3.6768659999999999e-09 106.25p 3.6897490000000001e-09 106.2625p 3.6979349999999998e-09 106.27500000000001p 3.7014239999999999e-09 106.28749999999999p 3.7002199999999999e-09 106.3p 3.6943330000000001e-09 106.3125p 3.6837810000000002e-09 106.325p 3.668586e-09 106.33749999999999p 3.6487759999999998e-09 106.34999999999999p 3.6243860000000001e-09 106.3625p 3.5954559999999999e-09 106.375p 3.5620320000000002e-09 106.3875p 3.5241659999999998e-09 106.40000000000001p 3.481915e-09 106.41250000000001p 3.435343e-09 106.425p 3.3845160000000002e-09
+ 106.4375p 3.32951e-09 106.45p 3.270402e-09 106.46249999999999p 3.207277e-09 106.47499999999999p 3.1402229999999999e-09 106.4875p 3.0693350000000001e-09 106.5p 2.9947099999999999e-09 106.5125p 2.9164529999999999e-09 106.52500000000001p 2.8346700000000001e-09 106.53750000000001p 2.7494730000000001e-09 106.55p 2.6609790000000001e-09 106.5625p 2.569307e-09 106.575p 2.4745820000000002e-09 106.58749999999999p 2.37693e-09 106.59999999999999p 2.276484e-09 106.6125p 2.1733760000000002e-09 106.625p 2.0677440000000002e-09 106.6375p 1.9597299999999998e-09 106.65000000000001p 1.849475e-09
+ 106.66250000000001p 1.7371270000000001e-09 106.675p 1.622831e-09 106.6875p 1.5067399999999999e-09 106.7p 1.389005e-09 106.71249999999999p 1.2697799999999999e-09 106.72499999999999p 1.1492200000000001e-09 106.7375p 1.027483e-09 106.75p 9.0472640000000003e-10 106.7625p 7.8110940000000002e-10 106.77500000000001p 6.5679180000000002e-10 106.78750000000001p 5.3193380000000001e-10 106.8p 4.0669589999999999e-10 106.8125p 2.8123909999999997e-10 106.825p 1.557238e-10 106.83749999999999p 3.0310570000000003e-11 106.84999999999999p -9.4840899999999995e-11 106.8625p -2.195714e-10 106.875p -3.4372279999999999e-10
+ 106.8875p -4.6713780000000002e-10 106.90000000000001p -5.8966079999999995e-10 106.91250000000001p -7.1113750000000002e-10 106.925p -8.3141520000000003e-10 106.9375p -9.5034330000000007e-10 106.95p -1.0677730000000001e-09 106.96249999999999p -1.1835590000000001e-09 106.97499999999999p -1.297556e-09 106.9875p -1.409624e-09 107p -1.519624e-09 107.0125p -1.6274210000000001e-09 107.02500000000001p -1.732883e-09 107.03750000000001p -1.8358800000000001e-09 107.05p -1.9362879999999999e-09 107.0625p -2.0339840000000001e-09 107.075p -2.1288510000000001e-09 107.08750000000001p -2.2207749999999999e-09 107.09999999999999p -2.3096449999999998e-09
+ 107.1125p -2.3953570000000002e-09 107.125p -2.477807e-09 107.1375p -2.556901e-09 107.15000000000001p -2.6325440000000001e-09 107.16250000000001p -2.7046500000000002e-09 107.175p -2.7731349999999999e-09 107.1875p -2.8379219999999999e-09 107.2p -2.8989370000000002e-09 107.21250000000001p -2.9561109999999999e-09 107.22499999999999p -3.0093829999999999e-09 107.2375p -3.0586939999999999e-09 107.25p -3.103992e-09 107.26249999999999p -3.145229e-09 107.27500000000001p -3.1823640000000002e-09 107.28750000000001p -3.2153599999999999e-09 107.3p -3.244187e-09 107.3125p -3.2688170000000002e-09 107.325p -3.289232e-09
+ 107.33750000000001p -3.3054169999999998e-09 107.34999999999999p -3.317362e-09 107.3625p -3.3250629999999998e-09 107.375p -3.328524e-09 107.38749999999999p -3.3277499999999998e-09 107.40000000000001p -3.3227549999999999e-09 107.41250000000001p -3.3135570000000002e-09 107.42500000000001p -3.3001790000000002e-09 107.4375p -3.28265e-09 107.45p -3.2610039999999998e-09 107.46250000000001p -3.2352809999999999e-09 107.47499999999999p -3.2055249999999998e-09 107.4875p -3.1717849999999999e-09 107.5p -3.1341169999999998e-09 107.51249999999999p -3.0925790000000002e-09 107.52499999999999p -3.0472370000000002e-09 107.53750000000001p -2.9981580000000001e-09 107.55000000000001p -2.9454180000000001e-09
+ 107.5625p -2.8890930000000001e-09 107.575p -2.829267e-09 107.58750000000001p -2.7660270000000001e-09 107.59999999999999p -2.6994640000000001e-09 107.6125p -2.6296729999999998e-09 107.625p -2.5567539999999999e-09 107.63749999999999p -2.480808e-09 107.64999999999999p -2.4019429999999998e-09 107.66250000000001p -2.320269e-09 107.67500000000001p -2.2358990000000002e-09 107.6875p -2.1489490000000002e-09 107.7p -2.0595390000000002e-09 107.71250000000001p -1.9677910000000002e-09 107.72499999999999p -1.8738309999999998e-09 107.7375p -1.777785e-09 107.75p -1.6797849999999999e-09 107.76249999999999p -1.5799610000000001e-09 107.77499999999999p -1.4784490000000001e-09
+ 107.78749999999999p -1.375383e-09 107.80000000000001p -1.270902e-09 107.8125p -1.165144e-09 107.825p -1.0582499999999999e-09 107.83750000000001p -9.5036020000000008e-10 107.84999999999999p -8.4161779999999996e-10 107.8625p -7.3216530000000002e-10 107.875p -6.221462e-10 107.8875p -5.117042e-10 107.89999999999999p -4.0098319999999998e-10 107.91249999999999p -2.901269e-10 107.92500000000001p -1.7927899999999999e-10 107.9375p -6.8582599999999999e-11 107.95p 4.1819689999999999e-11 107.96250000000001p 1.517861e-10 107.97499999999999p 2.6117590000000001e-10 107.9875p 3.6984939999999998e-10 108p 4.7766830000000004e-10
+ 108.0125p 5.844958e-10 108.02499999999999p 6.9019679999999997e-10 108.03749999999999p 7.9463800000000004e-10 108.05000000000001p 8.976883e-10 108.0625p 9.9921849999999992e-10 108.075p 1.0991020000000001e-09 108.08750000000001p 1.197215e-09 108.09999999999999p 1.2934350000000001e-09 108.1125p 1.387644e-09 108.125p 1.479726e-09 108.1375p 1.5695690000000001e-09 108.14999999999999p 1.657063e-09 108.16249999999999p 1.742102e-09 108.175p 1.824584e-09 108.1875p 1.9044090000000001e-09 108.2p 1.9814830000000002e-09 108.21250000000001p 2.0557150000000001e-09 108.22500000000001p 2.1270169999999998e-09
+ 108.2375p 2.1953059999999999e-09 108.25p 2.2605029999999999e-09 108.2625p 2.322533e-09 108.27499999999999p 2.3813260000000001e-09 108.28749999999999p 2.4368159999999998e-09 108.3p 2.4889410000000002e-09 108.3125p 2.5376449999999999e-09 108.325p 2.582876e-09 108.33750000000001p 2.624585e-09 108.35000000000001p 2.66273e-09 108.3625p 2.6972729999999999e-09 108.375p 2.72818e-09 108.3875p 2.755424e-09 108.39999999999999p 2.7789810000000002e-09 108.41249999999999p 2.7988330000000001e-09 108.425p 2.814964e-09 108.4375p 2.8273680000000001e-09 108.45p 2.8360400000000001e-09
+ 108.46250000000001p 2.8409799999999998e-09 108.47500000000001p 2.842195e-09 108.4875p 2.839696e-09 108.5p 2.8334989999999999e-09 108.5125p 2.823622e-09 108.52499999999999p 2.8100929999999999e-09 108.53749999999999p 2.7929400000000001e-09 108.55p 2.7721980000000002e-09 108.5625p 2.7479059999999998e-09 108.575p 2.7201079999999998e-09 108.58750000000001p 2.688853e-09 108.60000000000001p 2.6541909999999998e-09 108.6125p 2.6161809999999999e-09 108.625p 2.5748829999999998e-09 108.6375p 2.5303630000000001e-09 108.64999999999999p 2.4826889999999999e-09 108.66249999999999p 2.4319360000000002e-09 108.675p 2.3781789999999998e-09
+ 108.6875p 2.321499e-09 108.7p 2.2619819999999999e-09 108.71250000000001p 2.1997130000000002e-09 108.72500000000001p 2.1347860000000002e-09 108.7375p 2.0672929999999999e-09 108.75p 1.9973329999999999e-09 108.7625p 1.9250049999999998e-09 108.77499999999999p 1.8504129999999999e-09 108.78749999999999p 1.773663e-09 108.8p 1.694863e-09 108.8125p 1.614124e-09 108.825p 1.5315589999999999e-09 108.83750000000001p 1.447282e-09 108.85000000000001p 1.3614110000000001e-09 108.8625p 1.274065e-09 108.875p 1.1853630000000001e-09 108.8875p 1.095428e-09 108.89999999999999p 1.004382e-09
+ 108.91249999999999p 9.1234920000000001e-10 108.925p 8.1945509999999997e-10 108.9375p 7.2582500000000002e-10 108.95p 6.3158539999999997e-10 108.96250000000001p 5.3686299999999997e-10 108.97500000000001p 4.4178490000000001e-10 108.9875p 3.4647820000000002e-10 109p 2.5106990000000001e-10 109.0125p 1.5568669999999999e-10 109.02500000000001p 6.0455109999999998e-11 109.03749999999999p -3.449911e-11 109.05p -1.2905090000000001e-10 109.0625p -2.2307609999999999e-10 109.07499999999999p -3.1645160000000002e-10 109.08750000000001p -4.0905559999999997e-10 109.10000000000001p -5.0076759999999998e-10 109.1125p -5.9146859999999999e-10 109.125p -6.8104139999999999e-10
+ 109.1375p -7.6937059999999999e-10 109.15000000000001p -8.5634269999999999e-10 109.16249999999999p -9.418464000000001e-10 109.175p -1.025773e-09 109.1875p -1.1080149999999999e-09 109.19999999999999p -1.1884699999999999e-09 109.21250000000001p -1.2670339999999999e-09 109.22500000000001p -1.343611e-09 109.2375p -1.4181039999999999e-09 109.25p -1.490421e-09 109.2625p -1.5604719999999999e-09 109.27500000000001p -1.628172e-09 109.28749999999999p -1.6934360000000001e-09 109.3p -1.7561860000000001e-09 109.3125p -1.8163469999999999e-09 109.32499999999999p -1.8738450000000002e-09 109.33749999999999p -1.9286130000000002e-09 109.35000000000001p -1.9805860000000001e-09
+ 109.36250000000001p -2.0297029999999999e-09 109.375p -2.0759079999999999e-09 109.3875p -2.1191479999999998e-09 109.40000000000001p -2.1593750000000001e-09 109.41249999999999p -2.1965430000000001e-09 109.425p -2.230614e-09 109.4375p -2.2615499999999999e-09 109.44999999999999p -2.289321e-09 109.46249999999999p -2.3138979999999998e-09 109.47500000000001p -2.3352590000000002e-09 109.48750000000001p -2.3533859999999998e-09 109.5p -2.3682620000000001e-09 109.5125p -2.3798799999999999e-09 109.52500000000001p -2.3882319999999999e-09 109.53749999999999p -2.3933179999999999e-09 109.55p -2.395141e-09 109.5625p -2.3937090000000001e-09 109.57499999999999p -2.3890320000000002e-09
+ 109.58749999999999p -2.3811279999999998e-09 109.60000000000001p -2.3700150000000001e-09 109.61250000000001p -2.3557199999999998e-09 109.625p -2.3382709999999999e-09 109.6375p -2.3176990000000001e-09 109.65000000000001p -2.2940440000000001e-09 109.66249999999999p -2.2673440000000002e-09 109.675p -2.237646e-09 109.6875p -2.2049979999999999e-09 109.7p -2.169452e-09 109.71249999999999p -2.1310649999999998e-09 109.72499999999999p -2.0898969999999999e-09 109.73750000000001p -2.0460119999999999e-09 109.75p -1.9994749999999999e-09 109.7625p -1.9503580000000001e-09 109.77500000000001p -1.8987350000000001e-09 109.78749999999999p -1.844681e-09 109.8p -1.788277e-09
+ 109.8125p -1.729606e-09 109.825p -1.6687520000000001e-09 109.83749999999999p -1.6058049999999999e-09 109.84999999999999p -1.5408550000000001e-09 109.86250000000001p -1.4739949999999999e-09 109.875p -1.405321e-09 109.8875p -1.334931e-09 109.90000000000001p -1.2629240000000001e-09 109.91249999999999p -1.1894020000000001e-09 109.925p -1.1144690000000001e-09 109.9375p -1.0382289999999999e-09 109.95p -9.6078980000000009e-10 109.96249999999999p -8.8225870000000001e-10 109.97499999999999p -8.0274480000000004e-10 109.9875p -7.2235839999999998e-10 110p -6.4121040000000003e-10 110.0125p -5.5941269999999997e-10 110.02500000000001p -4.7707769999999996e-10
+ 110.03749999999999p -3.943181e-10 110.05p -3.1124709999999999e-10 110.0625p -2.279779e-10 110.075p -1.4462380000000001e-10 110.08749999999999p -6.1297869999999996e-11 110.09999999999999p 2.1887140000000002e-11 110.1125p 1.048189e-10 110.125p 1.8738579999999999e-10 110.1375p 2.694768e-10 110.15000000000001p 3.509819e-10 110.16250000000001p 4.3179210000000001e-10 110.175p 5.1179960000000001e-10 110.1875p 5.9089799999999998e-10 110.2p 6.6898230000000001e-10 110.21249999999999p 7.4594899999999998e-10 110.22499999999999p 8.2169649999999999e-10 110.2375p 8.9612509999999997e-10 110.25p 9.6913690000000007e-10
+ 110.2625p 1.040636e-09 110.27500000000001p 1.1105300000000001e-09 110.28750000000001p 1.178727e-09 110.3p 1.2451380000000001e-09 110.3125p 1.3096790000000001e-09 110.325p 1.372264e-09 110.33749999999999p 1.4328150000000001e-09 110.34999999999999p 1.4912529999999999e-09 110.3625p 1.5475039999999999e-09 110.375p 1.601497e-09 110.3875p 1.653163e-09 110.40000000000001p 1.7024379999999999e-09 110.41250000000001p 1.7492589999999999e-09 110.425p 1.7935689999999999e-09 110.4375p 1.8353130000000001e-09 110.45p 1.87444e-09 110.46249999999999p 1.9109019999999999e-09 110.47499999999999p 1.9446560000000002e-09
+ 110.4875p 1.9756610000000001e-09 110.5p 2.0038820000000001e-09 110.5125p 2.0292850000000002e-09 110.52500000000001p 2.0518429999999999e-09 110.53750000000001p 2.0715300000000002e-09 110.55p 2.088325e-09 110.5625p 2.1022120000000001e-09 110.575p 2.1131769999999998e-09 110.58749999999999p 2.1212130000000001e-09 110.59999999999999p 2.1263120000000001e-09 110.6125p 2.1284750000000001e-09 110.625p 2.127704e-09 110.6375p 2.1240069999999999e-09 110.65000000000001p 2.1173920000000001e-09 110.66250000000001p 2.1078759999999999e-09 110.675p 2.0954770000000002e-09 110.6875p 2.080216e-09 110.7p 2.0621209999999998e-09
+ 110.71249999999999p 2.0412200000000001e-09 110.72499999999999p 2.0175469999999998e-09 110.7375p 1.9911389999999999e-09 110.75p 1.9620380000000002e-09 110.7625p 1.9302869999999998e-09 110.77500000000001p 1.895935e-09 110.78750000000001p 1.8590310000000001e-09 110.8p 1.8196320000000001e-09 110.8125p 1.777794e-09 110.825p 1.733579e-09 110.83750000000001p 1.6870500000000001e-09 110.84999999999999p 1.638274e-09 110.8625p 1.5873220000000001e-09 110.875p 1.5342660000000001e-09 110.8875p 1.479181e-09 110.90000000000001p 1.422144e-09 110.91250000000001p 1.3632379999999999e-09 110.925p 1.3025430000000001e-09
+ 110.9375p 1.2401460000000001e-09 110.95p 1.1761330000000001e-09 110.96250000000001p 1.1105929999999999e-09 110.97499999999999p 1.043617e-09 110.9875p 9.7529889999999999e-10 111p 9.0573199999999995e-10 111.01249999999999p 8.350126e-10 111.02500000000001p 7.6323770000000004e-10 111.03750000000001p 6.9050610000000003e-10 111.05p 6.1691730000000004e-10 111.0625p 5.425719e-10 111.075p 4.6757129999999997e-10 111.08750000000001p 3.920177e-10 111.09999999999999p 3.160138e-10 111.1125p 2.3966270000000001e-10 111.125p 1.6306789999999999e-10 111.13749999999999p 8.6332949999999998e-11 111.15000000000001p 9.5613979999999997e-12
+ 111.16250000000001p -6.7143270000000001e-11 111.17500000000001p -1.4367780000000001e-10 111.1875p -2.1993949999999999e-10 111.2p -2.9582600000000002e-10 111.21250000000001p -3.712356e-10 111.22499999999999p -4.4606769999999998e-10 111.2375p -5.202223e-10 111.25p -5.9360070000000001e-10 111.26249999999999p -6.6610520000000001e-10 111.27499999999999p -7.3763949999999999e-10 111.28750000000001p -8.0810880000000005e-10 111.30000000000001p -8.7741979999999999e-10 111.3125p -9.4548100000000004e-10 111.325p -1.012203e-09 111.33750000000001p -1.0774969999999999e-09 111.34999999999999p -1.141278e-09 111.3625p -1.2034619999999999e-09 111.375p -1.263967e-09
+ 111.38749999999999p -1.3227159999999999e-09 111.39999999999999p -1.3796299999999999e-09 111.41250000000001p -1.434637e-09 111.42500000000001p -1.487664e-09 111.4375p -1.538644e-09 111.45p -1.58751e-09 111.46250000000001p -1.6341990000000001e-09 111.47499999999999p -1.678652e-09 111.4875p -1.720812e-09 111.5p -1.760625e-09 111.51249999999999p -1.7980399999999999e-09 111.52499999999999p -1.833011e-09 111.53749999999999p -1.865494e-09 111.55000000000001p -1.895447e-09 111.5625p -1.9228340000000001e-09 111.575p -1.9476220000000002e-09 111.58750000000001p -1.9697789999999999e-09 111.59999999999999p -1.98928e-09
+ 111.6125p -2.0061009999999998e-09 111.625p -2.0202220000000001e-09 111.6375p -2.031629e-09 111.64999999999999p -2.0403090000000001e-09 111.66249999999999p -2.0462530000000002e-09 111.67500000000001p -2.0494550000000001e-09 111.6875p -2.0499159999999999e-09 111.7p -2.0476370000000001e-09 111.71250000000001p -2.0426229999999998e-09 111.72499999999999p -2.0348849999999998e-09 111.7375p -2.0244360000000001e-09 111.75p -2.0112919999999998e-09 111.7625p -1.995474e-09 111.77499999999999p -1.977005e-09 111.78749999999999p -1.9559129999999998e-09 111.8p -1.9322279999999998e-09 111.8125p -1.9059830000000002e-09 111.825p -1.877218e-09
+ 111.83750000000001p -1.845972e-09 111.84999999999999p -1.8122879999999999e-09 111.8625p -1.776215e-09 111.875p -1.737802e-09 111.8875p -1.6971020000000001e-09 111.89999999999999p -1.654171e-09 111.91249999999999p -1.609069e-09 111.925p -1.561856e-09 111.9375p -1.5125979999999999e-09 111.95p -1.461362e-09 111.96250000000001p -1.4082160000000001e-09 111.97500000000001p -1.353233e-09 111.9875p -1.296487e-09 112p -1.238055e-09 112.0125p -1.1780150000000001e-09 112.02499999999999p -1.116448e-09 112.03749999999999p -1.053436e-09 112.05p -9.890636e-10
+ 112.0625p -9.2341699999999998e-10 112.075p -8.5658359999999996e-10 112.08750000000001p -7.8865229999999997e-10 112.10000000000001p -7.1971340000000004e-10 112.1125p -6.4985850000000001e-10 112.125p -5.7918009999999999e-10 112.1375p -5.0777170000000002e-10 112.14999999999999p -4.3572790000000001e-10 112.16249999999999p -3.6314349999999998e-10 112.175p -2.9011430000000002e-10 112.1875p -2.1673640000000001e-10 112.2p -1.4310629999999999e-10 112.21250000000001p -6.9320579999999998e-11 112.22500000000001p 4.5240099999999998e-12 112.2375p 7.8330799999999999e-11 112.25p 1.5200330000000001e-10 112.2625p 2.2544530000000001e-10 112.27499999999999p 2.9856109999999999e-10
+ 112.28749999999999p 3.712554e-10 112.3p 4.4343369999999998e-10 112.3125p 5.1500229999999999e-10 112.325p 5.8586839999999997e-10 112.33750000000001p 6.5594019999999997e-10 112.35000000000001p 7.2512719999999999e-10 112.3625p 7.9333990000000004e-10 112.375p 8.6049050000000005e-10 112.3875p 9.2649240000000001e-10 112.39999999999999p 9.9126100000000006e-10 112.41249999999999p 1.0547130000000001e-09 112.425p 1.1167669999999999e-09 112.4375p 1.1773449999999999e-09 112.45p 1.2363679999999999e-09 112.46250000000001p 1.293761e-09 112.47500000000001p 1.3494519999999999e-09 112.4875p 1.403369e-09 112.5p 1.455445e-09
+ 112.5125p 1.505614e-09 112.52499999999999p 1.553813e-09 112.53749999999999p 1.599981e-09 112.55p 1.6440609999999999e-09 112.5625p 1.685997e-09 112.575p 1.725737e-09 112.58750000000001p 1.7632319999999999e-09 112.60000000000001p 1.798436e-09 112.6125p 1.831305e-09 112.625p 1.861801e-09 112.6375p 1.8898840000000001e-09 112.64999999999999p 1.9155230000000001e-09 112.66249999999999p 1.938686e-09 112.675p 1.9593459999999998e-09 112.6875p 1.9774779999999999e-09 112.7p 1.9930629999999999e-09 112.71250000000001p 2.0060829999999999e-09 112.72500000000001p 2.016524e-09
+ 112.7375p 2.0243750000000001e-09 112.75p 2.0296279999999999e-09 112.7625p 2.0322809999999998e-09 112.77500000000001p 2.032332e-09 112.78749999999999p 2.0297849999999999e-09 112.8p 2.0246450000000001e-09 112.8125p 2.0169219999999999e-09 112.82499999999999p 2.0066279999999999e-09 112.83750000000001p 1.993781e-09 112.85000000000001p 1.9783989999999998e-09 112.8625p 1.9605059999999998e-09 112.875p 1.940126e-09 112.8875p 1.9172900000000001e-09 112.90000000000001p 1.8920289999999998e-09 112.91249999999999p 1.8643779999999999e-09 112.925p 1.8343769999999999e-09 112.9375p 1.8020659999999999e-09 112.94999999999999p 1.767489e-09
+ 112.96250000000001p 1.730694e-09 112.97500000000001p 1.691731e-09 112.9875p 1.6506520000000001e-09 113p 1.607512e-09 113.0125p 1.5623689999999999e-09 113.02500000000001p 1.515284e-09 113.03749999999999p 1.4663190000000001e-09 113.05p 1.4155389999999999e-09 113.0625p 1.363013e-09 113.07499999999999p 1.3088079999999999e-09 113.08749999999999p 1.2529960000000001e-09 113.10000000000001p 1.1956519999999999e-09 113.11250000000001p 1.1368500000000001e-09 113.125p 1.076667e-09 113.1375p 1.0151829999999999e-09 113.15000000000001p 9.5247680000000002e-10 113.16249999999999p 8.8863090000000004e-10 113.175p 8.2372810000000002e-10
+ 113.1875p 7.5785290000000002e-10 113.19999999999999p 6.9109049999999999e-10 113.21249999999999p 6.2352740000000002e-10 113.22500000000001p 5.552509e-10 113.23750000000001p 4.8634899999999997e-10 113.25p 4.1691050000000002e-10 113.2625p 3.4702459999999997e-10 113.27500000000001p 2.7678109999999999e-10 113.28749999999999p 2.0626979999999999e-10 113.3p 1.355811e-10 113.3125p 6.4805189999999996e-11 113.32499999999999p -5.967676e-12 113.33749999999999p -7.6647419999999999e-11 113.35000000000001p -1.4714419999999999e-10 113.36250000000001p -2.1736869999999999e-10 113.375p -2.8723189999999998e-10 113.3875p -3.5664550000000002e-10 113.40000000000001p -4.2552200000000001e-10
+ 113.41249999999999p -4.9377459999999996e-10 113.425p -5.6131760000000004e-10 113.4375p -6.2806609999999998e-10 113.45p -6.939368e-10 113.46249999999999p -7.5884719999999996e-10 113.47499999999999p -8.2271650000000005e-10 113.48750000000001p -8.8546529999999999e-10 113.5p -9.4701569999999998e-10 113.5125p -1.0072910000000001e-09 113.52500000000001p -1.0662180000000001e-09 113.53749999999999p -1.123724e-09 113.55p -1.179737e-09 113.5625p -1.2341889999999999e-09 113.575p -1.287015e-09 113.58749999999999p -1.3381490000000001e-09 113.59999999999999p -1.3875300000000001e-09 113.61250000000001p -1.4350979999999999e-09 113.625p -1.4807960000000001e-09
+ 113.6375p -1.52457e-09 113.65000000000001p -1.5663669999999999e-09 113.66249999999999p -1.606138e-09 113.675p -1.6438359999999999e-09 113.6875p -1.6794170000000001e-09 113.7p -1.7128389999999999e-09 113.71249999999999p -1.7440659999999999e-09 113.72499999999999p -1.7730600000000001e-09 113.7375p -1.7997889999999999e-09 113.75p -1.8242250000000001e-09 113.7625p -1.8463389999999999e-09 113.77500000000001p -1.866109e-09 113.78750000000001p -1.883513e-09 113.8p -1.898535e-09 113.8125p -1.9111599999999998e-09 113.825p -1.9213770000000001e-09 113.83749999999999p -1.9291760000000001e-09 113.84999999999999p -1.9345540000000001e-09
+ 113.8625p -1.937509e-09 113.875p -1.9380400000000001e-09 113.8875p -1.9361529999999999e-09 113.90000000000001p -1.931855e-09 113.91250000000001p -1.9251550000000001e-09 113.925p -1.9160680000000002e-09 113.9375p -1.9046100000000001e-09 113.95p -1.8907989999999998e-09 113.96249999999999p -1.8746589999999999e-09 113.97499999999999p -1.8562150000000001e-09 113.9875p -1.8354940000000001e-09 114p -1.8125279999999999e-09 114.0125p -1.7873509999999999e-09 114.02500000000001p -1.7599979999999999e-09 114.03750000000001p -1.730511e-09 114.05p -1.6989289999999999e-09 114.0625p -1.665298e-09 114.075p -1.629664e-09
+ 114.08749999999999p -1.5920779999999999e-09 114.09999999999999p -1.552591e-09 114.1125p -1.511256e-09 114.125p -1.4681310000000001e-09 114.1375p -1.423274e-09 114.15000000000001p -1.376746e-09 114.16250000000001p -1.328608e-09 114.175p -1.278926e-09 114.1875p -1.227766e-09 114.2p -1.1751969999999999e-09 114.21249999999999p -1.1212859999999999e-09 114.22499999999999p -1.066107e-09 114.2375p -1.009732e-09 114.25p -9.5223370000000007e-10 114.2625p -8.936889e-10 114.27500000000001p -8.3417369999999996e-10 114.28750000000001p -7.7376559999999995e-10 114.3p -7.1254309999999996e-10
+ 114.3125p -6.5058559999999997e-10 114.325p -5.8797310000000004e-10 114.33749999999999p -5.2478639999999999e-10 114.34999999999999p -4.6110679999999999e-10 114.3625p -3.9701600000000001e-10 114.375p -3.3259610000000002e-10 114.3875p -2.6792930000000001e-10 114.40000000000001p -2.030979e-10 114.41250000000001p -1.3818439999999999e-10 114.425p -7.3271020000000003e-11 114.4375p -8.4398880000000004e-12 114.45p 5.6227259999999998e-11 114.46249999999999p 1.2064909999999999e-10 114.47499999999999p 1.847447e-10 114.4875p 2.4843389999999999e-10 114.5p 3.1163720000000001e-10 114.5125p 3.7427590000000001e-10 114.52500000000001p 4.3627229999999999e-10
+ 114.53750000000001p 4.9754970000000001e-10 114.55p 5.5803240000000003e-10 114.5625p 6.17646e-10 114.575p 6.7631750000000003e-10 114.58750000000001p 7.3397500000000004e-10 114.59999999999999p 7.9054849999999996e-10 114.6125p 8.4596919999999998e-10 114.625p 9.0017019999999997e-10 114.6375p 9.530862000000001e-10 114.65000000000001p 1.0046540000000001e-09 114.66250000000001p 1.0548109999999999e-09 114.675p 1.1034990000000001e-09 114.6875p 1.15066e-09 114.7p 1.196238e-09 114.71250000000001p 1.24018e-09 114.72499999999999p 1.2824359999999999e-09 114.7375p 1.322955e-09 114.75p 1.361693e-09
+ 114.76249999999999p 1.3986050000000001e-09 114.77500000000001p 1.4336499999999999e-09 114.78750000000001p 1.466788e-09 114.8p 1.497983e-09 114.8125p 1.527201e-09 114.825p 1.5544109999999999e-09 114.83750000000001p 1.579585e-09 114.84999999999999p 1.602696e-09 114.8625p 1.6237220000000001e-09 114.875p 1.6426409999999999e-09 114.88749999999999p 1.6594370000000001e-09 114.90000000000001p 1.674094e-09 114.91250000000001p 1.6865999999999999e-09 114.92500000000001p 1.696946e-09 114.9375p 1.7051260000000001e-09 114.95p 1.711135e-09 114.96250000000001p 1.714973e-09 114.97499999999999p 1.716642e-09
+ 114.9875p 1.716145e-09 115p 1.713491e-09 115.01249999999999p 1.7086909999999999e-09 115.02499999999999p 1.701755e-09 115.03750000000001p 1.6927010000000001e-09 115.05000000000001p 1.6815469999999999e-09 115.0625p 1.668312e-09 115.075p 1.653022e-09 115.08750000000001p 1.6357020000000001e-09 115.09999999999999p 1.61638e-09 115.1125p 1.5950879999999999e-09 115.125p 1.57186e-09 115.13749999999999p 1.5467300000000001e-09 115.14999999999999p 1.5197390000000001e-09 115.16250000000001p 1.490925e-09 115.17500000000001p 1.4603320000000001e-09 115.1875p 1.4280060000000001e-09 115.2p 1.3939920000000001e-09
+ 115.21250000000001p 1.3583400000000001e-09 115.22499999999999p 1.321101e-09 115.2375p 1.2823289999999999e-09 115.25p 1.242077e-09 115.26249999999999p 1.2004019999999999e-09 115.27499999999999p 1.1573629999999999e-09 115.28749999999999p 1.113019e-09 115.30000000000001p 1.067431e-09 115.3125p 1.0206620000000001e-09 115.325p 9.7277670000000001e-10 115.33750000000001p 9.2383950000000003e-10 115.34999999999999p 8.7391689999999996e-10 115.3625p 8.2307650000000004e-10 115.375p 7.7138660000000001e-10 115.3875p 7.1891670000000002e-10 115.39999999999999p 6.657367e-10 115.41249999999999p 6.1191759999999995e-10 115.42500000000001p 5.5753060000000002e-10
+ 115.4375p 5.0264789999999997e-10 115.45p 4.4734160000000002e-10 115.46250000000001p 3.9168450000000002e-10 115.47499999999999p 3.3574940000000002e-10 115.4875p 2.7960939999999999e-10 115.5p 2.233374e-10 115.5125p 1.670066e-10 115.52499999999999p 1.106897e-10 115.53749999999999p 5.4459349999999998e-11 115.55p -1.612274e-12 115.5625p -5.7453330000000002e-11 115.575p -1.129926e-10 115.58750000000001p -1.681593e-10 115.59999999999999p -2.2288359999999999e-10 115.6125p -2.7709630000000001e-10 115.625p -3.3072909999999998e-10 115.6375p -3.8371479999999999e-10 115.64999999999999p -4.3598710000000002e-10
+ 115.66249999999999p -4.8748099999999996e-10 115.675p -5.3813259999999998e-10 115.6875p -5.8787919999999999e-10 115.7p -6.3665979999999999e-10 115.71250000000001p -6.8441460000000004e-10 115.72500000000001p -7.3108529999999995e-10 115.7375p -7.7661549999999996e-10 115.75p -8.2095009999999997e-10 115.7625p -8.6403589999999998e-10 115.77499999999999p -9.0582170000000001e-10 115.78749999999999p -9.4625779999999992e-10 115.8p -9.8529660000000005e-10 115.8125p -1.0228930000000001e-09 115.825p -1.059002e-09 115.83750000000001p -1.093583e-09 115.85000000000001p -1.1265970000000001e-09 115.8625p -1.1580070000000001e-09 115.875p -1.1877770000000001e-09
+ 115.8875p -1.2158740000000001e-09 115.89999999999999p -1.242269e-09 115.91249999999999p -1.266933e-09 115.925p -1.28984e-09 115.9375p -1.3109669999999999e-09 115.95p -1.330294e-09 115.96250000000001p -1.3478009999999999e-09 115.97500000000001p -1.3634720000000001e-09 115.9875p -1.3772939999999999e-09 116p -1.3892550000000001e-09 116.0125p -1.3993479999999999e-09 116.02499999999999p -1.407565e-09 116.03749999999999p -1.4139040000000001e-09 116.05p -1.418361e-09 116.0625p -1.4209400000000001e-09 116.075p -1.4216440000000001e-09 116.08750000000001p -1.420478e-09 116.10000000000001p -1.4174519999999999e-09
+ 116.1125p -1.4125760000000001e-09 116.125p -1.405864e-09 116.1375p -1.3973310000000001e-09 116.14999999999999p -1.386996e-09 116.16249999999999p -1.3748780000000001e-09 116.175p -1.361002e-09 116.1875p -1.345391e-09 116.2p -1.3280730000000001e-09 116.21250000000001p -1.309076e-09 116.22500000000001p -1.2884340000000001e-09 116.2375p -1.2661780000000001e-09 116.25p -1.2423439999999999e-09 116.2625p -1.2169710000000001e-09 116.27499999999999p -1.1900969999999999e-09 116.28749999999999p -1.1617630000000001e-09 116.3p -1.1320119999999999e-09 116.3125p -1.1008899999999999e-09 116.325p -1.068443e-09
+ 116.33750000000001p -1.0347179999999999e-09 116.35000000000001p -9.997652999999999e-10 116.3625p -9.636358000000001e-10 116.375p -9.2638190000000005e-10 116.3875p -8.880573e-10 116.39999999999999p -8.4871689999999999e-10 116.41249999999999p -8.0841690000000003e-10 116.42499999999998p -7.6721440000000004e-10 116.43749999999999p -7.2516769999999998e-10 116.45p -6.8233589999999998e-10 116.46250000000001p -6.3877900000000003e-10 116.47500000000001p -5.9455779999999998e-10 116.48750000000001p -5.4973369999999996e-10 116.50000000000001p -5.0436869999999999e-10 116.51249999999999p -4.5852549999999998e-10 116.52499999999999p -4.1226690000000001e-10 116.53749999999999p -3.656564e-10 116.55p -3.1875750000000002e-10
+ 116.5625p -2.7163400000000001e-10 116.575p -2.243499e-10 116.58750000000001p -1.769689e-10 116.59999999999999p -1.2955489999999999e-10 116.6125p -8.2171449999999996e-11 116.625p -3.488206e-11 116.6375p 1.225025e-11 116.65000000000001p 5.9162809999999999e-11 116.66250000000001p 1.057935e-10 116.67499999999998p 1.520807e-10 116.68749999999999p 1.9796340000000001e-10 116.69999999999999p 2.433815e-10 116.71250000000001p 2.882756e-10 116.72500000000001p 3.3258720000000002e-10 116.73750000000001p 3.7625879999999998e-10 116.75000000000001p 4.1923379999999998e-10 116.76249999999999p 4.6145690000000002e-10 116.77499999999999p 5.0287380000000001e-10
+ 116.78749999999999p 5.4343150000000002e-10 116.8p 5.8307859999999998e-10 116.8125p 6.2176450000000002e-10 116.825p 6.5944069999999996e-10 116.83750000000001p 6.9605959999999995e-10 116.84999999999999p 7.3157570000000005e-10 116.8625p 7.6594459999999996e-10 116.875p 7.9912399999999996e-10 116.8875p 8.3107319999999999e-10 116.90000000000001p 8.617531e-10 116.91250000000001p 8.9112659999999995e-10 116.92500000000001p 9.191585e-10 116.93749999999999p 9.4581539999999993e-10 116.94999999999999p 9.7106589999999997e-10 116.96249999999999p 9.948803999999999e-10 116.97500000000001p 1.017232e-09 116.98750000000001p 1.0380939999999999e-09 117.00000000000001p 1.057445e-09
+ 117.01249999999999p 1.075263e-09 117.02499999999999p 1.091528e-09 117.03749999999999p 1.106224e-09 117.05p 1.1193370000000001e-09 117.0625p 1.1308520000000001e-09 117.075p 1.1407619999999999e-09 117.08750000000001p 1.1490559999999999e-09 117.09999999999999p 1.1557280000000001e-09 117.1125p 1.160776e-09 117.125p 1.164198e-09 117.1375p 1.1659940000000001e-09 117.15000000000001p 1.1661660000000001e-09 117.16250000000001p 1.164721e-09 117.17500000000001p 1.1616639999999999e-09 117.18749999999999p 1.1570060000000001e-09 117.19999999999999p 1.1507569999999999e-09 117.21249999999999p 1.1429319999999999e-09 117.22499999999999p 1.1335449999999999e-09
+ 117.23750000000001p 1.1226150000000001e-09 117.25000000000001p 1.1101609999999999e-09 117.26250000000002p 1.0962049999999999e-09 117.27499999999999p 1.0807710000000001e-09 117.28749999999999p 1.0638840000000001e-09 117.3p 1.045572e-09 117.3125p 1.0258629999999999e-09 117.325p 1.00479e-09 117.33750000000001p 9.823856e-10 117.34999999999999p 9.5868369999999998e-10 117.3625p 9.3372090000000004e-10 117.375p 9.0753510000000004e-10 117.3875p 8.8016570000000005e-10 117.40000000000001p 8.5165380000000002e-10 117.41250000000001p 8.2204170000000001e-10 117.42500000000001p 7.9137309999999998e-10 117.43749999999999p 7.5969310000000005e-10 117.44999999999999p 7.2704820000000003e-10
+ 117.46249999999999p 6.9348570000000003e-10 117.47499999999999p 6.5905430000000004e-10 117.4875p 6.2380359999999997e-10 117.50000000000001p 5.877845e-10 117.51250000000002p 5.5104829999999995e-10 117.52499999999999p 5.1364750000000001e-10 117.53749999999999p 4.7563540000000001e-10 117.55p 4.370657e-10 117.5625p 3.9799289999999998e-10 117.575p 3.5847219999999998e-10 117.58750000000001p 3.1855899999999997e-10 117.60000000000001p 2.7830910000000002e-10 117.6125p 2.3777889999999999e-10 117.625p 1.9702479999999999e-10 117.6375p 1.5610340000000001e-10 117.65000000000001p 1.150714e-10 117.66250000000001p 7.3985600000000001e-11 117.67500000000001p 3.2902599999999999e-11
+ 117.68749999999999p -8.1210479999999993e-12 117.69999999999999p -4.902903e-11 117.71249999999999p -8.9765320000000003e-11 117.72499999999999p -1.3027430000000001e-10 117.7375p -1.7050059999999999e-10 117.75p -2.1038969999999999e-10 117.76250000000002p -2.498874e-10 117.77499999999999p -2.889402e-10 117.78749999999999p -3.2749539999999999e-10 117.8p -3.6550099999999999e-10 117.8125p -4.0290589999999999e-10 117.825p -4.3966000000000001e-10 117.83750000000001p -4.7571409999999997e-10 117.85000000000001p -5.1102009999999999e-10 117.86249999999998p -5.4553099999999998e-10 117.875p -5.7920100000000004e-10 117.8875p -6.1198549999999999e-10 117.90000000000001p -6.4384130000000002e-10
+ 117.91250000000001p -6.747264e-10 117.92500000000001p -7.0460039999999995e-10 117.93750000000001p -7.334241e-10 117.94999999999999p -7.6115999999999999e-10 117.96249999999999p -7.8777210000000001e-10 117.97499999999999p -8.1322599999999996e-10 117.9875p -8.3748899999999996e-10 118p -8.6052989999999999e-10 118.0125p -8.8231949999999995e-10 118.02499999999999p -9.028301e-10 118.03749999999999p -9.2203579999999996e-10 118.05p -9.3991279999999998e-10 118.0625p -9.5643889999999992e-10 118.075p -9.715937000000001e-10 118.08750000000001p -9.8535890000000006e-10 118.10000000000001p -9.9771809999999996e-10 118.11249999999998p -1.008657e-09 118.12499999999999p -1.0181619999999999e-09
+ 118.1375p -1.026224e-09 118.15000000000001p -1.032833e-09 118.16250000000001p -1.037984e-09 118.17500000000001p -1.0416710000000001e-09 118.18750000000001p -1.0438909999999999e-09 118.19999999999999p -1.0446440000000001e-09 118.21249999999999p -1.0439319999999999e-09 118.22499999999999p -1.041757e-09 118.2375p -1.0381250000000001e-09 118.25p -1.033044e-09 118.2625p -1.026521e-09 118.27500000000002p -1.018569e-09 118.28749999999999p -1.0092e-09 118.3p -9.9842959999999991e-10 118.3125p -9.8627420000000004e-10 118.325p -9.7275259999999998e-10 118.33750000000001p -9.5788499999999994e-10 118.35000000000001p -9.4169390000000009e-10
+ 118.36249999999998p -9.2420310000000003e-10 118.37499999999999p -9.0543840000000004e-10 118.38749999999999p -8.8542710000000002e-10 118.40000000000001p -8.6419820000000002e-10 118.41250000000001p -8.417824e-10 118.42500000000001p -8.1821179999999996e-10 118.43750000000001p -7.9352020000000003e-10 118.44999999999999p -7.6774250000000005e-10 118.46249999999999p -7.4091540000000004e-10 118.47499999999999p -7.130768e-10 118.4875p -6.8426589999999999e-10 118.5p -6.5452309999999999e-10 118.5125p -6.2389010000000004e-10 118.52500000000001p -5.924096e-10 118.53749999999999p -5.6012559999999995e-10 118.55p -5.2708300000000003e-10 118.5625p -4.9332750000000002e-10 118.575p -4.5890599999999999e-10
+ 118.58750000000001p -4.2386600000000002e-10 118.60000000000001p -3.8825569999999999e-10 118.61249999999998p -3.521243e-10 118.62499999999999p -3.1552150000000003e-10 118.63749999999999p -2.7849729999999999e-10 118.65000000000001p -2.4110270000000001e-10 118.66250000000001p -2.033886e-10 118.67500000000001p -1.6540670000000001e-10 118.68750000000001p -1.2720869999999999e-10 118.69999999999999p -8.8846700000000003e-11 118.71249999999999p -5.0372810000000003e-11 118.72499999999999p -1.183932e-11 118.7375p 2.6701499999999999e-11 118.75p 6.5197450000000006e-11 118.7625p 1.035964e-10 118.77500000000001p 1.4184660000000001e-10 118.78749999999999p 1.798963e-10 118.8p 2.1769419999999999e-10
+ 118.8125p 2.5518939999999999e-10 118.825p 2.9233160000000001e-10 118.83750000000001p 3.2907090000000001e-10 118.85000000000001p 3.6535779999999999e-10 118.86250000000001p 4.0114400000000001e-10 118.87499999999999p 4.3638139999999998e-10 118.88749999999999p 4.7102289999999999e-10 118.89999999999999p 5.0502229999999999e-10 118.91250000000001p 5.3833429999999997e-10 118.92500000000001p 5.709144e-10 118.93750000000001p 6.0271939999999998e-10 118.94999999999999p 6.3370709999999998e-10 118.96249999999999p 6.6383619999999998e-10 118.97499999999999p 6.9306679999999998e-10 118.9875p 7.213604e-10 119p 7.4867939999999996e-10 119.0125p 7.7498789999999998e-10 119.02500000000001p 8.0025119999999997e-10
+ 119.03749999999999p 8.244361e-10 119.05p 8.4751080000000005e-10 119.0625p 8.6944499999999999e-10 119.075p 8.902101e-10 119.08750000000001p 9.0977900000000003e-10 119.10000000000001p 9.2812609999999998e-10 119.11250000000001p 9.4522769999999994e-10 119.12499999999999p 9.6106160000000008e-10 119.13749999999999p 9.7560730000000007e-10 119.14999999999999p 9.8884599999999992e-10 119.16249999999999p 1.0007610000000001e-09 119.17500000000001p 1.011337e-09 119.18750000000001p 1.02056e-09 119.20000000000002p 1.0284200000000001e-09 119.21249999999999p 1.034905e-09 119.22499999999999p 1.0400089999999999e-09 119.2375p 1.0437249999999999e-09 119.25p 1.046049e-09
+ 119.2625p 1.046978e-09 119.27500000000001p 1.046512e-09 119.28749999999999p 1.044653e-09 119.3p 1.041402e-09 119.3125p 1.0367660000000001e-09 119.325p 1.0307510000000001e-09 119.33750000000001p 1.0233659999999999e-09 119.35000000000001p 1.01462e-09 119.36250000000001p 1.0045269999999999e-09 119.37499999999999p 9.9310020000000008e-10 119.38749999999999p 9.8035499999999997e-10 119.39999999999999p 9.6630910000000007e-10 119.41249999999999p 9.5098160000000005e-10 119.425p 9.343931999999999e-10 119.43750000000001p 9.1656639999999996e-10 119.45000000000002p 8.9752529999999995e-10 119.46249999999999p 8.7729540000000004e-10 119.47499999999999p 8.5590379999999998e-10
+ 119.4875p 8.3337929999999995e-10 119.5p 8.0975190000000001e-10 119.5125p 7.8505319999999998e-10 119.52500000000001p 7.5931599999999999e-10 119.53750000000001p 7.325746e-10 119.55p 7.048646e-10 119.5625p 6.762227e-10 119.575p 6.4668679999999998e-10 119.58750000000001p 6.16296e-10 119.60000000000001p 5.8509059999999998e-10 119.61250000000001p 5.5311159999999996e-10 119.62499999999999p 5.2040129999999998e-10 119.63749999999999p 4.8700280000000004e-10 119.64999999999999p 4.5296000000000001e-10 119.66249999999999p 4.1831760000000002e-10 119.675p 3.8312119999999999e-10 119.6875p 3.4741690000000002e-10 119.70000000000002p 3.112515e-10
+ 119.71249999999999p 2.746723e-10 119.72499999999999p 2.3772729999999998e-10 119.7375p 2.0046459999999999e-10 119.75p 1.62933e-10 119.7625p 1.2518140000000001e-10 119.77500000000001p 8.7258880000000004e-11 119.78750000000001p 4.921492e-11 119.79999999999998p 1.109895e-11 119.8125p -2.70395e-11 119.825p -6.5150929999999997e-11 119.83750000000001p -1.0318590000000001e-10 119.85000000000001p -1.410952e-10 119.86250000000001p -1.7882980000000001e-10 119.87500000000001p -2.1634069999999999e-10 119.88749999999999p -2.5357970000000003e-10 119.89999999999999p -2.9049869999999998e-10 119.91249999999999p -3.270501e-10 119.925p -3.6318679999999998e-10
+ 119.9375p -3.988624e-10 119.95p -4.3403100000000001e-10 119.96249999999999p -4.6864759999999999e-10 119.97499999999999p -5.0266769999999997e-10 119.9875p -5.3604789999999998e-10 120p -5.6874540000000001e-10 120.0125p -6.0071860000000004e-10 120.02500000000001p -6.3192659999999996e-10 120.03750000000001p -6.6232979999999996e-10 120.04999999999998p -6.9188950000000002e-10 120.06249999999999p -7.2056819999999997e-10 120.075p -7.4832960000000002e-10 120.08750000000001p -7.7513850000000001e-10 120.10000000000001p -8.0096110000000003e-10 120.11250000000001p -8.2576499999999999e-10 120.12500000000001p -8.4951880000000001e-10 120.13749999999999p -8.7219289999999996e-10 120.14999999999999p -8.9375879999999995e-10
+ 120.16249999999999p -9.141896e-10 120.175p -9.3346e-10 120.1875p -9.5154610000000009e-10 120.2p -9.6842549999999995e-10 120.21250000000001p -9.8407750000000001e-10 120.22499999999999p -9.9848289999999994e-10 120.2375p -1.0116239999999999e-09 120.25p -1.023485e-09 120.2625p -1.0340530000000001e-09 120.27500000000001p -1.0433129999999999e-09 120.28750000000001p -1.0512559999999999e-09 120.29999999999998p -1.057872e-09 120.31249999999999p -1.063154e-09 120.32499999999999p -1.0670959999999999e-09 120.33750000000001p -1.069695e-09 120.35000000000001p -1.0709480000000001e-09 120.36250000000001p -1.0708539999999999e-09 120.37500000000001p -1.0694150000000001e-09
+ 120.38749999999999p -1.066633e-09 120.39999999999999p -1.0625139999999999e-09 120.41249999999999p -1.0570639999999999e-09 120.425p -1.0502900000000001e-09 120.4375p -1.042204e-09 120.45p -1.032815e-09 120.46250000000001p -1.022137e-09 120.47499999999999p -1.0101850000000001e-09 120.4875p -9.9697579999999991e-10 120.5p -9.8252629999999998e-10 120.5125p -9.6685629999999997e-10 120.52500000000001p -9.4998700000000002e-10 120.53750000000001p -9.3194080000000004e-10 120.55000000000001p -9.1274180000000005e-10 120.56249999999999p -8.9241539999999999e-10 120.57499999999999p -8.7098829999999998e-10 120.58749999999999p -8.4848900000000003e-10 120.60000000000001p -8.2494680000000004e-10
+ 120.61250000000001p -8.003927e-10 120.62500000000001p -7.7485870000000005e-10 120.63749999999999p -7.483782e-10 120.64999999999999p -7.2098559999999995e-10 120.66249999999999p -6.9271639999999995e-10 120.675p -6.6360740000000005e-10 120.6875p -6.3369609999999999e-10 120.7p -6.0302120000000002e-10 120.71250000000001p -5.7162220000000002e-10 120.72499999999999p -5.3953959999999996e-10 120.7375p -5.0681460000000005e-10 120.75p -4.7348920000000004e-10 120.7625p -4.3960589999999998e-10 120.77500000000001p -4.0520830000000002e-10 120.78750000000001p -3.7034010000000002e-10 120.80000000000001p -3.350458e-10 120.81249999999999p -2.9937039999999999e-10 120.82499999999999p -2.6335920000000001e-10
+ 120.83749999999999p -2.2705789999999999e-10 120.85000000000001p -1.9051240000000001e-10 120.86250000000001p -1.537691e-10 120.87500000000001p -1.168742e-10 120.88749999999999p -7.9874430000000003e-11 120.89999999999999p -4.2816269999999999e-11 120.91249999999999p -5.7463229999999998e-12 120.925p 3.1288880000000002e-11 120.9375p 6.8242949999999999e-11 120.95p 1.0506959999999999e-10 120.96250000000001p 1.41723e-10 120.97499999999999p 1.781573e-10 120.9875p 2.1432720000000001e-10 121p 2.5018789999999999e-10 121.0125p 2.8569470000000002e-10 121.02500000000001p 3.2080390000000002e-10 121.03750000000001p 3.5547210000000001e-10 121.05000000000001p 3.8965659999999998e-10
+ 121.06249999999999p 4.2331520000000001e-10 121.07499999999999p 4.5640690000000002e-10 121.08749999999999p 4.8889099999999996e-10 121.09999999999999p 5.2072789999999997e-10 121.11250000000001p 5.5187890000000002e-10 121.12500000000001p 5.8230610000000003e-10 121.13750000000002p 6.1197279999999997e-10 121.14999999999999p 6.4084299999999996e-10 121.16249999999999p 6.6888210000000002e-10 121.175p 6.9605649999999999e-10 121.1875p 7.2233369999999997e-10 121.2p 7.4768250000000002e-10 121.21250000000001p 7.720729e-10 121.22499999999999p 7.9547599999999999e-10 121.2375p 8.1786449999999999e-10 121.25p 8.3921230000000005e-10 121.2625p 8.5949449999999998e-10 121.27500000000001p 8.7868799999999997e-10
+ 121.28750000000001p 8.9677070000000001e-10 121.30000000000001p 9.1372209999999997e-10 121.31249999999999p 9.2952339999999996e-10 121.32499999999999p 9.4415690000000002e-10 121.33749999999999p 9.5760679999999998e-10 121.34999999999999p 9.698583999999999e-10 121.3625p 9.8089900000000009e-10 121.37500000000001p 9.907172e-10 121.38750000000002p 9.9930310000000001e-10 121.39999999999999p 1.0066489999999999e-09 121.41249999999999p 1.0127469999999999e-09 121.425p 1.0175929999999999e-09 121.4375p 1.021184e-09 121.45p 1.0235170000000001e-09 121.46250000000001p 1.024593e-09 121.47500000000001p 1.024412e-09 121.4875p 1.0229779999999999e-09 121.5p 1.0202949999999999e-09
+ 121.5125p 1.0163700000000001e-09 121.52500000000001p 1.011209e-09 121.53750000000001p 1.0048220000000001e-09 121.55000000000001p 9.9721979999999993e-10 121.56249999999999p 9.8841450000000009e-10 121.57499999999999p 9.7841989999999999e-10 121.58749999999999p 9.6725100000000005e-10 121.59999999999999p 9.5492450000000004e-10 121.6125p 9.4145849999999991e-10 121.625p 9.2687239999999996e-10 121.63750000000002p 9.1118710000000004e-10 121.64999999999999p 8.9442470000000005e-10 121.66249999999999p 8.766086e-10 121.675p 8.5776369999999998e-10 121.6875p 8.3791589999999997e-10 121.7p 8.1709239999999996e-10 121.71250000000001p 7.9532149999999996e-10 121.72500000000001p 7.7263290000000004e-10
+ 121.73749999999998p 7.4905699999999997e-10 121.75p 7.2462539999999999e-10 121.7625p 6.9937090000000001e-10 121.77500000000001p 6.7332690000000004e-10 121.78750000000001p 6.4652809999999995e-10 121.80000000000001p 6.1900970000000002e-10 121.81250000000001p 5.9080800000000003e-10 121.82499999999999p 5.6195989999999996e-10 121.83749999999999p 5.3250319999999996e-10 121.84999999999999p 5.024761e-10 121.8625p 4.7191779999999998e-10 121.875p 4.4086769999999999e-10 121.8875p 4.0936589999999999e-10 121.89999999999999p 3.77453e-10 121.91249999999999p 3.4517000000000001e-10 121.925p 3.1255799999999999e-10 121.9375p 2.7965890000000001e-10 121.95p 2.465145e-10
+ 121.96250000000001p 2.1316679999999999e-10 121.97500000000001p 1.7965809999999999e-10 121.98749999999998p 1.460307e-10 121.99999999999999p 1.123269e-10 122.0125p 7.8589070000000003e-11 122.02500000000001p 4.4859510000000002e-11 122.03750000000001p 1.1180319999999999e-11 122.05000000000001p -2.240654e-11 122.06250000000001p -5.5859350000000001e-11 122.07499999999999p -8.9136679999999998e-11 122.08749999999999p -1.221974e-10 122.09999999999999p -1.5500090000000001e-10 122.1125p -1.875068e-10 122.125p -2.1967539999999999e-10 122.1375p -2.5146740000000001e-10 122.15000000000001p -2.8284420000000002e-10 122.16249999999999p -3.1376780000000002e-10 122.175p -3.4420080000000001e-10
+ 122.1875p -3.7410679999999998e-10 122.2p -4.0344979999999998e-10 122.21250000000001p -4.3219480000000001e-10 122.22500000000001p -4.6030780000000001e-10 122.23749999999998p -4.8775549999999999e-10 122.24999999999999p -5.1450550000000003e-10 122.26249999999999p -5.4052669999999998e-10 122.27500000000001p -5.6578869999999997e-10 122.28750000000001p -5.902623e-10 122.30000000000001p -6.1391929999999997e-10 122.31250000000001p -6.3673269999999996e-10 122.32499999999999p -6.5867670000000003e-10 122.33749999999999p -6.7972660000000004e-10 122.34999999999999p -6.9985880000000003e-10 122.3625p -7.1905130000000001e-10 122.375p -7.3728289999999995e-10 122.3875p -7.5453410000000004e-10 122.40000000000001p -7.707865e-10
+ 122.41249999999999p -7.8602299999999996e-10 122.425p -8.0022800000000002e-10 122.4375p -8.1338710000000003e-10 122.45p -8.2548740000000001e-10 122.46250000000001p -8.3651719999999996e-10 122.47500000000001p -8.4646660000000003e-10 122.48750000000001p -8.5532660000000004e-10 122.49999999999999p -8.6308999999999996e-10 122.51249999999999p -8.697509e-10 122.52499999999999p -8.7530480000000005e-10 122.53750000000001p -8.7974869999999999e-10 122.55000000000001p -8.8308079999999996e-10 122.56250000000001p -8.8530109999999997e-10 122.57499999999999p -8.8641069999999996e-10 122.58749999999999p -8.8641229999999995e-10 122.59999999999999p -8.8530989999999998e-10 122.6125p -8.8310899999999995e-10 122.625p -8.7981630000000003e-10
+ 122.6375p -8.7544019999999999e-10 122.65000000000001p -8.6999010000000004e-10 122.66249999999999p -8.6347699999999997e-10 122.675p -8.5591300000000002e-10 122.6875p -8.473118e-10 122.7p -8.3768819999999997e-10 122.71250000000001p -8.2705819999999998e-10 122.72500000000001p -8.1543909999999995e-10 122.73750000000001p -8.0284950000000002e-10 122.74999999999999p -7.8930909999999996e-10 122.76249999999999p -7.7483880000000001e-10 122.77499999999999p -7.5946050000000004e-10 122.78749999999999p -7.4319720000000002e-10 122.80000000000001p -7.2607320000000004e-10 122.81250000000001p -7.0811359999999996e-10 122.82500000000002p -6.8934460000000004e-10 122.83749999999999p -6.6979309999999997e-10 122.84999999999999p -6.4948729999999996e-10
+ 122.8625p -6.2845599999999999e-10 122.875p -6.0672889999999999e-10 122.8875p -5.8433649999999999e-10 122.90000000000001p -5.6131010000000003e-10 122.91249999999999p -5.3768160000000004e-10 122.925p -5.1348370000000001e-10 122.9375p -4.8874959999999997e-10 122.95p -4.6351300000000001e-10 122.96250000000001p -4.378085e-10 122.97500000000001p -4.116707e-10 122.98750000000001p -3.851349e-10 122.99999999999999p -3.5823689999999999e-10 123.01249999999999p -3.310125e-10 123.02499999999999p -3.0349819999999998e-10 123.03749999999999p -2.7573029999999998e-10 123.05p -2.4774559999999999e-10 123.06250000000001p -2.1958099999999999e-10 123.07500000000002p -1.9127350000000001e-10
+ 123.08749999999999p -1.6285999999999999e-10 123.09999999999999p -1.343777e-10 123.1125p -1.058635e-10 123.125p -7.7354279999999999e-11 123.1375p -4.8886780000000001e-11 123.15000000000001p -2.049757e-11 123.16250000000001p 7.7770320000000004e-12 123.175p 3.5900979999999997e-11 123.1875p 6.3838549999999999e-11 123.2p 9.1554420000000002e-11 123.21250000000001p 1.190137e-10 123.22500000000001p 1.4618180000000001e-10 123.23750000000001p 1.730249e-10 123.24999999999999p 1.9950959999999999e-10 123.26249999999999p 2.25603e-10 123.27499999999999p 2.512729e-10 123.28749999999999p 2.764879e-10 123.3p 3.0121720000000001e-10
+ 123.31250000000001p 3.254307e-10 123.32500000000002p 3.4909900000000001e-10 123.33749999999999p 3.7219389999999999e-10 123.34999999999999p 3.9468760000000002e-10 123.3625p 4.1655359999999998e-10 123.375p 4.3776590000000002e-10 123.3875p 4.582998e-10 123.40000000000001p 4.7813150000000005e-10 123.41250000000001p 4.9723800000000002e-10 123.42499999999998p 5.1559760000000002e-10 123.4375p 5.3318959999999997e-10 123.45p 5.4999419999999997e-10 123.46250000000001p 5.6599299999999995e-10 123.47500000000001p 5.8116850000000001e-10 123.48750000000001p 5.9550429999999999e-10 123.49999999999999p 6.089855e-10 123.51249999999999p 6.2159799999999999e-10 123.52499999999999p 6.3332919999999998e-10
+ 123.53749999999999p 6.4416739999999996e-10 123.55p 6.5410250000000002e-10 123.5625p 6.6312519999999998e-10 123.57500000000002p 6.7122769999999996e-10 123.58749999999999p 6.784034e-10 123.59999999999999p 6.8464699999999998e-10 123.6125p 6.8995430000000001e-10 123.625p 6.9432250000000001e-10 123.6375p 6.9774999999999999e-10 123.65000000000001p 7.0023630000000001e-10 123.66250000000001p 7.0178239999999997e-10 123.67499999999998p 7.0239040000000001e-10 123.6875p 7.0206359999999996e-10 123.7p 7.0080660000000004e-10 123.71250000000001p 6.9862520000000002e-10 123.72500000000001p 6.9552639999999997e-10 123.73750000000001p 6.9151840000000001e-10 123.75000000000001p 6.8661039999999999e-10
+ 123.76249999999999p 6.8081310000000001e-10 123.77499999999999p 6.7413810000000003e-10 123.78749999999999p 6.6659809999999997e-10 123.8p 6.5820700000000002e-10 123.8125p 6.4897980000000001e-10 123.825p 6.3893249999999995e-10 123.83749999999999p 6.2808199999999998e-10 123.84999999999999p 6.164465e-10 123.8625p 6.0404499999999995e-10 123.875p 5.9089739999999999e-10 123.8875p 5.7702459999999996e-10 123.90000000000001p 5.6244839999999996e-10 123.91250000000001p 5.4719139999999998e-10 123.92499999999998p 5.3127709999999995e-10 123.93749999999999p 5.1472970000000005e-10 123.95p 4.9757419999999996e-10 123.96250000000001p 4.7983639999999996e-10 123.97500000000001p 4.6154259999999999e-10
+ 123.98750000000001p 4.4271979999999999e-10 124.00000000000001p 4.2339580000000001e-10 124.01249999999999p 4.0359880000000001e-10 124.02499999999999p 3.8335740000000001e-10 124.03749999999999p 3.6270100000000001e-10 124.05p 3.4165930000000002e-10 124.0625p 3.2026220000000002e-10 124.075p 2.9854040000000001e-10 124.08750000000001p 2.7652460000000001e-10 124.09999999999999p 2.5424579999999998e-10 124.1125p 2.3173550000000001e-10 124.125p 2.0902500000000001e-10 124.1375p 1.8614599999999999e-10 124.15000000000001p 1.6313040000000001e-10 124.16250000000001p 1.4000999999999999e-10 124.17499999999998p 1.1681659999999999e-10 124.18749999999999p 9.3582130000000003e-11 124.19999999999999p 7.0338359999999996e-11
+ 124.21250000000001p 4.7117000000000001e-11 124.22500000000001p 2.3949590000000001e-11 124.23750000000001p 8.6752529999999995e-13 124.25000000000001p -2.2098070000000001e-11 124.26249999999999p -4.4916300000000002e-11 124.27499999999999p -6.7556610000000005e-11 124.28749999999999p -8.9988770000000005e-11 124.3p -1.121829e-10 124.3125p -1.341097e-10 124.325p -1.557401e-10 124.33750000000001p -1.770458e-10 124.34999999999999p -1.9799869999999999e-10 124.3625p -2.1857159999999999e-10 124.375p -2.3873769999999999e-10 124.3875p -2.58471e-10 124.40000000000001p -2.7774609999999999e-10 124.41250000000001p -2.9653810000000001e-10 124.42500000000001p -3.1482330000000002e-10
+ 124.43749999999999p -3.3257829999999998e-10 124.44999999999999p -3.497808e-10 124.46249999999999p -3.6640919999999998e-10 124.47500000000001p -3.8244279999999999e-10 124.48750000000001p -3.9786169999999998e-10 124.50000000000001p -4.1264710000000002e-10 124.51249999999999p -4.267808e-10 124.52499999999999p -4.4024580000000001e-10 124.53749999999999p -4.53026e-10 124.55p -4.6510630000000002e-10 124.5625p -4.7647249999999998e-10 124.575p -4.8711159999999998e-10 124.58750000000001p -4.9701139999999995e-10 124.59999999999999p -5.0616100000000005e-10 124.6125p -5.1455030000000004e-10 124.625p -5.2217059999999995e-10 124.6375p -5.2901379999999999e-10 124.65000000000001p -5.3507340000000004e-10
+ 124.66250000000001p -5.4034360000000003e-10 124.67500000000001p -5.4481989999999995e-10 124.68749999999999p -5.4849889999999998e-10 124.69999999999999p -5.5137810000000003e-10 124.71249999999999p -5.5345639999999996e-10 124.72499999999999p -5.5473360000000002e-10 124.73750000000001p -5.5521059999999997e-10 124.75000000000001p -5.5488949999999998e-10 124.76250000000002p -5.5377329999999996e-10 124.77499999999999p -5.5186630000000004e-10 124.78749999999999p -5.4917370000000002e-10 124.8p -5.4570189999999997e-10 124.8125p -5.4145829999999999e-10 124.825p -5.3645109999999998e-10 124.83750000000001p -5.3068990000000002e-10 124.84999999999999p -5.2418520000000005e-10 124.8625p -5.1694830000000004e-10 124.875p -5.0899160000000001e-10
+ 124.8875p -5.0032860000000004e-10 124.90000000000001p -4.9097339999999996e-10 124.91250000000001p -4.809413e-10 124.92500000000001p -4.7024840000000001e-10 124.93749999999999p -4.5891149999999998e-10 124.94999999999999p -4.4694860000000001e-10 124.96249999999999p -4.3437810000000002e-10 124.97499999999999p -4.2121950000000002e-10 124.9875p -4.074929e-10 125.00000000000001p -3.9321920000000002e-10 125.01250000000002p -3.7841989999999999e-10 125.02499999999999p -3.631173e-10 125.03749999999999p -3.4733420000000002e-10 125.05p -3.3109400000000003e-10 125.0625p -3.1442090000000001e-10 125.075p -2.9733939999999999e-10 125.08750000000001p -2.798746e-10 125.10000000000001p -2.6205189999999997e-10
+ 125.1125p -2.438974e-10 125.125p -2.254374e-10 125.1375p -2.0669869999999999e-10 125.15000000000001p -1.8770820000000001e-10 125.16250000000001p -1.684934e-10 125.17500000000001p -1.4908160000000001e-10 125.18749999999999p -1.2950089999999999e-10 125.19999999999999p -1.0977890000000001e-10 125.21249999999999p -8.994396e-11 125.22499999999999p -7.0024079999999997e-11 125.2375p -5.0047510000000001e-11 125.25p -3.0042490000000003e-11 125.26250000000002p -1.003722e-11 125.27499999999999p 9.9401339999999999e-12 125.28749999999999p 2.9861539999999998e-11 125.3p 4.969907e-11 125.3125p 6.9424990000000003e-11 125.325p 8.9011780000000005e-11
+ 125.33750000000001p 1.084322e-10 125.35000000000001p 1.276591e-10 125.36249999999998p 1.4666599999999999e-10 125.375p 1.6542650000000001e-10 125.3875p 1.8391460000000001e-10 125.40000000000001p 2.02105e-10 125.41250000000001p 2.1997240000000001e-10 125.42500000000001p 2.3749249999999999e-10 125.43750000000001p 2.546411e-10 125.44999999999999p 2.7139469999999998e-10 125.46249999999999p 2.8773059999999998e-10 125.47499999999999p 3.0362640000000001e-10 125.4875p 3.1906060000000002e-10 125.5p 3.3401210000000002e-10 125.5125p 3.4846070000000002e-10 125.52499999999999p 3.62387e-10 125.53749999999999p 3.75772e-10 125.55p 3.8859800000000002e-10
+ 125.5625p 4.008475e-10 125.575p 4.1250439999999998e-10 125.58750000000001p 4.2355299999999997e-10 125.60000000000001p 4.3397869999999998e-10 125.61249999999998p 4.4376760000000002e-10 125.62499999999999p 4.5290700000000002e-10 125.6375p 4.6138470000000001e-10 125.65000000000001p 4.6918980000000005e-10 125.66250000000001p 4.7631219999999996e-10 125.67500000000001p 4.8274260000000003e-10 125.68750000000001p 4.8847280000000003e-10 125.69999999999999p 4.9349569999999998e-10 125.71249999999999p 4.9780500000000002e-10 125.72499999999999p 5.0139540000000003e-10 125.7375p 5.0426259999999997e-10 125.75p 5.0640339999999998e-10 125.7625p 5.0781559999999995e-10 125.77500000000002p 5.0849770000000004e-10
+ 125.78749999999999p 5.0844960000000001e-10 125.8p 5.0767199999999998e-10 125.8125p 5.0616650000000004e-10 125.825p 5.0393610000000002e-10 125.83750000000001p 5.0098419999999995e-10 125.85000000000001p 4.9731560000000004e-10 125.86249999999998p 4.9293609999999995e-10 125.87499999999999p 4.8785209999999997e-10 125.88749999999999p 4.8207129999999997e-10 125.90000000000001p 4.7560219999999997e-10 125.91250000000001p 4.684543e-10 125.92500000000001p 4.6063789999999998e-10 125.93750000000001p 4.5216420000000001e-10 125.94999999999999p 4.430455e-10 125.96249999999999p 4.3329479999999999e-10 125.97499999999999p 4.2292589999999999e-10 125.9875p 4.1195349999999999e-10 126p 4.0039310000000001e-10
+ 126.0125p 3.8826100000000002e-10 126.02500000000001p 3.7557420000000002e-10 126.03749999999999p 3.6235059999999998e-10 126.05p 3.4860849999999999e-10 126.0625p 3.3436719999999999e-10 126.075p 3.1964659999999998e-10 126.08750000000001p 3.0446700000000001e-10 126.10000000000001p 2.8884960000000002e-10 126.11249999999998p 2.7281600000000001e-10 126.12499999999999p 2.5638839999999999e-10 126.13749999999999p 2.3958960000000002e-10 126.15000000000001p 2.2244260000000001e-10 126.16250000000001p 2.0497120000000001e-10 126.17500000000001p 1.871994e-10 126.18750000000001p 1.691516e-10 126.19999999999999p 1.5085279999999999e-10 126.21249999999999p 1.323279e-10 126.22499999999999p 1.136023e-10
+ 126.2375p 9.4701859999999994e-11 126.25p 7.5652300000000001e-11 126.2625p 5.6479710000000002e-11 126.27500000000001p 3.7210289999999999e-11 126.28749999999999p 1.787035e-11 126.3p -1.513717e-12 126.3125p -2.0915500000000001e-11 126.325p -4.0308549999999998e-11 126.33750000000001p -5.9666479999999996e-11 126.35000000000001p -7.8962939999999996e-11 126.36250000000001p -9.817171e-11 126.37499999999999p -1.1726670000000001e-10 126.38749999999999p -1.3622190000000001e-10 126.39999999999999p -1.550118e-10 126.41250000000001p -1.7361059999999999e-10 126.42500000000001p -1.919934e-10 126.43750000000001p -2.101351e-10 126.44999999999999p -2.2801119999999999e-10
+ 126.46249999999999p -2.4559749999999999e-10 126.47499999999999p -2.628702e-10 126.4875p -2.7980590000000003e-10 126.5p -2.9638180000000002e-10 126.5125p -3.1257549999999998e-10 126.52500000000001p -3.2836499999999998e-10 126.53749999999999p -3.4372909999999998e-10 126.55p -3.586471e-10 126.5625p -3.7309869999999998e-10 126.575p -3.8706449999999999e-10 126.58750000000001p -4.0052569999999999e-10 126.60000000000001p -4.1346400000000002e-10 126.61250000000001p -4.2586219999999999e-10 126.62499999999999p -4.3770330000000002e-10 126.63749999999999p -4.4897150000000001e-10 126.64999999999999p -4.5965150000000002e-10 126.66249999999999p -4.6972899999999998e-10 126.67500000000001p -4.791904e-10
+ 126.68750000000001p -4.880228e-10 126.70000000000002p -4.9621430000000001e-10 126.71249999999999p -5.0375390000000005e-10 126.72499999999999p -5.1063130000000003e-10 126.7375p -5.1683719999999998e-10 126.75p -5.2236329999999996e-10 126.7625p -5.2720179999999995e-10 126.77500000000001p -5.3134640000000002e-10 126.78749999999999p -5.3479120000000004e-10 126.8p -5.3753149999999997e-10 126.8125p -5.3956339999999999e-10 126.825p -5.4088419999999999e-10 126.83750000000001p -5.4149169999999998e-10 126.85000000000001p -5.4138510000000002e-10 126.86250000000001p -5.4056420000000004e-10 126.87499999999999p -5.3902990000000002e-10 126.88749999999999p -5.3678410000000005e-10 126.89999999999999p -5.3382949999999995e-10
+ 126.91249999999999p -5.3016970000000005e-10 126.925p -5.2580939999999998e-10 126.93750000000001p -5.2075410000000005e-10 126.95000000000002p -5.1501029999999995e-10 126.96249999999999p -5.0858520000000002e-10 126.97499999999999p -5.0148720000000003e-10 126.9875p -4.9372529999999996e-10 127p -4.853095e-10 127.0125p -4.7625059999999997e-10 127.02500000000001p -4.6656040000000001e-10 127.03750000000001p -4.5625120000000002e-10 127.05p -4.4533640000000003e-10 127.0625p -4.3383010000000002e-10 127.075p -4.2174699999999999e-10 127.08750000000001p -4.0910290000000001e-10 127.10000000000001p -3.9591400000000001e-10 127.11250000000001p -3.821973e-10 127.12499999999999p -3.6797060000000001e-10
+ 127.13749999999999p -3.5325220000000002e-10 127.14999999999999p -3.3806099999999998e-10 127.16249999999999p -3.2241680000000002e-10 127.175p -3.0633959999999997e-10 127.1875p -2.898502e-10 127.20000000000002p -2.7296990000000001e-10 127.21249999999999p -2.557204e-10 127.22499999999999p -2.381239e-10 127.2375p -2.2020310000000001e-10 127.25p -2.019812e-10 127.2625p -1.834814e-10 127.27500000000001p -1.647277e-10 127.28750000000001p -1.4574409999999999e-10 127.29999999999998p -1.2655509999999999e-10 127.3125p -1.0718529999999999e-10 127.325p -8.7659529999999998e-11 127.33750000000001p -6.8002949999999995e-11 127.35000000000001p -4.824075e-11
+ 127.36250000000001p -2.839827e-11 127.37500000000001p -8.500938e-12 127.38749999999999p 1.142575e-11 127.39999999999999p 3.135628e-11 127.41249999999999p 5.1265159999999999e-11 127.425p 7.1126910000000004e-11 127.4375p 9.0916149999999995e-11 127.45p 1.106076e-10 127.46249999999999p 1.3017619999999999e-10 127.47499999999999p 1.4959679999999999e-10 127.4875p 1.6884479999999999e-10 127.5p 1.8789569999999999e-10 127.5125p 2.0672510000000001e-10 127.52500000000001p 2.253092e-10 127.53750000000001p 2.4362430000000001e-10 127.54999999999998p 2.6164709999999998e-10 127.56249999999999p 2.793548e-10 127.575p 2.9672499999999998e-10
+ 127.58750000000001p 3.1373559999999999e-10 127.60000000000001p 3.3036510000000001e-10 127.61250000000001p 3.4659239999999998e-10 127.62500000000001p 3.623972e-10 127.63749999999999p 3.7775940000000001e-10 127.64999999999999p 3.9265970000000002e-10 127.66249999999999p 4.0707929999999999e-10 127.675p 4.2100010000000003e-10 127.6875p 4.3440459999999999e-10 127.7p 4.47276e-10 127.71250000000001p 4.5959830000000002e-10 127.72499999999999p 4.7135599999999998e-10 127.7375p 4.8253440000000005e-10 127.75p 4.9311960000000003e-10 127.7625p 5.0309849999999999e-10 127.77500000000001p 5.1245880000000004e-10 127.78750000000001p 5.2118879999999997e-10 127.79999999999998p 5.2927770000000005e-10
+ 127.81249999999999p 5.3671579999999999e-10 127.82499999999999p 5.4349380000000002e-10 127.83750000000001p 5.4960350000000002e-10 127.85000000000001p 5.5503750000000001e-10 127.86250000000001p 5.5978929999999997e-10 127.87500000000001p 5.6385329999999999e-10 127.88749999999999p 5.6722460000000005e-10 127.89999999999999p 5.6989939999999998e-10 127.91249999999999p 5.7187460000000003e-10 127.925p 5.7314819999999998e-10 127.9375p 5.7371890000000002e-10 127.95p 5.7358639999999997e-10 127.96250000000001p 5.7275119999999998e-10 127.97499999999999p 5.7121469999999998e-10 127.9875p 5.6897940000000005e-10 128p 5.6604840000000003e-10 128.01249999999999p 5.624258e-10 128.02500000000001p 5.5811659999999998e-10
+ 128.03750000000002p 5.5312659999999998e-10 128.05000000000001p 5.4746240000000003e-10 128.0625p 5.4113159999999996e-10 128.07499999999999p 5.3414259999999998e-10 128.08750000000001p 5.2650440000000005e-10 128.09999999999999p 5.1822720000000002e-10 128.11250000000001p 5.0932160000000005e-10 128.125p 4.9979920000000002e-10 128.13749999999999p 4.8967239999999996e-10 128.15000000000001p 4.7895410000000005e-10 128.16249999999999p 4.6765829999999999e-10 128.17500000000001p 4.5579939999999998e-10 128.1875p 4.4339260000000001e-10 128.20000000000002p 4.3045380000000002e-10 128.21250000000001p 4.169995e-10 128.22499999999999p 4.0304679999999998e-10 128.23749999999998p 3.8861349999999999e-10 128.25p 3.7371800000000001e-10
+ 128.26249999999999p 3.58379e-10 128.27500000000001p 3.4261619999999998e-10 128.28749999999999p 3.264492e-10 128.30000000000001p 3.0989869999999998e-10 128.3125p 2.9298540000000002e-10 128.32499999999999p 2.7573060000000002e-10 128.33750000000001p 2.5815599999999998e-10 128.34999999999999p 2.4028370000000001e-10 128.36250000000001p 2.2213609999999999e-10 128.375p 2.037359e-10 128.38750000000002p 1.8510600000000001e-10 128.39999999999998p 1.662698e-10 128.41249999999999p 1.4725059999999999e-10 128.42500000000001p 1.2807230000000001e-10 128.4375p 1.0875849999999999e-10 128.45000000000002p 8.9333270000000004e-11 128.46250000000001p 6.9820689999999995e-11 128.47499999999999p 5.0244869999999999e-11
+ 128.48749999999998p 3.0630000000000002e-11 128.5p 1.1000260000000001e-11 128.51249999999999p -8.6201800000000005e-12 128.52500000000001p -2.8207200000000001e-11 128.53749999999999p -4.7736779999999997e-11 128.55000000000001p -6.718498e-11 128.5625p -8.6528020000000005e-11 128.57499999999999p -1.057423e-10 128.58750000000001p -1.248044e-10 128.59999999999999p -1.4369119999999999e-10 128.61250000000001p -1.6237969999999999e-10 128.625p -1.8084729999999999e-10 128.63750000000002p -1.9907169999999999e-10 128.64999999999998p -2.170309e-10 128.66249999999999p -2.3470340000000003e-10 128.67500000000001p -2.5206789999999999e-10 128.6875p -2.6910370000000002e-10 128.70000000000002p -2.8579039999999998e-10
+ 128.71250000000001p -3.0210810000000002e-10 128.72499999999999p -3.1803759999999998e-10 128.73749999999998p -3.3355999999999998e-10 128.75p -3.4865699999999999e-10 128.76249999999999p -3.6331080000000001e-10 128.77500000000001p -3.7750449999999998e-10 128.78749999999999p -3.9122130000000002e-10 128.80000000000001p -4.044455e-10 128.8125p -4.1716179999999999e-10 128.82499999999999p -4.2935550000000002e-10 128.83750000000001p -4.410129e-10 128.84999999999999p -4.5212060000000002e-10 128.86250000000001p -4.6266619999999999e-10 128.875p -4.7263800000000002e-10 128.88750000000002p -4.8202489999999997e-10 128.89999999999998p -4.9081649999999999e-10 128.91249999999999p -4.9900360000000004e-10 128.92499999999998p -5.0657719999999996e-10
+ 128.9375p -5.135294e-10 128.95000000000002p -5.1985309999999997e-10 128.96250000000001p -5.2554200000000004e-10 128.97500000000002p -5.3059049999999998e-10 128.98749999999998p -5.3499369999999997e-10 129p -5.3874789999999998e-10 129.01249999999999p -5.4185000000000005e-10 129.02500000000001p -5.442975e-10 129.03749999999999p -5.4608910000000005e-10 129.05000000000001p -5.4722409999999996e-10 129.0625p -5.4770270000000001e-10 129.07499999999999p -5.4752590000000001e-10 129.08750000000001p -5.466955e-10 129.09999999999999p -5.4521409999999999e-10 129.11250000000001p -5.4308510000000002e-10 129.125p -5.4031280000000003e-10 129.13750000000002p -5.3690219999999995e-10 129.14999999999998p -5.3285909999999998e-10
+ 129.16249999999999p -5.2819000000000001e-10 129.17499999999998p -5.2290239999999996e-10 129.1875p -5.1700419999999997e-10 129.20000000000002p -5.105044e-10 129.21250000000001p -5.0341239999999996e-10 129.22500000000002p -4.9573859999999995e-10 129.23749999999998p -4.8749399999999997e-10 129.25p -4.7869009999999996e-10 129.26249999999999p -4.6933930000000004e-10 129.27500000000001p -4.594547e-10 129.28749999999999p -4.4904970000000002e-10 129.30000000000001p -4.381387e-10 129.3125p -4.2673629999999998e-10 129.32499999999999p -4.1485810000000002e-10 129.33750000000001p -4.0251989999999999e-10 129.34999999999999p -3.8973830000000002e-10 129.36250000000001p -3.7653010000000002e-10 129.375p -3.6291289999999998e-10
+ 129.38750000000002p -3.4890449999999999e-10 129.39999999999998p -3.345234e-10 129.41249999999999p -3.1978830000000002e-10 129.42499999999998p -3.0471840000000002e-10 129.4375p -2.8933309999999998e-10 129.44999999999999p -2.7365240000000002e-10 129.46250000000001p -2.5769650000000002e-10 129.47500000000002p -2.4148569999999998e-10 129.48749999999998p -2.2504090000000001e-10 129.5p -2.083829e-10 129.51249999999999p -1.915329e-10 129.52500000000001p -1.7451230000000001e-10 129.53749999999999p -1.5734249999999999e-10 129.55000000000001p -1.4004510000000001e-10 129.5625p -1.2264189999999999e-10 129.57499999999999p -1.0515450000000001e-10 129.58750000000001p -8.7604840000000002e-11 129.59999999999999p -7.0014640000000002e-11
+ 129.61250000000001p -5.240574e-11 129.625p -3.4799860000000002e-11 129.63750000000002p -1.7218699999999999e-11 129.65000000000001p 3.1618270000000002e-13 129.66249999999999p 1.7783329999999999e-11 129.67499999999998p 3.5161440000000002e-11 129.6875p 5.2429410000000002e-11 129.69999999999999p 6.956633e-11 129.71250000000001p 8.6551509999999994e-11 129.72500000000002p 1.0336450000000001e-10 129.73749999999998p 1.1998529999999999e-10 129.75p 1.3639390000000001e-10 129.76249999999999p 1.52571e-10 129.77500000000001p 1.684972e-10 129.78749999999999p 1.8415399999999999e-10 129.80000000000001p 1.9952289999999999e-10 129.8125p 2.14586e-10 129.82499999999999p 2.2932590000000001e-10
+ 129.83750000000001p 2.4372539999999998e-10 129.84999999999999p 2.5776800000000001e-10 129.86250000000001p 2.7143780000000002e-10 129.875p 2.8471930000000001e-10 129.88750000000002p 2.975973e-10 129.90000000000001p 3.100577e-10 129.91249999999999p 3.2208649999999999e-10 129.92499999999998p 3.336705e-10 129.9375p 3.4479709999999999e-10 129.94999999999999p 3.5545430000000002e-10 129.96250000000001p 3.6563070000000002e-10 129.97500000000002p 3.753156e-10 129.98750000000001p 3.8449900000000001e-10 130p 3.9317139999999998e-10 130.01249999999999p 4.0132420000000001e-10 130.02500000000001p 4.0894939999999998e-10 130.03749999999999p 4.1603949999999999e-10 130.05000000000001p 4.225881e-10
+ 130.0625p 4.2858920000000002e-10 130.07499999999999p 4.3403759999999999e-10 130.08750000000001p 4.3892879999999998e-10 130.09999999999999p 4.432591e-10 130.11250000000001p 4.4702539999999999e-10 130.125p 4.5022550000000002e-10 130.13750000000002p 4.5285789999999998e-10 130.15000000000001p 4.5492149999999998e-10 130.16249999999999p 4.564164e-10 130.17499999999998p 4.5734319999999998e-10 130.1875p 4.5770309999999999e-10 130.19999999999999p 4.5749820000000002e-10 130.21250000000001p 4.567312e-10 130.22499999999999p 4.5540570000000001e-10 130.23750000000001p 4.5352579999999999e-10 130.25p 4.510962e-10 130.26249999999999p 4.481226e-10 130.27500000000001p 4.446112e-10
+ 130.28749999999999p 4.4056870000000001e-10 130.30000000000001p 4.3600269999999998e-10 130.3125p 4.3092139999999998e-10 130.32500000000002p 4.253335e-10 130.33749999999998p 4.1924850000000001e-10 130.34999999999999p 4.1267619999999999e-10 130.36250000000001p 4.0562729999999999e-10 130.375p 3.9811289999999998e-10 130.38750000000002p 3.9014470000000001e-10 130.40000000000001p 3.8173489999999999e-10 130.41249999999999p 3.7289629999999998e-10 130.42499999999998p 3.6364209999999999e-10 130.4375p 3.53986e-10 130.44999999999999p 3.439421e-10 130.46250000000001p 3.3352510000000003e-10 130.47499999999999p 3.2275009999999998e-10 130.48750000000001p 3.1163239999999998e-10 130.5p 3.0018789999999998e-10
+ 130.51249999999999p 2.8843280000000002e-10 130.52500000000001p 2.7638350000000001e-10 130.53749999999999p 2.6405679999999998e-10 130.55000000000001p 2.514698e-10 130.5625p 2.3864000000000002e-10 130.57500000000002p 2.255849e-10 130.58749999999998p 2.1232230000000001e-10 130.59999999999999p 1.9887019999999999e-10 130.61250000000001p 1.8524679999999999e-10 130.625p 1.7147050000000001e-10 130.63750000000002p 1.575596e-10 130.65000000000001p 1.4353280000000001e-10 130.66250000000002p 1.2940859999999999e-10 130.67499999999998p 1.152058e-10 130.6875p 1.009429e-10 130.69999999999999p 8.663866e-11 130.71250000000001p 7.2311749999999996e-11 130.72499999999999p 5.7980780000000001e-11
+ 130.73750000000001p 4.3664259999999998e-11 130.75p 2.9380630000000001e-11 130.76249999999999p 1.5148199999999999e-11 130.77500000000001p 9.8513009999999992e-13 130.78749999999999p -1.3090580000000001e-11 130.80000000000001p -2.7061119999999998e-11 130.8125p -4.0908900000000002e-11 130.82500000000002p -5.4616579999999998e-11 130.83749999999998p -6.8167049999999999e-11 130.84999999999999p -8.1543500000000001e-11 130.86249999999998p -9.4729410000000001e-11 130.875p -1.077086e-10 130.88750000000002p -1.2046519999999999e-10 130.90000000000001p -1.3298370000000001e-10 130.91250000000002p -1.4524910000000001e-10 130.92499999999998p -1.572465e-10 130.9375p -1.689617e-10 130.94999999999999p -1.803809e-10
+ 130.96250000000001p -1.9149060000000001e-10 130.97499999999999p -2.022778e-10 130.98750000000001p -2.127301e-10 131p -2.228356e-10 131.01249999999999p -2.3258269999999999e-10 131.02500000000001p -2.4196059999999999e-10 131.03749999999999p -2.5095869999999998e-10 131.05000000000001p -2.5956729999999998e-10 131.0625p -2.6777709999999999e-10 131.07500000000002p -2.7557929999999998e-10 131.08749999999998p -2.8296569999999998e-10 131.09999999999999p -2.8992890000000001e-10 131.11249999999998p -2.964617e-10 131.125p -3.0255789999999999e-10 131.13750000000002p -3.0821169999999999e-10 131.15000000000001p -3.1341789999999999e-10 131.16250000000002p -3.181721e-10 131.17499999999998p -3.2247010000000001e-10
+ 131.1875p -3.2630889999999999e-10 131.19999999999999p -3.2968560000000002e-10 131.21250000000001p -3.3259839999999998e-10 131.22499999999999p -3.3504559999999999e-10 131.23750000000001p -3.3702670000000001e-10 131.25p -3.385413e-10 131.26249999999999p -3.3959009999999999e-10 131.27500000000001p -3.4017389999999998e-10 131.28749999999999p -3.4029470000000002e-10 131.30000000000001p -3.3995460000000002e-10 131.3125p -3.3915650000000002e-10 131.32500000000002p -3.3790410000000001e-10 131.33749999999998p -3.3620140000000002e-10 131.34999999999999p -3.3405310000000001e-10 131.36249999999998p -3.314645e-10 131.375p -3.2844139999999999e-10 131.38749999999999p -3.2499019999999999e-10 131.40000000000001p -3.2111800000000001e-10
+ 131.41250000000002p -3.1683209999999998e-10 131.42499999999998p -3.121406e-10 131.4375p -3.0705209999999999e-10 131.44999999999999p -3.0157550000000002e-10 131.46250000000001p -2.9572029999999998e-10 131.47499999999999p -2.8949659999999998e-10 131.48750000000001p -2.8291470000000001e-10 131.5p -2.7598559999999999e-10 131.51249999999999p -2.6872060000000001e-10 131.52500000000001p -2.6113119999999998e-10 131.53749999999999p -2.532298e-10 131.55000000000001p -2.450286e-10 131.5625p -2.3654059999999998e-10 131.57500000000002p -2.2777879999999999e-10 131.58750000000001p -2.1875679999999999e-10 131.59999999999999p -2.094884e-10 131.61249999999998p -1.999875e-10 131.625p -1.9026849999999999e-10
+ 131.63749999999999p -1.8034599999999999e-10 131.65000000000001p -1.7023460000000001e-10 131.66250000000002p -1.5994939999999999e-10 131.67499999999998p -1.495055e-10 131.6875p -1.3891819999999999e-10 131.69999999999999p -1.2820279999999999e-10 131.71250000000001p -1.17375e-10 131.72499999999999p -1.064503e-10 131.73750000000001p -9.5444510000000001e-11 131.75p -8.4373270000000002e-11 131.76249999999999p -7.3252379999999996e-11 131.77500000000001p -6.2097619999999994e-11 131.78749999999999p -5.0924749999999999e-11 131.80000000000001p -3.9749470000000003e-11 131.8125p -2.8587459999999999e-11 131.82500000000002p -1.745429e-11 131.83750000000001p -6.365447e-12 131.84999999999999p 4.6637189999999997e-12
+ 131.86249999999998p 1.561799e-11 131.875p 2.6482310000000001e-11 131.88749999999999p 3.7241809999999997e-11 131.90000000000001p 4.7881819999999998e-11 131.91249999999999p 5.8387879999999996e-11 131.92500000000001p 6.8745789999999995e-11 131.9375p 7.8941599999999994e-11 131.94999999999999p 8.8961630000000006e-11 131.96250000000001p 9.8792499999999998e-11 131.97499999999999p 1.084211e-10 131.98750000000001p 1.178348e-10 132p 1.2702110000000001e-10 132.01249999999999p 1.3596800000000001e-10 132.02499999999998p 1.446639e-10 132.03749999999999p 1.5309739999999999e-10 132.05000000000001p 1.6125770000000001e-10 132.0625p 1.6913429999999999e-10 132.07500000000002p 1.767173e-10
+ 132.08750000000001p 1.8399700000000001e-10 132.09999999999999p 1.9096440000000001e-10 132.11249999999998p 1.976108e-10 132.125p 2.03928e-10 132.13749999999999p 2.0990840000000001e-10 132.15000000000001p 2.1554460000000001e-10 132.16249999999999p 2.2083010000000001e-10 132.17500000000001p 2.257587e-10 132.1875p 2.3032470000000001e-10 132.19999999999999p 2.3452300000000001e-10 132.21250000000001p 2.3834890000000002e-10 132.22499999999999p 2.4179839999999999e-10 132.23750000000001p 2.4486799999999999e-10 132.25p 2.4755460000000001e-10 132.26250000000002p 2.4985589999999999e-10 132.27499999999998p 2.5176990000000002e-10 132.28749999999999p 2.5329529999999999e-10 132.30000000000001p 2.5443119999999999e-10
+ 132.3125p 2.5517750000000002e-10 132.32500000000002p 2.555344e-10 132.33750000000001p 2.5550269999999998e-10 132.34999999999999p 2.5508390000000001e-10 132.36249999999998p 2.5427980000000001e-10 132.375p 2.530929e-10 132.38749999999999p 2.5152619999999999e-10 132.40000000000001p 2.4958309999999999e-10 132.41249999999999p 2.4726770000000001e-10 132.42500000000001p 2.4458460000000002e-10 132.4375p 2.4153870000000003e-10 132.44999999999999p 2.3813560000000001e-10 132.46250000000001p 2.343814e-10 132.47499999999999p 2.3028239999999999e-10 132.48750000000001p 2.258457e-10 132.5p 2.210787e-10 132.51250000000002p 2.159892e-10 132.52499999999998p 2.1058560000000001e-10
+ 132.53749999999999p 2.0487649999999999e-10 132.55000000000001p 1.988711e-10 132.5625p 1.9257890000000001e-10 132.57500000000002p 1.8600969999999999e-10 132.58750000000001p 1.7917389999999999e-10 132.60000000000002p 1.7208210000000001e-10 132.61249999999998p 1.6474519999999999e-10 132.625p 1.5717439999999999e-10 132.63749999999999p 1.4938140000000001e-10 132.65000000000001p 1.4137799999999999e-10 132.66249999999999p 1.331762e-10 132.67500000000001p 1.2478860000000001e-10 132.6875p 1.1622760000000001e-10 132.69999999999999p 1.075062e-10 132.71250000000001p 9.8637240000000004e-11 132.72499999999999p 8.9634079999999995e-11 132.73750000000001p 8.0510009999999995e-11 132.75p 7.127857e-11
+ 132.76250000000002p 6.1953360000000004e-11 132.77499999999998p 5.2548140000000001e-11 132.78749999999999p 4.3076710000000002e-11 132.79999999999998p 3.3552979999999998e-11 132.8125p 2.3990870000000001e-11 132.82500000000002p 1.4404350000000001e-11 132.83750000000001p 4.8073929999999999e-12 132.85000000000002p -4.7860459999999999e-12 132.86249999999998p -1.436203e-11 132.875p -2.3906680000000001e-11 132.88749999999999p -3.3406180000000003e-11 132.90000000000001p -4.28468e-11 132.91249999999999p -5.2214920000000003e-11 132.92500000000001p -6.1497040000000005e-11 132.9375p -7.0679790000000003e-11 132.94999999999999p -7.9749999999999996e-11 132.96250000000001p -8.8694630000000003e-11 132.97499999999999p -9.7500860000000005e-11
+ 132.98750000000001p -1.061561e-10 133p -1.146479e-10 133.01250000000002p -1.2296430000000001e-10 133.02499999999998p -1.310932e-10 133.03749999999999p -1.3902319999999999e-10 133.04999999999998p -1.467429e-10 133.0625p -1.542413e-10 133.07500000000002p -1.6150779999999999e-10 133.08750000000001p -1.68532e-10 133.10000000000002p -1.7530399999999999e-10 133.11249999999998p -1.8181420000000001e-10 133.125p -1.880533e-10 133.13749999999999p -1.9401250000000001e-10 133.15000000000001p -1.996834e-10 133.16249999999999p -2.0505780000000001e-10 133.17500000000001p -2.101283e-10 133.1875p -2.148876e-10 133.19999999999999p -2.19329e-10
+ 133.21250000000001p -2.2344619999999999e-10 133.22499999999999p -2.2723329999999999e-10 133.23750000000001p -2.306851e-10 133.25p -2.3379669999999999e-10 133.26250000000002p -2.3656349999999999e-10 133.27500000000001p -2.3898179999999999e-10 133.28749999999999p -2.4104799999999999e-10 133.29999999999998p -2.427592e-10 133.3125p -2.4411289999999999e-10 133.32499999999999p -2.4510730000000001e-10 133.33750000000001p -2.4574080000000002e-10 133.35000000000002p -2.4601249999999998e-10 133.36249999999998p -2.4592199999999998e-10 133.375p -2.4546919999999998e-10 133.38749999999999p -2.4465480000000001e-10 133.40000000000001p -2.4347980000000001e-10 133.41249999999999p -2.4194579999999998e-10 133.42500000000001p -2.4005479999999999e-10
+ 133.4375p -2.3780939999999999e-10 133.44999999999999p -2.3521249999999998e-10 133.46250000000001p -2.3226780000000001e-10 133.47499999999999p -2.289792e-10 133.48750000000001p -2.2535109999999999e-10 133.5p -2.2138859999999999e-10 133.51250000000002p -2.1709700000000001e-10 133.52500000000001p -2.1248199999999999e-10 133.53749999999999p -2.0755020000000001e-10 133.54999999999998p -2.0230800000000001e-10 133.5625p -1.9676279999999999e-10 133.57499999999999p -1.9092199999999999e-10 133.58750000000001p -1.8479370000000001e-10 133.60000000000002p -1.7838609999999999e-10 133.61249999999998p -1.71708e-10 133.625p -1.6476860000000001e-10 133.63749999999999p -1.575772e-10 133.65000000000001p -1.501437e-10
+ 133.66249999999999p -1.424782e-10 133.67500000000001p -1.3459119999999999e-10 133.6875p -1.2649339999999999e-10 133.69999999999999p -1.181958e-10 133.71250000000001p -1.097098e-10 133.72499999999999p -1.01047e-10 133.73750000000001p -9.2219060000000006e-11 133.75p -8.3238089999999998e-11 133.76250000000002p -7.4116329999999999e-11 133.77500000000001p -6.4866190000000002e-11 133.78749999999999p -5.5500280000000002e-11 133.79999999999998p -4.6031349999999999e-11 133.8125p -3.6472300000000001e-11 133.82499999999999p -2.6836160000000001e-11 133.83750000000001p -1.7136049999999999e-11 133.84999999999999p -7.3851879999999992e-12 133.86250000000001p 2.4031519999999999e-12 133.875p 1.221563e-11
+ 133.88749999999999p 2.2038879999999999e-11 133.90000000000001p 3.185953e-11 133.91249999999999p 4.1664179999999997e-11 133.92500000000001p 5.1439470000000003e-11 133.9375p 6.1172089999999998e-11 133.94999999999999p 7.0848769999999994e-11 133.96249999999998p 8.0456310000000002e-11 133.97499999999999p 8.9981609999999995e-11 133.98750000000001p 9.9411670000000003e-11 134p 1.0873360000000001e-10 134.01250000000002p 1.1793480000000001e-10 134.02500000000001p 1.270025e-10 134.03749999999999p 1.3592439999999999e-10 134.04999999999998p 1.446884e-10 134.0625p 1.532824e-10 134.07499999999999p 1.6169470000000001e-10 134.08750000000001p 1.699137e-10 134.09999999999999p 1.7792809999999999e-10
+ 134.11250000000001p 1.8572709999999999e-10 134.125p 1.9329980000000001e-10 134.13749999999999p 2.006359e-10 134.15000000000001p 2.0772520000000001e-10 134.16249999999999p 2.1455790000000001e-10 134.17500000000001p 2.2112470000000001e-10 134.1875p 2.274165e-10 134.20000000000002p 2.3342440000000001e-10 134.21249999999998p 2.3914030000000001e-10 134.22499999999999p 2.44556e-10 134.23750000000001p 2.4966410000000001e-10 134.25p 2.5445729999999999e-10 134.26250000000002p 2.5892890000000002e-10 134.27500000000001p 2.630726e-10 134.28749999999999p 2.6688260000000001e-10 134.29999999999998p 2.7035319999999999e-10 134.3125p 2.7347950000000002e-10 134.32499999999999p 2.7625700000000001e-10
+ 134.33750000000001p 2.7868160000000001e-10 134.34999999999999p 2.8074949999999998e-10 134.36250000000001p 2.8245770000000002e-10 134.375p 2.8380339999999999e-10 134.38749999999999p 2.8478450000000001e-10 134.40000000000001p 2.8539900000000001e-10 134.41249999999999p 2.8564589999999998e-10 134.42500000000001p 2.8552429999999999e-10 134.4375p 2.8503380000000002e-10 134.45000000000002p 2.8417470000000001e-10 134.46249999999998p 2.829476e-10 134.47499999999999p 2.8135370000000001e-10 134.48749999999998p 2.7939460000000002e-10 134.5p 2.7707230000000002e-10 134.51250000000002p 2.7438950000000002e-10 134.52500000000001p 2.7134910000000002e-10 134.53750000000002p 2.6795469999999999e-10 134.54999999999998p 2.6421020000000002e-10
+ 134.5625p 2.6012010000000001e-10 134.57499999999999p 2.5568919999999998e-10 134.58750000000001p 2.5092280000000001e-10 134.59999999999999p 2.458267e-10 134.61250000000001p 2.4040699999999997e-10 134.625p 2.346704e-10 134.63749999999999p 2.286238e-10 134.65000000000001p 2.222747e-10 134.66249999999999p 2.1563080000000001e-10 134.67500000000001p 2.0870040000000001e-10 134.6875p 2.014919e-10 134.70000000000002p 1.9401439999999999e-10 134.71249999999998p 1.86277e-10 134.72499999999999p 1.782894e-10 134.73749999999998p 1.7006140000000001e-10 134.75p 1.6160330000000001e-10 134.76250000000002p 1.5292570000000001e-10 134.77500000000001p 1.4403930000000001e-10
+ 134.78750000000002p 1.3495520000000001e-10 134.79999999999998p 1.256848e-10 134.8125p 1.1623960000000001e-10 134.82499999999999p 1.066314e-10 134.83750000000001p 9.6872180000000002e-11 134.84999999999999p 8.6974209999999998e-11 134.86250000000001p 7.6949829999999995e-11 134.875p 6.6811579999999994e-11 134.88749999999999p 5.6572149999999999e-11 134.90000000000001p 4.6244349999999997e-11 134.91249999999999p 3.5841099999999998e-11 134.92500000000001p 2.5375429999999999e-11 134.9375p 1.486043e-11 134.95000000000002p 4.3092679999999999e-12 134.96249999999998p -6.2648449999999998e-12 134.97499999999999p -1.6848679999999999e-11 134.98749999999998p -2.7428979999999999e-11 135p -3.7992509999999998e-11
+ 135.01250000000002p -4.8526040000000001e-11 135.02500000000001p -5.9016410000000002e-11 135.03750000000002p -6.9450490000000002e-11 135.04999999999998p -7.9815219999999996e-11 135.0625p -9.0097650000000005e-11 135.07499999999999p -1.002849e-10 135.08750000000001p -1.1036429999999999e-10 135.09999999999999p -1.2032319999999999e-10 135.11250000000001p -1.3014919999999999e-10 135.125p -1.3983e-10 135.13749999999999p -1.4935350000000001e-10 135.15000000000001p -1.5870789999999999e-10 135.16249999999999p -1.6788150000000001e-10 135.17500000000001p -1.7686289999999999e-10 135.1875p -1.8564079999999999e-10 135.20000000000002p -1.9420439999999999e-10 135.21250000000001p -2.0254300000000001e-10 135.22499999999999p -2.1064619999999999e-10
+ 135.23749999999998p -2.18504e-10 135.25p -2.2610660000000001e-10 135.26249999999999p -2.3344450000000001e-10 135.27500000000001p -2.4050880000000001e-10 135.28750000000002p -2.4729049999999998e-10 135.29999999999998p -2.5378140000000001e-10 135.3125p -2.5997350000000001e-10 135.32499999999999p -2.6585899999999999e-10 135.33750000000001p -2.7143069999999998e-10 135.34999999999999p -2.7668180000000003e-10 135.36250000000001p -2.8160579999999998e-10 135.375p -2.8619660000000001e-10 135.38749999999999p -2.9044870000000001e-10 135.40000000000001p -2.9435680000000002e-10 135.41249999999999p -2.9791620000000002e-10 135.42500000000001p -3.0112259999999999e-10 135.4375p -3.03972e-10 135.45000000000002p -3.06461e-10
+ 135.46250000000001p -3.085867e-10 135.47499999999999p -3.1034640000000001e-10 135.48749999999998p -3.117382e-10 135.5p -3.1276050000000002e-10 135.51249999999999p -3.1341200000000002e-10 135.52500000000001p -3.13692e-10 135.53750000000002p -3.1360040000000001e-10 135.55000000000001p -3.1313740000000002e-10 135.5625p -3.1230369999999999e-10 135.57499999999999p -3.1110040000000001e-10 135.58750000000001p -3.0952909999999999e-10 135.59999999999999p -3.0759190000000001e-10 135.61250000000001p -3.0529140000000002e-10 135.625p -3.0263050000000002e-10 135.63749999999999p -2.9961249999999998e-10 135.65000000000001p -2.9624139999999998e-10 135.66249999999999p -2.925215e-10 135.67500000000001p -2.8845730000000002e-10
+ 135.6875p -2.8405420000000001e-10 135.70000000000002p -2.7931759999999998e-10 135.71250000000001p -2.7425349999999999e-10 135.72499999999999p -2.6886820000000002e-10 135.73749999999998p -2.6316850000000002e-10 135.75p -2.5716149999999998e-10 135.76249999999999p -2.5085470000000002e-10 135.77500000000001p -2.4425589999999998e-10 135.78749999999999p -2.3737339999999998e-10 135.80000000000001p -2.3021570000000001e-10 135.8125p -2.2279170000000001e-10 135.82499999999999p -2.151106e-10 135.83750000000001p -2.0718180000000001e-10 135.84999999999999p -1.990153e-10 135.86250000000001p -1.9062099999999999e-10 135.875p -1.8200930000000001e-10 135.88750000000002p -1.731908e-10 135.89999999999998p -1.6417630000000001e-10
+ 135.91249999999999p -1.5497690000000001e-10 135.92500000000001p -1.456039e-10 135.9375p -1.3606880000000001e-10 135.95000000000002p -1.2638319999999999e-10 135.96250000000001p -1.1655889999999999e-10 135.97499999999999p -1.066079e-10 135.98749999999998p -9.6542360000000002e-11 136p -8.6374490000000002e-11 136.01249999999999p -7.6116629999999998e-11 136.02500000000001p -6.5781230000000004e-11 136.03749999999999p -5.5380799999999997e-11 136.05000000000001p -4.4927910000000002e-11 136.0625p -3.4435190000000002e-11 136.07499999999999p -2.3915279999999999e-11 136.08750000000001p -1.3380829999999999e-11 136.09999999999999p -2.844503e-12 136.11250000000001p 7.6810639999999999e-12 136.125p 1.818327e-11
+ 136.13750000000002p 2.864957e-11 136.14999999999998p 3.906748e-11 136.16249999999999p 4.9424590000000002e-11 136.17500000000001p 5.9708599999999999e-11 136.1875p 6.9907319999999998e-11 136.20000000000002p 8.0008680000000004e-11 136.21250000000001p 9.0000759999999999e-11 136.22499999999999p 9.9871789999999999e-11 136.23749999999998p 1.096102e-10 136.25p 1.192045e-10 136.26249999999999p 1.2864359999999999e-10 136.27500000000001p 1.3791639999999999e-10 136.28749999999999p 1.4701209999999999e-10 136.30000000000001p 1.5592030000000001e-10 136.3125p 1.6463069999999999e-10 136.32499999999999p 1.7313310000000001e-10 136.33750000000001p 1.8141799999999999e-10 136.34999999999999p 1.8947580000000001e-10
+ 136.36250000000001p 1.972973e-10 136.375p 2.0487380000000001e-10 136.38750000000002p 2.121966e-10 136.39999999999998p 2.1925769999999999e-10 136.41249999999999p 2.2604910000000001e-10 136.42499999999998p 2.3256329999999999e-10 136.4375p 2.387932e-10 136.45000000000002p 2.4473200000000001e-10 136.46250000000001p 2.5037320000000002e-10 136.47500000000002p 2.5571090000000002e-10 136.48749999999998p 2.6073930000000001e-10 136.5p 2.6545319999999998e-10 136.51249999999999p 2.6984779999999997e-10 136.52500000000001p 2.7391859999999999e-10 136.53749999999999p 2.7766150000000001e-10 136.55000000000001p 2.8107289999999999e-10 136.5625p 2.8414960000000002e-10 136.57499999999999p 2.8688869999999998e-10
+ 136.58750000000001p 2.8928789999999999e-10 136.59999999999999p 2.9134529999999998e-10 136.61250000000001p 2.9305920000000002e-10 136.625p 2.944286e-10 136.63750000000002p 2.9545280000000001e-10 136.64999999999998p 2.961315e-10 136.66249999999999p 2.9646480000000001e-10 136.67499999999998p 2.9645339999999999e-10 136.6875p 2.9609830000000002e-10 136.70000000000002p 2.9540090000000001e-10 136.71250000000001p 2.943629e-10 136.72500000000002p 2.929868e-10 136.73749999999998p 2.9127509999999999e-10 136.75p 2.8923079999999999e-10 136.76249999999999p 2.8685750000000001e-10 136.77500000000001p 2.841591e-10 136.78749999999999p 2.8113969999999998e-10 136.80000000000001p 2.7780390000000002e-10
+ 136.8125p 2.7415690000000001e-10 136.82499999999999p 2.7020379999999998e-10 136.83750000000001p 2.6595059999999998e-10 136.84999999999999p 2.6140319999999998e-10 136.86250000000001p 2.5656809999999999e-10 136.875p 2.5145189999999998e-10 136.88750000000002p 2.4606190000000001e-10 136.89999999999998p 2.4040539999999998e-10 136.91249999999999p 2.3449010000000002e-10 136.92499999999998p 2.283239e-10 136.9375p 2.2191519999999999e-10 136.94999999999999p 2.1527240000000001e-10 136.96250000000001p 2.0840450000000001e-10 136.97500000000002p 2.0132040000000001e-10 136.98749999999998p 1.940295e-10 137p 1.865412e-10 137.01249999999999p 1.788653e-10 137.02500000000001p 1.7101170000000001e-10
+ 137.03749999999999p 1.629905e-10 137.05000000000001p 1.5481189999999999e-10 137.0625p 1.464866e-10 137.07499999999999p 1.3802489999999999e-10 137.08750000000001p 1.294376e-10 137.09999999999999p 1.2073560000000001e-10 137.11250000000001p 1.119299e-10 137.125p 1.0303130000000001e-10 137.13750000000002p 9.4051039999999994e-11 137.15000000000001p 8.5000290000000003e-11 137.16249999999999p 7.5890229999999999e-11 137.17499999999998p 6.6732099999999996e-11 137.1875p 5.7537180000000003e-11 137.19999999999999p 4.8316720000000001e-11 137.21250000000001p 3.9081970000000002e-11 137.22500000000002p 2.984418e-11 137.23749999999998p 2.0614519999999999e-11 137.25p 1.140415e-11
+ 137.26249999999999p 2.2241320000000001e-12 137.27500000000001p -6.9145359999999999e-12 137.28749999999999p -1.6000949999999999e-11 137.30000000000001p -2.5024320000000001e-11 137.3125p -3.3973969999999998e-11 137.32499999999999p -4.2839360000000003e-11 137.33750000000001p -5.1610089999999997e-11 137.34999999999999p -6.0275919999999995e-11 137.36250000000001p -6.8826799999999997e-11 137.375p -7.7252820000000004e-11 137.38750000000002p -8.5544310000000003e-11 137.40000000000001p -9.3691779999999995e-11 137.41249999999999p -1.01686e-10 137.42499999999998p -1.095178e-10 137.4375p -1.171786e-10 137.44999999999999p -1.2465969999999999e-10 137.46250000000001p -1.3195280000000001e-10 137.47500000000002p -1.3904989999999999e-10
+ 137.48750000000001p -1.4594339999999999e-10 137.5p -1.5262559999999999e-10 137.51249999999999p -1.5908950000000001e-10 137.52500000000001p -1.6532829999999999e-10 137.53749999999999p -1.713353e-10 137.55000000000001p -1.7710429999999999e-10 137.5625p -1.8262940000000001e-10 137.57499999999999p -1.879052e-10 137.58749999999998p -1.929262e-10 137.59999999999999p -1.976876e-10 137.61250000000001p -2.0218500000000001e-10 137.625p -2.06414e-10 137.63750000000002p -2.1037079999999999e-10 137.65000000000001p -2.1405199999999999e-10 137.66249999999999p -2.174545e-10 137.67499999999998p -2.2057540000000001e-10 137.6875p -2.234124e-10 137.69999999999999p -2.2596349999999999e-10
+ 137.71250000000001p -2.28227e-10 137.72499999999999p -2.3020169999999999e-10 137.73750000000001p -2.3188659999999999e-10 137.75p -2.3328109999999998e-10 137.76249999999999p -2.3438520000000003e-10 137.77500000000001p -2.351991e-10 137.78749999999999p -2.3572319999999997e-10 137.80000000000001p -2.3595850000000002e-10 137.8125p -2.3590630000000003e-10 137.82500000000002p -2.3556819999999999e-10 137.83749999999998p -2.3494630000000001e-10 137.84999999999999p -2.3404289999999999e-10 137.86250000000001p -2.3286069999999998e-10 137.875p -2.314027e-10 137.88750000000002p -2.296723e-10 137.90000000000001p -2.2767329999999999e-10 137.91249999999999p -2.254096e-10 137.92499999999998p -2.2288560000000001e-10
+ 137.9375p -2.2010589999999999e-10 137.94999999999999p -2.1707560000000001e-10 137.96250000000001p -2.1379979999999999e-10 137.97499999999999p -2.1028419999999999e-10 137.98750000000001p -2.065345e-10 138p -2.0255680000000001e-10 138.01249999999999p -1.9835760000000001e-10 138.02500000000001p -1.939434e-10 138.03749999999999p -1.8932109999999999e-10 138.05000000000001p -1.844977e-10 138.0625p -1.7948059999999999e-10 138.07500000000002p -1.742772e-10 138.08749999999998p -1.6889539999999999e-10 138.09999999999999p -1.6334310000000001e-10 138.11250000000001p -1.576282e-10 138.125p -1.517592e-10 138.13750000000002p -1.4574440000000001e-10 138.15000000000001p -1.395924e-10
+ 138.16250000000002p -1.3331180000000001e-10 138.17499999999998p -1.269116e-10 138.1875p -1.204005e-10 138.19999999999999p -1.137878e-10 138.21250000000001p -1.070825e-10 138.22499999999999p -1.002937e-10 138.23750000000001p -9.3430739999999995e-11 138.25p -8.6502909999999998e-11 138.26249999999999p -7.9519549999999999e-11 138.27500000000001p -7.2490010000000006e-11 138.28749999999999p -6.5423659999999998e-11 138.30000000000001p -5.8329880000000002e-11 138.3125p -5.121801e-11 138.32500000000002p -4.4097390000000001e-11 138.33749999999998p -3.6977320000000002e-11 138.34999999999999p -2.986704e-11 138.36249999999998p -2.2775740000000001e-11 138.375p -1.571253e-11
+ 138.38750000000002p -8.6864259999999995e-12 138.40000000000001p -1.7063710000000001e-12 138.41250000000002p 5.2188159999999999e-12 138.42499999999998p 1.208043e-11 138.4375p 1.8869899999999999e-11 138.44999999999999p 2.557879e-11 138.46250000000001p 3.2198810000000001e-11 138.47499999999999p 3.8721849999999998e-11 138.48750000000001p 4.5139950000000002e-11 138.5p 5.1445349999999998e-11 138.51249999999999p 5.763046e-11 138.52500000000001p 6.3687900000000005e-11 138.53749999999999p 6.9610499999999997e-11 138.55000000000001p 7.5391310000000004e-11 138.5625p 8.1023609999999998e-11 138.57500000000002p 8.6500880000000002e-11 138.58749999999998p 9.1816890000000001e-11 138.59999999999999p 9.6965610000000001e-11
+ 138.61249999999998p 1.019413e-10 138.625p 1.067385e-10 138.63750000000002p 1.1135189999999999e-10 138.65000000000001p 1.1577669999999999e-10 138.66250000000002p 1.200081e-10 138.67499999999998p 1.2404169999999999e-10 138.6875p 1.278735e-10 138.69999999999999p 1.3149969999999999e-10 138.71250000000001p 1.3491669999999999e-10 138.72499999999999p 1.3812139999999999e-10 138.73750000000001p 1.4111079999999999e-10 138.75p 1.4388230000000001e-10 138.76249999999999p 1.464337e-10 138.77500000000001p 1.4876290000000001e-10 138.78749999999999p 1.508684e-10 138.80000000000001p 1.5274860000000001e-10 138.8125p 1.5440270000000001e-10 138.82500000000002p 1.5582980000000001e-10
+ 138.83749999999998p 1.570295e-10 138.84999999999999p 1.580018e-10 138.86249999999998p 1.587467e-10 138.875p 1.5926490000000001e-10 138.88749999999999p 1.595571e-10 138.90000000000001p 1.596245e-10 138.91250000000002p 1.594684e-10 138.92499999999998p 1.590906e-10 138.9375p 1.5849309999999999e-10 138.94999999999999p 1.5767820000000001e-10 138.96250000000001p 1.5664850000000001e-10 138.97499999999999p 1.554068e-10 138.98750000000001p 1.5395620000000001e-10 139p 1.523003e-10 139.01249999999999p 1.5044270000000001e-10 139.02500000000001p 1.483872e-10 139.03749999999999p 1.4613819999999999e-10 139.05000000000001p 1.4370000000000001e-10
+ 139.0625p 1.4107730000000001e-10 139.07500000000002p 1.38275e-10 139.08750000000001p 1.3529829999999999e-10 139.09999999999999p 1.3215239999999999e-10 139.11249999999998p 1.2884299999999999e-10 139.125p 1.2537579999999999e-10 139.13749999999999p 1.2175670000000001e-10 139.15000000000001p 1.179918e-10 139.16250000000002p 1.140875e-10 139.17499999999998p 1.100503e-10 139.1875p 1.058866e-10 139.19999999999999p 1.016033e-10 139.21250000000001p 9.7207249999999995e-11 139.22499999999999p 9.2705490000000003e-11 139.23750000000001p 8.8105140000000006e-11 139.25p 8.3413419999999996e-11 139.26249999999999p 7.8637669999999998e-11 139.27500000000001p 7.378528e-11
+ 139.28749999999999p 6.8863739999999996e-11 139.30000000000001p 6.3880600000000001e-11 139.3125p 5.8843430000000003e-11 139.32500000000002p 5.3759889999999998e-11 139.33750000000001p 4.8637630000000001e-11 139.34999999999999p 4.348433e-11 139.36249999999998p 3.8307689999999999e-11 139.375p 3.3115389999999999e-11 139.38749999999999p 2.7915119999999999e-11 139.40000000000001p 2.271452e-11 139.41249999999999p 1.7521220000000001e-11 139.42500000000001p 1.2342789999999999e-11 139.4375p 7.1867489999999997e-12 139.44999999999999p 2.0605579999999999e-12 139.46250000000001p -3.028405e-12 139.47499999999999p -8.0728430000000007e-12 139.48750000000001p -1.306555e-11 139.5p -1.7999439999999999e-11
+ 139.51249999999999p -2.2867520000000001e-11 139.52499999999998p -2.766293e-11 139.53749999999999p -3.2378939999999998e-11 139.55000000000001p -3.7008970000000003e-11 139.5625p -4.1546569999999999e-11 139.57500000000002p -4.5985480000000002e-11 139.58750000000001p -5.0319569999999998e-11 139.59999999999999p -5.4542909999999999e-11 139.61249999999998p -5.8649729999999998e-11 139.625p -6.2634490000000002e-11 139.63749999999999p -6.6491789999999994e-11 139.65000000000001p -7.0216480000000001e-11 139.66249999999999p -7.3803589999999998e-11 139.67500000000001p -7.7248399999999999e-11 139.6875p -8.0546369999999994e-11 139.69999999999999p -8.3693219999999995e-11 139.71250000000001p -8.6684889999999997e-11 139.72499999999999p -8.9517560000000005e-11
+ 139.73750000000001p -9.218766e-11 139.75p -9.4691840000000001e-11 139.76250000000002p -9.7027039999999997e-11 139.77499999999998p -9.9190420000000005e-11 139.78749999999999p -1.011794e-10 139.80000000000001p -1.029917e-10 139.8125p -1.0462530000000001e-10 139.82500000000002p -1.060784e-10 139.83750000000001p -1.073494e-10 139.84999999999999p -1.084372e-10 139.86249999999998p -1.093407e-10 139.875p -1.100593e-10 139.88749999999999p -1.105925e-10 139.90000000000001p -1.109401e-10 139.91249999999999p -1.1110230000000001e-10 139.92500000000001p -1.110794e-10 139.9375p -1.108721e-10 139.94999999999999p -1.104812e-10
+ 139.96250000000001p -1.099079e-10 139.97499999999999p -1.091537e-10 139.98750000000001p -1.082202e-10 140p -1.071095e-10 140.01250000000002p -1.058236e-10 140.02499999999998p -1.0436500000000001e-10 140.03749999999999p -1.0273649999999999e-10 140.05000000000001p -1.0094090000000001e-10 140.0625p -9.8981419999999996e-11 140.07500000000002p -9.6861440000000006e-11 140.08750000000001p -9.4584600000000004e-11 140.10000000000002p -9.2154719999999997e-11 140.11249999999998p -8.9575869999999996e-11 140.125p -8.6852310000000005e-11 140.13749999999999p -8.3988490000000006e-11 140.15000000000001p -8.0989079999999995e-11 140.16249999999999p -7.785892e-11 140.17500000000001p -7.4603040000000003e-11
+ 140.1875p -7.1226639999999995e-11 140.19999999999999p -6.7735079999999994e-11 140.21250000000001p -6.4133880000000006e-11 140.22499999999999p -6.0428720000000003e-11 140.23750000000001p -5.6625410000000002e-11 140.25p -5.2729879999999997e-11 140.26250000000002p -4.874822e-11 140.27499999999998p -4.4686609999999998e-11 140.28749999999999p -4.0551340000000003e-11 140.29999999999998p -3.6348790000000002e-11 140.3125p -3.208544e-11 140.32500000000002p -2.776786e-11 140.33750000000001p -2.3402670000000001e-11 140.35000000000002p -1.8996539999999999e-11 140.36249999999998p -1.4556230000000001e-11 140.375p -1.008851e-11 140.38749999999999p -5.6001889999999996e-12 140.40000000000001p -1.0981030000000001e-12
+ 140.41249999999999p 3.4109039999999998e-12 140.42500000000001p 7.9199819999999995e-12 140.4375p 1.242229e-11 140.44999999999999p 1.6910999999999999e-11 140.46250000000001p 2.1379310000000001e-11 140.47499999999999p 2.5820459999999998e-11 140.48750000000001p 3.0227729999999997e-11 140.5p 3.4594449999999997e-11 140.51250000000002p 3.8914019999999999e-11 140.52499999999998p 4.31799e-11 140.53749999999999p 4.7385640000000001e-11 140.54999999999998p 5.1524899999999998e-11 140.5625p 5.559139e-11 140.57500000000002p 5.9578990000000001e-11 140.58750000000001p 6.3481629999999994e-11 140.60000000000002p 6.7293429999999997e-11 140.61249999999998p 7.1008580000000003e-11 140.625p 7.4621470000000005e-11
+ 140.63749999999999p 7.8126590000000002e-11 140.65000000000001p 8.1518610000000005e-11 140.66249999999999p 8.4792360000000004e-11 140.67500000000001p 8.7942830000000001e-11 140.6875p 9.0965209999999998e-11 140.69999999999999p 9.3854849999999999e-11 140.71250000000001p 9.6607299999999995e-11 140.72499999999999p 9.9218299999999995e-11 140.73750000000001p 1.016838e-10 140.75p 1.04e-10 140.76250000000002p 1.061631e-10 140.77500000000001p 1.0816989999999999e-10 140.78749999999999p 1.100171e-10 140.79999999999998p 1.117017e-10 140.8125p 1.1322100000000001e-10 140.82499999999999p 1.1457249999999999e-10 140.83750000000001p 1.157539e-10 140.85000000000002p 1.167632e-10
+ 140.86249999999998p 1.1759860000000001e-10 140.875p 1.1825860000000001e-10 140.88749999999999p 1.187418e-10 140.90000000000001p 1.190472e-10 140.91249999999999p 1.191741e-10 140.92500000000001p 1.1912190000000001e-10 140.9375p 1.188902e-10 140.94999999999999p 1.1847910000000001e-10 140.96250000000001p 1.178888e-10 140.97499999999999p 1.1711960000000001e-10 140.98750000000001p 1.161724e-10 141p 1.1504809999999999e-10 141.01250000000002p 1.13748e-10 141.02500000000001p 1.122733e-10 141.03749999999999p 1.10626e-10 141.04999999999998p 1.088079e-10 141.0625p 1.068211e-10 141.07499999999999p 1.0466819999999999e-10
+ 141.08750000000001p 1.0235180000000001e-10 141.10000000000002p 9.9874710000000005e-11 141.11250000000001p 9.7240110000000004e-11 141.125p 9.4451310000000001e-11 141.13749999999999p 9.1511860000000003e-11 141.15000000000001p 8.8425510000000005e-11 141.16249999999999p 8.5196240000000001e-11 141.17500000000001p 8.1828210000000004e-11 141.1875p 7.8325779999999996e-11 141.19999999999999p 7.4693499999999994e-11 141.21250000000001p 7.0936119999999999e-11 141.22499999999999p 6.7058539999999996e-11 141.23750000000001p 6.3065850000000004e-11 141.25p 5.8963289999999995e-11 141.26250000000002p 5.4756269999999999e-11 141.27500000000001p 5.045034e-11 141.28749999999999p 4.6051180000000001e-11 141.29999999999998p 4.156464e-11
+ 141.3125p 3.6996659999999999e-11 141.32499999999999p 3.2353310000000001e-11 141.33750000000001p 2.7640779999999999e-11 141.34999999999999p 2.2865349999999998e-11 141.36250000000001p 1.8033380000000001e-11 141.375p 1.315135e-11 141.38749999999999p 8.2257889999999993e-12 141.40000000000001p 3.2632960000000002e-12 141.41249999999999p -1.729467e-12 141.42500000000001p -6.7457889999999999e-12 141.4375p -1.177892e-11 141.44999999999999p -1.6822079999999999e-11 141.46249999999998p -2.186847e-11 141.47499999999999p -2.691127e-11 141.48750000000001p -3.1943650000000002e-11 141.5p -3.6958819999999998e-11 141.51250000000002p -4.1949959999999997e-11 141.52500000000001p -4.6910290000000002e-11
+ 141.53749999999999p -5.1833089999999997e-11 141.54999999999998p -5.6711630000000001e-11 141.5625p -6.1539279999999999e-11 141.57499999999999p -6.6309440000000001e-11 141.58750000000001p -7.1015579999999999e-11 141.59999999999999p -7.5651250000000003e-11 141.61250000000001p -8.0210109999999999e-11 141.625p -8.4685859999999995e-11 141.63749999999999p -8.9072360000000001e-11 141.65000000000001p -9.3363540000000003e-11 141.66249999999999p -9.7553459999999996e-11 141.67500000000001p -1.0163629999999999e-10 141.6875p -1.056064e-10 141.70000000000002p -1.094583e-10 141.71249999999998p -1.1318649999999999e-10 141.72499999999999p -1.167858e-10 141.73750000000001p -1.2025109999999999e-10 141.75p -1.2357750000000001e-10
+ 141.76250000000002p -1.2676040000000001e-10 141.77500000000001p -1.297952e-10 141.78749999999999p -1.3267750000000001e-10 141.79999999999998p -1.354032e-10 141.8125p -1.3796829999999999e-10 141.82499999999999p -1.4036899999999999e-10 141.83750000000001p -1.4260189999999999e-10 141.84999999999999p -1.446636e-10 141.86250000000001p -1.4655100000000001e-10 141.875p -1.4826120000000001e-10 141.88749999999999p -1.4979149999999999e-10 141.90000000000001p -1.511395e-10 141.91249999999999p -1.5230310000000001e-10 141.92500000000001p -1.532803e-10 141.9375p -1.540693e-10 141.95000000000002p -1.5466869999999999e-10 141.96249999999998p -1.5507720000000001e-10 141.97499999999999p -1.5529389999999999e-10
+ 141.98749999999998p -1.55318e-10 142p -1.551491e-10 142.01250000000002p -1.547868e-10 142.02500000000001p -1.5423119999999999e-10 142.03750000000002p -1.534826e-10 142.04999999999998p -1.525414e-10 142.0625p -1.514084e-10 142.07499999999999p -1.500845e-10 142.08750000000001p -1.485711e-10 142.09999999999999p -1.4686960000000001e-10 142.11250000000001p -1.449818e-10 142.125p -1.429095e-10 142.13749999999999p -1.406551e-10 142.15000000000001p -1.3822089999999999e-10 142.16249999999999p -1.3560960000000001e-10 142.17500000000001p -1.328241e-10 142.1875p -1.298676e-10 142.20000000000002p -1.2674339999999999e-10
+ 142.21249999999998p -1.2345499999999999e-10 142.22499999999999p -1.2000620000000001e-10 142.23749999999998p -1.16401e-10 142.25p -1.126436e-10 142.26250000000002p -1.087383e-10 142.27500000000001p -1.046898e-10 142.28750000000002p -1.005027e-10 142.29999999999998p -9.6181980000000003e-11 142.3125p -9.1732780000000005e-11 142.32499999999999p -8.7160340000000002e-11 142.33750000000001p -8.2470099999999994e-11 142.34999999999999p -7.7667630000000004e-11 142.36250000000001p -7.2758649999999999e-11 142.375p -6.774904e-11 142.38749999999999p -6.2644779999999996e-11 142.40000000000001p -5.7451989999999998e-11 142.41249999999999p -5.2176900000000002e-11 142.42500000000001p -4.6825849999999997e-11
+ 142.4375p -4.1405269999999999e-11 142.45000000000002p -3.5921700000000003e-11 142.46249999999998p -3.0381749999999998e-11 142.47499999999999p -2.479209e-11 142.48749999999998p -1.9159479999999999e-11 142.5p -1.349073e-11 142.51250000000002p -7.7926960000000002e-12 142.52500000000001p -2.0722660000000001e-12 142.53750000000002p 3.6636300000000002e-12 142.54999999999998p 9.4080429999999993e-12 142.5625p 1.5154009999999999e-11 142.57499999999999p 2.0894560000000001e-11 142.58750000000001p 2.6622739999999999e-11 142.59999999999999p 3.2331599999999999e-11 142.61250000000001p 3.8014200000000001e-11 142.625p 4.3663640000000002e-11 142.63749999999999p 4.9273080000000002e-11 142.65000000000001p 5.4835690000000001e-11
+ 142.66249999999999p 6.0344729999999999e-11 142.67500000000001p 6.5793489999999998e-11 142.6875p 7.1175369999999996e-11 142.70000000000002p 7.6483830000000004e-11 142.71250000000001p 8.1712419999999996e-11 142.72499999999999p 8.6854779999999996e-11 142.73749999999998p 9.1904689999999994e-11 142.75p 9.6855999999999994e-11 142.76249999999999p 1.017027e-10 142.77500000000001p 1.0643889999999999e-10 142.78750000000002p 1.110589e-10 142.79999999999998p 1.1555710000000001e-10 142.8125p 1.199279e-10 142.82499999999999p 1.241662e-10 142.83750000000001p 1.282668e-10 142.84999999999999p 1.322246e-10 142.86250000000001p 1.3603500000000001e-10 142.875p 1.3969340000000001e-10
+ 142.88749999999999p 1.431952e-10 142.90000000000001p 1.465362e-10 142.91249999999999p 1.4971249999999999e-10 142.92500000000001p 1.527202e-10 142.9375p 1.555557e-10 142.95000000000002p 1.5821550000000001e-10 142.96250000000001p 1.6069649999999999e-10 142.97499999999999p 1.6299570000000001e-10 142.98749999999998p 1.651103e-10 143p 1.670378e-10 143.01249999999999p 1.687759e-10 143.02500000000001p 1.7032250000000001e-10 143.03750000000002p 1.716758e-10 143.05000000000001p 1.7283430000000001e-10 143.0625p 1.737964e-10 143.07499999999999p 1.745611e-10 143.08750000000001p 1.751276e-10 143.09999999999999p 1.754951e-10
+ 143.11250000000001p 1.7566330000000001e-10 143.125p 1.7563200000000001e-10 143.13749999999999p 1.7540139999999999e-10 143.15000000000001p 1.7497160000000001e-10 143.16249999999999p 1.7434330000000001e-10 143.17500000000001p 1.735173e-10 143.1875p 1.7249469999999999e-10 143.20000000000002p 1.712766e-10 143.21250000000001p 1.6986469999999999e-10 143.22499999999999p 1.6826070000000001e-10 143.23749999999998p 1.6646649999999999e-10 143.25p 1.6448430000000001e-10 143.26249999999999p 1.623167e-10 143.27500000000001p 1.599662e-10 143.28749999999999p 1.574357e-10 143.30000000000001p 1.5472829999999999e-10 143.3125p 1.5184729999999999e-10 143.32499999999999p 1.487962e-10
+ 143.33750000000001p 1.455786e-10 143.34999999999999p 1.421986e-10 143.36250000000001p 1.386601e-10 143.375p 1.349675e-10 143.38750000000002p 1.3112520000000001e-10 143.39999999999998p 1.2713789999999999e-10 143.41249999999999p 1.2301029999999999e-10 143.42500000000001p 1.187474e-10 143.4375p 1.1435420000000001e-10 143.45000000000002p 1.098362e-10 143.46250000000001p 1.051987e-10 143.47499999999999p 1.004472e-10 143.48749999999998p 9.5587360000000004e-11 143.5p 9.0625069999999999e-11 143.51249999999999p 8.5566190000000006e-11 143.52500000000001p 8.0416739999999997e-11 143.53749999999999p 7.5182840000000004e-11 143.55000000000001p 6.9870689999999998e-11
+ 143.5625p 6.4486600000000004e-11 143.57499999999999p 5.9036920000000003e-11 143.58750000000001p 5.3528099999999997e-11 143.59999999999999p 4.7966630000000003e-11 143.61250000000001p 4.2359049999999997e-11 143.625p 3.6711970000000002e-11 143.63750000000002p 3.1032009999999999e-11 143.64999999999998p 2.5325830000000001e-11 143.66249999999999p 1.9600099999999998e-11 143.67500000000001p 1.3861499999999999e-11 143.6875p 8.1167370000000003e-12 143.70000000000002p 2.37248e-12 143.71250000000001p -3.3645969999999999e-12 143.72500000000002p -9.0878440000000005e-12 143.73749999999998p -1.4790649999999999e-11 143.75p -2.046642e-11 143.76249999999999p -2.6108630000000002e-11 143.77500000000001p -3.1710789999999997e-11
+ 143.78749999999999p -3.7266490000000001e-11 143.80000000000001p -4.2769380000000002e-11 143.8125p -4.8213180000000001e-11 143.82499999999999p -5.3591709999999998e-11 143.83750000000001p -5.8898859999999999e-11 143.84999999999999p -6.4128640000000006e-11 143.86250000000001p -6.9275160000000003e-11 143.875p -7.4332640000000002e-11 143.88750000000002p -7.9295420000000006e-11 143.89999999999998p -8.4157970000000001e-11 143.91249999999999p -8.8914889999999999e-11 143.92499999999998p -9.3560919999999999e-11 143.9375p -9.809095e-11 143.95000000000002p -1.025e-10 143.96250000000001p -1.067833e-10 143.97500000000002p -1.109362e-10 143.98749999999998p -1.149542e-10 144p -1.1883299999999999e-10
+ 144.01249999999999p -1.2256850000000001e-10 144.02500000000001p -1.2615679999999999e-10 144.03749999999999p -1.295941e-10 144.05000000000001p -1.328768e-10 144.0625p -1.3600150000000001e-10 144.07499999999999p -1.3896520000000001e-10 144.08750000000001p -1.4176479999999999e-10 144.09999999999999p -1.4439749999999999e-10 144.11250000000001p -1.468609e-10 144.125p -1.4915249999999999e-10 144.13750000000002p -1.512702e-10 144.14999999999998p -1.5321220000000001e-10 144.16249999999999p -1.549767e-10 144.17499999999998p -1.565622e-10 144.1875p -1.579674e-10 144.20000000000002p -1.591914e-10 144.21250000000001p -1.6023329999999999e-10 144.22500000000002p -1.610924e-10
+ 144.23749999999998p -1.6176840000000001e-10 144.25p -1.6226120000000001e-10 144.26249999999999p -1.6257080000000001e-10 144.27500000000001p -1.626975e-10 144.28749999999999p -1.6264169999999999e-10 144.30000000000001p -1.624042e-10 144.3125p -1.6198599999999999e-10 144.32499999999999p -1.6138800000000001e-10 144.33750000000001p -1.6061180000000001e-10 144.34999999999999p -1.5965890000000001e-10 144.36250000000001p -1.58531e-10 144.375p -1.5723009999999999e-10 144.38750000000002p -1.557585e-10 144.39999999999998p -1.5411839999999999e-10 144.41249999999999p -1.523124e-10 144.42499999999998p -1.5034330000000001e-10 144.4375p -1.4821410000000001e-10 144.44999999999999p -1.4592790000000001e-10
+ 144.46250000000001p -1.4348789999999999e-10 144.47500000000002p -1.4089760000000001e-10 144.48749999999998p -1.3816079999999999e-10 144.5p -1.3528110000000001e-10 144.51249999999999p -1.3226259999999999e-10 144.52500000000001p -1.291094e-10 144.53749999999999p -1.258258e-10 144.55000000000001p -1.2241599999999999e-10 144.5625p -1.1888480000000001e-10 144.57499999999999p -1.152367e-10 144.58750000000001p -1.114766e-10 144.59999999999999p -1.076093e-10 144.61250000000001p -1.036399e-10 144.625p -9.9573500000000003e-11 144.63750000000002p -9.5415279999999994e-11 144.65000000000001p -9.1170580000000006e-11 144.66249999999999p -8.6844769999999995e-11 144.67499999999998p -8.2443329999999998e-11
+ 144.6875p -7.7971779999999997e-11 144.69999999999999p -7.3435720000000005e-11 144.71250000000001p -6.8840789999999995e-11 144.72500000000002p -6.4192699999999995e-11 144.73749999999998p -5.9497169999999996e-11 144.75p -5.4759980000000001e-11 144.76249999999999p -4.998691e-11 144.77500000000001p -4.5183779999999997e-11 144.78749999999999p -4.0356409999999999e-11 144.80000000000001p -3.5510619999999998e-11 144.8125p -3.0652239999999999e-11 144.82499999999999p -2.5787070000000001e-11 144.83750000000001p -2.0920909999999999e-11 144.84999999999999p -1.6059520000000001e-11 144.86250000000001p -1.1208639999999999e-11 144.875p -6.3739680000000002e-12 144.88750000000002p -1.5611420000000001e-12 144.90000000000001p 3.22424e-12
+ 144.91249999999999p 7.9766419999999998e-12 144.92499999999998p 1.2690599999999999e-11 144.9375p 1.7360710000000001e-11 144.94999999999999p 2.198166e-11 144.96250000000001p 2.6548230000000001e-11 144.97500000000002p 3.1055280000000003e-11 144.98750000000001p 3.549776e-11 145p 3.987075e-11 145.01249999999999p 4.4169420000000002e-11 145.02500000000001p 4.8389050000000001e-11 145.03749999999999p 5.2525070000000002e-11 145.05000000000001p 5.6573009999999997e-11 145.0625p 6.0528539999999994e-11 145.07499999999999p 6.4387460000000004e-11 145.08749999999998p 6.8145720000000003e-11 145.09999999999999p 7.1799400000000003e-11 145.11250000000001p 7.5344760000000003e-11 145.125p 7.8778179999999995e-11
+ 145.13750000000002p 8.2096219999999995e-11 145.15000000000001p 8.5295569999999994e-11 145.16249999999999p 8.8373140000000004e-11 145.17499999999998p 9.1325940000000005e-11 145.1875p 9.4151210000000006e-11 145.19999999999999p 9.6846320000000002e-11 145.21250000000001p 9.9408850000000004e-11 145.22499999999999p 1.018365e-10 145.23750000000001p 1.041273e-10 145.25p 1.062792e-10 145.26249999999999p 1.0829060000000001e-10 145.27500000000001p 1.101599e-10 145.28749999999999p 1.118859e-10 145.30000000000001p 1.134672e-10 145.3125p 1.149031e-10 145.32500000000002p 1.161926e-10 145.33749999999998p 1.173352e-10 145.34999999999999p 1.183305e-10
+ 145.36250000000001p 1.191783e-10 145.375p 1.1987849999999999e-10 145.38750000000002p 1.2043129999999999e-10 145.40000000000001p 1.208371e-10 145.41249999999999p 1.2109630000000001e-10 145.42499999999998p 1.2120959999999999e-10 145.4375p 1.211781e-10 145.44999999999999p 1.210026e-10 145.46250000000001p 1.206844e-10 145.47499999999999p 1.2022499999999999e-10 145.48750000000001p 1.1962589999999999e-10 145.5p 1.188889e-10 145.51249999999999p 1.1801590000000001e-10 145.52500000000001p 1.1700900000000001e-10 145.53749999999999p 1.1587039999999999e-10 145.55000000000001p 1.146024e-10 145.5625p 1.1320770000000001e-10 145.57500000000002p 1.116889e-10
+ 145.58749999999998p 1.100488e-10 145.59999999999999p 1.0829040000000001e-10 145.61250000000001p 1.0641679999999999e-10 145.625p 1.044312e-10 145.63750000000002p 1.023369e-10 145.65000000000001p 1.0013749999999999e-10 145.66250000000002p 9.7836540000000001e-11 145.67499999999998p 9.5437640000000003e-11 145.6875p 9.2944639999999994e-11 145.69999999999999p 9.0361420000000004e-11 145.71250000000001p 8.7691960000000004e-11 145.72499999999999p 8.4940330000000003e-11 145.73750000000001p 8.211067e-11 145.75p 7.9207220000000001e-11 145.76249999999999p 7.6234270000000001e-11 145.77500000000001p 7.3196159999999997e-11 145.78749999999999p 7.0097309999999994e-11 145.80000000000001p 6.6942179999999995e-11
+ 145.8125p 6.373529e-11 145.82500000000002p 6.0481169999999998e-11 145.83749999999998p 5.7184410000000003e-11 145.84999999999999p 5.3849600000000002e-11 145.86249999999998p 5.0481379999999998e-11 145.875p 4.7084380000000002e-11 145.88750000000002p 4.3663239999999997e-11 145.90000000000001p 4.0222619999999998e-11 145.91250000000002p 3.6767150000000002e-11 145.92499999999998p 3.3301469999999999e-11 145.9375p 2.9830200000000001e-11 145.94999999999999p 2.6357909999999999e-11 145.96250000000001p 2.288918e-11 145.97499999999999p 1.9428540000000002e-11 145.98750000000001p 1.598046e-11 146p 1.2549400000000001e-11 146.01249999999999p 9.1397400000000004e-12 146.02500000000001p 5.7558110000000001e-12
+ 146.03749999999999p 2.401883e-12 146.05000000000001p -9.1784509999999997e-13 146.0625p -4.199246e-12 146.07500000000002p -7.4382730000000005e-12 146.08749999999998p -1.063096e-11 146.09999999999999p -1.377344e-11 146.11249999999998p -1.6861920000000001e-11 146.125p -1.9892730000000001e-11 146.13750000000002p -2.2862270000000001e-11 146.15000000000001p -2.576708e-11 146.16250000000002p -2.860379e-11 146.17499999999998p -3.1369159999999997e-11 146.1875p -3.406005e-11 146.19999999999999p -3.6673450000000002e-11 146.21250000000001p -3.9206490000000003e-11 146.22499999999999p -4.1656399999999998e-11 146.23750000000001p -4.402056e-11 146.25p -4.6296490000000001e-11
+ 146.26249999999999p -4.848183e-11 146.27500000000001p -5.0574380000000001e-11 146.28749999999999p -5.2572069999999999e-11 146.30000000000001p -5.4472970000000002e-11 146.3125p -5.62753e-11 146.32500000000002p -5.7977429999999999e-11 146.33749999999998p -5.9577879999999994e-11 146.34999999999999p -6.1075319999999997e-11 146.36249999999998p -6.2468569999999994e-11 146.375p -6.3756599999999997e-11 146.38749999999999p -6.4938539999999995e-11 146.40000000000001p -6.6013660000000006e-11 146.41250000000002p -6.6981389999999999e-11 146.42499999999998p -6.784133e-11 146.4375p -6.8593209999999997e-11 146.44999999999999p -6.9236920000000004e-11 146.46250000000001p -6.9772509999999997e-11 146.47499999999999p -7.0200160000000002e-11
+ 146.48750000000001p -7.0520229999999996e-11 146.5p -7.0733219999999995e-11 146.51249999999999p -7.0839749999999996e-11 146.52500000000001p -7.084063e-11 146.53749999999999p -7.0736779999999995e-11 146.55000000000001p -7.0529270000000006e-11 146.5625p -7.0219330000000005e-11 146.57500000000002p -6.9808309999999996e-11 146.58750000000001p -6.9297689999999994e-11 146.59999999999999p -6.8689090000000002e-11 146.61249999999998p -6.7984259999999998e-11 146.625p -6.7185080000000006e-11 146.63749999999999p -6.6293550000000005e-11 146.65000000000001p -6.5311779999999999e-11 146.66250000000002p -6.424201e-11 146.67499999999998p -6.3086589999999995e-11 146.6875p -6.1847970000000003e-11 146.69999999999999p -6.0528719999999995e-11
+ 146.71250000000001p -5.9131490000000001e-11 146.72499999999999p -5.7659049999999999e-11 146.73750000000001p -5.6114249999999998e-11 146.75p -5.4500019999999998e-11 146.76249999999999p -5.2819380000000002e-11 146.77500000000001p -5.1075439999999997e-11 146.78749999999999p -4.9271359999999998e-11 146.80000000000001p -4.7410399999999999e-11 146.8125p -4.549585e-11 146.82500000000002p -4.353109e-11 146.83750000000001p -4.1519530000000003e-11 146.84999999999999p -3.9464640000000002e-11 146.86249999999998p -3.736994e-11 146.875p -3.5238979999999999e-11 146.88749999999999p -3.3075340000000002e-11 146.90000000000001p -3.088264e-11 146.91249999999999p -2.866451e-11 146.92500000000001p -2.642461e-11
+ 146.9375p -2.416661e-11 146.94999999999999p -2.1894180000000001e-11 146.96250000000001p -1.961099e-11 146.97499999999999p -1.732072e-11 146.98750000000001p -1.5027039999999999e-11 147p -1.273359e-11 147.01249999999999p -1.044401e-11 147.02499999999998p -8.1619069999999998e-12 147.03749999999999p -5.8908559999999999e-12 147.05000000000001p -3.6344019999999999e-12 147.0625p -1.396054e-12 147.07500000000002p 8.2072789999999998e-13 147.08750000000001p 3.0125299999999999e-12 147.09999999999999p 5.175992e-12 147.11249999999998p 7.3078129999999994e-12 147.125p 9.404753e-12 147.13749999999999p 1.1463639999999999e-11 147.15000000000001p 1.3481370000000001e-11
+ 147.16249999999999p 1.5454930000000001e-11 147.17500000000001p 1.7381359999999999e-11 147.1875p 1.92578e-11 147.19999999999999p 2.1081480000000001e-11 147.21250000000001p 2.2849710000000001e-11 147.22499999999999p 2.4559919999999999e-11 147.23750000000001p 2.6209589999999998e-11 147.25p 2.7796359999999999e-11 147.26250000000002p 2.9317920000000003e-11 147.27499999999998p 3.0772109999999997e-11 147.28749999999999p 3.2156849999999999e-11 147.30000000000001p 3.3470200000000001e-11 147.3125p 3.4710319999999999e-11 147.32500000000002p 3.5875479999999998e-11 147.33750000000001p 3.6964079999999997e-11 147.34999999999999p 3.7974650000000002e-11 147.36249999999998p 3.8905830000000001e-11 147.375p 3.9756379999999998e-11
+ 147.38749999999999p 4.0525220000000001e-11 147.40000000000001p 4.1211360000000002e-11 147.41249999999999p 4.1813950000000001e-11 147.42500000000001p 4.2332280000000002e-11 147.4375p 4.2765769999999999e-11 147.44999999999999p 4.3113959999999999e-11 147.46250000000001p 4.3376519999999997e-11 147.47499999999999p 4.3553280000000001e-11 147.48750000000001p 4.3644160000000001e-11 147.5p 4.364924e-11 147.51250000000002p 4.3568720000000002e-11 147.52499999999998p 4.3402929999999998e-11 147.53749999999999p 4.315235e-11 147.54999999999998p 4.2817560000000001e-11 147.5625p 4.2399270000000002e-11 147.57500000000002p 4.1898339999999997e-11 147.58750000000001p 4.1315740000000002e-11 147.60000000000002p 4.0652550000000002e-11
+ 147.61249999999998p 3.9910000000000001e-11 147.625p 3.908941e-11 147.63749999999999p 3.819224e-11 147.65000000000001p 3.7220059999999998e-11 147.66249999999999p 3.6174530000000001e-11 147.67500000000001p 3.505746e-11 147.6875p 3.3870730000000003e-11 147.69999999999999p 3.261634e-11 147.71250000000001p 3.1296400000000001e-11 147.72499999999999p 2.9913100000000003e-11 147.73750000000001p 2.8468720000000001e-11 147.75p 2.696567e-11 147.76250000000002p 2.5406399999999999e-11 147.77499999999998p 2.3793469999999999e-11 147.78749999999999p 2.212951e-11 147.79999999999998p 2.0417239999999999e-11 147.8125p 1.8659430000000001e-11 147.82500000000002p 1.685893e-11
+ 147.83750000000001p 1.5018670000000001e-11 147.85000000000002p 1.314161e-11 147.86249999999998p 1.123077e-11 147.875p 9.2892469999999993e-12 147.88749999999999p 7.3201540000000004e-12 147.90000000000001p 5.3266589999999997e-12 147.91249999999999p 3.3119660000000002e-12 147.92500000000001p 1.2793109999999999e-12 147.9375p -7.6804289999999998e-13 147.94999999999999p -2.8268100000000001e-12 147.96250000000001p -4.8936870000000002e-12 147.97499999999999p -6.9653550000000001e-12 147.98750000000001p -9.0384879999999998e-12 148p -1.110976e-11 148.01250000000002p -1.317583e-11 148.02499999999998p -1.5233380000000001e-11 148.03749999999999p -1.7279110000000001e-11 148.04999999999998p -1.93097e-11
+ 148.0625p -2.1321889999999999e-11 148.07500000000002p -2.3312419999999999e-11 148.08750000000001p -2.527807e-11 148.10000000000002p -2.721565e-11 148.11249999999998p -2.9121989999999997e-11 148.125p -3.0994010000000002e-11 148.13749999999999p -3.2828630000000002e-11 148.15000000000001p -3.4622850000000003e-11 148.16249999999999p -3.6373710000000002e-11 148.17500000000001p -3.807831e-11 148.1875p -3.9733840000000001e-11 148.19999999999999p -4.1337529999999999e-11 148.21250000000001p -4.2886690000000002e-11 148.22499999999999p -4.4378709999999998e-11 148.23750000000001p -4.5811059999999999e-11 148.25p -4.718129e-11 148.26250000000002p -4.8487029999999997e-11 148.27500000000001p -4.9726020000000002e-11
+ 148.28749999999999p -5.0896079999999999e-11 148.29999999999998p -5.1995120000000002e-11 148.3125p -5.3021169999999998e-11 148.32499999999999p -5.3972350000000002e-11 148.33750000000001p -5.4846869999999999e-11 148.35000000000002p -5.5643080000000002e-11 148.36249999999998p -5.6359420000000001e-11 148.375p -5.6994449999999999e-11 148.38749999999999p -5.7546830000000003e-11 148.40000000000001p -5.8015350000000001e-11 148.41249999999999p -5.8398919999999997e-11 148.42500000000001p -5.8696560000000006e-11 148.4375p -5.8907420000000003e-11 148.44999999999999p -5.9030760000000001e-11 148.46250000000001p -5.9065989999999995e-11 148.47499999999999p -5.90126e-11 148.48750000000001p -5.8870250000000002e-11 148.5p -5.8638709999999996e-11
+ 148.51250000000002p -5.8317860000000004e-11 148.52500000000001p -5.7907729999999998e-11 148.53749999999999p -5.7408460000000002e-11 148.54999999999998p -5.6820320000000001e-11 148.5625p -5.6143720000000001e-11 148.57499999999999p -5.5379179999999999e-11 148.58750000000001p -5.4527359999999999e-11 148.60000000000002p -5.3589010000000003e-11 148.61250000000001p -5.2565049999999998e-11 148.625p -5.1456489999999999e-11 148.63749999999999p -5.0264479999999997e-11 148.65000000000001p -4.8990269999999998e-11 148.66249999999999p -4.7635250000000001e-11 148.67500000000001p -4.6200900000000002e-11 148.6875p -4.4688839999999999e-11 148.69999999999999p -4.3100790000000002e-11 148.71250000000001p -4.1438580000000002e-11 148.72499999999999p -3.9704150000000001e-11
+ 148.73750000000001p -3.7899549999999998e-11 148.75p -3.6026909999999997e-11 148.76250000000002p -3.4088479999999997e-11 148.77500000000001p -3.2086609999999997e-11 148.78749999999999p -3.0023729999999998e-11 148.79999999999998p -2.790237e-11 148.8125p -2.572515e-11 148.82499999999999p -2.3494740000000001e-11 148.83750000000001p -2.121394e-11 148.84999999999999p -1.8885599999999999e-11 148.86250000000001p -1.6512629999999999e-11 148.875p -1.409804e-11 148.88749999999999p -1.164489e-11 148.90000000000001p -9.1562809999999992e-12 148.91249999999999p -6.6354039999999997e-12 148.92500000000001p -4.0854829999999998e-12 148.9375p -1.509795e-12 148.94999999999999p 1.0883419999999999e-12
+ 148.96249999999998p 3.7055670000000002e-12 148.97499999999999p 6.3384860000000001e-12 148.98750000000001p 8.9836740000000005e-12 149p 1.163768e-11 149.01250000000002p 1.429703e-11 149.02500000000001p 1.695825e-11 149.03749999999999p 1.9617820000000001e-11 149.04999999999998p 2.2272239999999998e-11 149.0625p 2.4917989999999999e-11 149.07499999999999p 2.7551579999999999e-11 149.08750000000001p 3.01695e-11 149.09999999999999p 3.2768249999999998e-11 149.11250000000001p 3.5344350000000001e-11 149.125p 3.789437e-11 149.13749999999999p 4.041486e-11 149.15000000000001p 4.2902420000000003e-11 149.16249999999999p 4.5353690000000001e-11 149.17500000000001p 4.7765329999999999e-11
+ 149.1875p 5.0134070000000003e-11 149.20000000000002p 5.2456670000000003e-11 149.21249999999998p 5.472993e-11 149.22499999999999p 5.6950740000000002e-11 149.23750000000001p 5.9116009999999996e-11 149.25p 6.1222740000000001e-11 149.26250000000002p 6.3268000000000001e-11 149.27500000000001p 6.5248920000000004e-11 149.28749999999999p 6.7162699999999999e-11 149.29999999999998p 6.9006649999999995e-11 149.3125p 7.0778120000000001e-11 149.32499999999999p 7.2474580000000004e-11 149.33750000000001p 7.4093579999999998e-11 149.34999999999999p 7.5632760000000005e-11 149.36250000000001p 7.7089870000000005e-11 149.375p 7.8462730000000005e-11 149.38749999999999p 7.9749300000000006e-11 149.40000000000001p 8.0947610000000005e-11
+ 149.41249999999999p 8.2055829999999996e-11 149.42500000000001p 8.3072220000000006e-11 149.4375p 8.3995149999999999e-11 149.45000000000002p 8.4823129999999995e-11 149.46249999999998p 8.5554750000000006e-11 149.47499999999999p 8.6188759999999997e-11 149.48749999999998p 8.6723990000000002e-11 149.5p 8.7159430000000006e-11 149.51250000000002p 8.7494170000000003e-11 149.52500000000001p 8.7727420000000001e-11 149.53750000000002p 8.7858540000000005e-11 149.54999999999998p 8.7887000000000006e-11 149.5625p 8.7812399999999994e-11 149.57499999999999p 8.763448e-11 149.58750000000001p 8.7353090000000001e-11 149.59999999999999p 8.6968229999999997e-11 149.61250000000001p 8.6479999999999995e-11 149.625p 8.5888669999999995e-11
+ 149.63749999999999p 8.5194610000000004e-11 149.65000000000001p 8.439832e-11 149.66249999999999p 8.3500440000000004e-11 149.67500000000001p 8.2501730000000003e-11 149.6875p 8.1403089999999998e-11 149.70000000000002p 8.0205519999999999e-11 149.71249999999998p 7.8910160000000004e-11 149.72499999999999p 7.7518290000000002e-11 149.73749999999998p 7.6031270000000004e-11 149.75p 7.4450630000000001e-11 149.76250000000002p 7.2777980000000003e-11 149.77500000000001p 7.1015050000000003e-11 149.78750000000002p 6.9163719999999999e-11 149.79999999999998p 6.722593e-11 149.8125p 6.5203760000000004e-11 149.82499999999999p 6.3099399999999997e-11 149.83750000000001p 6.0915139999999994e-11 149.84999999999999p 5.865336e-11
+ 149.86250000000001p 5.6316549999999998e-11 149.875p 5.3907279999999998e-11 149.88749999999999p 5.1428250000000002e-11 149.90000000000001p 4.88822e-11 149.91249999999999p 4.6272000000000003e-11 149.92500000000001p 4.3600559999999997e-11 149.9375p 4.0870909999999999e-11 149.95000000000002p 3.8086130000000003e-11 149.96249999999998p 3.5249369999999999e-11 149.97499999999999p 3.2363859999999997e-11 149.98749999999998p 2.9432879999999997e-11 150p 2.645979e-11 150.01249999999999p 2.3447980000000001e-11 150.02500000000001p 2.0400900000000001e-11 150.03750000000002p 1.7322049999999999e-11 150.04999999999998p 1.4214979999999999e-11 150.0625p 1.1083269999999999e-11 150.07499999999999p 7.9305129999999992e-12
+ 150.08750000000001p 4.7603660000000004e-12 150.09999999999999p 1.5764889999999999e-12 150.11250000000001p -1.6174310000000001e-12 150.125p -4.8176940000000001e-12 150.13749999999999p -8.0205869999999997e-12 150.15000000000001p -1.1222389999999999e-11 150.16249999999999p -1.441939e-11 150.17500000000001p -1.760786e-11 150.1875p -2.0784109999999999e-11 150.20000000000002p -2.394441e-11 150.21250000000001p -2.7085110000000002e-11 150.22499999999999p -3.0202540000000002e-11 150.23749999999998p -3.3293049999999999e-11 150.25p -3.6353059999999998e-11 150.26249999999999p -3.9378990000000002e-11 150.27500000000001p -4.2367299999999997e-11 150.28750000000002p -4.5314520000000001e-11 150.29999999999998p -4.8217190000000002e-11
+ 150.3125p -5.107194e-11 150.32499999999999p -5.3875419999999998e-11 150.33750000000001p -5.6624370000000003e-11 150.34999999999999p -5.9315569999999997e-11 150.36250000000001p -6.1945889999999996e-11 150.375p -6.4512240000000006e-11 150.38749999999999p -6.7011650000000006e-11 150.40000000000001p -6.9441180000000004e-11 150.41249999999999p -7.1798010000000002e-11 150.42500000000001p -7.4079379999999995e-11 150.4375p -7.6282649999999999e-11 150.45000000000002p -7.8405230000000003e-11 150.46250000000001p -8.0444670000000003e-11 150.47499999999999p -8.2398580000000002e-11 150.48749999999998p -8.4264700000000001e-11 150.5p -8.6040849999999994e-11 150.51249999999999p -8.7724980000000001e-11 150.52500000000001p -8.9315130000000001e-11
+ 150.53750000000002p -9.0809460000000006e-11 150.55000000000001p -9.2206239999999998e-11 150.5625p -9.3503860000000005e-11 150.57499999999999p -9.4700829999999994e-11 150.58750000000001p -9.5795749999999997e-11 150.59999999999999p -9.6787390000000002e-11 150.61250000000001p -9.7674609999999996e-11 150.625p -9.8456389999999999e-11 150.63749999999999p -9.9131850000000006e-11 150.65000000000001p -9.970022e-11 150.66249999999999p -1.001609e-10 150.67500000000001p -1.005133e-10 150.6875p -1.007571e-10 150.70000000000002p -1.008921e-10 150.71250000000001p -1.009181e-10 150.72499999999999p -1.008351e-10 150.73749999999998p -1.006432e-10 150.75p -1.0034269999999999e-10
+ 150.76249999999999p -9.9934049999999996e-11 150.77500000000001p -9.9417670000000003e-11 150.78749999999999p -9.8794230000000001e-11 150.80000000000001p -9.8064479999999997e-11 150.8125p -9.7229309999999999e-11 150.82499999999999p -9.6289729999999997e-11 150.83750000000001p -9.5246869999999997e-11 150.84999999999999p -9.4101970000000003e-11 150.86250000000001p -9.285639e-11 150.875p -9.151163e-11 150.88750000000002p -9.0069269999999998e-11 150.89999999999998p -8.8531019999999998e-11 150.91249999999999p -8.6898700000000004e-11 150.92500000000001p -8.5174240000000006e-11 150.9375p -8.335967e-11 150.95000000000002p -8.1457109999999995e-11 150.96250000000001p -7.9468809999999996e-11 150.97499999999999p -7.7397079999999994e-11
+ 150.98749999999998p -7.524436e-11 151p -7.3013160000000003e-11 151.01249999999999p -7.070607e-11 151.02500000000001p -6.8325789999999998e-11 151.03749999999999p -6.587508e-11 151.05000000000001p -6.3356789999999997e-11 151.0625p -6.0773830000000001e-11 151.07499999999999p -5.8129200000000001e-11 151.08750000000001p -5.5425949999999998e-11 151.09999999999999p -5.2667200000000003e-11 151.11250000000001p -4.9856129999999998e-11 151.125p -4.6995969999999999e-11 151.13750000000002p -4.4090009999999999e-11 151.14999999999998p -4.114158e-11 151.16249999999999p -3.8154039999999998e-11 151.17500000000001p -3.513083e-11 151.1875p -3.2075380000000003e-11 151.20000000000002p -2.8991180000000001e-11
+ 151.21250000000001p -2.588172e-11 151.22500000000002p -2.2750540000000001e-11 151.23749999999998p -1.9601190000000001e-11 151.25p -1.6437209999999999e-11 151.26249999999999p -1.326219e-11 151.27500000000001p -1.0079689999999999e-11 151.28749999999999p -6.8932799999999999e-12 151.30000000000001p -3.7065399999999997e-12 151.3125p -5.2302779999999999e-13 151.32499999999999p 2.6537060000000001e-12 151.33750000000001p 5.8201269999999996e-12 151.34999999999999p 8.9727230000000007e-12 151.36250000000001p 1.2108010000000001e-11 151.375p 1.5222510000000002e-11 151.38750000000002p 1.8312819999999999e-11 151.39999999999998p 2.1375539999999999e-11 151.41249999999999p 2.440732e-11 151.42499999999998p 2.7404860000000001e-11
+ 151.4375p 3.0364889999999998e-11 151.45000000000002p 3.3284229999999999e-11 151.46250000000001p 3.6159710000000002e-11 151.47500000000002p 3.8988260000000003e-11 151.48749999999998p 4.1766849999999999e-11 151.5p 4.4492510000000001e-11 151.51249999999999p 4.7162379999999999e-11 151.52500000000001p 4.9773620000000002e-11 151.53749999999999p 5.2323499999999998e-11 151.55000000000001p 5.4809370000000001e-11 151.5625p 5.7228640000000002e-11 151.57499999999999p 5.9578829999999999e-11 151.58750000000001p 6.1857539999999995e-11 151.59999999999999p 6.4062450000000002e-11 151.61250000000001p 6.6191340000000004e-11 151.625p 6.8242099999999999e-11 151.63750000000002p 7.0212689999999998e-11 151.64999999999998p 7.2101199999999997e-11
+ 151.66249999999999p 7.3905790000000006e-11 151.67499999999998p 7.5624749999999995e-11 151.6875p 7.7256470000000004e-11 151.70000000000002p 7.8799429999999996e-11 151.71250000000001p 8.0252239999999995e-11 151.72500000000002p 8.1613619999999999e-11 151.73749999999998p 8.288237e-11 151.75p 8.4057450000000006e-11 151.76249999999999p 8.513789e-11 151.77500000000001p 8.6122860000000005e-11 151.78749999999999p 8.7011630000000003e-11 151.80000000000001p 8.7803599999999994e-11 151.8125p 8.8498270000000001e-11 151.82499999999999p 8.9095259999999999e-11 151.83750000000001p 8.9594319999999997e-11 151.84999999999999p 8.9995280000000002e-11 151.86250000000001p 9.0298120000000001e-11 151.875p 9.0502929999999996e-11
+ 151.88750000000002p 9.0609889999999999e-11 151.89999999999998p 9.0619329999999994e-11 151.91249999999999p 9.0531650000000006e-11 151.92499999999998p 9.0347400000000002e-11 151.9375p 9.0067220000000003e-11 151.94999999999999p 8.9691869999999996e-11 151.96250000000001p 8.9222209999999999e-11 151.97500000000002p 8.8659199999999998e-11 151.98749999999998p 8.800393e-11 152p 8.7257580000000003e-11 152.01249999999999p 8.6421420000000003e-11 152.02500000000001p 8.5496829999999994e-11 152.03749999999999p 8.4485290000000005e-11 152.05000000000001p 8.3388380000000004e-11 152.0625p 8.2207760000000006e-11 152.07499999999999p 8.0945190000000004e-11 152.08750000000001p 7.9602510000000003e-11 152.09999999999999p 7.8181659999999997e-11
+ 152.11250000000001p 7.6684640000000004e-11 152.125p 7.5113549999999994e-11 152.13750000000002p 7.3470569999999999e-11 152.15000000000001p 7.1757940000000006e-11 152.16249999999999p 6.9977970000000005e-11 152.17499999999998p 6.8133050000000004e-11 152.1875p 6.6225629999999998e-11 152.19999999999999p 6.4258230000000005e-11 152.21250000000001p 6.2233399999999999e-11 152.22500000000002p 6.0153780000000005e-11 152.23749999999998p 5.8022049999999998e-11 152.25p 5.5840919999999999e-11 152.26249999999999p 5.3613169999999997e-11 152.27500000000001p 5.13416e-11 152.28749999999999p 4.9029069999999997e-11 152.30000000000001p 4.6678449999999998e-11 152.3125p 4.4292650000000001e-11 152.32499999999999p 4.1874619999999998e-11
+ 152.33750000000001p 3.9427299999999999e-11 152.34999999999999p 3.6953690000000003e-11 152.36250000000001p 3.445676e-11 152.375p 3.1939530000000002e-11 152.38750000000002p 2.940501e-11 152.40000000000001p 2.685622e-11 152.41249999999999p 2.4296159999999999e-11 152.42499999999998p 2.1727860000000001e-11 152.4375p 1.9154319999999999e-11 152.44999999999999p 1.657853e-11 152.46250000000001p 1.400347e-11 152.47500000000002p 1.1432109999999999e-11 152.48750000000001p 8.8673779999999994e-12 152.5p 6.3121999999999997e-12 152.51249999999999p 3.7694570000000003e-12 152.52500000000001p 1.2420030000000001e-12 152.53749999999999p -1.2673420000000001e-12 152.55000000000001p -3.7557999999999998e-12
+ 152.5625p -6.2206320000000003e-12 152.57499999999999p -8.6591460000000004e-12 152.58749999999998p -1.1068699999999999e-11 152.59999999999999p -1.344669e-11 152.61250000000001p -1.5790599999999999e-11 152.625p -1.8097919999999999e-11 152.63750000000002p -2.0366259999999999e-11 152.65000000000001p -2.259323e-11 152.66249999999999p -2.4776549999999999e-11 152.67499999999998p -2.6913999999999999e-11 152.6875p -2.900342e-11 152.69999999999999p -3.1042719999999997e-11 152.71250000000001p -3.3029900000000002e-11 152.72499999999999p -3.496302e-11 152.73750000000001p -3.6840220000000003e-11 152.75p -3.8659750000000003e-11 152.76249999999999p -4.0419900000000001e-11 152.77500000000001p -4.2119069999999999e-11
+ 152.78749999999999p -4.3755740000000002e-11 152.80000000000001p -4.5328480000000002e-11 152.8125p -4.683593e-11 152.82500000000002p -4.8276849999999998e-11 152.83749999999998p -4.965006e-11 152.84999999999999p -5.0954490000000003e-11 152.86250000000001p -5.2189170000000002e-11 152.875p -5.3353200000000001e-11 152.88750000000002p -5.4445779999999997e-11 152.90000000000001p -5.5466219999999999e-11 152.91249999999999p -5.6413919999999997e-11 152.92499999999998p -5.7288340000000001e-11 152.9375p -5.8089090000000001e-11 152.94999999999999p -5.881584e-11 152.96250000000001p -5.9468350000000006e-11 152.97499999999999p -6.0046499999999998e-11 152.98750000000001p -6.0550239999999997e-11 153p -6.0979640000000005e-11
+ 153.01249999999999p -6.133482e-11 153.02500000000001p -6.1616040000000004e-11 153.03749999999999p -6.1823619999999995e-11 153.05000000000001p -6.1957979999999996e-11 153.0625p -6.2019630000000002e-11 153.07500000000002p -6.200917e-11 153.08749999999998p -6.1927270000000001e-11 153.09999999999999p -6.1774710000000002e-11 153.11250000000001p -6.1552329999999998e-11 153.125p -6.1261070000000001e-11 153.13750000000002p -6.0901950000000005e-11 153.15000000000001p -6.0476050000000002e-11 153.16250000000002p -5.9984540000000006e-11 153.17499999999998p -5.9428659999999997e-11 153.1875p -5.8809739999999994e-11 153.19999999999999p -5.8129159999999997e-11 153.21250000000001p -5.7388359999999998e-11 153.22499999999999p -5.6588870000000002e-11
+ 153.23750000000001p -5.5732280000000002e-11 153.25p -5.4820220000000002e-11 153.26249999999999p -5.3854390000000001e-11 153.27500000000001p -5.283656e-11 153.28749999999999p -5.1768540000000003e-11 153.30000000000001p -5.0652179999999999e-11 153.3125p -4.9489399999999998e-11 153.32500000000002p -4.8282140000000001e-11 153.33749999999998p -4.703241e-11 153.34999999999999p -4.5742230000000003e-11 153.36249999999998p -4.4413669999999997e-11 153.375p -4.3048849999999998e-11 153.38750000000002p -4.1649890000000001e-11 153.40000000000001p -4.0218949999999999e-11 153.41250000000002p -3.8758219999999997e-11 153.42499999999998p -3.7269889999999999e-11 153.4375p -3.5756209999999998e-11 153.44999999999999p -3.4219390000000002e-11
+ 153.46250000000001p -3.2661699999999999e-11 153.47499999999999p -3.1085380000000001e-11 153.48750000000001p -2.949271e-11 153.5p -2.7885950000000002e-11 153.51249999999999p -2.6267370000000001e-11 153.52500000000001p -2.4639220000000001e-11 153.53749999999999p -2.3003760000000001e-11 153.55000000000001p -2.1363240000000001e-11 153.5625p -1.9719900000000001e-11 153.57500000000002p -1.8075939999999999e-11 153.58749999999998p -1.6433570000000001e-11 153.59999999999999p -1.4794970000000001e-11 153.61249999999998p -1.316229e-11 153.625p -1.153765e-11 153.63750000000002p -9.9231619999999994e-12 153.65000000000001p -8.3208820000000003e-12 153.66250000000002p -6.7328440000000001e-12 153.67499999999998p -5.16104e-12
+ 153.6875p -3.6074239999999999e-12 153.69999999999999p -2.0739060000000001e-12 153.71250000000001p -5.6235459999999995e-13 153.72499999999999p 9.2541169999999996e-13 153.73750000000001p 2.3876219999999998e-12 153.75p 3.8225559999999999e-12 153.76249999999999p 5.2285490000000002e-12 153.77500000000001p 6.6039870000000003e-12 153.78749999999999p 7.9473180000000002e-12 153.80000000000001p 9.2570450000000008e-12 153.8125p 1.053173e-11 153.82500000000002p 1.1770009999999999e-11 153.83750000000001p 1.2970569999999999e-11 153.84999999999999p 1.413216e-11 153.86249999999998p 1.52536e-11 153.875p 1.633379e-11 153.88749999999999p 1.7371680000000001e-11 153.90000000000001p 1.836631e-11
+ 153.91250000000002p 1.9316760000000001e-11 153.92499999999998p 2.0222209999999999e-11 153.9375p 2.1081889999999999e-11 153.94999999999999p 2.189513e-11 153.96250000000001p 2.2661309999999999e-11 153.97499999999999p 2.3379889999999999e-11 153.98750000000001p 2.4050410000000001e-11 154p 2.4672459999999999e-11 154.01249999999999p 2.5245749999999999e-11 154.02500000000001p 2.5770010000000001e-11 154.03749999999999p 2.6245089999999999e-11 154.05000000000001p 2.667089e-11 154.0625p 2.7047379999999999e-11 154.07500000000002p 2.737462e-11 154.08750000000001p 2.7652729999999999e-11 154.09999999999999p 2.78819e-11 154.11249999999998p 2.806241e-11 154.125p 2.8194589999999999e-11
+ 154.13749999999999p 2.8278840000000001e-11 154.15000000000001p 2.8315639999999999e-11 154.16250000000002p 2.8305529999999998e-11 154.17499999999998p 2.8249109999999999e-11 154.1875p 2.8147079999999999e-11 154.19999999999999p 2.800015e-11 154.21250000000001p 2.7809120000000001e-11 154.22499999999999p 2.7574869999999998e-11 154.23750000000001p 2.729829e-11 154.25p 2.698038e-11 154.26249999999999p 2.6622150000000001e-11 154.27500000000001p 2.62247e-11 154.28749999999999p 2.5789159999999999e-11 154.30000000000001p 2.531671e-11 154.3125p 2.480859e-11 154.32500000000002p 2.426608e-11 154.33750000000001p 2.3690499999999999e-11 154.34999999999999p 2.308322e-11
+ 154.36249999999998p 2.2445640000000001e-11 154.375p 2.1779200000000002e-11 154.38749999999999p 2.1085370000000001e-11 154.40000000000001p 2.0365670000000001e-11 154.41249999999999p 1.962163e-11 154.42500000000001p 1.8854809999999999e-11 154.4375p 1.80668e-11 154.44999999999999p 1.7259229999999999e-11 154.46250000000001p 1.6433699999999999e-11 154.47499999999999p 1.559189e-11 154.48750000000001p 1.4735449999999999e-11 154.5p 1.3866050000000001e-11 154.51249999999999p 1.2985380000000001e-11 154.52499999999998p 1.2095150000000001e-11 154.53749999999999p 1.119703e-11 154.55000000000001p 1.0292739999999999e-11 154.5625p 9.3839779999999998e-12 154.57500000000002p 8.4724310000000003e-12
+ 154.58750000000001p 7.5597939999999999e-12 154.59999999999999p 6.6477489999999996e-12 154.61249999999998p 5.7379680000000001e-12 154.625p 4.8321109999999999e-12 154.63749999999999p 3.9318190000000003e-12 154.65000000000001p 3.038719e-12 154.66249999999999p 2.1544140000000002e-12 154.67500000000001p 1.280488e-12 154.6875p 4.1849589999999999e-13 154.69999999999999p -4.3003100000000001e-13 154.71250000000001p -1.263592e-12 154.72499999999999p -2.08072e-12 154.73750000000001p -2.8799789999999998e-12 154.75p -3.6599710000000004e-12 154.76250000000002p -4.4193329999999996e-12 154.77499999999998p -5.1567449999999998e-12 154.78749999999999p -5.8709270000000002e-12 154.80000000000001p -6.5606420000000001e-12
+ 154.8125p -7.2246990000000003e-12 154.82500000000002p -7.8619550000000001e-12 154.83750000000001p -8.4713120000000005e-12 154.84999999999999p -9.0517249999999994e-12 154.86249999999998p -9.6022010000000002e-12 154.875p -1.01218e-11 154.88749999999999p -1.0609630000000001e-11 154.90000000000001p -1.106485e-11 154.91249999999999p -1.148671e-11 154.92500000000001p -1.187447e-11 154.9375p -1.222748e-11 154.94999999999999p -1.2545129999999999e-11 154.96250000000001p -1.282689e-11 154.97499999999999p -1.3072279999999999e-11 154.98750000000001p -1.3280880000000001e-11 155p -1.345233e-11 155.01250000000002p -1.358633e-11 155.02499999999998p -1.368267e-11
+ 155.03749999999999p -1.374116e-11 155.04999999999998p -1.376171e-11 155.0625p -1.374427e-11 155.07500000000002p -1.3688859999999999e-11 155.08750000000001p -1.359557e-11 155.10000000000002p -1.346454e-11 155.11249999999998p -1.3295990000000001e-11 155.125p -1.309017e-11 155.13749999999999p -1.2847430000000001e-11 155.15000000000001p -1.256817e-11 155.16249999999999p -1.2252820000000001e-11 155.17500000000001p -1.190191e-11 155.1875p -1.151601e-11 155.19999999999999p -1.109575e-11 155.21250000000001p -1.0641809999999999e-11 155.22499999999999p -1.015495e-11 155.23750000000001p -9.6359430000000008e-12 155.25p -9.0856550000000002e-12
+ 155.26250000000002p -8.504985e-12 155.27499999999998p -7.8948859999999994e-12 155.28749999999999p -7.25636e-12 155.29999999999998p -6.5904559999999999e-12 155.3125p -5.8982719999999996e-12 155.32500000000002p -5.1809469999999999e-12 155.33750000000001p -4.4396629999999998e-12 155.35000000000002p -3.6756460000000001e-12 155.36249999999998p -2.8901570000000002e-12 155.375p -2.0844979999999999e-12 155.38749999999999p -1.260002e-12 155.40000000000001p -4.1803889999999997e-13 155.41249999999999p 4.399917e-13 155.42500000000001p 1.312661e-12 155.4375p 2.198514e-12 155.44999999999999p 3.0960700000000002e-12 155.46250000000001p 4.0038250000000003e-12 155.47499999999999p 4.9202569999999998e-12
+ 155.48750000000001p 5.8438230000000002e-12 155.5p 6.7729669999999999e-12 155.51250000000002p 7.7061160000000004e-12 155.52499999999998p 8.6416900000000001e-12 155.53749999999999p 9.5780960000000003e-12 155.54999999999998p 1.051374e-11 155.5625p 1.144702e-11 155.57500000000002p 1.237632e-11 155.58750000000001p 1.3300059999999999e-11 155.60000000000002p 1.4216619999999999e-11 155.61249999999998p 1.5124410000000001e-11 155.625p 1.6021849999999998e-11 155.63749999999999p 1.6907360000000001e-11 155.65000000000001p 1.777938e-11 155.66249999999999p 1.863634e-11 155.67500000000001p 1.947673e-11 155.6875p 2.0299029999999999e-11 155.69999999999999p 2.110174e-11
+ 155.71250000000001p 2.1883400000000001e-11 155.72499999999999p 2.2642569999999999e-11 155.73750000000001p 2.3377819999999999e-11 155.75p 2.4087779999999999e-11 155.76250000000002p 2.4771090000000001e-11 155.77500000000001p 2.542643e-11 155.78749999999999p 2.6052520000000001e-11 155.79999999999998p 2.664812e-11 155.8125p 2.7212030000000001e-11 155.82499999999999p 2.7743070000000001e-11 155.83750000000001p 2.8240130000000002e-11 155.85000000000002p 2.8702149999999999e-11 155.86249999999998p 2.9128079999999997e-11 155.875p 2.9516960000000001e-11 155.88749999999999p 2.9867860000000002e-11 155.90000000000001p 3.0179890000000001e-11 155.91249999999999p 3.0452229999999997e-11 155.92500000000001p 3.0684109999999999e-11
+ 155.9375p 3.0874830000000002e-11 155.94999999999999p 3.1023710000000003e-11 155.96250000000001p 3.1130160000000002e-11 155.97499999999999p 3.1193639999999999e-11 155.98750000000001p 3.1213660000000001e-11 156p 3.1189789999999999e-11 156.01250000000002p 3.1121689999999998e-11 156.02500000000001p 3.100904e-11 156.03749999999999p 3.0851600000000002e-11 156.04999999999998p 3.0649210000000002e-11 156.0625p 3.0401740000000002e-11 156.07499999999999p 3.010916e-11 156.08750000000001p 2.977146e-11 156.10000000000002p 2.9388739999999998e-11 156.11250000000001p 2.8961129999999999e-11 156.125p 2.8488839999999999e-11 156.13749999999999p 2.797213e-11 156.15000000000001p 2.741134e-11
+ 156.16249999999999p 2.6806869999999998e-11 156.17500000000001p 2.6159169999999999e-11 156.1875p 2.5468759999999999e-11 156.19999999999999p 2.4736240000000001e-11 156.21250000000001p 2.3962229999999999e-11 156.22499999999999p 2.3147440000000001e-11 156.23750000000001p 2.229264e-11 156.25p 2.1398650000000001e-11 156.26250000000002p 2.046636e-11 156.27500000000001p 1.9496689999999999e-11 156.28749999999999p 1.849064e-11 156.29999999999998p 1.7449249999999999e-11 156.3125p 1.6373629999999999e-11 156.32499999999999p 1.526493e-11 156.33750000000001p 1.4124349999999999e-11 156.34999999999999p 1.295315e-11 156.36250000000001p 1.1752610000000001e-11 156.375p 1.0524079999999999e-11
+ 156.38749999999999p 9.2689619999999993e-12 156.40000000000001p 7.988674e-12 156.41249999999999p 6.6846889999999997e-12 156.42500000000001p 5.3585179999999997e-12 156.4375p 4.011707e-12 156.45000000000002p 2.6458369999999998e-12 156.46249999999998p 1.2625209999999999e-12 156.47499999999999p -1.365941e-13 156.48750000000001p -1.5498370000000001e-12 156.5p -2.975507e-12 156.51250000000002p -4.4118800000000004e-12 156.52500000000001p -5.8572109999999996e-12 156.53749999999999p -7.3097329999999995e-12 156.54999999999998p -8.7676630000000007e-12 156.5625p -1.02292e-11 156.57499999999999p -1.169254e-11 156.58750000000001p -1.315585e-11 156.59999999999999p -1.4617309999999998e-11
+ 156.61250000000001p -1.6075069999999998e-11 156.625p -1.7527310000000001e-11 156.63749999999999p -1.8972169999999999e-11 156.65000000000001p -2.0407819999999999e-11 156.66249999999999p -2.1832430000000001e-11 156.67500000000001p -2.324415e-11 156.6875p -2.4641180000000001e-11 156.70000000000002p -2.60217e-11 156.71249999999998p -2.7383909999999999e-11 156.72499999999999p -2.8726039999999999e-11 156.73750000000001p -3.0046309999999998e-11 156.75p -3.1342989999999999e-11 156.76250000000002p -3.2614360000000001e-11 156.77500000000001p -3.3858709999999998e-11 156.78749999999999p -3.5074390000000002e-11 156.79999999999998p -3.6259739999999998e-11 156.8125p -3.7413169999999998e-11 156.82499999999999p -3.8533100000000001e-11
+ 156.83750000000001p -3.9617979999999998e-11 156.84999999999999p -4.0666320000000002e-11 156.86250000000001p -4.1676660000000003e-11 156.875p -4.2647580000000002e-11 156.88749999999999p -4.3577689999999997e-11 156.90000000000001p -4.4465669999999997e-11 156.91249999999999p -4.5310239999999999e-11 156.92500000000001p -4.6110159999999998e-11 156.9375p -4.6864239999999999e-11 156.95000000000002p -4.757136e-11 156.96249999999998p -4.823044e-11 156.97499999999999p -4.8840439999999998e-11 156.98749999999998p -4.9400420000000002e-11 157p -4.9909449999999998e-11 157.01250000000002p -5.0366689999999999e-11 157.02500000000001p -5.0771340000000001e-11 157.03750000000002p -5.1122690000000002e-11 157.04999999999998p -5.1420069999999997e-11
+ 157.0625p -5.1662870000000002e-11 157.07499999999999p -5.1850560000000001e-11 157.08750000000001p -5.1982670000000001e-11 157.09999999999999p -5.2058789999999999e-11 157.11250000000001p -5.2078579999999997e-11 157.125p -5.2041770000000003e-11 157.13749999999999p -5.1948149999999997e-11 157.15000000000001p -5.1797590000000003e-11 157.16249999999999p -5.1590019999999998e-11 157.17500000000001p -5.1325429999999997e-11 157.1875p -5.1003900000000001e-11 157.20000000000002p -5.0625569999999999e-11 157.21249999999998p -5.0190629999999999e-11 157.22499999999999p -4.9699359999999999e-11 157.23749999999998p -4.9152099999999997e-11 157.25p -4.8549260000000002e-11 157.26250000000002p -4.7891320000000002e-11 157.27500000000001p -4.7178830000000002e-11
+ 157.28750000000002p -4.6412380000000002e-11 157.29999999999998p -4.5592659999999999e-11 157.3125p -4.4720409999999999e-11 157.32499999999999p -4.3796430000000001e-11 157.33750000000001p -4.28216e-11 157.34999999999999p -4.1796829999999999e-11 157.36250000000001p -4.072313e-11 157.375p -3.9601540000000001e-11 157.38749999999999p -3.8433169999999998e-11 157.40000000000001p -3.7219199999999999e-11 157.41249999999999p -3.5960849999999997e-11 157.42500000000001p -3.4659390000000003e-11 157.4375p -3.3316160000000001e-11 157.45000000000002p -3.1932549999999998e-11 157.46249999999998p -3.0509990000000001e-11 157.47499999999999p -2.9049949999999999e-11 157.48749999999998p -2.7553980000000001e-11 157.5p -2.6023650000000001e-11
+ 157.51249999999999p -2.4460570000000001e-11 157.52500000000001p -2.286641e-11 157.53750000000002p -2.1242859999999999e-11 157.54999999999998p -1.959165e-11 157.5625p -1.7914570000000001e-11 157.57499999999999p -1.6213409999999999e-11 157.58750000000001p -1.449e-11 157.59999999999999p -1.274622e-11 157.61250000000001p -1.098394e-11 157.625p -9.2050929999999992e-12 157.63749999999999p -7.4116040000000003e-12 157.65000000000001p -5.6054309999999996e-12 157.66249999999999p -3.7885480000000001e-12 157.67500000000001p -1.9629420000000001e-12 157.6875p -1.3061429999999999e-13 157.70000000000002p 1.706425e-12 157.71250000000001p 3.546156e-12 157.72499999999999p 5.3865560000000001e-12
+ 157.73749999999998p 7.2255970000000001e-12 157.75p 9.0612519999999995e-12 157.76249999999999p 1.089149e-11 157.77500000000001p 1.27143e-11 157.78750000000002p 1.452766e-11 157.79999999999998p 1.6329570000000001e-11 157.8125p 1.8118030000000001e-11 157.82499999999999p 1.989106e-11 157.83750000000001p 2.164669e-11 157.84999999999999p 2.3382979999999999e-11 157.86250000000001p 2.5098010000000001e-11 157.875p 2.6789880000000001e-11 157.88749999999999p 2.8456699999999999e-11 157.90000000000001p 3.0096629999999998e-11 157.91249999999999p 3.170784e-11 157.92500000000001p 3.3288559999999998e-11 157.9375p 3.4837029999999997e-11 157.95000000000002p 3.6351520000000001e-11
+ 157.96250000000001p 3.783037e-11 157.97499999999999p 3.927193e-11 157.98749999999998p 4.0674609999999999e-11 158p 4.2036850000000002e-11 158.01249999999999p 4.3357140000000003e-11 158.02500000000001p 4.4634029999999999e-11 158.03750000000002p 4.5866110000000002e-11 158.05000000000001p 4.7052009999999999e-11 158.0625p 4.819043e-11 158.07499999999999p 4.9280110000000002e-11 158.08750000000001p 5.0319859999999997e-11 158.09999999999999p 5.130853e-11 158.11250000000001p 5.2245049999999999e-11 158.125p 5.3128390000000003e-11 158.13749999999999p 5.395757e-11 158.15000000000001p 5.473171e-11 158.16249999999999p 5.5449970000000002e-11 158.17500000000001p 5.6111560000000003e-11
+ 158.1875p 5.6715779999999999e-11 158.20000000000002p 5.7261969999999998e-11 158.21250000000001p 5.7749559999999999e-11 158.22499999999999p 5.8178039999999999e-11 158.23749999999998p 5.8546959999999997e-11 158.25p 5.8855929999999994e-11 158.26249999999999p 5.9104650000000004e-11 158.27500000000001p 5.9292880000000005e-11 158.28749999999999p 5.9420430000000003e-11 158.30000000000001p 5.9487200000000005e-11 158.3125p 5.9493159999999995e-11 158.32499999999999p 5.9438320000000003e-11 158.33750000000001p 5.9322810000000002e-11 158.34999999999999p 5.9146769999999994e-11 158.36250000000001p 5.8910440000000002e-11 158.375p 5.8614140000000004e-11 158.38750000000002p 5.8258210000000002e-11 158.39999999999998p 5.7843120000000002e-11
+ 158.41249999999999p 5.7369339999999998e-11 158.42500000000001p 5.6837460000000002e-11 158.4375p 5.6248110000000001e-11 158.45000000000002p 5.560197e-11 158.46250000000001p 5.4899819999999999e-11 158.47499999999999p 5.4142459999999998e-11 158.48749999999998p 5.3330790000000002e-11 158.5p 5.2465739999999997e-11 158.51249999999999p 5.1548309999999999e-11 158.52500000000001p 5.0579559999999999e-11 158.53749999999999p 4.9560599999999999e-11 158.55000000000001p 4.8492590000000001e-11 158.5625p 4.7376769999999999e-11 158.57499999999999p 4.6214390000000002e-11 158.58750000000001p 4.5006790000000003e-11 158.59999999999999p 4.3755319999999999e-11 158.61250000000001p 4.2461410000000001e-11 158.625p 4.1126519999999999e-11
+ 158.63750000000002p 3.9752149999999999e-11 158.64999999999998p 3.8339849999999998e-11 158.66249999999999p 3.6891200000000003e-11 158.67500000000001p 3.5407829999999998e-11 158.6875p 3.389139e-11 158.70000000000002p 3.2343570000000001e-11 158.71250000000001p 3.0766089999999999e-11 158.72500000000002p 2.9160720000000001e-11 158.73749999999998p 2.752922e-11 158.75p 2.5873400000000002e-11 158.76249999999999p 2.419509e-11 158.77500000000001p 2.2496140000000001e-11 158.78749999999999p 2.0778410000000001e-11 158.80000000000001p 1.904379e-11 158.8125p 1.7294169999999999e-11 158.82499999999999p 1.553146e-11 158.83750000000001p 1.375758e-11 158.84999999999999p 1.197445e-11
+ 158.86250000000001p 1.018401e-11 158.875p 8.3881949999999997e-12 158.88750000000002p 6.5889319999999998e-12 158.89999999999998p 4.7881570000000004e-12 158.91249999999999p 2.9877979999999999e-12 158.92499999999998p 1.1897770000000001e-12 158.9375p -6.0398960000000001e-13 158.95000000000002p -2.3915989999999999e-12 158.96250000000001p -4.1711600000000002e-12 158.97500000000002p -5.9407969999999998e-12 158.98749999999998p -7.6986490000000003e-12 159p -9.4428780000000007e-12 159.01249999999999p -1.117166e-11 159.02500000000001p -1.288321e-11 159.03749999999999p -1.4575749999999999e-11 159.05000000000001p -1.624754e-11 159.0625p -1.789687e-11 159.07499999999999p -1.9522039999999999e-11
+ 159.08750000000001p -2.1121419999999999e-11 159.09999999999999p -2.269339e-11 159.11250000000001p -2.4236360000000001e-11 159.125p -2.574881e-11 159.13750000000002p -2.7229220000000001e-11 159.14999999999998p -2.8676149999999999e-11 159.16249999999999p -3.008817e-11 159.17499999999998p -3.1463910000000002e-11 159.1875p -3.280205e-11 159.20000000000002p -3.4101309999999997e-11 159.21250000000001p -3.5360470000000001e-11 159.22500000000002p -3.6578340000000003e-11 159.23749999999998p -3.7753790000000002e-11 159.25p -3.8885750000000003e-11 159.26249999999999p -3.9973209999999997e-11 159.27500000000001p -4.1015180000000001e-11 159.28749999999999p -4.2010759999999998e-11 159.30000000000001p -4.2959089999999998e-11
+ 159.3125p -4.3859370000000002e-11 159.32499999999999p -4.4710849999999999e-11 159.33750000000001p -4.5512870000000002e-11 159.34999999999999p -4.6264779999999997e-11 159.36250000000001p -4.6966030000000003e-11 159.375p -4.7616099999999997e-11 159.38750000000002p -4.8214560000000003e-11 159.39999999999998p -4.8761010000000003e-11 159.41249999999999p -4.925513e-11 159.42499999999998p -4.9696649999999999e-11 159.4375p -5.008538e-11 159.44999999999999p -5.0421160000000003e-11 159.46250000000001p -5.0703919999999998e-11 159.47500000000002p -5.0933630000000001e-11 159.48749999999998p -5.1110320000000002e-11 159.5p -5.1234100000000002e-11 159.51249999999999p -5.1305130000000002e-11 159.52500000000001p -5.132361e-11
+ 159.53749999999999p -5.1289819999999998e-11 159.55000000000001p -5.1204089999999997e-11 159.5625p -5.1066819999999997e-11 159.57499999999999p -5.0878440000000001e-11 159.58750000000001p -5.0639459999999998e-11 159.59999999999999p -5.0350430000000002e-11 159.61250000000001p -5.0011969999999997e-11 159.625p -4.9624730000000002e-11 159.63750000000002p -4.9189420000000001e-11 159.65000000000001p -4.8706819999999999e-11 159.66249999999999p -4.8177740000000003e-11 159.67499999999998p -4.7603039999999999e-11 159.6875p -4.6983619999999998e-11 159.69999999999999p -4.6320460000000002e-11 159.71250000000001p -4.5614530000000002e-11 159.72500000000002p -4.4866889999999997e-11 159.73749999999998p -4.4078620000000003e-11 159.75p -4.3250849999999999e-11
+ 159.76249999999999p -4.2384740000000003e-11 159.77500000000001p -4.1481480000000003e-11 159.78749999999999p -4.0542309999999999e-11 159.80000000000001p -3.9568499999999999e-11 159.8125p -3.8561349999999998e-11 159.82499999999999p -3.7522190000000001e-11 159.83750000000001p -3.6452369999999999e-11 159.84999999999999p -3.5353289999999999e-11 159.86250000000001p -3.4226340000000001e-11 159.875p -3.3072969999999997e-11 159.88750000000002p -3.1894630000000003e-11 159.90000000000001p -3.0692790000000001e-11 159.91249999999999p -2.9468939999999998e-11 159.92499999999998p -2.8224580000000001e-11 159.9375p -2.6961240000000002e-11 159.94999999999999p -2.568045e-11 159.96250000000001p -2.4383740000000001e-11 159.97499999999999p -2.3072670000000001e-11
+ 159.98750000000001p -2.1748779999999999e-11 160p -2.0413650000000001e-11 160.01249999999999p -1.9068819999999999e-11 160.02500000000001p -1.7715859999999999e-11 160.03749999999999p -1.6356320000000001e-11 160.05000000000001p -1.4991769999999999e-11 160.0625p -1.362376e-11 160.07499999999999p -1.225381e-11 160.08749999999998p -1.088348e-11 160.09999999999999p -9.514277e-12 160.11250000000001p -8.1477149999999999e-12 160.125p -6.7852900000000001e-12 160.13750000000002p -5.4284820000000003e-12 160.15000000000001p -4.0787500000000002e-12 160.16249999999999p -2.737537e-12 160.17499999999998p -1.406265e-12 160.1875p -8.6330359999999995e-14 160.19999999999999p 1.220893e-12
+ 160.21250000000001p 2.5140570000000002e-12 160.22499999999999p 3.7918410000000003e-12 160.23750000000001p 5.0529539999999997e-12 160.25p 6.2961350000000002e-12 160.26249999999999p 7.5201529999999997e-12 160.27500000000001p 8.7238109999999995e-12 160.28749999999999p 9.9059469999999993e-12 160.30000000000001p 1.106543e-11 160.3125p 1.2201170000000001e-11 160.32500000000002p 1.331212e-11 160.33749999999998p 1.439726e-11 160.34999999999999p 1.5455600000000001e-11 160.36250000000001p 1.6486230000000001e-11 160.375p 1.7488240000000001e-11 160.38750000000002p 1.8460780000000001e-11 160.40000000000001p 1.9403039999999999e-11 160.41249999999999p 2.0314259999999999e-11 160.42499999999998p 2.1193719999999999e-11
+ 160.4375p 2.204074e-11 160.44999999999999p 2.2854680000000001e-11 160.46250000000001p 2.3634979999999999e-11 160.47499999999999p 2.4381070000000001e-11 160.48750000000001p 2.5092480000000001e-11 160.5p 2.5768750000000001e-11 160.51249999999999p 2.6409500000000001e-11 160.52500000000001p 2.7014359999999999e-11 160.53749999999999p 2.758304e-11 160.55000000000001p 2.8115269999999999e-11 160.5625p 2.8610850000000001e-11 160.57500000000002p 2.9069610000000001e-11 160.58749999999998p 2.9491439999999997e-11 160.59999999999999p 2.9876270000000003e-11 160.61250000000001p 3.0224080000000003e-11 160.625p 3.0534900000000001e-11 160.63750000000002p 3.0808780000000002e-11 160.65000000000001p 3.1045850000000001e-11
+ 160.66250000000002p 3.1246260000000001e-11 160.67499999999998p 3.1410230000000002e-11 160.6875p 3.1537999999999997e-11 160.69999999999999p 3.1629850000000002e-11 160.71250000000001p 3.1686129999999998e-11 160.72499999999999p 3.1707199999999999e-11 160.73750000000001p 3.1693480000000002e-11 160.75p 3.164543e-11 160.76249999999999p 3.156354e-11 160.77500000000001p 3.1448339999999997e-11 160.78749999999999p 3.1300400000000003e-11 160.80000000000001p 3.1120320000000002e-11 160.8125p 3.0908750000000002e-11 160.82500000000002p 3.0666350000000002e-11 160.83749999999998p 3.0393829999999999e-11 160.84999999999999p 3.0091929999999999e-11 160.86249999999998p 2.9761410000000002e-11 160.875p 2.9403079999999998e-11
+ 160.88750000000002p 2.9017740000000001e-11 160.90000000000001p 2.8606260000000001e-11 160.91250000000002p 2.81695e-11 160.92499999999998p 2.770837e-11 160.9375p 2.7223769999999999e-11 160.94999999999999p 2.671666e-11 160.96250000000001p 2.6187979999999999e-11 160.97499999999999p 2.5638729999999999e-11 160.98750000000001p 2.5069879999999999e-11 161p 2.4482450000000001e-11 161.01249999999999p 2.387746e-11 161.02500000000001p 2.325595e-11 161.03749999999999p 2.2618940000000001e-11 161.05000000000001p 2.196751e-11 161.0625p 2.1302700000000001e-11 161.07500000000002p 2.0625590000000001e-11 161.08749999999998p 1.9937240000000001e-11 161.09999999999999p 1.9238720000000001e-11
+ 161.11249999999998p 1.8531110000000001e-11 161.125p 1.7815480000000001e-11 161.13750000000002p 1.70929e-11 161.15000000000001p 1.636444e-11 161.16250000000002p 1.5631169999999999e-11 161.17499999999998p 1.4894150000000001e-11 161.1875p 1.415441e-11 161.19999999999999p 1.341301e-11 161.21250000000001p 1.267098e-11 161.22499999999999p 1.192933e-11 161.23750000000001p 1.1189079999999999e-11 161.25p 1.0451210000000001e-11 161.26249999999999p 9.7167079999999994e-12 161.27500000000001p 8.9865269999999996e-12 161.28749999999999p 8.2616120000000007e-12 161.30000000000001p 7.5428850000000003e-12 161.3125p 6.8312509999999998e-12 161.32500000000002p 6.1275910000000003e-12
+ 161.33750000000001p 5.4327629999999997e-12 161.34999999999999p 4.7476050000000001e-12 161.36249999999998p 4.0729260000000002e-12 161.375p 3.409514e-12 161.38749999999999p 2.7581260000000002e-12 161.40000000000001p 2.1194960000000001e-12 161.41250000000002p 1.494328e-12 161.42499999999998p 8.8329629999999997e-13 161.4375p 2.8704720000000002e-13 161.44999999999999p -2.9380400000000001e-13 161.46250000000001p -8.5867239999999999e-13 161.47499999999999p -1.407005e-12 161.48750000000001p -1.9382809999999999e-12 161.5p -2.4520120000000001e-12 161.51249999999999p -2.9477420000000001e-12 161.52500000000001p -3.4250490000000001e-12 161.53749999999999p -3.8835449999999999e-12 161.55000000000001p -4.3228749999999998e-12
+ 161.5625p -4.7427200000000002e-12 161.57500000000002p -5.1427919999999997e-12 161.58750000000001p -5.5228419999999999e-12 161.59999999999999p -5.8826529999999999e-12 161.61249999999998p -6.2220440000000003e-12 161.625p -6.5408659999999999e-12 161.63749999999999p -6.8390089999999998e-12 161.65000000000001p -7.1163939999999996e-12 161.66250000000002p -7.3729790000000002e-12 161.67499999999998p -7.6087530000000008e-12 161.6875p -7.8237420000000003e-12 161.69999999999999p -8.0180039999999999e-12 161.71250000000001p -8.1916319999999998e-12 161.72499999999999p -8.3447479999999996e-12 161.73750000000001p -8.4775119999999994e-12 161.75p -8.5901110000000006e-12 161.76249999999999p -8.6827659999999999e-12 161.77500000000001p -8.7557290000000005e-12
+ 161.78749999999999p -8.8092799999999994e-12 161.80000000000001p -8.8437299999999999e-12 161.8125p -8.8594210000000008e-12 161.82500000000002p -8.8567190000000001e-12 161.83750000000001p -8.8360200000000001e-12 161.84999999999999p -8.7977460000000007e-12 161.86249999999998p -8.7423439999999996e-12 161.875p -8.6702870000000001e-12 161.88749999999999p -8.5820709999999994e-12 161.90000000000001p -8.4782140000000008e-12 161.91249999999999p -8.3592589999999995e-12 161.92500000000001p -8.2257660000000005e-12 161.9375p -8.0783190000000001e-12 161.94999999999999p -7.9175169999999999e-12 161.96250000000001p -7.7439800000000007e-12 161.97499999999999p -7.5583430000000008e-12 161.98750000000001p -7.3612560000000006e-12 162p -7.1533840000000002e-12
+ 162.01249999999999p -6.9354069999999997e-12 162.02499999999998p -6.7080159999999996e-12 162.03749999999999p -6.4719099999999996e-12 162.05000000000001p -6.2278020000000001e-12 162.0625p -5.9764119999999999e-12 162.07500000000002p -5.7184659999999997e-12 162.08750000000001p -5.4546979999999998e-12 162.09999999999999p -5.1858459999999999e-12 162.11249999999998p -4.9126510000000002e-12 162.125p -4.6358579999999997e-12 162.13749999999999p -4.3562110000000002e-12 162.15000000000001p -4.0744559999999997e-12 162.16249999999999p -3.7913370000000002e-12 162.17500000000001p -3.5075950000000001e-12 162.1875p -3.2239680000000001e-12 162.19999999999999p -2.941188e-12 162.21250000000001p -2.659984e-12 162.22499999999999p -2.3810730000000002e-12
+ 162.23750000000001p -2.1051680000000001e-12 162.25p -1.83297e-12 162.26250000000002p -1.5651700000000001e-12 162.27499999999998p -1.302448e-12 162.28749999999999p -1.045469e-12 162.30000000000001p -7.9488649999999996e-13 162.3125p -5.5133789999999995e-13 162.32500000000002p -3.154447e-13 162.33750000000001p -8.781172e-14 162.34999999999999p 1.3097400000000001e-13 162.36249999999998p 3.4034440000000001e-13 162.375p 5.3975149999999995e-13 162.38749999999999p 7.2866710000000001e-13 162.40000000000001p 9.0658500000000002e-13 162.41249999999999p 1.073021e-12 162.42500000000001p 1.227513e-12 162.4375p 1.369625e-12 162.44999999999999p 1.498942e-12
+ 162.46250000000001p 1.6150769999999999e-12 162.47499999999999p 1.717667e-12 162.48750000000001p 1.806375e-12 162.5p 1.880892e-12 162.51250000000002p 1.9409340000000002e-12 162.52499999999998p 1.9862469999999998e-12 162.53749999999999p 2.016604e-12 162.54999999999998p 2.0318069999999999e-12 162.5625p 2.0316850000000001e-12 162.57500000000002p 2.0160970000000001e-12 162.58750000000001p 1.9849329999999998e-12 162.60000000000002p 1.9381080000000002e-12 162.61249999999998p 1.8755720000000002e-12 162.625p 1.7973e-12 162.63749999999999p 1.7032990000000001e-12 162.65000000000001p 1.593606e-12 162.66249999999999p 1.4682849999999999e-12 162.67500000000001p 1.3274320000000001e-12
+ 162.6875p 1.1711720000000001e-12 162.69999999999999p 9.9965870000000006e-13 162.71250000000001p 8.1307489999999999e-13 162.72499999999999p 6.1163220000000005e-13 162.73750000000001p 3.9557059999999999e-13 162.75p 1.6515840000000001e-13 162.76250000000002p -7.9308649999999995e-14 162.77499999999998p -3.3750779999999998e-13 162.78749999999999p -6.0908909999999997e-13 162.79999999999998p -8.9367629999999997e-13 162.8125p -1.190868e-12 162.82500000000002p -1.500237e-12 162.83750000000001p -1.8213319999999998e-12 162.85000000000002p -2.1536779999999998e-12 162.86249999999998p -2.4967770000000001e-12 162.875p -2.8501079999999999e-12 162.88749999999999p -3.2131280000000001e-12 162.90000000000001p -3.585276e-12
+ 162.91249999999999p -3.965968e-12 162.92500000000001p -4.3546020000000004e-12 162.9375p -4.7505569999999998e-12 162.94999999999999p -5.153198e-12 162.96250000000001p -5.5618690000000002e-12 162.97499999999999p -5.9759009999999998e-12 162.98750000000001p -6.3946119999999999e-12 163p -6.8173049999999997e-12 163.01250000000002p -7.2432710000000003e-12 163.02499999999998p -7.6717889999999998e-12 163.03749999999999p -8.1021289999999994e-12 163.04999999999998p -8.5335529999999994e-12 163.0625p -8.9653120000000006e-12 163.07500000000002p -9.3966529999999997e-12 163.08750000000001p -9.8268169999999994e-12 163.10000000000002p -1.025504e-11 163.11249999999998p -1.068055e-11 163.125p -1.1102580000000001e-11
+ 163.13749999999999p -1.152037e-11 163.15000000000001p -1.193313e-11 163.16249999999999p -1.234011e-11 163.17500000000001p -1.2740520000000001e-11 163.1875p -1.313362e-11 163.19999999999999p -1.3518640000000001e-11 163.21250000000001p -1.389483e-11 163.22499999999999p -1.426145e-11 163.23750000000001p -1.461775e-11 163.25p -1.4963020000000001e-11 163.26250000000002p -1.5296519999999999e-11 163.27500000000001p -1.561757e-11 163.28749999999999p -1.592546e-11 163.29999999999998p -1.6219520000000001e-11 163.3125p -1.649908e-11 163.32499999999999p -1.67635e-11 163.33750000000001p -1.7012139999999999e-11 163.35000000000002p -1.7244390000000001e-11
+ 163.36249999999998p -1.745967e-11 163.375p -1.765738e-11 163.38749999999999p -1.7836990000000001e-11 163.40000000000001p -1.7997949999999998e-11 163.41249999999999p -1.8139770000000001e-11 163.42500000000001p -1.8261950000000001e-11 163.4375p -1.8364029999999998e-11 163.44999999999999p -1.8445579999999999e-11 163.46250000000001p -1.850619e-11 163.47499999999999p -1.8545469999999999e-11 163.48750000000001p -1.856307e-11 163.5p -1.855866e-11 163.51250000000002p -1.8531929999999999e-11 163.52500000000001p -1.848263e-11 163.53749999999999p -1.8410489999999999e-11 163.54999999999998p -1.8315320000000001e-11 163.5625p -1.819694e-11 163.57499999999999p -1.805518e-11
+ 163.58750000000001p -1.7889930000000001e-11 163.60000000000002p -1.7701109999999999e-11 163.61250000000001p -1.7488660000000001e-11 163.625p -1.725256e-11 163.63749999999999p -1.6992799999999998e-11 163.65000000000001p -1.670944e-11 163.66249999999999p -1.6402550000000001e-11 163.67500000000001p -1.607223e-11 163.6875p -1.571862e-11 163.69999999999999p -1.5341890000000001e-11 163.71250000000001p -1.4942249999999999e-11 163.72499999999999p -1.451993e-11 163.73750000000001p -1.40752e-11 163.75p -1.360837e-11 163.76250000000002p -1.311975e-11 163.77500000000001p -1.2609720000000001e-11 163.78749999999999p -1.2078660000000001e-11 163.79999999999998p -1.1527010000000001e-11
+ 163.8125p -1.095522e-11 163.82499999999999p -1.036378e-11 163.83750000000001p -9.7531930000000001e-12 163.84999999999999p -9.1240110000000002e-12 163.86250000000001p -8.4768030000000005e-12 163.875p -7.8121690000000001e-12 163.88749999999999p -7.1307340000000001e-12 163.90000000000001p -6.4331509999999997e-12 163.91249999999999p -5.7200989999999997e-12 163.92500000000001p -4.992279e-12 163.9375p -4.2504179999999996e-12 163.95000000000002p -3.495266e-12 163.96249999999998p -2.727594e-12 163.97499999999999p -1.9481950000000001e-12 163.98750000000001p -1.157884e-12 164p -3.574918e-13 164.01250000000002p 4.5212949999999998e-13 164.02500000000001p 1.2701110000000001e-12
+ 164.03749999999999p 2.095569e-12 164.04999999999998p 2.9276020000000001e-12 164.0625p 3.7652959999999998e-12 164.07499999999999p 4.6077250000000001e-12 164.08750000000001p 5.4539470000000001e-12 164.09999999999999p 6.3030140000000001e-12 164.11250000000001p 7.1539660000000002e-12 164.125p 8.0058340000000007e-12 164.13749999999999p 8.8576439999999993e-12 164.15000000000001p 9.7084129999999995e-12 164.16249999999999p 1.0557160000000001e-11 164.17500000000001p 1.1402880000000001e-11 164.1875p 1.2244600000000001e-11 164.20000000000002p 1.3081319999999999e-11 164.21249999999998p 1.391204e-11 164.22499999999999p 1.4735779999999999e-11 164.23750000000001p 1.5551540000000001e-11 164.25p 1.635834e-11
+ 164.26250000000002p 1.71552e-11 164.27500000000001p 1.794115e-11 164.28749999999999p 1.8715220000000001e-11 164.29999999999998p 1.9476459999999999e-11 164.3125p 2.0223910000000001e-11 164.32499999999999p 2.095664e-11 164.33750000000001p 2.1673729999999999e-11 164.34999999999999p 2.2374280000000001e-11 164.36250000000001p 2.305737e-11 164.375p 2.3722140000000001e-11 164.38749999999999p 2.436773e-11 164.40000000000001p 2.4993289999999998e-11 164.41249999999999p 2.5598e-11 164.42500000000001p 2.6181060000000002e-11 164.4375p 2.674168e-11 164.45000000000002p 2.7279109999999998e-11 164.46249999999998p 2.77926e-11 164.47499999999999p 2.8281460000000001e-11
+ 164.48749999999998p 2.8744980000000001e-11 164.5p 2.9182530000000003e-11 164.51250000000002p 2.9593459999999999e-11 164.52500000000001p 2.9977159999999998e-11 164.53750000000002p 3.0333070000000002e-11 164.54999999999998p 3.0660640000000002e-11 164.5625p 3.0959360000000001e-11 164.57499999999999p 3.1228740000000001e-11 164.58750000000001p 3.1468330000000001e-11 164.59999999999999p 3.1677720000000003e-11 164.61250000000001p 3.1856500000000003e-11 164.625p 3.2004350000000003e-11 164.63749999999999p 3.2120930000000002e-11 164.65000000000001p 3.2205969999999998e-11 164.66249999999999p 3.2259210000000003e-11 164.67500000000001p 3.2280439999999999e-11 164.6875p 3.2269489999999998e-11 164.70000000000002p 3.2226209999999998e-11
+ 164.71249999999998p 3.2150509999999997e-11 164.72499999999999p 3.2042310000000002e-11 164.73749999999998p 3.1901580000000002e-11 164.75p 3.1728330000000002e-11 164.76250000000002p 3.1522609999999999e-11 164.77500000000001p 3.1284480000000002e-11 164.78750000000002p 3.1014070000000002e-11 164.79999999999998p 3.071154e-11 164.8125p 3.0377069999999998e-11 164.82499999999999p 3.0010889999999998e-11 164.83750000000001p 2.9613270000000002e-11 164.84999999999999p 2.9184500000000003e-11 164.86250000000001p 2.8724919999999999e-11 164.875p 2.823491e-11 164.88749999999999p 2.7714870000000001e-11 164.90000000000001p 2.716524e-11 164.91249999999999p 2.658651e-11 164.92500000000001p 2.5979179999999999e-11
+ 164.9375p 2.534379e-11 164.95000000000002p 2.468092e-11 164.96249999999998p 2.3991190000000001e-11 164.97499999999999p 2.3275229999999999e-11 164.98749999999998p 2.2533710000000001e-11 165p 2.1767339999999999e-11 165.01249999999999p 2.0976849999999999e-11 165.02500000000001p 2.0163000000000001e-11 165.03750000000002p 1.932657e-11 165.04999999999998p 1.8468380000000001e-11 165.0625p 1.7589269999999999e-11 165.07499999999999p 1.6690110000000001e-11 165.08750000000001p 1.5771780000000001e-11 165.09999999999999p 1.4835199999999999e-11 165.11250000000001p 1.3881300000000001e-11 165.125p 1.291104e-11 165.13749999999999p 1.1925390000000001e-11 165.15000000000001p 1.092535e-11
+ 165.16249999999999p 9.9119279999999994e-12 165.17500000000001p 8.8861510000000006e-12 165.1875p 7.849064e-12 165.20000000000002p 6.8017259999999996e-12 165.21250000000001p 5.7452059999999996e-12 165.22499999999999p 4.6805879999999996e-12 165.23749999999998p 3.6089630000000001e-12 165.25p 2.5314340000000001e-12 165.26249999999999p 1.449112e-12 165.27500000000001p 3.6311230000000002e-13 165.28750000000002p -7.2544239999999996e-13 165.29999999999998p -1.815425e-12 165.3125p -2.9057079999999998e-12 165.32499999999999p -3.9951590000000003e-12 165.33750000000001p -5.0826479999999996e-12 165.34999999999999p -6.1670440000000002e-12 165.36250000000001p -7.2472200000000003e-12 165.375p -8.3220520000000004e-12
+ 165.38749999999999p -9.3904199999999995e-12 165.40000000000001p -1.0451210000000001e-11 165.41249999999999p -1.1503319999999999e-11 165.42500000000001p -1.2545650000000001e-11 165.4375p -1.357711e-11 165.45000000000002p -1.459663e-11 165.46250000000001p -1.5603149999999999e-11 165.47499999999999p -1.6595609999999999e-11 165.48749999999998p -1.7572979999999998e-11 165.5p -1.8534240000000001e-11 165.51249999999999p -1.9478390000000001e-11 165.52500000000001p -2.0404439999999999e-11 165.53750000000002p -2.131144e-11 165.55000000000001p -2.219843e-11 165.5625p -2.3064499999999999e-11 165.57499999999999p -2.3908740000000001e-11 165.58750000000001p -2.4730290000000001e-11 165.59999999999999p -2.552828e-11
+ 165.61250000000001p -2.6301890000000001e-11 165.625p -2.705033e-11 165.63749999999999p -2.7772820000000001e-11 165.65000000000001p -2.8468620000000001e-11 165.66249999999999p -2.9137000000000002e-11 165.67500000000001p -2.9777299999999998e-11 165.6875p -3.038885e-11 165.70000000000002p -3.0971029999999998e-11 165.71250000000001p -3.152325e-11 165.72499999999999p -3.2044950000000001e-11 165.73749999999998p -3.2535599999999998e-11 165.75p -3.2994719999999998e-11 165.76249999999999p -3.3421850000000001e-11 165.77500000000001p -3.3816559999999997e-11 165.78749999999999p -3.4178470000000001e-11 165.80000000000001p -3.4507219999999997e-11 165.8125p -3.480251e-11 165.82499999999999p -3.5064049999999998e-11
+ 165.83750000000001p -3.5291590000000002e-11 165.84999999999999p -3.5484939999999998e-11 165.86250000000001p -3.564392e-11 165.875p -3.5768410000000003e-11 165.88750000000002p -3.58583e-11 165.89999999999998p -3.5913550000000003e-11 165.91249999999999p -3.5934119999999999e-11 165.92500000000001p -3.592005e-11 165.9375p -3.5871380000000003e-11 165.95000000000002p -3.5788200000000001e-11 165.96250000000001p -3.5670649999999998e-11 165.97499999999999p -3.5518879999999997e-11 165.98749999999998p -3.5333110000000001e-11 166p -3.5113570000000001e-11 166.01249999999999p -3.4860529999999999e-11 166.02500000000001p -3.4574299999999997e-11 166.03749999999999p -3.4255229999999999e-11 166.05000000000001p -3.3903689999999998e-11
+ 166.0625p -3.3520099999999997e-11 166.07499999999999p -3.3104909999999998e-11 166.08750000000001p -3.265859e-11 166.09999999999999p -3.2181660000000001e-11 166.11250000000001p -3.1674660000000001e-11 166.125p -3.1138169999999999e-11 166.13750000000002p -3.0572789999999999e-11 166.14999999999998p -2.9979150000000003e-11 166.16249999999999p -2.9357930000000003e-11 166.17500000000001p -2.870981e-11 166.1875p -2.803551e-11 166.20000000000002p -2.733578e-11 166.21250000000001p -2.6611380000000001e-11 166.22500000000002p -2.586312e-11 166.23749999999998p -2.5091809999999999e-11 166.25p -2.42983e-11 166.26249999999999p -2.3483440000000001e-11 166.27500000000001p -2.2648120000000001e-11
+ 166.28749999999999p -2.1793249999999999e-11 166.30000000000001p -2.0919739999999999e-11 166.3125p -2.0028540000000001e-11 166.32499999999999p -1.9120600000000002e-11 166.33750000000001p -1.819689e-11 166.34999999999999p -1.7258390000000002e-11 166.36250000000001p -1.630611e-11 166.375p -1.5341050000000001e-11 166.38750000000002p -1.436423e-11 166.39999999999998p -1.337668e-11 166.41249999999999p -1.237944e-11 166.42499999999998p -1.137354e-11 166.4375p -1.036005e-11 166.45000000000002p -9.3400189999999998e-12 166.46250000000001p -8.3144980000000002e-12 166.47500000000002p -7.2845499999999993e-12 166.48749999999998p -6.251238e-12 166.5p -5.2156220000000003e-12
+ 166.51249999999999p -4.1787619999999998e-12 166.52500000000001p -3.1417139999999998e-12 166.53749999999999p -2.1055329999999999e-12 166.55000000000001p -1.0712660000000001e-12 166.5625p -3.9955909999999999e-14 166.57499999999999p 9.8736190000000003e-13 166.58750000000001p 2.0096600000000001e-12 166.59999999999999p 3.025922e-12 166.61250000000001p 4.0351410000000003e-12 166.625p 5.0363210000000003e-12 166.63750000000002p 6.0284810000000004e-12 166.64999999999998p 7.0106510000000004e-12 166.66249999999999p 7.9818779999999996e-12 166.67499999999998p 8.9412230000000003e-12 166.6875p 9.8877660000000005e-12 166.70000000000002p 1.08206e-11 166.71250000000001p 1.173885e-11 166.72500000000002p 1.2641639999999999e-11
+ 166.73749999999998p 1.352813e-11 166.75p 1.43975e-11 166.76249999999999p 1.5248940000000001e-11 166.77500000000001p 1.6081690000000001e-11 166.78749999999999p 1.6894980000000002e-11 166.80000000000001p 1.7688079999999999e-11 166.8125p 1.8460289999999999e-11 166.82499999999999p 1.9210940000000001e-11 166.83750000000001p 1.9939369999999999e-11 166.84999999999999p 2.064495e-11 166.86250000000001p 2.1327099999999999e-11 166.875p 2.1985239999999999e-11 166.88750000000002p 2.2618829999999998e-11 166.89999999999998p 2.3227360000000001e-11 166.91249999999999p 2.3810360000000001e-11 166.92499999999998p 2.4367369999999999e-11 166.9375p 2.489797e-11 166.94999999999999p 2.5401770000000002e-11
+ 166.96250000000001p 2.5878420000000001e-11 166.97500000000002p 2.6327589999999999e-11 166.98749999999998p 2.6748980000000001e-11 167p 2.714234e-11 167.01249999999999p 2.7507420000000001e-11 167.02500000000001p 2.784404e-11 167.03749999999999p 2.8152010000000001e-11 167.05000000000001p 2.8431219999999999e-11 167.0625p 2.8681539999999999e-11 167.07499999999999p 2.8902920000000001e-11 167.08750000000001p 2.9095320000000001e-11 167.09999999999999p 2.9258710000000003e-11 167.11250000000001p 2.9393139999999998e-11 167.125p 2.9498649999999998e-11 167.13750000000002p 2.9575320000000002e-11 167.15000000000001p 2.9623279999999997e-11 167.16249999999999p 2.9642680000000003e-11 167.17499999999998p 2.9633690000000003e-11
+ 167.1875p 2.9596510000000001e-11 167.19999999999999p 2.9531390000000001e-11 167.21250000000001p 2.9438579999999998e-11 167.22500000000002p 2.9318390000000003e-11 167.23749999999998p 2.9171130000000001e-11 167.25p 2.8997159999999999e-11 167.26249999999999p 2.8796850000000001e-11 167.27500000000001p 2.8570589999999999e-11 167.28749999999999p 2.8318829999999999e-11 167.30000000000001p 2.8041999999999999e-11 167.3125p 2.77406e-11 167.32499999999999p 2.7415109999999999e-11 167.33750000000001p 2.706606e-11 167.34999999999999p 2.6693999999999999e-11 167.36250000000001p 2.6299489999999999e-11 167.375p 2.5883110000000001e-11 167.38750000000002p 2.5445480000000002e-11 167.40000000000001p 2.498722e-11
+ 167.41249999999999p 2.4508970000000001e-11 167.42499999999998p 2.4011390000000001e-11 167.4375p 2.3495160000000001e-11 167.44999999999999p 2.2960959999999999e-11 167.46250000000001p 2.2409510000000002e-11 167.47499999999999p 2.184153e-11 167.48750000000001p 2.1257730000000001e-11 167.5p 2.0658879999999999e-11 167.51249999999999p 2.0045719999999999e-11 167.52500000000001p 1.941901e-11 167.53749999999999p 1.8779529999999999e-11 167.55000000000001p 1.8128060000000001e-11 167.5625p 1.7465370000000002e-11 167.57499999999999p 1.6792279999999999e-11 167.58749999999998p 1.6109560000000001e-11 167.59999999999999p 1.541803e-11 167.61250000000001p 1.471848e-11 167.625p 1.4011730000000001e-11
+ 167.63750000000002p 1.329857e-11 167.65000000000001p 1.257982e-11 167.66249999999999p 1.185627e-11 167.67499999999998p 1.1128739999999999e-11 167.6875p 1.0398009999999999e-11 167.69999999999999p 9.6649019999999997e-12 167.71250000000001p 8.9301880000000004e-12 167.72499999999999p 8.1946610000000003e-12 167.73750000000001p 7.4590980000000005e-12 167.75p 6.7242730000000001e-12 167.76249999999999p 5.9909479999999997e-12 167.77500000000001p 5.2598779999999997e-12 167.78749999999999p 4.5318080000000003e-12 167.80000000000001p 3.8074709999999999e-12 167.8125p 3.087589e-12 167.82500000000002p 2.3728720000000001e-12 167.83749999999998p 1.6640159999999999e-12 167.84999999999999p 9.6170460000000006e-13
+ 167.86250000000001p 2.6660530000000003e-13 167.875p -4.206279e-13 167.88750000000002p -1.0993589999999999e-12 167.90000000000001p -1.768966e-12 167.91249999999999p -2.428847e-12 167.92499999999998p -3.0784150000000001e-12 167.9375p -3.7171030000000001e-12 167.94999999999999p -4.3443619999999998e-12 167.96250000000001p -4.959663e-12 167.97499999999999p -5.5624949999999997e-12 167.98750000000001p -6.15237e-12 168p -6.7288189999999998e-12 168.01249999999999p -7.2913929999999994e-12 168.02500000000001p -7.839666e-12 168.03749999999999p -8.3732329999999996e-12 168.05000000000001p -8.8917110000000001e-12 168.0625p -9.3947389999999998e-12 168.07500000000002p -9.8819799999999999e-12
+ 168.08749999999998p -1.035312e-11 168.09999999999999p -1.080786e-11 168.11250000000001p -1.124594e-11 168.125p -1.16671e-11 168.13750000000002p -1.207113e-11 168.15000000000001p -1.245782e-11 168.16250000000002p -1.2826999999999999e-11 168.17499999999998p -1.317852e-11 168.1875p -1.351223e-11 168.19999999999999p -1.3828049999999999e-11 168.21250000000001p -1.4125869999999999e-11 168.22499999999999p -1.440565e-11 168.23750000000001p -1.4667329999999999e-11 168.25p -1.4910909999999999e-11 168.26249999999999p -1.5136399999999998e-11 168.27500000000001p -1.5343810000000001e-11 168.28749999999999p -1.5533199999999999e-11 168.30000000000001p -1.5704640000000001e-11
+ 168.3125p -1.585823e-11 168.32500000000002p -1.5994070000000002e-11 168.33749999999998p -1.6112309999999999e-11 168.34999999999999p -1.6213090000000002e-11 168.36249999999998p -1.6296590000000001e-11 168.375p -1.6363010000000001e-11 168.38750000000002p -1.641255e-11 168.40000000000001p -1.644544e-11 168.41250000000002p -1.646193e-11 168.42499999999998p -1.6462290000000001e-11 168.4375p -1.6446809999999999e-11 168.44999999999999p -1.6415760000000002e-11 168.46250000000001p -1.6369480000000001e-11 168.47499999999999p -1.6308279999999999e-11 168.48750000000001p -1.6232519999999999e-11 168.5p -1.6142540000000001e-11 168.51249999999999p -1.6038720000000001e-11 168.52500000000001p -1.5921439999999999e-11
+ 168.53749999999999p -1.5791080000000001e-11 168.55000000000001p -1.564807e-11 168.5625p -1.54928e-11 168.57500000000002p -1.5325709999999999e-11 168.58749999999998p -1.5147230000000001e-11 168.59999999999999p -1.495779e-11 168.61249999999998p -1.4757860000000001e-11 168.625p -1.4547889999999999e-11 168.63750000000002p -1.4328329999999999e-11 168.65000000000001p -1.4099659999999999e-11 168.66250000000002p -1.386234e-11 168.67499999999998p -1.3616860000000001e-11 168.6875p -1.33637e-11 168.69999999999999p -1.3103339999999999e-11 168.71250000000001p -1.283625e-11 168.72499999999999p -1.256293e-11 168.73750000000001p -1.228387e-11 168.75p -1.199954e-11
+ 168.76249999999999p -1.171043e-11 168.77500000000001p -1.141702e-11 168.78749999999999p -1.11198e-11 168.80000000000001p -1.081924e-11 168.8125p -1.0515809999999999e-11 168.82500000000002p -1.020999e-11 168.83750000000001p -9.9022320000000003e-12 168.84999999999999p -9.5929990000000002e-12 168.86249999999998p -9.2827429999999994e-12 168.875p -8.9719089999999993e-12 168.88749999999999p -8.6609340000000002e-12 168.90000000000001p -8.3502490000000005e-12 168.91250000000002p -8.0402740000000003e-12 168.92499999999998p -7.731421e-12 168.9375p -7.4240929999999994e-12 168.94999999999999p -7.1186809999999999e-12 168.96250000000001p -6.815569e-12 168.97499999999999p -6.5151249999999999e-12
+ 168.98750000000001p -6.2177100000000002e-12 169p -5.9236700000000003e-12 169.01249999999999p -5.6333409999999997e-12 169.02500000000001p -5.3470440000000001e-12 169.03749999999999p -5.0650900000000002e-12 169.05000000000001p -4.787773e-12 169.0625p -4.5153770000000004e-12 169.07500000000002p -4.2481679999999997e-12 169.08750000000001p -3.9864009999999998e-12 169.09999999999999p -3.7303170000000001e-12 169.11249999999998p -3.480139e-12 169.125p -3.236077e-12 169.13749999999999p -2.9983279999999999e-12 169.15000000000001p -2.7670699999999998e-12 169.16250000000002p -2.5424670000000001e-12 169.17500000000001p -2.32467e-12 169.1875p -2.1138119999999998e-12 169.19999999999999p -1.910011e-12
+ 169.21250000000001p -1.71337e-12 169.22499999999999p -1.523976e-12 169.23750000000001p -1.3419e-12 169.25p -1.1672010000000001e-12 169.26249999999999p -9.9991650000000004e-13 169.27500000000001p -8.4007399999999996e-13 169.28749999999999p -6.876841e-13 169.30000000000001p -5.4274220000000003e-13 169.3125p -4.0522900000000001e-13 169.32500000000002p -2.7511079999999998e-13 169.33750000000001p -1.5233939999999999e-13 169.34999999999999p -3.6852070000000002e-14 169.36249999999998p 7.142701e-14 169.375p 1.7258809999999999e-13 169.38749999999999p 2.667346e-13 169.40000000000001p 3.539825e-13 169.41249999999999p 4.3446129999999999e-13 169.42500000000001p 5.0831200000000003e-13
+ 169.4375p 5.7568840000000003e-13 169.44999999999999p 6.3675519999999996e-13 169.46250000000001p 6.9168859999999995e-13 169.47499999999999p 7.4067589999999999e-13 169.48750000000001p 7.839136e-13 169.5p 8.2160940000000003e-13 169.51249999999999p 8.5397990000000001e-13 169.52499999999998p 8.8125049999999999e-13 169.53749999999999p 9.0365530000000002e-13 169.55000000000001p 9.2143609999999993e-13 169.5625p 9.3484280000000008e-13 169.57500000000002p 9.4413109999999997e-13 169.58750000000001p 9.4956399999999993e-13 169.59999999999999p 9.5141060000000003e-13 169.61249999999998p 9.4994459999999992e-13 169.625p 9.4544490000000006e-13 169.63749999999999p 9.3819420000000007e-13 169.65000000000001p 9.284793000000001e-13
+ 169.66249999999999p 9.1659049999999992e-13 169.67500000000001p 9.0281929999999998e-13 169.6875p 8.8746070000000004e-13 169.69999999999999p 8.7081e-13 169.71250000000001p 8.5316410000000002e-13 169.72499999999999p 8.3481990000000001e-13 169.73750000000001p 8.1607329999999996e-13 169.75p 7.9722059999999995e-13 169.76250000000002p 7.7855579999999997e-13 169.77499999999998p 7.6037120000000001e-13 169.78749999999999p 7.4295620000000002e-13 169.80000000000001p 7.265978e-13 169.8125p 7.115788e-13 169.82500000000002p 6.9817789999999996e-13 169.83750000000001p 6.8666960000000001e-13 169.84999999999999p 6.7732250000000002e-13 169.86249999999998p 6.7039999999999995e-13 169.875p 6.6615870000000002e-13
+ 169.88749999999999p 6.648494e-13 169.90000000000001p 6.6671480000000004e-13 169.91249999999999p 6.7199050000000003e-13 169.92500000000001p 6.8090400000000004e-13 169.9375p 6.9367379999999998e-13 169.94999999999999p 7.1051019999999998e-13 169.96250000000001p 7.3161369999999996e-13 169.97499999999999p 7.5717460000000002e-13 169.98750000000001p 7.8737420000000001e-13)
R_LOAD OUT 0 10
I_IBIAS 0 IBIAS pwl(0p 0 1p 35u 2p 35u 170p 35u)
.tran 0.0125p 170p
.print P(BJs|XBQ) V(BJs|XBQ) I(BJs|XBQ)
.print P(BJL1|XBQ) V(BJL1|XBQ) I(BJL1|XBQ)
.print P(BJL2|XBQ) V(BJL2|XBQ) I(BJL2|XBQ)
.print I(I_REPLAY) I(I_IBIAS) V(IN) V(OUT) I(R_LOAD)
.print I(Lin|XBQ) I(L0|XBQ) I(L1|XBQ) I(L2|XBQ) I(RB|XBQ) I(RJ1|XBQ) I(RJ2|XBQ)
.end
