* R15-C logical0 + canonical READ.
.include jjmit.cir
.include bvm_cell.cir
.include jset_causal.cir

XBVM1 WL1 BL1 SE1 SL1 BVM
XJSET SL1 JSET_CAUSAL

I_WL1 0 WL1 pwl(0p 0 10p 0 11p -100U 20p -100U 21p 0 95p 0 96p +100U 105p +100U 106p 0 170p 0)
I_BL1 0 BL1 pwl(0p 0 10p 0 11p -100U 20p -100U 21p 0 170p 0)
I_SE1 0 SE1 pwl(0p 0 95p 0 96p +100U 105p +100U 106p 0 170p 0)

.tran 0.0125p 170p
.print P(B_DET|XJSET) V(B_DET|XJSET) I(B_DET|XJSET)
.print P(B_SET|XJSET) V(B_SET|XJSET) I(B_SET|XJSET)
.print I(L_TX|XJSET) I(L_RET|XJSET) I(L_S|XJSET)
.print I(I_SET|XJSET) I(R_BIAS|XJSET) I(R_IN|XJSET) I(I_DET|XJSET)
.print V(SL1) V(N6|XBVM1) I(L_SL|XBVM1)
.print P(B_JM1|XBVM1) V(B_JM1|XBVM1) P(B_JM2|XBVM1) V(B_JM2|XBVM1)
.print P(B_JS1|XBVM1) V(B_JS1|XBVM1) P(B_JS2|XBVM1) V(B_JS2|XBVM1)
.print I(L_S1|XBVM1) I(L_S2|XBVM1) I(L_S3|XBVM1) I(L_M3|XBVM1)
.print I(I_WL1) I(I_BL1) I(I_SE1)
.end
