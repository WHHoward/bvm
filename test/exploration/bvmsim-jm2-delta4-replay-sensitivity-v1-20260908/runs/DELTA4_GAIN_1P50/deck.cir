* GENERATED DELTA4_GAIN_1P50 DECK: delta4 exact-current ideal replay
* source_class=PASSIVE_CAPTURE_MARGINAL_COUNTERFACTUAL
* source construction: test/exploration/bvmsim-jm2-delta4-replay-sensitivity-v1-20260908/data/DELTA4_GAIN_1P50_source.csv
* source signal: I(B_JSL8); N3 background plus registered signed delta4 component
* transformation: signed delta_I4 gain 1.50
* exact source-grid timestamp lookup; no interpolation, smoothing, resampling, fitting or pulse reconstruction
* out-of-range or missing exact delta timestamp: zero
* orientation: I_REPLAY 0 QBIN; positive current injects QBIN in the JSL8 -> QBIN sense

.include ../../../../../circuits/models/jjmit.cir
.include ../../../../../BVMSim/BQ.cir
.include ../../../../../BVMSim/library_josim/jtl2.cir

XBQ1 QBIN QBOUT BQ
XJTL1_1 QBOUT JTL1_OUT jtl
XJTL1_2 JTL1_OUT JTL2_OUT jtl
XJTL1_3 JTL2_OUT JTL3_OUT jtl
XJTL1_4 JTL3_OUT JTL4_OUT jtl
XJTL1_5 JTL4_OUT JTL5_OUT jtl
XJTL1_6 JTL5_OUT JTL6_OUT jtl
R_TERM JTL6_OUT 0 10

I_REPLAY 0 QBIN pwl(0p 0.000000e+00 0.1p 0.000000e+00 0.2p 0.000000e+00 0.3p 0.000000e+00 0.4p 0.000000e+00 0.5p 0.000000e+00 0.6p 0.000000e+00 0.7p 0.000000e+00 0.8p 0.000000e+00 0.9p 0.000000e+00 1p 0.000000e+00 1.1p 0.000000e+00 1.2p 0.000000e+00 1.3p 0.000000e+00 1.4p 0.000000e+00 1.5p 0.000000e+00 1.6p 0.000000e+00 1.7p 0.000000e+00
+ 1.8p 0.000000e+00 1.9p 0.000000e+00 2p 0.000000e+00 2.1p 0.000000e+00 2.2p 0.000000e+00 2.3p 0.000000e+00 2.4p 0.000000e+00 2.5p 0.000000e+00 2.6p 0.000000e+00 2.7p 0.000000e+00 2.8p 0.000000e+00 2.9p 0.000000e+00 3p 0.000000e+00 3.1p 0.000000e+00 3.2p 0.000000e+00 3.3p 0.000000e+00 3.4p 0.000000e+00 3.5p 0.000000e+00
+ 3.6p 0.000000e+00 3.7p 0.000000e+00 3.8p 0.000000e+00 3.9p 0.000000e+00 4p 0.000000e+00 4.1p 0.000000e+00 4.2p 0.000000e+00 4.3p 0.000000e+00 4.4p 0.000000e+00 4.5p 0.000000e+00 4.6p 0.000000e+00 4.7p 0.000000e+00 4.8p 0.000000e+00 4.9p 0.000000e+00 5p 0.000000e+00 5.1p 0.000000e+00 5.2p 0.000000e+00 5.3p 0.000000e+00
+ 5.4p 0.000000e+00 5.5p 0.000000e+00 5.6p 0.000000e+00 5.7p 0.000000e+00 5.8p 0.000000e+00 5.9p 0.000000e+00 6p 0.000000e+00 6.1p 0.000000e+00 6.2p 0.000000e+00 6.3p 0.000000e+00 6.4p 0.000000e+00 6.5p 0.000000e+00 6.6p 0.000000e+00 6.7p 0.000000e+00 6.8p 0.000000e+00 6.9p 0.000000e+00 7p 0.000000e+00 7.1p 0.000000e+00
+ 7.2p 0.000000e+00 7.3p 0.000000e+00 7.4p 0.000000e+00 7.5p 0.000000e+00 7.6p 0.000000e+00 7.7p 0.000000e+00 7.8p 0.000000e+00 7.9p 0.000000e+00 8p 0.000000e+00 8.1p 0.000000e+00 8.2p 0.000000e+00 8.3p 0.000000e+00 8.4p 0.000000e+00 8.5p 0.000000e+00 8.6p 0.000000e+00 8.7p 0.000000e+00 8.8p 0.000000e+00 8.9p 0.000000e+00
+ 9p 0.000000e+00 9.1p 0.000000e+00 9.2p 0.000000e+00 9.3p 0.000000e+00 9.4p 0.000000e+00 9.5p 0.000000e+00 9.6p 0.000000e+00 9.7p 0.000000e+00 9.8p 0.000000e+00 9.9p 0.000000e+00 10p 0.000000e+00 10.1p 0.000000e+00 10.2p 0.000000e+00 10.3p 0.000000e+00 10.4p 0.000000e+00 10.5p 0.000000e+00 10.6p 0.000000e+00 10.7p 0.000000e+00
+ 10.8p 0.000000e+00 10.9p 0.000000e+00 11p 0.000000e+00 11.1p 0.000000e+00 11.2p 0.000000e+00 11.3p 0.000000e+00 11.4p 0.000000e+00 11.5p 0.000000e+00 11.6p 0.000000e+00 11.7p 0.000000e+00 11.8p 0.000000e+00 11.9p 0.000000e+00 12p 0.000000e+00 12.1p 0.000000e+00 12.2p 0.000000e+00 12.3p 0.000000e+00 12.4p 0.000000e+00 12.5p 0.000000e+00
+ 12.6p 0.000000e+00 12.7p 0.000000e+00 12.8p 0.000000e+00 12.9p 0.000000e+00 13p 0.000000e+00 13.1p 0.000000e+00 13.2p 0.000000e+00 13.3p 0.000000e+00 13.4p 0.000000e+00 13.5p 0.000000e+00 13.6p 0.000000e+00 13.7p 0.000000e+00 13.8p 0.000000e+00 13.9p 0.000000e+00 14p 0.000000e+00 14.1p 0.000000e+00 14.2p 0.000000e+00 14.3p 0.000000e+00
+ 14.4p 0.000000e+00 14.5p 0.000000e+00 14.6p 0.000000e+00 14.7p 0.000000e+00 14.9p 0.000000e+00 15p 0.000000e+00 15.1p 0.000000e+00 15.2p 0.000000e+00 15.3p 0.000000e+00 15.4p 0.000000e+00 15.5p 0.000000e+00 15.6p 0.000000e+00 15.7p 0.000000e+00 15.8p 0.000000e+00 15.9p 0.000000e+00 16p 0.000000e+00 16.1p 0.000000e+00 16.2p 0.000000e+00
+ 16.3p 0.000000e+00 16.4p 0.000000e+00 16.5p 0.000000e+00 16.6p 0.000000e+00 16.7p 0.000000e+00 16.8p 0.000000e+00 16.9p 0.000000e+00 17p 0.000000e+00 17.1p 0.000000e+00 17.2p 0.000000e+00 17.3p 0.000000e+00 17.4p 0.000000e+00 17.5p 0.000000e+00 17.6p 0.000000e+00 17.7p 0.000000e+00 17.8p 0.000000e+00 17.9p 0.000000e+00 18p 0.000000e+00
+ 18.1p 0.000000e+00 18.2p 0.000000e+00 18.3p 0.000000e+00 18.4p 0.000000e+00 18.5p 0.000000e+00 18.6p 0.000000e+00 18.7p 0.000000e+00 18.8p 0.000000e+00 18.9p 0.000000e+00 19p 0.000000e+00 19.1p 0.000000e+00 19.2p 0.000000e+00 19.3p 0.000000e+00 19.4p 0.000000e+00 19.5p 0.000000e+00 19.6p 0.000000e+00 19.7p 0.000000e+00 19.8p 0.000000e+00
+ 19.9p 0.000000e+00 20p 0.000000e+00 20.1p 0.000000e+00 20.2p 0.000000e+00 20.3p 0.000000e+00 20.4p 0.000000e+00 20.5p 0.000000e+00 20.6p 0.000000e+00 20.7p 0.000000e+00 20.8p 0.000000e+00 20.9p 0.000000e+00 21p 0.000000e+00 21.1p 0.000000e+00 21.2p 0.000000e+00 21.3p 0.000000e+00 21.4p 0.000000e+00 21.5p 0.000000e+00 21.6p 0.000000e+00
+ 21.7p 0.000000e+00 21.8p 0.000000e+00 21.9p 0.000000e+00 22p 0.000000e+00 22.1p 0.000000e+00 22.2p 0.000000e+00 22.3p 0.000000e+00 22.4p 0.000000e+00 22.5p 0.000000e+00 22.6p 0.000000e+00 22.7p 0.000000e+00 22.8p 0.000000e+00 22.9p 0.000000e+00 23p 0.000000e+00 23.1p 0.000000e+00 23.2p 0.000000e+00 23.3p 0.000000e+00 23.4p 0.000000e+00
+ 23.5p 0.000000e+00 23.6p 0.000000e+00 23.7p 0.000000e+00 23.8p 0.000000e+00 23.9p 0.000000e+00 24p 0.000000e+00 24.1p 0.000000e+00 24.2p 0.000000e+00 24.3p 0.000000e+00 24.4p 0.000000e+00 24.5p 0.000000e+00 24.6p 0.000000e+00 24.7p 0.000000e+00 24.8p 0.000000e+00 24.9p 0.000000e+00 25p 0.000000e+00 25.1p 0.000000e+00 25.2p 0.000000e+00
+ 25.3p 0.000000e+00 25.4p 0.000000e+00 25.5p 0.000000e+00 25.6p 0.000000e+00 25.7p 0.000000e+00 25.8p 0.000000e+00 25.9p 0.000000e+00 26p 0.000000e+00 26.1p 0.000000e+00 26.2p 0.000000e+00 26.3p 0.000000e+00 26.4p 0.000000e+00 26.5p 0.000000e+00 26.6p 0.000000e+00 26.7p 0.000000e+00 26.8p 0.000000e+00 26.9p 0.000000e+00 27p 0.000000e+00
+ 27.1p 0.000000e+00 27.2p 0.000000e+00 27.3p 0.000000e+00 27.4p 0.000000e+00 27.5p 0.000000e+00 27.6p 0.000000e+00 27.7p 0.000000e+00 27.8p 0.000000e+00 27.9p 0.000000e+00 28p 0.000000e+00 28.1p 0.000000e+00 28.2p 0.000000e+00 28.3p 0.000000e+00 28.4p 0.000000e+00 28.5p 0.000000e+00 28.6p 0.000000e+00 28.7p 0.000000e+00 28.8p 0.000000e+00
+ 28.9p 0.000000e+00 29p 0.000000e+00 29.1p 0.000000e+00 29.2p 0.000000e+00 29.3p 0.000000e+00 29.4p 0.000000e+00 29.5p 0.000000e+00 29.6p 0.000000e+00 29.7p 0.000000e+00 29.8p 0.000000e+00 29.9p 0.000000e+00 30p 0.000000e+00 30.1p 0.000000e+00 30.2p 0.000000e+00 30.3p 0.000000e+00 30.4p 0.000000e+00 30.5p 0.000000e+00 30.6p 0.000000e+00
+ 30.7p 0.000000e+00 30.8p 0.000000e+00 30.9p 0.000000e+00 31p 0.000000e+00 31.1p 0.000000e+00 31.2p 0.000000e+00 31.3p 0.000000e+00 31.4p 0.000000e+00 31.5p 0.000000e+00 31.6p 0.000000e+00 31.7p 0.000000e+00 31.8p 0.000000e+00 31.9p 0.000000e+00 32p 0.000000e+00 32.1p 0.000000e+00 32.2p 0.000000e+00 32.3p 0.000000e+00 32.4p 0.000000e+00
+ 32.5p 0.000000e+00 32.6p 0.000000e+00 32.7p 0.000000e+00 32.8p 0.000000e+00 32.9p 0.000000e+00 33p 0.000000e+00 33.1p 0.000000e+00 33.2p 0.000000e+00 33.3p 0.000000e+00 33.4p 0.000000e+00 33.5p 0.000000e+00 33.6p 0.000000e+00 33.7p 0.000000e+00 33.8p 0.000000e+00 33.9p 0.000000e+00 34p 0.000000e+00 34.1p 0.000000e+00 34.2p 0.000000e+00
+ 34.3p 0.000000e+00 34.4p 0.000000e+00 34.5p 0.000000e+00 34.6p 0.000000e+00 34.7p 0.000000e+00 34.8p 0.000000e+00 34.9p 0.000000e+00 35p 0.000000e+00 35.1p 0.000000e+00 35.2p 0.000000e+00 35.3p 0.000000e+00 35.4p 0.000000e+00 35.5p 0.000000e+00 35.6p 0.000000e+00 35.7p 0.000000e+00 35.8p 0.000000e+00 35.9p 0.000000e+00 36p 0.000000e+00
+ 36.1p 0.000000e+00 36.2p 0.000000e+00 36.3p 0.000000e+00 36.4p 0.000000e+00 36.5p 0.000000e+00 36.6p 0.000000e+00 36.7p 0.000000e+00 36.8p 0.000000e+00 36.9p 0.000000e+00 37p 0.000000e+00 37.1p 0.000000e+00 37.2p 0.000000e+00 37.3p 0.000000e+00 37.4p 0.000000e+00 37.5p 0.000000e+00 37.6p 0.000000e+00 37.7p 0.000000e+00 37.8p 0.000000e+00
+ 37.9p 0.000000e+00 38p 0.000000e+00 38.1p 0.000000e+00 38.2p 0.000000e+00 38.3p 0.000000e+00 38.4p 0.000000e+00 38.5p 0.000000e+00 38.6p 0.000000e+00 38.7p 0.000000e+00 38.8p 0.000000e+00 38.9p 0.000000e+00 39p 0.000000e+00 39.1p 0.000000e+00 39.2p 0.000000e+00 39.3p 0.000000e+00 39.4p 0.000000e+00 39.5p 0.000000e+00 39.6p 0.000000e+00
+ 39.7p 0.000000e+00 39.8p 0.000000e+00 39.9p 0.000000e+00 40p 0.000000e+00 40.1p 0.000000e+00 40.2p 0.000000e+00 40.3p 0.000000e+00 40.4p 0.000000e+00 40.5p 0.000000e+00 40.6p 0.000000e+00 40.7p 0.000000e+00 40.8p 0.000000e+00 40.9p 0.000000e+00 41p 0.000000e+00 41.1p 0.000000e+00 41.2p 0.000000e+00 41.3p 0.000000e+00 41.4p 0.000000e+00
+ 41.5p 0.000000e+00 41.6p 0.000000e+00 41.7p 0.000000e+00 41.8p 0.000000e+00 41.9p 0.000000e+00 42p 0.000000e+00 42.1p 0.000000e+00 42.2p 0.000000e+00 42.3p 0.000000e+00 42.4p 0.000000e+00 42.5p 0.000000e+00 42.6p 0.000000e+00 42.7p 0.000000e+00 42.8p 0.000000e+00 42.9p 0.000000e+00 43p 0.000000e+00 43.1p 0.000000e+00 43.2p 0.000000e+00
+ 43.3p 0.000000e+00 43.4p 0.000000e+00 43.5p 0.000000e+00 43.6p 0.000000e+00 43.7p 0.000000e+00 43.8p 0.000000e+00 43.9p 0.000000e+00 44p 0.000000e+00 44.1p 0.000000e+00 44.2p 0.000000e+00 44.3p 0.000000e+00 44.4p 0.000000e+00 44.5p 0.000000e+00 44.6p 0.000000e+00 44.7p 0.000000e+00 44.8p 0.000000e+00 44.9p 0.000000e+00 45p 0.000000e+00
+ 45.1p 0.000000e+00 45.2p 0.000000e+00 45.3p 0.000000e+00 45.4p 0.000000e+00 45.5p 0.000000e+00 45.6p 0.000000e+00 45.7p 0.000000e+00 45.8p 0.000000e+00 45.9p 0.000000e+00 46p 0.000000e+00 46.1p 0.000000e+00 46.2p 0.000000e+00 46.3p 0.000000e+00 46.4p 0.000000e+00 46.5p 0.000000e+00 46.6p 0.000000e+00 46.7p 0.000000e+00 46.8p 0.000000e+00
+ 46.9p 0.000000e+00 47p 0.000000e+00 47.1p 0.000000e+00 47.2p 0.000000e+00 47.3p 0.000000e+00 47.4p 0.000000e+00 47.5p 0.000000e+00 47.6p 0.000000e+00 47.7p 0.000000e+00 47.8p 0.000000e+00 47.9p 0.000000e+00 48p 0.000000e+00 48.1p 0.000000e+00 48.2p 0.000000e+00 48.3p 0.000000e+00 48.4p 0.000000e+00 48.5p 0.000000e+00 48.6p 0.000000e+00
+ 48.7p 0.000000e+00 48.8p 0.000000e+00 48.9p 0.000000e+00 49p 0.000000e+00 49.1p 0.000000e+00 49.2p 0.000000e+00 49.3p 0.000000e+00 49.4p 0.000000e+00 49.5p 0.000000e+00 49.6p 0.000000e+00 49.7p 0.000000e+00 49.8p 0.000000e+00 49.9p 0.000000e+00 50p 0.000000e+00 50.1p -8.34312900e-6 50.2p -1.18240900e-5 50.3p -1.23989100e-5 50.4p -1.21521100e-5
+ 50.5p -1.24664900e-5 50.6p -1.38153400e-5 50.7p -1.59613400e-5 50.8p -1.83295200e-5 50.9p -2.03599100e-5 51p -2.17268400e-5 51.1p -1.40561600e-5 51.2p -1.07530800e-5 51.3p -1.01704100e-5 51.4p -1.05212000e-5 51.5p -1.06299300e-5 51.6p -1.01152400e-5 51.7p -9.21057500e-6 51.8p -8.43390500e-6 51.9p -8.27776800e-6 52p -9.01633800e-6 52.1p -1.06494000e-5 52.2p -1.29505400e-5
+ 52.3p -1.55661800e-5 52.4p -1.81173700e-5 52.5p -2.02750500e-5 52.6p -2.17996600e-5 52.7p -2.25506800e-5 52.8p -2.24777600e-5 52.9p -2.16051700e-5 53p -2.00171200e-5 53.1p -1.78463000e-5 53.2p -1.52642600e-5 53.3p -1.24704600e-5 53.4p -9.67747400e-6 53.5p -7.09246600e-6 53.6p -4.89755500e-6 53.7p -3.23343700e-6 53.8p -2.19003300e-6 53.9p -1.80577800e-6 54p -2.07414900e-6
+ 54.1p -2.95374000e-6 54.2p -4.37750900e-6 54.3p -6.25808700e-6 54.4p -8.48843400e-6 54.5p -1.09396800e-5 54.6p -1.34594800e-5 54.7p -1.58742600e-5 54.8p -1.79979000e-5 54.9p -1.96479700e-5 55p -2.06688100e-5 55.1p -2.09578900e-5 55.2p -2.04880900e-5 55.3p -1.93171700e-5 55.4p -1.75795300e-5 55.5p -1.54622700e-5 55.6p -1.31738600e-5 55.7p -1.09144700e-5 55.8p -8.85393100e-6
+ 55.9p -7.11966200e-6 56p -5.79366700e-6 56.1p -4.91664400e-6 56.2p -4.49660800e-6 56.3p -4.51910400e-6 56.4p -4.95598800e-6 56.5p -5.77014800e-6 56.6p -6.91483600e-6 56.7p -8.32827700e-6 56.8p -9.92632500e-6 56.9p -1.15972500e-5 57p -1.32025600e-5 57.1p -1.45861700e-5 57.2p -1.55911600e-5 57.3p -1.60812100e-5 57.4p -1.59616200e-5 57.5p -1.51954500e-5 57.6p -1.38110900e-5
+ 57.7p -1.18999900e-5 57.8p -9.60516400e-6 57.9p -7.10259700e-6 58p -4.57895900e-6 58.1p -2.20951300e-6 58.2p -1.39987700e-7 58.3p 1.52465300e-6 58.4p 2.72327500e-6 58.5p 3.43423900e-6 58.6p 3.66633800e-6 58.7p 3.44870000e-6 58.8p 2.82323800e-6 58.9p 1.84183500e-6 59p 5.68343900e-7 59.1p -9.16664400e-7 59.2p -2.51185500e-6 59.3p -4.09527800e-6 59.4p -5.53091500e-6
+ 59.5p -6.68158700e-6 59.6p -7.42598900e-6 59.7p -7.67609300e-6 59.8p -7.39102100e-6 59.9p -6.58435300e-6 60p -5.32346300e-6 60.1p 4.62197500e-6 60.2p 9.90771900e-6 60.3p 1.23450800e-5 60.4p 1.38868200e-5 60.5p 1.58090200e-5 60.6p 1.85052300e-5 60.7p 2.16776400e-5 60.8p 2.46976500e-5 60.9p 2.69488400e-5 61p 2.80469600e-5 61.1p 1.95710100e-5 61.2p 1.49161100e-5
+ 61.3p 1.24909900e-5 61.4p 1.06486100e-5 61.5p 8.43160400e-6 61.6p 5.72238900e-6 61.7p 3.01415800e-6 61.8p 1.03001900e-6 61.9p 3.77201800e-7 62p 1.34085700e-6 62.1p 3.83679400e-6 62.2p 7.48419400e-6 62.3p 1.17371100e-5 62.4p 1.60197800e-5 62.5p 1.98308100e-5 62.6p 2.28023400e-5 62.7p 2.47159600e-5 62.8p 2.54863200e-5 62.9p 2.51272700e-5 63p 2.37156700e-5
+ 63.1p 2.13649000e-5 63.2p 1.82144200e-5 63.3p 1.44341700e-5 63.4p 1.02359200e-5 63.5p 5.88012500e-6 63.6p 1.66858100e-6 63.7p -2.08012900e-6 63.8p -5.06791300e-6 63.9p -7.05697000e-6 64p -7.90156000e-6 64.1p -7.56515600e-6 64.2p -6.12192900e-6 64.3p -3.74551000e-6 64.4p -6.88884000e-7 64.5p 2.74192000e-6 64.6p 6.21884800e-6 64.7p 9.42547300e-6 64.8p 1.20891700e-5
+ 64.9p 1.40061400e-5 65p 1.50541700e-5 65.1p 1.51915400e-5 65.2p 1.44450700e-5 65.3p 1.28938100e-5 65.4p 1.06554700e-5 65.5p 7.87952500e-6 65.6p 4.74644600e-6 65.7p 1.46771800e-6 65.8p -1.71954900e-6 65.9p -4.56764800e-6 66p -6.84234200e-6 66.1p -8.35096500e-6 66.2p -8.96751400e-6 66.3p -8.64885600e-6 66.4p -7.43939900e-6 66.5p -5.46486500e-6 66.6p -2.91767000e-6
+ 66.7p -3.66432800e-8 66.8p 2.91678200e-6 66.9p 5.68399100e-6 67p 8.03380700e-6 67.1p 9.78318900e-6 67.2p 1.08108800e-5 67.3p 1.10622500e-5 67.4p 1.05459600e-5 67.5p 9.32499000e-6 67.6p 7.50604300e-6 67.7p 5.22997800e-6 67.8p 2.66432100e-6 67.9p -3.54019600e-9 68p -2.57492800e-6 68.1p -4.85213400e-6 68.2p -6.65447400e-6 68.3p -7.83607000e-6 68.4p -8.30203500e-6
+ 68.5p -8.01974400e-6 68.6p -7.02306000e-6 68.7p -5.40898600e-6 68.8p -3.32752000e-6 68.9p -9.66270100e-7 69p 1.46823000e-6 69.1p 3.77038500e-6 69.2p 5.75426000e-6 69.3p 7.26895500e-6 69.4p 8.20894100e-6 69.5p 8.51873100e-6 69.6p 8.19252700e-6 69.7p 7.27040200e-6 69.8p 5.83275800e-6 69.9p 3.99421700e-6 70p 1.89699700e-6 70.1p 1.68211000e-5 70.2p 2.21006700e-5
+ 70.3p 2.19649300e-5 70.4p 2.08446000e-5 70.5p 2.16809400e-5 70.6p 2.55071000e-5 70.7p 3.18542100e-5 70.8p 3.95097000e-5 70.9p 4.72365500e-5 71p 5.42282900e-5 71.1p 4.31317100e-5 71.2p 4.10098000e-5 71.3p 4.42536400e-5 71.4p 4.90192200e-5 71.5p 5.27348100e-5 71.6p 5.44452300e-5 71.7p 5.44338300e-5 71.8p 5.35602900e-5 71.9p 5.26610500e-5 72p 5.21989200e-5
+ 72.1p 5.21890000e-5 72.2p 5.23217000e-5 72.3p 5.21652800e-5 72.4p 5.13478000e-5 72.5p 4.96631500e-5 72.6p 4.70927200e-5 72.7p 4.37658300e-5 72.8p 3.98939900e-5 72.9p 3.57091300e-5 73p 3.14229800e-5 73.1p 2.72104200e-5 73.2p 2.32104200e-5 73.3p 1.95342900e-5 73.4p 1.62727300e-5 73.5p 1.34974400e-5 73.6p 1.12572700e-5 73.7p 9.57215700e-6 73.8p 8.42857200e-6
+ 73.9p 7.77941700e-6 74p 7.54924400e-6 74.1p 7.64380300e-6 74.2p 7.96182000e-6 74.3p 8.40675600e-6 74.4p 8.89695000e-6 74.5p 9.37330200e-6 74.6p 9.80421600e-6 74.7p 1.01874800e-5 74.8p 1.05485000e-5 74.9p 1.09341400e-5 75p 1.14020000e-5 75.1p 1.20059800e-5 75.2p 1.27807700e-5 75.3p 1.37284600e-5 75.4p 1.48109200e-5 75.5p 1.59500900e-5 75.6p 1.70364300e-5
+ 75.7p 1.79435100e-5 75.8p 1.85456800e-5 75.9p 1.87351100e-5 76p 1.84355000e-5 76.1p 1.76108900e-5 76.2p 1.62694300e-5 76.3p 1.44628700e-5 76.4p 1.22827900e-5 76.5p 9.85403200e-6 76.6p 7.32549100e-6 76.7p 4.85774200e-6 76.8p 2.60732400e-6 76.9p 7.08350100e-7 77p -7.46235300e-7 77.1p -1.71989100e-6 77.2p -2.23975500e-6 77.3p -2.39257000e-6 77.4p -2.30862500e-6
+ 77.5p -2.13661700e-6 77.6p -2.01519600e-6 77.7p -2.04783300e-6 77.8p -2.28632200e-6 77.9p -2.72532500e-6 78p -3.30730400e-6 78.1p -3.93514600e-6 78.2p -4.48912200e-6 78.3p -4.84525900e-6 78.4p -4.89301600e-6 78.5p -4.55062600e-6 78.6p -3.77666000e-6 78.7p -2.57641600e-6 78.8p -1.00211800e-6 78.9p 8.53192900e-7 79p 2.86701500e-6 79.1p 4.90189200e-6 79.2p 6.82044300e-6
+ 79.3p 8.49846500e-6 79.4p 9.83447100e-6 79.5p 1.07550300e-5 79.6p 1.12162800e-5 79.7p 1.12026600e-5 79.8p 1.07240200e-5 79.9p 9.81223200e-6 80p 8.51793700e-6 80.1p -1.02104200e-5 80.2p -1.94949300e-5 80.3p -2.33839700e-5 80.4p -2.61506900e-5 80.5p -3.05741300e-5 80.6p -3.74863300e-5 80.7p -4.61605100e-5 80.8p -5.50904000e-5 80.9p -6.27785900e-5 81p -6.82933800e-5
+ 81.1p -5.43842500e-5 81.2p -4.84867500e-5 81.3p -4.75723500e-5 81.4p -4.84284800e-5 81.5p -4.89756300e-5 81.6p -4.84737900e-5 81.7p -4.71198400e-5 81.8p -4.54780100e-5 81.9p -4.40420000e-5 82p -4.30441500e-5 82.1p -4.24776700e-5 82.2p -4.22219300e-5 82.3p -4.21586000e-5 82.4p -4.22145700e-5 82.5p -4.23295800e-5 82.6p -4.23936600e-5 82.7p -4.22101600e-5 82.8p -4.15168000e-5
+ 82.9p -4.00582900e-5 83p -3.76740200e-5 83.1p -3.43590600e-5 83.2p -3.02732400e-5 83.3p -2.57003400e-5 83.4p -2.09795500e-5 83.5p -1.64383100e-5 83.6p -1.23483200e-5 83.7p -8.91141200e-6 83.8p -6.26783000e-6 83.9p -4.51181200e-6 84p -3.70066200e-6 84.1p -3.85103100e-6 84.2p -4.92560100e-6 84.3p -6.81947400e-6 84.4p -9.35590500e-6 84.5p -1.22961700e-5 84.6p -1.53618100e-5
+ 84.7p -1.82630400e-5 84.8p -2.07266800e-5 84.9p -2.25194200e-5 85p -2.34654200e-5 85.1p -2.34584200e-5 85.2p -2.24691800e-5 85.3p -2.05476600e-5 85.4p -1.78190800e-5 85.5p -1.44735300e-5 85.6p -1.07494200e-5 85.7p -6.91282100e-6 85.8p -3.23555500e-6 85.9p 2.58781400e-8 86p 2.64948900e-6 86.1p 4.46540400e-6 86.2p 5.37174200e-6 86.3p 5.34671800e-6 86.4p 4.45309300e-6
+ 86.5p 2.83112600e-6 86.6p 6.79162300e-7 86.7p -1.77441800e-6 86.8p -4.30037000e-6 86.9p -6.69091100e-6 87p -8.77066000e-6 87.1p -1.03974900e-5 87.2p -1.14598200e-5 87.3p -1.18785000e-5 87.4p -1.16181200e-5 87.5p -1.07052200e-5 87.6p -9.24355600e-6 87.7p -7.41340300e-6 87.8p -5.44673100e-6 87.9p -3.58071900e-6 88p -2.00377200e-6 88.1p -8.13922600e-7 88.2p -6.03240900e-9
+ 88.3p 5.06811600e-7 88.4p 8.45547900e-7 88.5p 1.10862900e-6 88.6p 1.32726900e-6 88.7p 1.44882000e-6 88.8p 1.35522100e-6 88.9p 9.11512700e-7 89p 2.81609700e-8 89.1p -1.28575200e-6 89.2p -2.89999200e-6 89.3p -4.58211600e-6 89.4p -6.05234900e-6 89.5p -7.05426600e-6 89.6p -7.41548500e-6 89.7p -7.07861300e-6 89.8p -6.09655900e-6 89.9p -4.60106600e-6 90p -2.76191000e-6
+ 90.1p 7.58932900e-6 90.2p 1.30832400e-5 90.3p 1.55238300e-5 90.4p 1.68532100e-5 90.5p 1.83258700e-5 90.6p 2.03150900e-5 90.7p 2.25296000e-5 90.8p 2.43974600e-5 90.9p 2.54159700e-5 91p 2.53554700e-5 91.1p 1.59564600e-5 91.2p 1.07439100e-5 91.3p 8.19495500e-6 91.4p 6.65960200e-6 91.5p 5.11741400e-6 91.6p 3.35275000e-6 91.7p 1.75268300e-6 91.8p 9.45565200e-7
+ 91.9p 1.46403500e-6 92p 3.54010800e-6 92.1p 7.05710300e-6 92.2p 1.16224800e-5 92.3p 1.66989000e-5 92.4p 2.17345600e-5 92.5p 2.62556500e-5 92.6p 2.99103300e-5 92.7p 3.24734200e-5 92.8p 3.38301300e-5 92.9p 3.39551100e-5 93p 3.28964900e-5 93.1p 3.07675900e-5 93.2p 2.77443400e-5 93.3p 2.40634100e-5 93.4p 2.00125400e-5 93.5p 1.59061500e-5 93.6p 1.20482600e-5
+ 93.7p 8.69635100e-6 93.8p 6.04152900e-6 93.9p 4.21147400e-6 94p 3.28843900e-6 94.1p 3.32627200e-6 94.2p 4.35221400e-6 94.3p 6.34961600e-6 94.4p 9.23037300e-6 94.5p 1.28138200e-5 94.6p 1.68274200e-5 94.7p 2.09344900e-5 94.8p 2.47810100e-5 94.9p 2.80448800e-5 95p 3.04717200e-5 95.1p 3.18911400e-5 95.2p 3.22191400e-5 95.3p 3.14599300e-5 95.4p 2.97163300e-5
+ 95.5p 2.72044200e-5 95.6p 2.42541800e-5 95.7p 2.12754400e-5 95.8p 1.86842200e-5 95.9p 1.68080900e-5 96p 1.58053600e-5 96.1p 1.56303400e-5 96.2p 1.60583100e-5 96.3p 1.67602000e-5 96.4p 1.74003100e-5 96.5p 1.77260100e-5 96.6p 1.76257100e-5 96.7p 1.71436300e-5 96.8p 1.64526100e-5 96.9p 1.57946900e-5 97p 1.54050700e-5 97.1p 1.54377100e-5 97.2p 1.59115600e-5
+ 97.3p 1.66931100e-5 97.4p 1.75214800e-5 97.5p 1.80696400e-5 97.6p 1.80230100e-5 97.7p 1.71519500e-5 97.8p 1.53587900e-5 97.9p 1.26911200e-5 98p 9.32479400e-6 98.1p 5.52785100e-6 98.2p 1.61731200e-6 98.3p -2.08243300e-6 98.4p -5.27545900e-6 98.5p -7.72286900e-6 98.6p -9.26304700e-6 98.7p -9.82207000e-6 98.8p -9.41308800e-6 98.9p -8.12519000e-6 99p -6.10470200e-6
+ 99.1p -3.53366400e-6 99.2p -6.10396500e-7 99.3p 2.46456300e-6 99.4p 5.49642800e-6 99.5p 8.29985300e-6 99.6p 1.07016600e-5 99.7p 1.25458600e-5 99.8p 1.37027300e-5 99.9p 1.40813400e-5 100p 1.36426300e-5 100.1p 4.06577400e-6 100.2p -1.36542700e-6 100.3p -4.48116300e-6 100.4p -7.20622200e-6 100.5p -1.07428800e-5 100.6p -1.53712400e-5 100.7p -2.06498700e-5 100.8p -2.57877000e-5
+ 100.9p -3.00000000e-5 101p -3.27430200e-5 101.1p -2.54617800e-5 101.2p -2.14615900e-5 101.3p -1.91190700e-5 101.4p -1.68160800e-5 101.5p -1.36746700e-5 101.6p -9.68676100e-6 101.7p -5.46375700e-6 101.8p -1.84280600e-6 101.9p 4.59689200e-7 102p 1.04779900e-6 102.1p -1.09725600e-7 102.2p -2.74266100e-6 102.3p -6.38814900e-6 102.4p -1.05003500e-5 102.5p -1.45415900e-5 102.6p -1.80524300e-5
+ 102.7p -2.07010600e-5 102.8p -2.23085600e-5 102.9p -2.28449000e-5 103p -2.23955700e-5 103.1p -2.11084800e-5 103.2p -1.91393000e-5 103.3p -1.66145300e-5 103.4p -1.36254600e-5 103.5p -1.02529600e-5 103.6p -6.60917800e-6 103.7p -2.87381800e-6 103.8p 6.95785200e-7 103.9p 3.78993600e-6 104p 6.10010400e-6 104.1p 7.38124200e-6 104.2p 7.50098200e-6 104.3p 6.46146200e-6 104.4p 4.39202800e-6
+ 104.5p 1.52155800e-6 104.6p -1.85712500e-6 104.7p -5.42113500e-6 104.8p -8.84623100e-6 104.9p -1.18315900e-5 105p -1.41227400e-5 105.1p -1.55325500e-5 105.2p -1.59569800e-5 105.3p -1.53818600e-5 105.4p -1.38784600e-5 105.5p -1.15892300e-5 105.6p -8.70803800e-6 105.7p -5.45981100e-6 105.8p -2.08319800e-6 105.9p 1.18287100e-6 106p 4.11034500e-6 106.1p 6.49340500e-6 106.2p 8.16162600e-6
+ 106.3p 8.99454900e-6 106.4p 8.93526600e-6 106.5p 7.99963600e-6 106.6p 6.27812500e-6 106.7p 3.92878000e-6 106.8p 1.16186500e-6 106.9p -1.78149000e-6 107p -4.65308500e-6 107.1p -7.22023400e-6 107.2p -9.28425400e-6 107.3p -1.06934200e-5 107.4p -1.13505100e-5 107.5p -1.12160800e-5 107.6p -1.03089000e-5 107.7p -8.70424000e-6 107.8p -6.52985000e-6 107.9p -3.95841700e-6 108p -1.19560400e-6
+ 108.1p 1.53646600e-6 108.2p 4.01879300e-6 108.3p 6.05552000e-6 108.4p 7.49152300e-6 108.5p 8.22551200e-6 108.6p 8.21778900e-6 108.7p 7.49268300e-6 108.8p 6.13580100e-6 108.9p 4.28586600e-6 109p 2.12083600e-6 109.1p -1.61123600e-7 109.2p -2.36356200e-6 109.3p -4.31260500e-6 109.4p -5.87236000e-6 109.5p -6.95182200e-6 109.6p -7.50310200e-6 109.7p -7.51388500e-6 109.8p -6.99895800e-6
+ 109.9p -5.99528300e-6 110p -4.56272600e-6 110.1p 1.64689100e-5 110.2p 2.67880850e-5 110.3p 3.08116750e-5 110.4p 3.31805300e-5 110.5p 3.68933900e-5 110.6p 4.28752500e-5 110.7p 5.04698000e-5 110.8p 5.83235850e-5 110.9p 6.52241350e-5 111p 7.06383250e-5 111.1p 5.56252100e-5 111.2p 5.13718100e-5 111.3p 5.46130800e-5 111.4p 6.17172700e-5 111.5p 7.02289300e-5 111.6p 7.91719600e-5
+ 111.7p 8.86463650e-5 111.8p 9.92007950e-5 111.9p 1.113195900e-4 112p 1.251691450e-4 112.1p 1.405808500e-4 112.2p 1.571567950e-4 112.3p 1.743614200e-4 112.4p 1.91510150e-4 112.5p 2.07630650e-4 112.6p 2.21282250e-4 112.7p 2.30530950e-4 112.8p 2.33316750e-4 112.9p 2.28301000e-4 113p 2.15857850e-4 113.1p 1.98548400e-4 113.2p 1.80576400e-4 113.3p 1.66391450e-4 113.4p 1.59174000e-4
+ 113.5p 1.59963950e-4 113.6p 1.67725200e-4 113.7p 1.801116050e-4 113.8p 1.944202050e-4 113.9p 2.08310500e-4 114p 2.20170450e-4 114.1p 2.29231350e-4 114.2p 2.35479950e-4 114.3p 2.39344900e-4 114.4p 2.41253250e-4 114.5p 2.41311750e-4 114.6p 2.39323700e-4 114.7p 2.35119450e-4 114.8p 2.28985350e-4 114.9p 2.21925300e-4 115p 2.15603600e-4 115.1p 2.11975150e-4 115.2p 2.12733250e-4
+ 115.3p 2.18747000e-4 115.4p 2.29617250e-4 115.5p 2.43414200e-4 115.6p 2.56680850e-4 115.7p 2.64915100e-4 115.8p 2.63780700e-4 115.9p 2.50911400e-4 116p 2.27447000e-4 116.1p 1.98173150e-4 116.2p 1.69898650e-4 116.3p 1.48912350e-4 116.4p 1.38908700e-4 116.5p 1.40313850e-4 116.6p 1.51001650e-4 116.7p 1.67681650e-4 116.8p 1.87139150e-4 116.9p 2.06878550e-4 117p 2.25201750e-4
+ 117.1p 2.41017700e-4 117.2p 2.53636100e-4 117.3p 2.62642900e-4 117.4p 2.67836600e-4 117.5p 2.69156350e-4 117.6p 2.66543000e-4 117.7p 2.59840400e-4 117.8p 2.49045200e-4 117.9p 2.35058600e-4 118p 2.20512050e-4 118.1p 2.09843300e-4 118.2p 2.08147300e-4 118.3p 2.19150650e-4 118.4p 2.43175400e-4 118.5p 2.75903000e-4 118.6p 3.08516150e-4 118.7p 3.29804050e-4 118.8p 3.30399950e-4
+ 118.9p 3.07576150e-4 119p 2.67389300e-4 119.1p 2.22196300e-4 119.2p 1.84973400e-4 119.3p 1.64006150e-4 119.4p 1.60708600e-4 119.5p 1.70950900e-4 119.6p 1.88379500e-4 119.7p 2.07677900e-4 119.8p 2.26267950e-4 119.9p 2.44014300e-4 120p 2.61603150e-4 120.1p 2.59652550e-4 120.2p 2.66851200e-4 120.3p 2.76382750e-4 120.4p 2.81638150e-4 120.5p 2.78950150e-4 120.6p 2.67998800e-4
+ 120.7p 2.50503500e-4 120.8p 2.28380650e-4 120.9p 2.02565550e-4 121p 1.73138950e-4 121.1p 1.59711000e-4 121.2p 1.33799150e-4 121.3p 1.03163000e-4 121.4p 7.62478300e-5 121.5p 5.87319000e-5 121.6p 5.19162450e-5 121.7p 5.30667950e-5 121.8p 5.71739550e-5 121.9p 5.92007450e-5 122p 5.59579250e-5 122.1p 4.71224350e-5 122.2p 3.52858800e-5 122.3p 2.50678150e-5 122.4p 2.13746550e-5
+ 122.5p 2.71954950e-5 122.6p 4.18973850e-5 122.7p 6.11093850e-5 122.8p 7.84693250e-5 122.9p 8.83381050e-5 123p 8.80435200e-5 123.1p 7.86065200e-5 123.2p 6.37990700e-5 123.3p 4.81782050e-5 123.4p 3.50799800e-5 123.5p 2.54344100e-5 123.6p 1.78519700e-5 123.7p 9.8822350e-6 123.8p -2.233050e-7 123.9p -1.222524850e-5 124p -2.381379600e-5 124.1p -3.17173750e-5 124.2p -3.329327100e-5
+ 124.3p -2.771223450e-5 124.4p -1.620678850e-5 124.5p -1.41315400e-6 124.6p 1.375100200e-5 124.7p 2.71158650e-5 124.8p 3.77799700e-5 124.9p 4.598809300e-5 125p 5.253071350e-5 125.1p 5.802206350e-5 125.2p 6.24209600e-5 125.3p 6.49871550e-5 125.4p 6.46258250e-5 125.5p 6.03989800e-5 125.6p 5.19521300e-5 125.7p 3.96940450e-5 125.8p 2.47004500e-5 125.9p 8.4257300e-6 126p -7.63479800e-6
+ 126.1p -2.220262300e-5 126.2p -3.43358400e-5 126.3p -4.343137550e-5 126.4p -4.916758400e-5 126.5p -5.143736350e-5 126.6p -5.02978050e-5 126.7p -4.59453750e-5 126.8p -3.87182150e-5 126.9p -2.91177950e-5 127p -1.78269700e-5 127.1p -5.6907400e-6 127.2p 6.363757750e-6 127.3p 1.745894600e-5 127.4p 2.690313350e-5 127.5p 3.426697200e-5 127.6p 3.935707750e-5 127.7p 4.21007000e-5 127.8p 4.24204750e-5
+ 127.9p 4.02052400e-5 128p 3.54369150e-5 128.1p 2.84224900e-5 128.2p 1.99725450e-5 128.3p 1.13558450e-5 128.4p 3.97878700e-6 128.5p -1.08543650e-6 128.6p -3.486468650e-6 128.7p -3.7086092200e-6 128.8p -2.85193700e-6 128.9p -2.18292750e-6 129p -2.63675900e-6 129.1p -4.44695550e-6 129.2p -7.01922150e-6 129.3p -9.09866400e-6 129.4p -9.21134550e-6 129.5p -6.26839750e-6 129.6p -1.0900400e-7
+ 129.7p 8.28780850e-6 129.8p 1.707594800e-5 129.9p 2.420085600e-5 130p 2.81278050e-5 130.1p 2.82965700e-5 130.2p 2.51292600e-5 130.3p 1.96568200e-5 130.4p 1.29989650e-5 130.5p 5.96215350e-6 130.6p -1.07691700e-6 130.7p -8.00057200e-6 130.8p -1.464341750e-5 130.9p -2.056325000e-5 131p -2.503872300e-5 131.1p -2.72938000e-5 131.2p -2.68130550e-5 131.3p -2.35721900e-5 131.4p -1.80715300e-5
+ 131.5p -1.11730250e-5 131.6p -3.83314600e-6 131.7p 3.145511800e-6 131.8p 9.25119600e-6 131.9p 1.4260962150e-5 132p 1.813511400e-5 132.1p 2.087962400e-5 132.2p 2.24465950e-5 132.3p 2.27116350e-5 132.4p 2.15250650e-5 132.5p 1.88003700e-5 132.6p 1.45930550e-5 132.7p 9.1351800e-6 132.8p 2.81713300e-6 132.9p -3.868060750e-6 133p -1.039271150e-5 133.1p -1.625455200e-5 133.2p -2.102066300e-5
+ 133.3p -2.435612050e-5 133.4p -2.60415400e-5 133.5p -2.59819750e-5 133.6p -2.42087650e-5 133.7p -2.08741450e-5 133.8p -1.62393800e-5 133.9p -1.06560700e-5 134p -4.54038800e-6 134.1p 1.659461400e-6 134.2p 7.49968600e-6 134.3p 1.257595050e-5 134.4p 1.655186050e-5 134.5p 1.917980500e-5 134.6p 2.03175750e-5 134.7p 1.99441900e-5 134.8p 1.81721000e-5 134.9p 1.52455300e-5 135p 1.15132050e-5
+ 135.1p 7.37192550e-6 135.2p 3.19314450e-6 135.3p -7.43020450e-7 135.4p -4.279595350e-6 135.5p -7.36539000e-6 135.6p -9.99352400e-6 135.7p -1.212097700e-5 135.8p -1.360610200e-5 135.9p -1.419906350e-5 136p -1.360309450e-5 136.1p -1.159485050e-5 136.2p -8.15903500e-6 136.3p -3.57408750e-6 136.4p 1.602254900e-6 136.5p 6.655100900e-6 136.6p 1.089602200e-5 136.7p 1.383081950e-5 136.8p 1.524410600e-5
+ 136.9p 1.517763850e-5 137p 1.383162500e-5 137.1p 1.145082850e-5 137.2p 8.25625700e-6 137.3p 4.44953800e-6 137.4p 2.7134850e-7 137.5p -3.939414950e-6 137.6p -7.74045200e-6 137.7p -1.065682900e-5 137.8p -1.230285350e-5 137.9p -1.249850750e-5 138p -1.132508100e-5 138.1p -9.09493100e-6 138.2p -6.25009700e-6 138.3p -3.23271000e-6 138.4p -3.7676300e-7 138.5p 2.143702900e-6 138.6p 4.3001837150e-6
+ 138.7p 6.14493600e-6 138.8p 7.72833400e-6 138.9p 9.03388700e-6 139p 9.95574150e-6 139.1p 1.032397900e-5 139.2p 9.96338850e-6 139.3p 8.75977000e-6 139.4p 6.70834300e-6 139.5p 3.92949500e-6 139.6p 6.5131600e-7 139.7p -2.830313550e-6 139.8p -6.19895100e-6 139.9p -9.15931900e-6 140p -1.146666500e-5 140.1p -1.294316200e-5 140.2p -1.348455000e-5 140.3p -1.306108000e-5 140.4p -1.171534300e-5
+ 140.5p -9.55760300e-6 140.6p -6.75743000e-6 140.7p -3.53095150e-6 140.8p -1.23732250e-7 140.9p 3.208926400e-6 141p 6.22188100e-6 141.1p 8.69823200e-6 141.2p 1.046448250e-5 141.3p 1.140241950e-5 141.4p 1.145732550e-5 141.5p 1.064178800e-5 141.6p 9.03402050e-6 141.7p 6.77040350e-6 141.8p 4.03277500e-6 141.9p 1.03265900e-6 142p -2.004871050e-6 142.1p -4.85541100e-6 142.2p -7.30705000e-6
+ 142.3p -9.17128550e-6 142.4p -1.029556000e-5 142.5p -1.057883550e-5 142.6p -9.98863150e-6 142.7p -8.57448750e-6 142.8p -6.47118200e-6 142.9p -3.88682350e-6 143p -1.07595300e-6 143.1p 1.696176750e-6 143.2p 4.18827900e-6 143.3p 6.20749500e-6 143.4p 7.61954250e-6 143.5p 8.34716600e-6 143.6p 8.36430450e-6 143.7p 7.69354750e-6 143.8p 6.40971400e-6 143.9p 4.64541050e-6 144p 2.58948700e-6
+ 144.1p 4.70106900e-7 144.2p -1.4790995400e-6 144.3p -3.06192350e-6 144.4p -4.15702850e-6 144.5p -4.73568000e-6 144.6p -4.85257450e-6 144.7p -4.61313650e-6 144.8p -4.12983150e-6 144.9p -3.48380950e-6 145p -2.70581750e-6 145.1p -1.78260150e-6 145.2p -6.85261650e-7 145.3p 5.924684300e-7 145.4p 2.002123150e-6 145.5p 3.42842600e-6 145.6p 4.70320100e-6 145.7p 5.64078400e-6 145.8p 6.08218650e-6
+ 145.9p 5.93258550e-6 146p 5.18068800e-6 146.1p 3.89656350e-6 146.2p 2.21258000e-6 146.3p 2.96812400e-7 146.4p -1.671918900e-6 146.5p -3.52205950e-6 146.6p -5.10000100e-6 146.7p -6.27660400e-6 146.8p -6.95324350e-6 146.9p -7.06929900e-6 147p -6.61001050e-6 147.1p -5.61174800e-6 147.2p -4.16152150e-6 147.3p -2.38923300e-6 147.4p -4.53515100e-7 147.5p 1.476061300e-6 147.6p 3.23694600e-6
+ 147.7p 4.68880450e-6 147.8p 5.72433250e-6 147.9p 6.27538600e-6 148p 6.31505700e-6 148.1p 5.85658500e-6 148.2p 4.94990300e-6 148.3p 3.67627150e-6 148.4p 2.14133950e-6 148.5p 4.66904250e-7 148.6p -1.2181912950e-6 148.7p -2.78748050e-6 148.8p -4.12603050e-6 148.9p -5.13870950e-6 149p -5.75702500e-6 149.1p -5.94395350e-6 149.2p -5.69632250e-6 149.3p -5.04444450e-6 149.4p -4.04901300e-6
+ 149.5p -2.79554100e-6 149.6p -1.38695050e-6 149.7p 6.49766400e-8 149.8p 1.448595500e-6 149.9p 2.66124050e-6 150p 3.61740800e-6 150.1p 4.25572600e-6 150.2p 4.54399600e-6 150.3p 4.48143650e-6 150.4p 4.09737300e-6 150.5p 3.44603000e-6 150.6p 2.59806100e-6 150.7p 1.63041600e-6 150.8p 6.16934350e-7 150.9p -3.78055000e-7 151p -1.301687100e-6 151.1p -2.11026450e-6 151.2p -2.76453550e-6
+ 151.3p -3.22550300e-6 151.4p -3.45368200e-6 151.5p -3.41353450e-6 151.6p -3.08270450e-6 151.7p -2.46336900e-6 151.8p -1.59150450e-6 151.9p -5.39865400e-7 152p 5.87772650e-7 152.1p 1.670601750e-6 152.2p 2.58956650e-6 152.3p 3.24587750e-6 152.4p 3.57453400e-6 152.5p 3.55026900e-6 152.6p 3.18616400e-6 152.7p 2.52732950e-6 152.8p 1.64283550e-6 152.9p 6.18123700e-7 153p -4.514882450e-7
+ 153.1p -1.467144800e-6 153.2p -2.33394200e-6 153.3p -2.97008500e-6 153.4p -3.31670200e-6 153.5p -3.34605700e-6 153.6p -3.06559550e-6 153.7p -2.51623750e-6 153.8p -1.76499750e-6 153.9p -8.93793700e-7 154p 1.2722100e-8 154.1p 8.77457700e-7 154.2p 1.637459150e-6 154.3p 2.24631550e-6 154.4p 2.67327000e-6 154.5p 2.90066550e-6 154.6p 2.92142800e-6 154.7p 2.73769500e-6 154.8p 2.36088900e-6
+ 154.9p 1.81270900e-6 155p 1.126096350e-6 155.1p 3.45161350e-7 155.2p -4.765451000e-7 155.3p -1.279550200e-6 155.4p -2.00335500e-6 155.5p -2.59197150e-6 155.6p -2.99924300e-6 155.7p -3.19319450e-6 155.8p -3.15889750e-6 155.9p -2.89960500e-6 156p -2.43616800e-6 156.1p -1.80493100e-6 156.2p -1.054439800e-6 156.3p -2.41329950e-7 156.4p 5.74202650e-7 156.5p 1.332954750e-6 156.6p 1.98096950e-6
+ 156.7p 2.47320900e-6 156.8p 2.77646550e-6 156.9p 2.87138300e-6 157p 2.75355600e-6 157.1p 2.43370100e-6 157.2p 1.93693950e-6 157.3p 1.301267200e-6 157.4p 5.75234000e-7 157.5p -1.851049600e-7 157.6p -9.19967800e-7 157.7p -1.570274550e-6 157.8p -2.08257150e-6 157.9p -2.41410500e-6 158p -2.53748150e-6 158.1p -2.44417800e-6 158.2p -2.14615650e-6 158.3p -1.67503950e-6 158.4p -1.078722250e-6
+ 158.5p -4.15892550e-7 158.6p 2.506750800e-7 158.7p 8.60886800e-7 158.8p 1.363151550e-6 158.9p 1.718617000e-6 159p 1.90367350e-6 159.1p 1.91092800e-6 159.2p 1.74898000e-6 159.3p 1.44120550e-6 159.4p 1.023494100e-6 159.5p 5.40795500e-7 159.6p 4.24474750e-8 159.7p -4.23370850e-7 159.8p -8.15262000e-7 159.9p -1.103223400e-6 160p -1.271236300e-6 160.1p -1.317291100e-6 160.2p -1.250997150e-6
+ 160.3p -1.089645950e-6 160.4p -8.53967250e-7 160.5p -5.64809950e-7 160.6p -2.41512300e-7 160.7p 9.79381150e-8 160.8p 4.35550000e-7 160.9p 7.51785200e-7 161p 1.024859800e-6 161.1p 1.231562800e-6 161.2p 1.349663350e-6 161.3p 1.361378450e-6 161.4p 1.256961750e-6 161.5p 1.037427550e-6 161.6p 7.15688100e-7 161.7p 3.15818350e-7 161.8p -1.2932381000e-7 161.9p -5.81595700e-7 162p -1.001525000e-6
+ 162.1p -1.352144400e-6 162.2p -1.602317700e-6 162.3p -1.72934900e-6 162.4p -1.72081250e-6 162.5p -1.575574750e-6 162.6p -1.303949650e-6 162.7p -9.26989350e-7 162.8p -4.74826300e-7 162.9p 1.580632400e-8 163p 5.04742800e-7 163.1p 9.51934200e-7 163.2p 1.321021250e-6 163.3p 1.582552650e-6 163.4p 1.71651550e-6 163.5p 1.71392600e-6 163.6p 1.577381050e-6 163.7p 1.320513400e-6 163.8p 9.66510850e-7
+ 163.9p 5.45829700e-7 164p 9.3385700e-8 164.1p -3.54523000e-7 164.2p -7.63270400e-7 164.3p -1.102675750e-6 164.4p -1.349268450e-6 164.5p -1.487878600e-6 164.6p -1.512463150e-6 164.7p -1.426128050e-6 164.8p -1.240419500e-6 164.9p -9.73989650e-7 165p -6.50769550e-7 165.1p -2.97854350e-7 165.2p 5.67565450e-8 165.3p 3.86390200e-7 165.4p 6.67750150e-7 165.5p 8.82634550e-7 165.6p 1.019174900e-6
+ 165.7p 1.072464200e-6 165.8p 1.044493650e-6 165.9p 9.43398550e-7 166p 7.82128750e-7 166.1p 5.76768700e-7 166.2p 3.44801400e-7 166.3p 1.036119100e-7 166.4p -1.305652400e-7 166.5p -3.43196000e-7 166.6p -5.21609750e-7 166.7p -6.55013650e-7 166.8p -7.34636750e-7 166.9p -7.54204200e-7 167p -7.10779350e-7 167.1p -6.05808650e-7 167.2p -4.46035200e-7 167.3p -2.43891100e-7 167.4p -1.70478700e-8
+ 167.5p 2.13004800e-7 167.6p 4.23217450e-7 167.7p 5.91717950e-7 167.8p 7.00536550e-7 167.9p 7.37832100e-7 168p 6.99270400e-7 168.1p 5.88410550e-7 168.2p 4.16149700e-7 168.3p 1.99416900e-7 168.4p -4.06437700e-8 168.5p -2.80776500e-7 168.6p -4.97826350e-7 168.7p -6.70912600e-7 168.8p -7.83409500e-7 168.9p -8.24566350e-7 169p -7.90572400e-7 169.1p -6.84902450e-7 169.2p -5.17858800e-7
+ 169.3p -3.05342000e-7 169.4p -6.70209650e-8 169.5p 1.758263650e-7 169.6p 4.02486000e-7 169.7p 5.94705850e-7 169.8p 7.38114550e-7 169.9p 8.23070750e-7 170p 8.44960700e-7 170.1p 8.04043100e-7 170.2p 7.04972600e-7 170.3p 5.56130350e-7 170.4p 3.68855050e-7 170.5p 1.56626850e-7 170.6p -6.578189400e-8 170.7p -2.83184450e-7 170.8p -4.80888300e-7 170.9p -6.45607350e-7 171p -7.66336250e-7
+ 171.1p -8.35114000e-7 171.2p -8.47606850e-7 171.3p -8.03437150e-7 171.4p -7.06215300e-7 171.5p -5.63258200e-7 171.6p -3.85018350e-7 171.7p -1.84275400e-7 171.8p 2.4827275500e-8 171.9p 2.27817550e-7 172p 4.10908500e-7 172.1p 5.61921100e-7 172.2p 6.71060400e-7 172.3p 7.31513400e-7 172.4p 7.39853200e-7 172.5p 6.96247100e-7 172.6p 6.04465250e-7 172.7p 4.71688300e-7 172.8p 3.08102150e-7
+ 172.9p 1.262712300e-7 173p -5.97082050e-8 173.1p -2.35255750e-7 173.2p -3.86497000e-7 173.3p -5.01501900e-7 173.4p -5.71439050e-7 173.5p -5.91499100e-7 173.6p -5.61441450e-7 173.7p -4.85664250e-7 173.8p -3.72757000e-7 173.9p -2.34578950e-7 174p -8.49800800e-8 174.1p 6.16641650e-8 174.2p 1.91916200e-7 174.3p 2.94563300e-7 174.4p 3.61601450e-7 174.5p 3.88839250e-7 174.6p 3.76101250e-7
+ 174.7p 3.27044400e-7 174.8p 2.48625000e-7 174.9p 1.50277000e-7 175p 4.28731850e-8 175.1p -6.242997450e-8 175.2p -1.553416650e-7 175.3p -2.27445600e-7 175.4p -2.72941350e-7 175.5p -2.89024800e-7 175.6p -2.75881400e-7 175.7p -2.36326100e-7 175.8p -1.75198200e-7 175.9p -9.86436250e-8 176p -1.34234300e-8 176.1p 7.36515650e-8 176.2p 1.561169000e-7 176.3p 2.28097250e-7 176.4p 2.84456050e-7
+ 176.5p 3.20924550e-7 176.6p 3.34272150e-7 176.7p 3.22534150e-7 176.8p 2.85277550e-7 176.9p 2.23838500e-7 177p 1.41458800e-7 177.1p 4.32500500e-8 177.2p -6.40515800e-8 177.3p -1.725404650e-7 177.4p -2.73763850e-7 177.5p -3.59444100e-7 177.6p -4.22217000e-7 177.7p -4.56306400e-7 177.8p -4.58067500e-7 177.9p -4.26352500e-7 178p -3.62666050e-7 178.1p -2.71104550e-7 178.2p -1.58077350e-7
+ 178.3p -3.18352650e-8 178.4p 9.81680750e-8 178.5p 2.22030750e-7 178.6p 3.30216700e-7 178.7p 4.14358200e-7 178.8p 4.67975400e-7 178.9p 4.87041350e-7 179p 4.70334300e-7 179.1p 4.19539850e-7 179.2p 3.39087550e-7 179.3p 2.35738450e-7 179.4p 1.179630000e-7 179.5p -4.82558900e-9 179.6p -1.231057650e-7 179.7p -2.28064400e-7 179.8p -3.12319050e-7 179.9p -3.70476550e-7 180p -3.99485950e-7
+ 180.1p -3.98764250e-7 180.2p -3.70098550e-7 180.3p -3.17350250e-7 180.4p -2.46005850e-7 180.5p -1.62623500e-7 180.6p -7.42321800e-8 180.7p 1.226418350e-8 180.8p 9.06286650e-8 180.9p 1.557402350e-7 181p 2.03917300e-7 181.1p 2.33094850e-7 181.2p 2.42848900e-7 181.3p 2.34274050e-7 181.4p 2.09739650e-7 181.5p 1.72561400e-7 181.6p 1.266359450e-7 181.7p 7.60855250e-8 181.8p 2.49506650e-8
+ 181.9p -2.30462100e-8 182p -6.46652450e-8 182.1p -9.72572550e-8 182.2p -1.188414400e-7 182.3p -1.281772750e-7 182.4p -1.248436400e-7 182.5p -1.093192450e-7 182.6p -8.30421350e-8 182.7p -4.84097000e-8 182.8p -8.68606000e-9 182.9p 3.22078550e-8 183p 7.00209300e-8 183.1p 1.005883300e-7 183.2p 1.202874950e-7 183.3p 1.264693400e-7 183.4p 1.178013800e-7 183.5p 9.44709450e-8 183.6p 5.82183600e-8
+ 183.7p 1.21968750e-8 183.8p -3.93236700e-8 183.9p -9.13728800e-8 184p -1.387696550e-7 184.1p -1.766353050e-7 184.2p -2.00879100e-7 184.3p -2.08610750e-7 184.4p -1.98438200e-7 184.5p -1.70621100e-7 184.6p -1.270621050e-7 184.7p -7.11340650e-8 184.8p -7.3601950e-9 184.9p 5.90169750e-8 185p 1.225316750e-7 185.1p 1.779990800e-7 185.2p 2.20974150e-7 185.3p 2.48117800e-7 185.4p 2.57440050e-7
+ 185.5p 2.48406500e-7 185.6p 2.21908800e-7 185.7p 1.80120900e-7 185.8p 1.262619300e-7 185.9p 6.43023100e-8 186p -1.36094250e-9 186.1p -6.62308850e-8 186.2p -1.260185350e-7 186.3p -1.76915350e-7 186.4p -2.15819450e-7 186.5p -2.40506250e-7 186.6p -2.49738150e-7 186.7p -2.43311000e-7 186.8p -2.22033250e-7 186.9p -1.87644900e-7 187p -1.426768500e-7 187.1p -9.02659900e-8 187.2p -3.39348450e-8
+ 187.3p 2.26448050e-8 187.4p 7.58899950e-8 187.5p 1.225299800e-7 187.6p 1.598021850e-7 187.7p 1.85611900e-7 187.8p 1.98649200e-7 187.9p 1.98458950e-7 188p 1.85464150e-7 188.1p 1.60937750e-7 188.2p 1.269245900e-7 188.3p 8.61106150e-8 188.4p 4.16426850e-8 188.5p -3.09771700e-9 188.6p -4.47530850e-8 188.7p -8.02636000e-8 188.8p -1.071308000e-7 188.9p -1.236429800e-7 189p -1.290341650e-7
+ 189.1p -1.235535950e-7 189.2p -1.084327050e-7 189.3p -8.57489150e-8 189.4p -5.82009000e-8 189.5p -2.88194100e-8 189.6p -6.4907350e-10 189.7p 2.35626900e-8 189.8p 4.16345750e-8 189.9p 5.21503250e-8 190p 5.45696950e-8 190.1p 4.92435850e-8 190.2p 3.73366350e-8 190.3p 2.06690600e-8 190.4p 1.49722550e-9 190.5p -1.774220750e-8 190.6p -3.46965750e-8 190.7p -4.73415900e-8 190.8p -5.41797400e-8
+ 190.9p -5.43725750e-8 191p -4.77954250e-8 191.1p -3.50132650e-8 191.2p -1.71867550e-8 191.3p 4.073768400e-9 191.4p 2.688384350e-8 191.5p 4.92667200e-8 191.6p 6.93212400e-8 191.7p 8.53620550e-8 191.8p 9.60257550e-8 191.9p 1.003427750e-7 192p 9.77794550e-8 192.1p 8.82562100e-8 192.2p 7.21465150e-8 192.3p 5.02591250e-8 192.4p 2.38024800e-8 192.5p -5.67054550e-9 192.6p -3.63408100e-8
+ 192.7p -6.62242400e-8 192.8p -9.32941800e-8 192.9p -1.156182950e-7 193p -1.315006700e-7 193.1p -1.396169750e-7 193.2p -1.391296250e-7 193.3p -1.297735550e-7 193.4p -1.119002000e-7 193.5p -8.64765500e-8 193.6p -5.50366400e-8 193.7p -1.95863450e-8 193.8p 1.753178050e-8 193.9p 5.38052650e-8 194p 8.67377900e-8 194.1p 1.140404800e-7 194.2p 1.338127350e-7 194.3p 1.446965800e-7 194.4p 1.459898250e-7
+ 194.5p 1.377069050e-7 194.6p 1.205798300e-7 194.7p 9.59960500e-8 194.8p 6.58810150e-8 194.9p 3.25322700e-8 195p -1.576543400e-9 195.1p -3.40040650e-8 195.2p -6.25411450e-8 195.3p -8.53832850e-8 195.4p -1.012598750e-7 195.5p -1.095096250e-7 195.6p -1.100977950e-7 195.7p -1.035770150e-7 195.8p -9.09994000e-8 195.9p -7.37914350e-8 196p -5.36064150e-8 196.1p -3.21694950e-8 196.2p -1.113016900e-8
+ 196.3p 8.06525350e-9 196.4p 2.42715800e-8 196.5p 3.67068250e-8 196.6p 4.49762450e-8 196.7p 4.90600000e-8 196.8p 4.92693350e-8 196.9p 4.61792300e-8 197p 4.05471100e-8 197.1p 3.32273700e-8 197.2p 2.50909800e-8 197.3p 1.69567150e-8 197.4p 9.53766100e-9 197.5p 3.4040841150e-9 197.6p -1.03953600e-9 197.7p -3.56607000e-9 197.8p -4.12917100e-9 197.9p -2.86042550e-9 198p -6.036700e-11
+ 198.1p 3.818314900e-9 198.2p 8.19792450e-9 198.3p 1.241558650e-8 198.4p 1.577638350e-8 198.5p 1.76178750e-8 198.6p 1.73809450e-8 198.7p 1.46795900e-8 198.8p 9.36049050e-9 198.9p 1.54355300e-9 199p -8.36383150e-9 199.1p -1.968301900e-8 199.2p -3.15113050e-8 199.3p -4.27966800e-8 199.4p -5.24332100e-8 199.5p -5.93677300e-8 199.6p -6.27068000e-8 199.7p -6.18131450e-8 199.8p -5.63810300e-8
+ 199.9p -4.64825100e-8 200p -2.882568e-8 200.1p -2.882568e-8 200.2p -2.882568e-8 200.3p -2.882568e-8 200.4p -2.882568e-8 200.5p -2.882568e-8 200.6p -2.882568e-8 200.7p -2.882568e-8 200.8p -2.882568e-8 200.9p -2.882568e-8 201p -2.882568e-8 201.1p -2.882568e-8 201.2p -2.882568e-8 201.3p -2.882568e-8 201.4p -2.882568e-8 201.5p -2.882568e-8 201.6p -2.882568e-8
+ 201.7p -2.882568e-8 201.8p -2.882568e-8 201.9p -2.882568e-8 202p -2.882568e-8 202.1p -2.882568e-8 202.2p -2.882568e-8 202.3p -2.882568e-8 202.4p -2.882568e-8 202.5p -2.882568e-8 202.6p -2.882568e-8 202.7p -2.882568e-8 202.8p -2.882568e-8 202.9p -2.882568e-8 203p -2.882568e-8 203.1p -2.882568e-8 203.2p -2.882568e-8 203.3p -2.882568e-8 203.4p -2.882568e-8
+ 203.5p -2.882568e-8 203.6p -2.882568e-8 203.7p -2.882568e-8 203.8p -2.882568e-8 203.9p -2.882568e-8 204p -2.882568e-8 204.1p -2.882568e-8 204.2p -2.882568e-8 204.3p -2.882568e-8 204.4p -2.882568e-8 204.5p -2.882568e-8 204.6p -2.882568e-8 204.7p -2.882568e-8 204.8p -2.882568e-8 204.9p -2.882568e-8 205p -2.882568e-8 205.1p -2.882568e-8 205.2p -2.882568e-8
+ 205.3p -2.882568e-8 205.4p -2.882568e-8 205.5p -2.882568e-8 205.6p -2.882568e-8 205.7p -2.882568e-8 205.8p -2.882568e-8 205.9p -2.882568e-8)

.tran 0.1p 206p

.print V(QBIN) V(QBOUT)
.print I(I_REPLAY)
.print I(LIN|XBQ1) V(LIN|XBQ1) I(L1|XBQ1) V(L1|XBQ1) I(L2|XBQ1) V(L2|XBQ1) I(L3|XBQ1) V(L3|XBQ1)
.print I(RJ1|XBQ1) V(RJ1|XBQ1) I(RJ2|XBQ1) V(RJ2|XBQ1) I(IB|XBQ1) V(IB|XBQ1)
.print P(BJS|XBQ1) V(BJS|XBQ1) I(BJS|XBQ1)
.print P(BJ1|XBQ1) V(BJ1|XBQ1) I(BJ1|XBQ1)
.print P(BJ2|XBQ1) V(BJ2|XBQ1) I(BJ2|XBQ1)
.print P(B01|XJTL1_1) V(B01|XJTL1_1) I(B01|XJTL1_1) P(B02|XJTL1_1) V(B02|XJTL1_1) I(B02|XJTL1_1)
.print V(JTL1_OUT)
.print P(B01|XJTL1_2) V(B01|XJTL1_2) I(B01|XJTL1_2) P(B02|XJTL1_2) V(B02|XJTL1_2) I(B02|XJTL1_2)
.print V(JTL2_OUT)
.print P(B01|XJTL1_3) V(B01|XJTL1_3) I(B01|XJTL1_3) P(B02|XJTL1_3) V(B02|XJTL1_3) I(B02|XJTL1_3)
.print V(JTL3_OUT)
.print P(B01|XJTL1_4) V(B01|XJTL1_4) I(B01|XJTL1_4) P(B02|XJTL1_4) V(B02|XJTL1_4) I(B02|XJTL1_4)
.print V(JTL4_OUT)
.print P(B01|XJTL1_5) V(B01|XJTL1_5) I(B01|XJTL1_5) P(B02|XJTL1_5) V(B02|XJTL1_5) I(B02|XJTL1_5)
.print V(JTL5_OUT)
.print P(B01|XJTL1_6) V(B01|XJTL1_6) I(B01|XJTL1_6) P(B02|XJTL1_6) V(B02|XJTL1_6) I(B02|XJTL1_6)
.print V(JTL6_OUT)
.print I(R_TERM)
.end
