* R15-A logical0 + canonical READ.
.include jjmit.cir
.include bvm_cell.cir
.include DCSFQ_BVM.cir
.include afq3.cir

XBVM1 WL1 BL1 SE1 SL1 BVM
XAFQ  SL1 DCS_A AFQ3
XDCS  DCS_A DCS_Q THmitll_DCSFQ_BVM
R_DCS_LOAD DCS_Q 0 10.0

I_WL1 0 WL1 pwl(0p 0 10p 0 11p -100U 20p -100U 21p 0 95p 0 96p +100U 105p +100U 106p 0 170p 0)
I_BL1 0 BL1 pwl(0p 0 10p 0 11p -100U 20p -100U 21p 0 170p 0)
I_SE1 0 SE1 pwl(0p 0 95p 0 96p +100U 105p +100U 106p 0 170p 0)

.tran 0.0125p 170p
.print P(B_DET|XAFQ) V(B_DET|XAFQ) I(B_DET|XAFQ)
.print P(B_SET|XAFQ) V(B_SET|XAFQ) I(B_SET|XAFQ)
.print P(B_Q|XAFQ) V(B_Q|XAFQ) I(B_Q|XAFQ)
.print P(B_OUT|XAFQ) V(B_OUT|XAFQ) I(B_OUT|XAFQ)
.print I(L_TX|XAFQ) I(L_S|XAFQ) I(L_Q|XAFQ) I(L_F|XAFQ) I(L_CTL|XAFQ) I(L_INJ|XAFQ)
.print I(R_IN|XAFQ) I(R_Q|XAFQ) I(R_F|XAFQ) I(R_SRC|XAFQ) I(I_DET|XAFQ) I(I_SET|XAFQ) I(I_OUT|XAFQ)
.print P(B1|XDCS) V(B1|XDCS) I(B1|XDCS) P(B2|XDCS) V(B2|XDCS) I(B2|XDCS) P(B3|XDCS) V(B3|XDCS) I(B3|XDCS)
.print V(DCS_A) I(L1|XDCS) V(DCS_Q) I(R_DCS_LOAD)
.print V(SL1) V(N6|XBVM1) I(L_SL|XBVM1) I(L_PSL|XBVM1)
.print P(B_JM1|XBVM1) V(B_JM1|XBVM1) P(B_JM2|XBVM1) V(B_JM2|XBVM1)
.print P(B_JS1|XBVM1) V(B_JS1|XBVM1) P(B_JS2|XBVM1) V(B_JS2|XBVM1)
.print I(L_S1|XBVM1) I(L_S2|XBVM1) I(L_S3|XBVM1) I(L_M3|XBVM1)
.print I(I_WL1) I(I_BL1) I(I_SE1)
.end
