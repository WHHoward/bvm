* GENERATED PAPERLIKE COMMON-SL DECK: mask=0010
* source_class=HISTORICAL_BVMSIM_JM2_CONNECTED_VARIANT
* all four BVMs are initialized to stored-1111; only final READ WL+SE follows mask
* topology change: each internal BVM RSL/LSL terminates directly on COMMON_SL
* exactly one shared twelve-junction 500-uA load; no QB/JTL/termination
* final READ active BVMs: BVM3

.include ../../../../../circuits/models/jjmit.cir
.include ../../../bvmsim-jm2-connected-single-ab-v1-20260903/variants/bvm_jm2_connected.cir

XBVM1 WL1 BL1 SE1 COMMON_SL BVM
XBVM2 WL2 BL2 SE2 COMMON_SL BVM
XBVM3 WL3 BL3 SE3 COMMON_SL BVM
XBVM4 WL4 BL4 SE4 COMMON_SL BVM

* One common column load; jjmit base Ic=100uA and area=5.0 => Ic=500uA.
B_COL_LOAD01 COMMON_SL COL01 jjmit area=5.0
B_COL_LOAD02 COL01 COL02 jjmit area=5.0
B_COL_LOAD03 COL02 COL03 jjmit area=5.0
B_COL_LOAD04 COL03 COL04 jjmit area=5.0
B_COL_LOAD05 COL04 COL05 jjmit area=5.0
B_COL_LOAD06 COL05 COL06 jjmit area=5.0
B_COL_LOAD07 COL06 COL07 jjmit area=5.0
B_COL_LOAD08 COL07 COL08 jjmit area=5.0
B_COL_LOAD09 COL08 COL09 jjmit area=5.0
B_COL_LOAD10 COL09 COL10 jjmit area=5.0
B_COL_LOAD11 COL10 COL11 jjmit area=5.0
B_COL_LOAD12 COL11 0 jjmit area=5.0

I_WL1 0 WL1 pwl(0 0 50p 0 51p -100u 60p -100u 61p 0 70p 0 81p 0 90p 0 91p 100u 100p 100u 101p 0 110p 0 111p 0 120p 0 121p 0 200p 0)
I_BL1 0 BL1 pwl(0 0 50p 0 51p -100u 60p -100u 61p 0 70p 0 90p 0 91p 100u 100p 100u 101p 0 110p 0 111p 0 120p 0 121p 0 200p 0)
I_SE1 0 SE1 pwl(0 0 50p 0 70p 0 90p 0 110p 0 111p 0 120p 0 121p 0 200p 0)
I_WL2 0 WL2 pwl(0 0 50p 0 51p -100u 60p -100u 61p 0 70p 0 81p 0 90p 0 91p 100u 100p 100u 101p 0 110p 0 111p 0 120p 0 121p 0 200p 0)
I_BL2 0 BL2 pwl(0 0 50p 0 51p -100u 60p -100u 61p 0 70p 0 90p 0 91p 100u 100p 100u 101p 0 110p 0 111p 0 120p 0 121p 0 200p 0)
I_SE2 0 SE2 pwl(0 0 50p 0 70p 0 90p 0 110p 0 111p 0 120p 0 121p 0 200p 0)
I_WL3 0 WL3 pwl(0 0 50p 0 51p -100u 60p -100u 61p 0 70p 0 81p 0 90p 0 91p 100u 100p 100u 101p 0 110p 0 111p 100u 120p 100u 121p 0 200p 0)
I_BL3 0 BL3 pwl(0 0 50p 0 51p -100u 60p -100u 61p 0 70p 0 90p 0 91p 100u 100p 100u 101p 0 110p 0 111p 0 120p 0 121p 0 200p 0)
I_SE3 0 SE3 pwl(0 0 50p 0 70p 0 90p 0 110p 0 111p 100u 120p 100u 121p 0 200p 0)
I_WL4 0 WL4 pwl(0 0 50p 0 51p -100u 60p -100u 61p 0 70p 0 81p 0 90p 0 91p 100u 100p 100u 101p 0 110p 0 111p 0 120p 0 121p 0 200p 0)
I_BL4 0 BL4 pwl(0 0 50p 0 51p -100u 60p -100u 61p 0 70p 0 90p 0 91p 100u 100p 100u 101p 0 110p 0 111p 0 120p 0 121p 0 200p 0)
I_SE4 0 SE4 pwl(0 0 50p 0 70p 0 90p 0 110p 0 111p 0 120p 0 121p 0 200p 0)

.tran 0.1p 200p 45p

* Controls and complete per-BVM branch schema
.print I(I_WL1) I(I_BL1) I(I_SE1) I(I_WL2) I(I_BL2) I(I_SE2) I(I_WL3) I(I_BL3) I(I_SE3) I(I_WL4)
.print I(I_BL4) I(I_SE4) P(B_JM1|XBVM1) V(B_JM1|XBVM1) I(B_JM1|XBVM1) P(B_JM2|XBVM1) V(B_JM2|XBVM1) I(B_JM2|XBVM1) P(B_JS1|XBVM1) V(B_JS1|XBVM1)
.print I(B_JS1|XBVM1) P(B_JS2|XBVM1) V(B_JS2|XBVM1) I(B_JS2|XBVM1) I(L_M1|XBVM1) I(L_M2|XBVM1) I(L_M3|XBVM1) I(L_PM|XBVM1) I(R_JM1|XBVM1) I(L_S1|XBVM1)
.print I(L_S2|XBVM1) I(R_S|XBVM1) I(L_S3|XBVM1) I(R_SE|XBVM1) I(L_PSE|XBVM1) I(L_PSL|XBVM1) I(R_SL|XBVM1) I(L_SL|XBVM1) V(R_JM1|XBVM1) V(L_S1|XBVM1)
.print V(L_S2|XBVM1) V(R_S|XBVM1) V(L_S3|XBVM1) V(R_SE|XBVM1) V(L_PSE|XBVM1) V(L_PSL|XBVM1) V(R_SL|XBVM1) V(L_SL|XBVM1) P(B_JM1|XBVM2) V(B_JM1|XBVM2)
.print I(B_JM1|XBVM2) P(B_JM2|XBVM2) V(B_JM2|XBVM2) I(B_JM2|XBVM2) P(B_JS1|XBVM2) V(B_JS1|XBVM2) I(B_JS1|XBVM2) P(B_JS2|XBVM2) V(B_JS2|XBVM2) I(B_JS2|XBVM2)
.print I(L_M1|XBVM2) I(L_M2|XBVM2) I(L_M3|XBVM2) I(L_PM|XBVM2) I(R_JM1|XBVM2) I(L_S1|XBVM2) I(L_S2|XBVM2) I(R_S|XBVM2) I(L_S3|XBVM2) I(R_SE|XBVM2)
.print I(L_PSE|XBVM2) I(L_PSL|XBVM2) I(R_SL|XBVM2) I(L_SL|XBVM2) V(R_JM1|XBVM2) V(L_S1|XBVM2) V(L_S2|XBVM2) V(R_S|XBVM2) V(L_S3|XBVM2) V(R_SE|XBVM2)
.print V(L_PSE|XBVM2) V(L_PSL|XBVM2) V(R_SL|XBVM2) V(L_SL|XBVM2) P(B_JM1|XBVM3) V(B_JM1|XBVM3) I(B_JM1|XBVM3) P(B_JM2|XBVM3) V(B_JM2|XBVM3) I(B_JM2|XBVM3)
.print P(B_JS1|XBVM3) V(B_JS1|XBVM3) I(B_JS1|XBVM3) P(B_JS2|XBVM3) V(B_JS2|XBVM3) I(B_JS2|XBVM3) I(L_M1|XBVM3) I(L_M2|XBVM3) I(L_M3|XBVM3) I(L_PM|XBVM3)
.print I(R_JM1|XBVM3) I(L_S1|XBVM3) I(L_S2|XBVM3) I(R_S|XBVM3) I(L_S3|XBVM3) I(R_SE|XBVM3) I(L_PSE|XBVM3) I(L_PSL|XBVM3) I(R_SL|XBVM3) I(L_SL|XBVM3)
.print V(R_JM1|XBVM3) V(L_S1|XBVM3) V(L_S2|XBVM3) V(R_S|XBVM3) V(L_S3|XBVM3) V(R_SE|XBVM3) V(L_PSE|XBVM3) V(L_PSL|XBVM3) V(R_SL|XBVM3) V(L_SL|XBVM3)
.print P(B_JM1|XBVM4) V(B_JM1|XBVM4) I(B_JM1|XBVM4) P(B_JM2|XBVM4) V(B_JM2|XBVM4) I(B_JM2|XBVM4) P(B_JS1|XBVM4) V(B_JS1|XBVM4) I(B_JS1|XBVM4) P(B_JS2|XBVM4)
.print V(B_JS2|XBVM4) I(B_JS2|XBVM4) I(L_M1|XBVM4) I(L_M2|XBVM4) I(L_M3|XBVM4) I(L_PM|XBVM4) I(R_JM1|XBVM4) I(L_S1|XBVM4) I(L_S2|XBVM4) I(R_S|XBVM4)
.print I(L_S3|XBVM4) I(R_SE|XBVM4) I(L_PSE|XBVM4) I(L_PSL|XBVM4) I(R_SL|XBVM4) I(L_SL|XBVM4) V(R_JM1|XBVM4) V(L_S1|XBVM4) V(L_S2|XBVM4) V(R_S|XBVM4)
.print V(L_S3|XBVM4) V(R_SE|XBVM4) V(L_PSE|XBVM4) V(L_PSL|XBVM4) V(R_SL|XBVM4) V(L_SL|XBVM4) V(COMMON_SL) P(B_COL_LOAD01) V(B_COL_LOAD01) I(B_COL_LOAD01)
.print P(B_COL_LOAD02) V(B_COL_LOAD02) I(B_COL_LOAD02) P(B_COL_LOAD03) V(B_COL_LOAD03) I(B_COL_LOAD03) P(B_COL_LOAD04) V(B_COL_LOAD04) I(B_COL_LOAD04) P(B_COL_LOAD05)
.print V(B_COL_LOAD05) I(B_COL_LOAD05) P(B_COL_LOAD06) V(B_COL_LOAD06) I(B_COL_LOAD06) P(B_COL_LOAD07) V(B_COL_LOAD07) I(B_COL_LOAD07) P(B_COL_LOAD08) V(B_COL_LOAD08)
.print I(B_COL_LOAD08) P(B_COL_LOAD09) V(B_COL_LOAD09) I(B_COL_LOAD09) P(B_COL_LOAD10) V(B_COL_LOAD10) I(B_COL_LOAD10) P(B_COL_LOAD11) V(B_COL_LOAD11) I(B_COL_LOAD11)
.print P(B_COL_LOAD12) V(B_COL_LOAD12) I(B_COL_LOAD12)
.end
