* S2 init_negative_control R_LD=1ohm at 0.0125ps -- BVM-S2 load characterization (frozen)
* Closure: copied jjmit + bvm_cell; XBVM1 WL1 BL1 SE1 SL1 BVM; only variable is R_LD SL1 0 1
* Init: WL/BL ramp to -100U over 10-20 ps, return to 0 by 21 ps.
* Read: WL+SE +100 uA 96-105 ps (matched zero-read control: knots identical, amplitudes 0)
.include jjmit.cir
.include bvm_cell.cir

XBVM1 WL1 BL1 SE1 SL1 BVM

R_LD SL1 0 1

I_WL1 0 WL1 pwl(0p 0 9p 0 10p -100U 20p -100U 21p 0 95p 0 96p 0 105p 0 106p 0 170p 0)
I_BL1 0 BL1 pwl(0p 0 9p 0 10p -100U 20p -100U 21p 0 170p 0)
I_SE1 0 SE1 pwl(0p 0 95p 0 96p 0 105p 0 106p 0 170p 0)

.tran 0.0125p 170p

* Direct probes (preregistration.yaml):
*   V(SL1) SL1->0; I(L_SL|XBVM1) N8->SL1
*   I(I_WL1) 0->WL1; I(I_BL1) 0->BL1; I(I_SE1) 0->SE1
*   P/V(B_JM1|XBVM1) N1->n_jm1o vts=+1 rd=+1
*   P/V(B_JM2|XBVM1) n_jm2i->N2 vts=+1 rd=+1
*   P/V(B_JS1|XBVM1) n_js1p->N3 vts=+1 rd=+1
*   P/V(B_JS2|XBVM1) n_js2p->N6 vts=+1 rd=+1
.print P(B_JM1|XBVM1) V(B_JM1|XBVM1)
.print P(B_JM2|XBVM1) V(B_JM2|XBVM1)
.print P(B_JS1|XBVM1) V(B_JS1|XBVM1)
.print P(B_JS2|XBVM1) V(B_JS2|XBVM1)
.print V(SL1) I(L_SL|XBVM1)
.print I(I_WL1) I(I_BL1) I(I_SE1)
.end
