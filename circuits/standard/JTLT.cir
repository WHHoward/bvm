* JTLT — ColdFlux RSFQ Standard Cell
* Source: IARPA SuperTools/ColdFlux Cell Library v3.0
* MIT-LL SFQ Process | JoSIM-compatible
* Ports: a q
* Junctions: 3 total
*   B1: area=1.6, IC=160uA
*   B2: area=0.81, IC=81uA
*   B3: area=2.5, IC=250uA
*
* Bias: 2.6mV DC bias line (resistors calculated per ColdFlux methodology)
* Usage: .include circuits/standard/JTLT.cir
*        .model jjmit jj(rtype=1, vg=2.8m, cap=0.07p, r0=160, rn=16, icrit=0.1m)
*
.subckt THmitll_JTLT a q
.param Phi0=2.067833848E-15
.param B0=1
.param Ic0=0.0001
.param IcRs=100u*6.859904418
.param B0Rs=IcRs/Ic0*B0
.param Rsheet=2
.param Lsheet=1.13e-12
.param LP=0.5p
.param IC=2.5
.param ICreceive=1.6
.param ICtrans=2.5
.param LB=2p
.param BiasCoef=0.7
.param Lptl=2p
.param RD=1.36
.param B1=1.6
.param B2=0.81
.param B3=2.5
.param IB1=112u
.param IB2=239u
.param LB1=LB
.param LB2=LB
.param L1=Lptl
.param L2=8.2192p
.param L3=1.4265p
.param L4=2.2384p
.param L5=Lptl
.param LP1=LP
.param LP2=LP
.param LP3=LP
.param RB1=B0Rs/B1
.param RB2=B0Rs/B2
.param RB3=B0Rs/B3
.param LRB1=(RB1/Rsheet)*Lsheet+LP
.param LRB2=(RB2/Rsheet)*Lsheet+LP
.param LRB3=(RB3/Rsheet)*Lsheet+LP
B1 1 2 jjmit area=B1
B2 4 5 jjmit area=B2
B3 8 9 jjmit area=B3
IB1 0 3 pwl(0 0 5p IB1)
IB2 0 7 pwl(0 0 5p IB2)
LB1 3 1 3.202E-012
LB2 7 6 2.142E-013
L1 a 1 1.986E-012
L2 1 4 8.188E-012
L3 4 6 1.431E-012
L4 6 8 2.254E-012
L5 8 10 7.542E-013
RD 10 q RD
LP1 2 0 4.596E-013
LP2 5 0 4.684E-013
LP3 9 0 4.113E-013
RB1 1 101 RB1
LRB1 101 0 LRB1
RB2 4 104 RB2
LRB2 104 0 LRB2
RB3 8 108 RB3
LRB3 108 0 LRB3
.ends
