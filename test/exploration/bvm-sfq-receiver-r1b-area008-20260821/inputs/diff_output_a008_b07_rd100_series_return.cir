* R1b AREA=.08 activation point: same accepted differential topology as
* e3a18da0, with only B_OUT AREA changed from .10 to .08.
* L_SEC -> series R_SEC_LOAD return; B_OUT is N_SEC -> ground.
.subckt SERIES_PICKUP_DIFF_SERIES_RETURN_A008 IN

* Canonical SL -> R_IN -> L_TX -> B_TRIG front end, unchanged.
R_IN          IN          N_PICK      12.0
L_TX          N_PICK      N_TRIG       0.20p
B_TRIG        N_TRIG      0            jjmit area=0.50
I_TRIG_BIAS   0           N_TRIG       pwl(0p 0 2p 15U 80p 15U 140p 15U 170p 15U)

* Accepted R1a pickup values and differential secondary return, unchanged.
L_SEC         N_SEC       N_SEC_RTN     2.0p
R_SEC_LOAD    N_SEC_RTN   0            12.0
K_TX          L_TX        L_SEC        0.80

* Only independent variable in this Exploration: B_OUT AREA=.08.
* For N_SEC currents positive toward ground:
*   i_LSEC + i_BOUT + i_RDAMP - I_BIAS = 0
*   i_BOUT = I_BIAS - i_LSEC - i_RDAMP
* V(B_OUT)=V(N_SEC)-V(0), so the transformer transient is differential.
B_OUT         N_SEC       0             jjmit area=0.08
I_OUT_BIAS    0           N_SEC         pwl(0p 0 2p 7U 80p 7U 140p 7U 170p 7U)
R_OUT_DAMP    N_SEC       0            100.0

.ends SERIES_PICKUP_DIFF_SERIES_RETURN_A008
