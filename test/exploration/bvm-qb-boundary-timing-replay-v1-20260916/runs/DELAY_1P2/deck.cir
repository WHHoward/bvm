* BVM -> QB boundary timing replay; case=DELAY_1P2; exact stored-index shift.
* Causal replay / ideal voltage forcing; not a circuit-equivalent reconstruction.
* P(...) is raw phase in radians; rad/(2*pi) is navigation only.
.include ../../../../../circuits/models/jjmit.cir
.include ../../../bvm-population-scaling-rj2p12-l1p14-l2p20-ib260-rj32-bjs400-v1-20260910/inputs/bvm_jm2_connected.cir

XBVM1 WL1 BL1 SE1 COMMON_SL BVM
XBVM2 WL2 BL2 SE2 COMMON_SL BVM
XBVM3 WL3 BL3 SE3 COMMON_SL BVM
XBVM4 WL4 BL4 SE4 COMMON_SL BVM

B_JSL1 COMMON_SL JSL_NODE1 jjmit area=5.0
B_JSL2 JSL_NODE1 JSL_NODE2 jjmit area=5.0
B_JSL3 JSL_NODE2 JSL_NODE3 jjmit area=5.0
B_JSL4 JSL_NODE3 JSL_NODE4 jjmit area=5.0
B_JSL5 JSL_NODE4 JSL_NODE5 jjmit area=5.0
B_JSL6 JSL_NODE5 JSL_NODE6 jjmit area=5.0
B_JSL7 JSL_NODE6 JSL_NODE7 jjmit area=5.0
B_JSL8 JSL_NODE7 QBIN jjmit area=5.0
V_REPLAY QBIN 0 PWL(0 0.000000e+00 0.10000000000000001p 5.083294e-06 0.20000000000000001p 1.821272e-05 0.29999999999999999p 4.128495e-05 0.40000000000000002p 7.496149e-05 0.5p 1.184456e-04 0.59999999999999998p 1.694899e-04 0.70000000000000007p 2.247009e-04 0.80000000000000004p 2.800844e-04 0.90000000000000002p 3.317101e-04 1p 3.763520e-04 1.0999999999999999p 4.068970e-04 1.2p 4.196784e-04 1.2999999999999998p 4.133633e-04 1.4000000000000001p 3.887667e-04 1.5p 3.485934e-04 1.6000000000000001p 2.969432e-04 1.7p 2.386235e-04 1.8p 1.784028e-04 1.8999999999999999p 1.203505e-04 2p 6.738282e-05 2.1000000000000001p 2.108315e-05 2.1999999999999997p -1.820253e-05 2.2999999999999998p -5.104752e-05 2.3999999999999999p -7.849969e-05 2.5p -1.016213e-04 2.5999999999999996p -1.211168e-04 2.6999999999999997p -1.371208e-04 2.8000000000000003p -1.491776e-04 2.9000000000000004p -1.563968e-04 3p -1.577294e-04 3.1000000000000001p -1.522910e-04 3.2000000000000002p -1.396501e-04 3.3000000000000003p -1.200180e-04 3.3999999999999999p -9.430424e-05 3.5p -6.403337e-05 3.6000000000000001p -3.115102e-05 3.7000000000000002p 2.234457e-06 3.7999999999999998p 3.411904e-05 3.8999999999999999p 6.282844e-05 4p 8.716632e-05 4.0999999999999996p 1.064697e-04 4.2000000000000002p 1.205765e-04 4.2999999999999998p 1.297259e-04 4.3999999999999995p 1.344230e-04 4.5p 1.352978e-04 4.5999999999999996p 1.329875e-04 4.7000000000000002p 1.280575e-04 4.7999999999999998p 1.209671e-04 4.8999999999999995p 1.120754e-04 5p 1.016743e-04 5.0999999999999996p 9.003371e-05 5.1999999999999993p 7.744189e-05 5.2999999999999998p 6.423165e-05 5.3999999999999995p 5.078514e-05 5.5p 3.751830e-05 5.6000000000000005p 2.485027e-05 5.7000000000000002p 1.316599e-05 5.8000000000000007p 2.781191e-06 5.9000000000000004p -6.082790e-06 6p -1.331001e-05 6.1000000000000005p -1.888574e-05 6.2000000000000002p -2.287967e-05 6.2999999999999998p -2.542120e-05 6.4000000000000004p -2.667254e-05 6.5p -2.680485e-05 6.6000000000000005p -2.598108e-05 6.7000000000000002p -2.434715e-05 6.7999999999999998p -2.203079e-05 6.9000000000000004p -1.914601e-05 7p -1.579992e-05 7.0999999999999996p -1.209915e-05 7.2000000000000002p -8.153269e-06 7.2999999999999998p -4.074399e-06 7.4000000000000004p 2.688223e-08 7.5p 4.048000e-06 7.5999999999999996p 7.901283e-06 7.7000000000000002p 1.151935e-05 7.7999999999999998p 1.485749e-05 7.8999999999999995p 1.789230e-05 8p 2.061694e-05 8.0999999999999996p 2.303378e-05 8.1999999999999993p 2.514639e-05 8.2999999999999989p 2.695217e-05 8.4000000000000004p 2.843746e-05 8.5p 2.957579e-05 8.5999999999999996p 3.032970e-05 8.6999999999999993p 3.065563e-05 8.7999999999999989p 3.051090e-05 8.9000000000000004p 2.986157e-05 9p 2.868968e-05 9.0999999999999996p 2.699892e-05 9.1999999999999993p 2.481794e-05 9.2999999999999989p 2.220086e-05 9.4000000000000004p 1.922527e-05 9.5p 1.598816e-05 9.5999999999999996p 1.260033e-05 9.6999999999999993p 9.180143e-06 9.7999999999999989p 5.847160e-06 9.8999999999999986p 2.716139e-06 10p -1.082634e-07 10.1p -2.536000e-06 10.199999999999999p -4.495306e-06 10.299999999999999p -5.935551e-06 10.399999999999999p -6.829262e-06 10.5p -7.173255e-06 10.6p -6.988743e-06 10.699999999999999p -6.320292e-06 10.799999999999999p -5.233483e-06 10.899999999999999p -3.811259e-06 11p -2.149048e-06 11.100000000000001p -3.489072e-07 11.200000000000001p 1.486896e-06 11.300000000000001p 3.262355e-06 11.4p 4.893675e-06 11.5p 6.314159e-06 11.600000000000001p 7.477588e-06 11.700000000000001p 8.359792e-06 11.800000000000001p 8.958342e-06 11.9p 9.290451e-06 12p 9.389396e-06 12.100000000000001p 9.299878e-06 12.200000000000001p 9.072832e-06 12.300000000000001p 8.760208e-06 12.4p 8.410188e-06 12.5p 8.063241e-06 12.6p 7.749273e-06 12.700000000000001p 7.486010e-06 12.800000000000001p 7.278649e-06 12.9p 7.120668e-06 13p 6.995652e-06 13.1p 6.879884e-06 13.200000000000001p 6.745457e-06 13.300000000000001p 6.563618e-06 13.4p 6.308074e-06 13.5p 5.958004e-06 13.6p 5.500529e-06 13.700000000000001p 4.932479e-06 13.800000000000001p 4.261290e-06 13.9p 3.504979e-06 14p 2.691178e-06 14.1p 1.855309e-06 14.199999999999999p 1.038026e-06 14.300000000000001p 2.821425e-07 14.4p -3.707114e-07 14.5p -8.834252e-07 14.6p -1.226450e-06 14.700000000000001p -1.380289e-06 14.900000000000002p -1.102117e-06 15p -6.922389e-07 15.100000000000001p -1.360987e-07 15.199999999999999p 5.285867e-07 15.300000000000001p 1.257644e-06 15.4p 2.003671e-06 15.500000000000002p 2.719484e-06 15.6p 3.361496e-06 15.700000000000001p 3.892754e-06 15.799999999999999p 4.285411e-06 15.900000000000002p 4.522432e-06 16p 4.598430e-06 16.100000000000001p 4.519575e-06 16.199999999999999p 4.302625e-06 16.300000000000001p 3.973175e-06 16.399999999999999p 3.563283e-06 16.5p 3.108702e-06 16.599999999999998p 2.645923e-06 16.700000000000003p 2.209295e-06 16.800000000000001p 1.828428e-06 16.900000000000002p 1.526093e-06 17p 1.316738e-06 17.100000000000001p 1.205757e-06 17.199999999999999p 1.189498e-06 17.300000000000001p 1.256030e-06 17.399999999999999p 1.386544e-06 17.5p 1.557283e-06 17.599999999999998p 1.741818e-06 17.699999999999999p 1.913478e-06 17.800000000000001p 2.047716e-06 17.900000000000002p 2.124250e-06 18p 2.128763e-06 18.100000000000001p 2.054068e-06 18.199999999999999p 1.900631e-06 18.300000000000001p 1.676417e-06 18.399999999999999p 1.396112e-06 18.5p 1.079763e-06 18.599999999999998p 7.509936e-07 18.699999999999999p 4.349332e-07 18.800000000000001p 1.560479e-07 18.900000000000002p -6.394278e-08 19p -2.078931e-07 19.100000000000001p -2.646522e-07 19.199999999999999p -2.299685e-07 19.300000000000001p -1.068108e-07 19.399999999999999p 9.491168e-08 19.5p 3.591960e-07 19.599999999999998p 6.652817e-07 19.699999999999999p 9.893581e-07 19.799999999999997p 1.306497e-06 19.900000000000002p 1.592649e-06 20p 1.826538e-06 20.100000000000001p 1.991298e-06 20.199999999999999p 2.075732e-06 20.300000000000001p 2.075084e-06 20.399999999999999p 1.991280e-06 20.5p 1.832620e-06 20.599999999999998p 1.612969e-06 20.699999999999999p 1.350510e-06 20.799999999999997p 1.066182e-06 20.899999999999999p 7.819279e-07 21p 5.189114e-07 21.100000000000001p 2.958329e-07 21.199999999999999p 1.274934e-07 21.300000000000001p 2.370915e-08 21.399999999999999p -1.134011e-08 21.5p 2.071173e-08 21.599999999999998p 1.127191e-07 21.699999999999999p 2.527698e-07 21.799999999999997p 4.253018e-07 21.899999999999999p 6.124942e-07 22p 7.958102e-07 22.100000000000001p 9.575646e-07 22.200000000000003p 1.082386e-06 22.300000000000001p 1.158454e-06 22.400000000000002p 1.178417e-06 22.5p 1.139918e-06 22.600000000000001p 1.045696e-06 22.699999999999999p 9.032607e-07 22.800000000000001p 7.241733e-07 22.899999999999999p 5.230103e-07 23p 3.160917e-07 23.100000000000001p 1.200901e-07 23.200000000000003p -4.936478e-08 23.300000000000001p -1.789690e-07 23.400000000000002p -2.588125e-07 23.5p -2.831487e-07 23.600000000000001p -2.508072e-07 23.699999999999999p -1.652245e-07 23.800000000000001p -3.409564e-08 23.899999999999999p 1.313160e-07 24p 3.171480e-07 24.099999999999998p 5.081037e-07 24.200000000000003p 6.887121e-07 24.300000000000001p 8.445792e-07 24.400000000000002p 9.635284e-07 24.5p 1.036539e-06 24.600000000000001p 1.058408e-06 24.699999999999999p 1.028094e-06 24.800000000000001p 9.487084e-07 24.899999999999999p 8.271761e-07 25p 6.735914e-07 25.099999999999998p 5.003320e-07 25.199999999999999p 3.210078e-07 25.300000000000001p 1.493343e-07 25.400000000000002p -1.975258e-09 25.5p -1.222099e-07 25.600000000000001p -2.034734e-07 25.699999999999999p -2.412479e-07 25.800000000000001p -2.346681e-07 25.899999999999999p -1.864912e-07 26p -1.027716e-07 26.099999999999998p 7.725731e-09 26.199999999999999p 1.343194e-07 26.300000000000001p 2.653432e-07 26.400000000000002p 3.891356e-07 26.5p 4.950044e-07 26.600000000000001p 5.740881e-07 26.699999999999999p 6.200442e-07 26.800000000000001p 6.295129e-07 26.899999999999999p 6.023215e-07 27p 5.414192e-07 27.099999999999998p 4.525537e-07 27.199999999999999p 3.437220e-07 27.299999999999997p 2.244459e-07 27.400000000000002p 1.049370e-07 27.5p -4.777971e-09 27.600000000000001p -9.569634e-08 27.699999999999999p -1.605766e-07 27.800000000000001p -1.945120e-07 27.899999999999999p -1.952988e-07 28p -1.635705e-07 28.099999999999998p -1.026941e-07 28.199999999999999p -1.844005e-08 28.299999999999997p 8.154122e-08 28.399999999999999p 1.883902e-07 28.5p 2.927970e-07 28.600000000000001p 3.857844e-07 28.699999999999999p 4.594496e-07 28.800000000000001p 5.076037e-07 28.899999999999999p 5.262586e-07 29p 5.139232e-07 29.099999999999998p 4.716876e-07 29.199999999999999p 4.030934e-07 29.299999999999997p 3.138029e-07 29.400000000000002p 2.111003e-07 29.5p 1.032669e-07 29.600000000000001p -1.113933e-09 29.699999999999999p -9.386463e-08 29.800000000000004p -1.678756e-07 29.900000000000002p -2.176679e-07 30p -2.398124e-07 30.099999999999998p -2.331736e-07 30.200000000000003p -1.989622e-07 30.300000000000001p -1.405946e-07 30.399999999999999p -6.337563e-08 30.499999999999996p 2.596669e-08 30.600000000000001p 1.198539e-07 30.700000000000003p 2.104877e-07 30.800000000000001p 2.904868e-07 30.899999999999999p 3.534770e-07 31.000000000000004p 3.945879e-07 31.100000000000001p 4.108168e-07 31.199999999999999p 4.012345e-07 31.299999999999997p 3.670163e-07 31.400000000000002p 3.113027e-07 31.5p 2.389020e-07 31.599999999999998p 1.558643e-07 31.699999999999999p 6.896361e-08 31.800000000000004p -1.486809e-08 31.900000000000002p -8.910626e-08 32p -1.481537e-07 32.099999999999994p -1.877731e-07 32.200000000000003p -2.053988e-07 32.300000000000004p -2.003053e-07 32.399999999999999p -1.736220e-07 32.5p -1.281961e-07 32.600000000000001p -6.831928e-08 32.700000000000003p 6.580453e-10 32.799999999999997p 7.278877e-08 32.899999999999999p 1.420296e-07 33p 2.027369e-07 33.100000000000001p 2.501186e-07 33.199999999999996p 2.806045e-07 33.299999999999997p 2.921080e-07 33.400000000000006p 2.841589e-07 33.5p 2.579011e-07 33.600000000000001p 2.159557e-07 33.699999999999996p 1.621677e-07 33.800000000000004p 1.012562e-07 33.899999999999999p 3.840175e-08 34p -2.119436e-08 34.099999999999994p -7.274216e-08 34.200000000000003p -1.122504e-07 34.299999999999997p -1.368384e-07 34.399999999999999p -1.449489e-07 34.5p -1.364450e-07 34.600000000000001p -1.125878e-07 34.700000000000003p -7.589805e-08 34.799999999999997p -2.991557e-08 34.899999999999999p 2.112025e-08 35p 7.264162e-08 35.100000000000001p 1.201428e-07 35.199999999999996p 1.595572e-07 35.299999999999997p 1.875900e-07 35.399999999999999p 2.019791e-07 35.5p 2.016655e-07 35.600000000000001p 1.868585e-07 35.699999999999996p 1.589949e-07 35.800000000000004p 1.205958e-07 35.899999999999999p 7.503520e-08 36p 2.624272e-08 36.099999999999994p -2.163561e-08 36.200000000000003p -6.458803e-08 36.299999999999997p -9.907052e-08 36.399999999999999p -1.222956e-07 36.5p -1.324533e-07 36.600000000000001p -1.288473e-07 36.700000000000003p -1.119366e-07 36.799999999999997p -8.328066e-08 36.900000000000006p -4.539449e-08 37p -1.527476e-09 37.100000000000001p 4.461520e-08 37.199999999999996p 8.918400e-08 37.300000000000004p 1.285034e-07 37.399999999999999p 1.593708e-07 37.5p 1.793120e-07 37.600000000000001p 1.867726e-07 37.700000000000003p 1.812311e-07 37.800000000000004p 1.632258e-07 37.899999999999999p 1.342947e-07 38p 9.683515e-08 38.100000000000001p 5.389526e-08 38.200000000000003p 8.917157e-09 38.299999999999997p -3.454791e-08 38.399999999999999p -7.312775e-08 38.5p -1.038976e-07 38.600000000000001p -1.246069e-07 38.700000000000003p -1.338474e-07 38.799999999999997p -1.311499e-07 38.900000000000006p -1.170022e-07 39p -9.279083e-08 39.100000000000001p -6.067006e-08 39.199999999999996p -2.337263e-08 39.300000000000004p 1.602256e-08 39.399999999999999p 5.434537e-08 39.5p 8.859104e-08 39.599999999999994p 1.161574e-07 39.700000000000003p 1.350439e-07 39.800000000000004p 1.439975e-07 39.899999999999999p 1.425941e-07 40p 1.312508e-07 40.100000000000001p 1.111699e-07 40.200000000000003p 8.422004e-08 40.299999999999997p 5.276666e-08 40.399999999999999p 1.946599e-08 40.5p -1.295903e-08 40.600000000000001p -4.194246e-08 40.699999999999996p -6.528034e-08 40.799999999999997p -8.130050e-08 40.900000000000006p -8.898424e-08 41p -8.803107e-08 41.100000000000001p -7.886257e-08 41.199999999999996p -6.256668e-08 41.300000000000004p -4.078832e-08 41.399999999999999p -1.557688e-08 41.5p 1.079583e-08 41.599999999999994p 3.603144e-08 41.700000000000003p 5.799798e-08 41.799999999999997p 7.490413e-08 41.899999999999999p 8.544066e-08 42p 8.887804e-08 42.100000000000001p 8.511321e-08 42.200000000000003p 7.466263e-08 42.299999999999997p 5.860360e-08 42.399999999999999p 3.846968e-08 42.5p 1.611020e-08 42.600000000000001p -6.473797e-09 42.699999999999996p -2.730292e-08 42.799999999999997p -4.458733e-08 42.899999999999999p -5.687532e-08 43p -6.317051e-08 43.100000000000001p -6.300853e-08 43.199999999999996p -5.648746e-08 43.300000000000004p -4.425044e-08 43.399999999999999p -2.742281e-08 43.5p -7.509699e-09 43.599999999999994p 1.373644e-08 43.700000000000003p 3.446705e-08 43.799999999999997p 5.289434e-08 43.899999999999999p 6.744070e-08 44p 7.686848e-08 44.100000000000001p 8.037947e-08 44.200000000000003p 7.767645e-08 44.299999999999997p 6.898237e-08 44.400000000000006p 5.501605e-08 44.5p 3.692732e-08 44.600000000000001p 1.619743e-08 44.699999999999996p -5.486402e-09 44.800000000000004p -2.637165e-08 44.899999999999999p -4.478449e-08 45p -5.926534e-08 45.100000000000001p -6.868491e-08 45.200000000000003p -7.233171e-08 45.300000000000004p -6.996415e-08 45.399999999999999p -6.182384e-08 45.5p -4.860937e-08 45.600000000000001p -3.141365e-08 45.700000000000003p -1.163038e-08 45.799999999999997p 9.162178e-09 45.899999999999999p 2.933022e-08 46p 4.731565e-08 46.100000000000001p 6.175881e-08 46.200000000000003p 7.160288e-08 46.299999999999997p 7.617208e-08 46.400000000000006p 7.521755e-08 46.5p 6.892820e-08 46.600000000000001p 5.790618e-08 46.699999999999996p 4.310977e-08 46.800000000000004p 2.576903e-08 46.899999999999999p 7.281592e-09 47p -1.090247e-08 47.099999999999994p -2.739719e-08 47.200000000000003p -4.098926e-08 47.300000000000004p -5.072987e-08 47.399999999999999p -5.600294e-08 47.5p -5.656476e-08 47.600000000000001p -5.255252e-08 47.700000000000003p -4.446187e-08 47.799999999999997p -3.309610e-08 47.899999999999999p -1.949182e-08 48p -4.827864e-09 48.100000000000001p 9.674837e-09 48.199999999999996p 2.285384e-08 48.299999999999997p 3.369808e-08 48.400000000000006p 4.142563e-08 48.5p 4.554037e-08 48.600000000000001p 4.586338e-08 48.699999999999996p 4.253728e-08 48.800000000000004p 3.600384e-08 48.899999999999999p 2.695727e-08 49p 1.627805e-08 49.099999999999994p 4.952912e-09 49.200000000000003p -6.011644e-09 49.299999999999997p -1.567520e-08 49.399999999999999p -2.324132e-08 49.5p -2.812122e-08 49.600000000000001p -2.997827e-08 49.700000000000003p -2.875001e-08 49.799999999999997p -2.464640e-08 49.899999999999999p -1.812495e-08 50p -9.845411e-09 50.100000000000001p -6.549927e-05 50.199999999999996p -4.060493e-05 50.299999999999997p -4.318941e-05 50.399999999999999p -4.909719e-05 50.5p -5.734051e-05 50.600000000000001p -6.669145e-05 50.699999999999996p -7.586745e-05 50.800000000000004p -8.371645e-05 50.899999999999999p -8.937044e-05 51p -9.234131e-05 51.100000000000001p -2.704780e-05 51.200000000000003p -4.963607e-05 51.299999999999997p -4.276243e-05 51.399999999999999p -3.123308e-05 51.5p -1.671250e-05 51.600000000000001p -1.062430e-06 51.700000000000003p 1.387315e-05 51.799999999999997p 2.645703e-05 51.900000000000006p 3.541230e-05 52p 3.993271e-05 52.100000000000001p 3.974233e-05 52.199999999999996p 3.509797e-05 52.300000000000004p 2.673165e-05 52.399999999999999p 1.573936e-05 52.5p 3.433016e-06 52.600000000000001p -8.820049e-06 52.700000000000003p -1.974537e-05 52.800000000000004p -2.827905e-05 52.899999999999999p -3.364683e-05 53p -3.540460e-05 53.100000000000001p -3.344541e-05 53.200000000000003p -2.797847e-05 53.299999999999997p -1.948620e-05 53.399999999999999p -8.666030e-06 53.5p 3.634548e-06 53.600000000000001p 1.648067e-05 53.700000000000003p 2.890442e-05 53.799999999999997p 3.994995e-05 53.900000000000006p 4.871445e-05 54p 5.439306e-05 54.100000000000001p 5.633423e-05 54.199999999999996p 5.410587e-05 54.300000000000004p 4.756451e-05 54.399999999999999p 3.691275e-05 54.5p 2.272835e-05 54.599999999999994p 5.951806e-06 54.700000000000003p -1.217348e-05 54.800000000000004p -3.020733e-05 54.899999999999999p -4.665867e-05 55p -6.015670e-05 55.100000000000001p -6.961856e-05 55.200000000000003p -7.437244e-05 55.299999999999997p -7.420346e-05 55.399999999999999p -6.932075e-05 55.5p -6.027346e-05 55.600000000000001p -4.785021e-05 55.699999999999996p -3.298545e-05 55.799999999999997p -1.668251e-05 55.899999999999999p 4.452046e-08 56p 1.621196e-05 56.100000000000001p 3.089538e-05 56.199999999999996p 4.325407e-05 56.300000000000004p 5.256001e-05 56.399999999999999p 5.823853e-05 56.5p 5.992176e-05 56.599999999999994p 5.750760e-05 56.700000000000003p 5.121003e-05 56.799999999999997p 4.158232e-05 56.899999999999999p 2.949766e-05 57p 1.608038e-05 57.100000000000001p 2.593336e-06 57.200000000000003p -9.700986e-06 57.299999999999997p -1.968180e-05 57.399999999999999p -2.648976e-05 57.5p -2.960707e-05 57.600000000000001p -2.888897e-05 57.699999999999996p -2.454677e-05 57.799999999999997p -1.709053e-05 57.899999999999999p -7.245031e-06 58p 4.143987e-06 58.100000000000001p 1.619708e-05 58.199999999999996p 2.806905e-05 58.299999999999997p 3.899197e-05 58.399999999999999p 4.829543e-05 58.500000000000007p 5.541288e-05 58.599999999999994p 5.988598e-05 58.700000000000003p 6.137733e-05 58.800000000000004p 5.969631e-05 58.899999999999999p 5.483532e-05 59p 4.700590e-05 59.099999999999994p 3.666038e-05 59.200000000000003p 2.448534e-05 59.300000000000004p 1.135927e-05 59.399999999999999p -1.724233e-06 59.5p -1.375682e-05 59.600000000000009p -2.382272e-05 59.699999999999996p -3.119491e-05 59.800000000000004p -3.540517e-05 59.899999999999991p -3.627921e-05 60p -3.393462e-05 60.100000000000001p 3.675303e-05 60.199999999999996p 1.937965e-05 60.300000000000004p 3.117649e-05 60.400000000000006p 4.731930e-05 60.5p 6.615093e-05 60.600000000000001p 8.578039e-05 60.699999999999996p 1.042590e-04 60.799999999999997p 1.197633e-04 60.900000000000006p 1.307776e-04 60.999999999999993p 1.362628e-04 61.100000000000001p 7.029008e-05 61.200000000000003p 8.897170e-05 61.299999999999997p 7.533199e-05 61.400000000000006p 5.492525e-05 61.499999999999993p 3.042256e-05 61.600000000000001p 4.766225e-06 61.700000000000003p -1.923121e-05 61.799999999999997p -3.921101e-05 61.899999999999999p -5.348210e-05 62.000000000000007p -6.112130e-05 62.099999999999994p -6.197228e-05 62.200000000000003p -5.655959e-05 62.299999999999997p -4.593606e-05 62.399999999999999p -3.149077e-05 62.500000000000007p -1.475565e-05 62.599999999999994p 2.749793e-06 62.700000000000003p 1.960993e-05 62.800000000000004p 3.454249e-05 62.899999999999999p 4.639452e-05 63p 5.414648e-05 63.099999999999994p 5.695843e-05 63.199999999999996p 5.426669e-05 63.300000000000004p 4.590798e-05 63.399999999999999p 3.222562e-05 63.5p 1.411124e-05 63.600000000000009p -7.043809e-06 63.699999999999996p -2.948210e-05 63.800000000000004p -5.126825e-05 63.899999999999991p -7.049322e-05 64p -8.546389e-05 64.100000000000009p -9.486102e-05 64.199999999999989p -9.785771e-05 64.299999999999997p -9.419157e-05 64.400000000000006p -8.418164e-05 64.5p -6.868341e-05 64.600000000000009p -4.898563e-05 64.699999999999989p -2.666739e-05 64.799999999999997p -3.443853e-06 64.900000000000006p 1.897301e-05 65p 3.898487e-05 65.099999999999994p 5.519136e-05 65.200000000000003p 6.646149e-05 65.299999999999997p 7.200553e-05 65.400000000000006p 7.144938e-05 65.5p 6.489871e-05 65.599999999999994p 5.296881e-05 65.700000000000003p 3.675715e-05 65.799999999999997p 1.774866e-05 65.900000000000006p -2.336125e-06 66p -2.172339e-05 66.099999999999994p -3.876648e-05 66.200000000000003p -5.209761e-05 66.300000000000011p -6.073636e-05 66.399999999999991p -6.415139e-05 66.5p -6.227790e-05 66.599999999999994p -5.549495e-05 66.700000000000003p -4.456716e-05 66.800000000000011p -3.055744e-05 66.899999999999991p -1.472159e-05 67p 1.601787e-06 67.100000000000009p 1.709321e-05 67.200000000000003p 3.053900e-05 67.299999999999997p 4.090225e-05 67.399999999999991p 4.738258e-05 67.5p 4.946917e-05 67.600000000000009p 4.698644e-05 67.700000000000003p 4.012557e-05 67.799999999999997p 2.944996e-05 67.900000000000006p 1.586433e-05 68p 5.429249e-07 68.100000000000009p -1.517743e-05 68.199999999999989p -2.992560e-05 68.299999999999997p -4.242790e-05 68.400000000000006p -5.162614e-05 68.5p -5.676957e-05 68.599999999999994p -5.747318e-05 68.700000000000003p -5.373942e-05 68.799999999999997p -4.594385e-05 68.900000000000006p -3.478834e-05 69p -2.122875e-05 69.099999999999994p -6.386310e-06 69.200000000000003p 8.546821e-06 69.299999999999997p 2.239938e-05 69.400000000000006p 3.410452e-05 69.5p 4.277293e-05 69.599999999999994p 4.775477e-05 69.700000000000003p 4.868908e-05 69.799999999999997p 4.553683e-05 69.900000000000006p 3.859138e-05 70p 2.846070e-05 70.099999999999994p 1.504059e-04 70.200000000000003p 8.768274e-05 70.300000000000011p 8.205411e-05 70.399999999999991p 8.546561e-05 70.5p 9.703665e-05 70.599999999999994p 1.151944e-04 70.700000000000003p 1.379670e-04 70.799999999999997p 1.633117e-04 70.899999999999991p 1.894295e-04 71p 2.150142e-04 71.100000000000009p 1.050190e-04 71.200000000000003p 1.771065e-04 71.299999999999997p 1.908973e-04 71.399999999999991p 1.958819e-04 71.5p 1.940508e-04 71.600000000000009p 1.875093e-04 71.699999999999989p 1.781212e-04 71.799999999999997p 1.673000e-04 71.900000000000006p 1.559463e-04 72p 1.445001e-04 72.100000000000009p 1.330621e-04 72.199999999999989p 1.215368e-04 72.299999999999997p 1.097606e-04 72.400000000000006p 9.759343e-05 72.5p 8.496702e-05 72.599999999999994p 7.189456e-05 72.700000000000003p 5.845510e-05 72.799999999999997p 4.476750e-05 72.900000000000006p 3.096767e-05 73p 1.719770e-05 73.099999999999994p 3.609085e-06 73.200000000000003p -9.623654e-06 73.299999999999997p -2.228705e-05 73.400000000000006p -3.411999e-05 73.5p -4.481970e-05 73.599999999999994p -5.406557e-05 73.700000000000003p -6.155770e-05 73.800000000000011p -6.706181e-05 73.899999999999991p -7.044944e-05 74p -7.172342e-05 74.099999999999994p -7.102327e-05 74.200000000000003p -6.861127e-05 74.300000000000011p -6.484454e-05 74.399999999999991p -6.014037e-05 74.5p -5.494038e-05 74.600000000000009p -4.967643e-05 74.700000000000003p -4.473933e-05 74.799999999999997p -4.045187e-05 74.899999999999991p -3.704921e-05 75p -3.467138e-05 75.100000000000009p -3.337114e-05 75.200000000000003p -3.313642e-05 75.299999999999997p -3.392101e-05 75.400000000000006p -3.567359e-05 75.5p -3.835542e-05 75.600000000000009p -4.194159e-05 75.699999999999989p -4.640713e-05 75.799999999999997p -5.170505e-05 75.900000000000006p -5.774570e-05 76p -6.438541e-05 76.099999999999994p -7.142814e-05 76.200000000000003p -7.863848e-05 76.299999999999997p -8.576046e-05 76.400000000000006p -9.253527e-05 76.5p -9.871240e-05 76.599999999999994p -1.040525e-04 76.700000000000003p -1.083251e-04 76.799999999999997p -1.113072e-04 76.900000000000006p -1.127896e-04 77p -1.125955e-04 77.099999999999994p -1.106081e-04 77.200000000000003p -1.068003e-04 77.299999999999997p -1.012546e-04 77.400000000000006p -9.416452e-05 77.5p -8.581347e-05 77.599999999999994p -7.653866e-05 77.700000000000003p -6.668928e-05 77.800000000000011p -5.659164e-05 77.899999999999991p -4.652801e-05 78p -3.672971e-05 78.099999999999994p -2.737986e-05 78.200000000000003p -1.861936e-05 78.299999999999997p -1.055130e-05 78.399999999999991p -3.242637e-06 78.5p 3.275654e-06 78.600000000000009p 9.007044e-06 78.700000000000003p 1.398479e-05 78.799999999999997p 1.826361e-05 78.899999999999991p 2.190853e-05 79p 2.498220e-05 79.100000000000009p 2.753198e-05 79.199999999999989p 2.957777e-05 79.299999999999997p 3.110171e-05 79.400000000000006p 3.204106e-05 79.5p 3.228618e-05 79.600000000000009p 3.168525e-05 79.699999999999989p 3.005714e-05 79.799999999999997p 2.721235e-05 79.900000000000006p 2.298084e-05 80p 1.724358e-05 80.099999999999994p -1.244236e-04 80.200000000000003p -8.459752e-05 80.299999999999997p -1.041550e-04 80.400000000000006p -1.339696e-04 80.5p -1.718053e-04 80.599999999999994p -2.143637e-04 80.700000000000003p -2.575977e-04 80.799999999999997p -2.972471e-04 80.900000000000006p -3.295646e-04 81p -3.520754e-04 81.099999999999994p -2.297227e-04 81.200000000000003p -2.814854e-04 81.300000000000011p -2.690977e-04 81.399999999999991p -2.442209e-04 81.5p -2.104116e-04 81.599999999999994p -1.704914e-04 81.700000000000003p -1.264155e-04 81.800000000000011p -7.958799e-05 81.899999999999991p -3.135546e-05 82p 1.657047e-05 82.100000000000009p 6.193108e-05 82.200000000000003p 1.020461e-04 82.299999999999997p 1.342214e-04 82.399999999999991p 1.563292e-04 82.5p 1.673775e-04 82.600000000000009p 1.678595e-04 82.700000000000003p 1.597234e-04 82.799999999999997p 1.459429e-04 82.900000000000006p 1.298258e-04 83p 1.142941e-04 83.100000000000009p 1.013552e-04 83.199999999999989p 9.188361e-05 83.299999999999997p 8.571048e-05 83.400000000000006p 8.192796e-05 83.5p 7.927700e-05 83.599999999999994p 7.650019e-05 83.700000000000003p 7.258385e-05 83.799999999999997p 6.686672e-05 83.900000000000006p 5.903638e-05 84p 4.905916e-05 84.099999999999994p 3.709081e-05 84.200000000000003p 2.340135e-05 84.299999999999997p 8.327798e-06 84.400000000000006p -7.745151e-06 84.5p -2.438142e-05 84.599999999999994p -4.107101e-05 84.700000000000003p -5.719571e-05 84.799999999999997p -7.199802e-05 84.900000000000006p -8.457394e-05 85p -9.390807e-05 85.099999999999994p -9.895682e-05 85.200000000000003p -9.877135e-05 85.300000000000011p -9.264036e-05 85.399999999999991p -8.022836e-05 85.5p -6.168557e-05 85.599999999999994p -3.771061e-05 85.700000000000003p -9.554744e-06 85.799999999999997p 2.103704e-05 85.899999999999991p 5.194805e-05 86p 8.087229e-05 86.100000000000009p 1.055473e-04 86.200000000000003p 1.240128e-04 86.299999999999997p 1.348505e-04 86.399999999999991p 1.373531e-04 86.5p 1.315768e-04 86.600000000000009p 1.182708e-04 86.699999999999989p 9.871178e-05 86.799999999999997p 7.450428e-05 86.900000000000006p 4.740560e-05 87p 1.920810e-05 87.100000000000009p -8.325171e-06 87.199999999999989p -3.350649e-05 87.299999999999997p -5.479469e-05 87.400000000000006p -7.091627e-05 87.5p -8.102112e-05 87.599999999999994p -8.481791e-05 87.700000000000003p -8.261933e-05 87.799999999999997p -7.525511e-05 87.900000000000006p -6.386793e-05 88p -4.966345e-05 88.099999999999994p -3.370499e-05 88.200000000000003p -1.681965e-05 88.299999999999997p 3.690510e-07 88.400000000000006p 1.731739e-05 88.5p 3.341215e-05 88.599999999999994p 4.786572e-05 88.700000000000003p 5.970845e-05 88.800000000000011p 6.789995e-05 88.899999999999991p 7.154137e-05 89p 7.012987e-05 89.099999999999994p 6.376765e-05 89.200000000000003p 5.323850e-05 89.300000000000011p 3.990550e-05 89.399999999999991p 2.545029e-05 89.5p 1.153790e-05 89.600000000000009p -4.846166e-07 89.700000000000003p -9.769245e-06 89.799999999999997p -1.599666e-05 89.899999999999991p -1.928009e-05 90p -2.000571e-05 90.100000000000009p 4.682170e-05 90.200000000000003p 2.479245e-05 90.299999999999997p 3.126189e-05 90.400000000000006p 4.159838e-05 90.5p 5.437815e-05 90.600000000000009p 6.799571e-05 90.699999999999989p 8.086901e-05 90.799999999999997p 9.163114e-05 90.900000000000006p 9.927331e-05 91p 1.032240e-04 91.099999999999994p 3.787072e-05 91.200000000000003p 5.940095e-05 91.299999999999997p 5.063342e-05 91.400000000000006p 3.669186e-05 91.5p 1.970374e-05 91.599999999999994p 2.075695e-06 91.700000000000003p -1.382177e-05 91.799999999999997p -2.594622e-05 91.900000000000006p -3.280835e-05 92p -3.360221e-05 92.099999999999994p -2.823292e-05 92.200000000000003p -1.725427e-05 92.299999999999997p -1.743782e-06 92.400000000000006p 1.685082e-05 92.5p 3.686605e-05 92.599999999999994p 5.656408e-05 92.700000000000003p 7.426033e-05 92.800000000000011p 8.843951e-05 92.899999999999991p 9.785817e-05 93p 1.016280e-04 93.099999999999994p 9.927759e-05 93.200000000000003p 9.079365e-05 93.299999999999997p 7.663063e-05 93.399999999999991p 5.766295e-05 93.5p 3.507139e-05 93.600000000000009p 1.020634e-05 93.700000000000003p -1.550592e-05 93.799999999999997p -4.058379e-05 93.899999999999991p -6.346880e-05 94p -8.252919e-05 94.100000000000009p -9.614776e-05 94.199999999999989p -1.029106e-04 94.299999999999997p -1.018571e-04 94.400000000000006p -9.270908e-05 94.5p -7.598806e-05 94.600000000000009p -5.297146e-05 94.700000000000003p -2.550302e-05 94.799999999999997p 4.268282e-06 94.900000000000006p 3.413297e-05 95p 6.199582e-05 95.099999999999994p 8.598463e-05 95.200000000000003p 1.045424e-04 95.299999999999997p 1.165546e-04 95.400000000000006p 1.215143e-04 95.5p 1.196569e-04 95.599999999999994p 1.119566e-04 95.700000000000003p 9.992172e-05 95.799999999999997p 8.523271e-05 95.900000000000006p 6.935571e-05 96p 5.327786e-05 96.099999999999994p 3.744487e-05 96.200000000000003p 2.189177e-05 96.300000000000011p 6.488466e-06 96.399999999999991p -8.801472e-06 96.5p -2.373410e-05 96.599999999999994p -3.771813e-05 96.700000000000003p -4.987580e-05 96.800000000000011p -5.920932e-05 96.899999999999991p -6.483178e-05 97p -6.621005e-05 97.100000000000009p -6.336084e-05 97.200000000000003p -5.694233e-05 97.299999999999997p -4.820120e-05 97.399999999999991p -3.877177e-05 97.5p -3.037101e-05 97.600000000000009p -2.447012e-05 97.700000000000003p -2.203132e-05 97.799999999999997p -2.337334e-05 97.900000000000006p -2.818465e-05 98p -3.565966e-05 98.100000000000009p -4.470592e-05 98.199999999999989p -5.416387e-05 98.299999999999997p -6.299064e-05 98.400000000000006p -7.037778e-05 98.5p -7.579259e-05 98.599999999999994p -7.895029e-05 98.700000000000003p -7.973862e-05 98.799999999999997p -7.812506e-05 98.900000000000006p -7.407922e-05 99p -6.753634e-05 99.099999999999994p -5.841497e-05 99.200000000000003p -4.668429e-05 99.299999999999997p -3.246072e-05 99.400000000000006p -1.610362e-05 99.5p 1.721808e-06 99.599999999999994p 2.003906e-05 99.700000000000003p 3.762351e-05 99.799999999999997p 5.312865e-05 99.900000000000006p 6.525396e-05 100p 7.292127e-05 100.09999999999999p 9.925132e-06 100.2p 3.181161e-05 100.30000000000001p 2.083299e-05 100.39999999999999p 1.659051e-06 100.5p -2.386845e-05 100.59999999999999p -5.338518e-05 100.7p -8.423746e-05 100.8p -1.137165e-04 100.89999999999999p -1.392892e-04 101p -1.588246e-04 101.10000000000001p -1.053114e-04 101.2p -1.339056e-04 101.3p -1.269142e-04 101.39999999999999p -1.094756e-04 101.5p -8.414120e-05 101.60000000000001p -5.397960e-05 101.69999999999999p -2.212909e-05 101.8p 8.534156e-06 101.90000000000001p 3.558259e-05 102p 5.711896e-05 102.10000000000001p 7.182125e-05 102.2p 7.899513e-05 102.3p 7.862492e-05 102.40000000000001p 7.137221e-05 102.5p 5.847430e-05 102.59999999999999p 4.154243e-05 102.7p 2.231648e-05 102.8p 2.458669e-06 102.90000000000001p -1.655459e-05 103p -3.343703e-05 103.09999999999999p -4.703883e-05 103.2p -5.630525e-05 103.3p -6.030703e-05 103.40000000000001p -5.836386e-05 103.5p -5.023216e-05 103.59999999999999p -3.628743e-05 103.7p -1.761889e-05 103.80000000000001p 4.022108e-06 103.89999999999999p 2.642647e-05 104p 4.723725e-05 104.09999999999999p 6.428643e-05 104.2p 7.588177e-05 104.30000000000001p 8.099422e-05 104.39999999999999p 7.933064e-05 104.5p 7.130310e-05 104.60000000000001p 5.791916e-05 104.7p 4.062000e-05 104.8p 2.109206e-05 104.89999999999999p 1.077715e-06 105p -1.779120e-05 105.10000000000001p -3.411760e-05 105.2p -4.681233e-05 105.3p -5.512059e-05 105.40000000000001p -5.861712e-05 105.5p -5.718929e-05 105.60000000000001p -5.102356e-05 105.69999999999999p -4.060033e-05 105.8p -2.669150e-05 105.90000000000001p -1.034701e-05 106p 7.145027e-06 106.09999999999999p 2.433540e-05 106.2p 3.972880e-05 106.3p 5.192672e-05 106.40000000000001p 5.977824e-05 106.5p 6.251393e-05 106.59999999999999p 5.983918e-05 106.7p 5.197043e-05 106.8p 3.960903e-05 106.90000000000001p 2.386021e-05 107p 6.113690e-06 107.09999999999999p -1.209377e-05 107.2p -2.921589e-05 107.3p -4.382266e-05 107.40000000000001p -5.470876e-05 107.5p -6.098234e-05 107.59999999999999p -6.213167e-05 107.7p -5.806498e-05 107.80000000000001p -4.911690e-05 107.89999999999999p -3.601747e-05 108p -1.982487e-05 108.09999999999999p -1.830059e-06 108.2p 1.655397e-05 108.3p 3.390615e-05 108.39999999999999p 4.890591e-05 108.5p 6.043214e-05 108.60000000000001p 6.764950e-05 108.7p 7.007630e-05 108.8p 6.762410e-05 108.89999999999999p 6.059873e-05 109p 4.965727e-05 109.10000000000001p 3.572638e-05 109.19999999999999p 1.989847e-05 109.3p 3.327420e-06 109.40000000000001p -1.285759e-05 109.5p -2.761188e-05 109.60000000000001p -4.001289e-05 109.7p -4.928845e-05 109.8p -5.484932e-05 109.90000000000001p -5.633327e-05 110p -5.365604e-05 110.09999999999999p -5.365604e-05 110.2p -5.365604e-05 110.3p -5.365604e-05 110.40000000000001p -5.365604e-05 110.5p -5.365604e-05 110.59999999999999p -5.365604e-05 110.7p -5.365604e-05 110.8p -5.365604e-05 110.90000000000001p -5.365604e-05 111p -5.365604e-05 111.09999999999999p -5.365604e-05 111.2p -5.365604e-05 111.30000000000001p 5.373654e-05 111.39999999999999p 2.691453e-05 111.5p 4.543542e-05 111.59999999999999p 7.126665e-05 111.7p 1.017372e-04 111.8p 1.338580e-04 111.89999999999999p 1.647475e-04 112p 1.920566e-04 112.10000000000001p 2.143436e-04 112.2p 2.313361e-04 112.3p 1.432271e-04 112.39999999999999p 1.902158e-04 112.5p 1.941421e-04 112.60000000000001p 1.940253e-04 112.7p 1.927631e-04 112.8p 1.927676e-04 112.90000000000001p 1.958095e-04 113p 2.030864e-04 113.10000000000001p 2.154107e-04 113.19999999999999p 2.334087e-04 113.3p 2.576458e-04 113.40000000000001p 2.886177e-04 113.5p 3.265763e-04 113.59999999999999p 3.711708e-04 113.7p 4.209221e-04 113.8p 4.726572e-04 113.90000000000001p 5.212605e-04 114p 5.603468e-04 114.09999999999999p 5.842773e-04 114.2p 5.909188e-04 114.3p 5.833209e-04 114.40000000000001p 5.687277e-04 114.5p 5.552918e-04 114.59999999999999p 5.485166e-04 114.7p 5.493171e-04 114.8p 5.542775e-04 114.90000000000001p 5.574896e-04 115p 5.528763e-04 115.09999999999999p 5.360809e-04 115.2p 5.055888e-04 115.30000000000001p 4.632674e-04 115.39999999999999p 4.143330e-04 115.5p 3.663088e-04 115.59999999999999p 3.270939e-04 115.7p 3.031250e-04 115.8p 2.984741e-04 115.89999999999999p 3.149750e-04 116p 3.529617e-04 116.10000000000001p 4.120772e-04 116.2p 4.916718e-04 116.3p 5.903496e-04 116.39999999999999p 7.041850e-04 116.50000000000001p 8.233658e-04 116.59999999999999p 9.287183e-04 116.69999999999999p 9.935196e-04 116.8p 9.964037e-04 116.90000000000001p 9.381469e-04 117.00000000000001p 8.440273e-04 117.09999999999999p 7.488448e-04 117.19999999999999p 6.795625e-04 117.3p 6.470641e-04 117.40000000000001p 6.474085e-04 117.50000000000001p 6.677922e-04 117.60000000000001p 6.931739e-04 117.69999999999999p 7.114724e-04 117.8p 7.162424e-04 117.90000000000001p 7.069544e-04 118p 6.882750e-04 118.10000000000001p 6.691843e-04 118.19999999999999p 6.611952e-04 118.3p 6.751283e-04 118.40000000000001p 7.115517e-04 118.5p 7.803416e-04 118.60000000000001p 8.711113e-04 118.69999999999999p 9.698708e-04 118.8p 1.060366e-03 118.89999999999999p 1.126849e-03 119p 1.155190e-03 119.10000000000001p 1.131787e-03 119.20000000000002p 1.044228e-03 119.3p 8.898194e-04 119.39999999999999p 6.882147e-04 119.5p 4.824284e-04 119.60000000000001p 3.230230e-04 119.70000000000002p 2.480601e-04 119.79999999999998p 2.710075e-04 119.89999999999999p 3.787940e-04 120p 5.368058e-04 120.10000000000001p 6.991430e-04 120.2p 8.245794e-04 120.29999999999998p 8.934065e-04 120.39999999999999p 9.134639e-04 120.5p 9.108574e-04 120.60000000000001p 9.142138e-04 120.7p 9.430599e-04 120.80000000000001p 1.003896e-03 120.89999999999999p 1.091542e-03 121p 1.192039e-03 121.09999999999999p 1.285304e-03 121.2p 1.347575e-03 121.30000000000001p 1.253704e-03 121.39999999999999p 1.222236e-03 121.5p 1.065737e-03 121.59999999999999p 8.331462e-04 121.7p 5.556617e-04 121.80000000000001p 2.734470e-04 121.89999999999999p 2.400200e-05 121.99999999999999p -1.661038e-04 122.09999999999999p -2.840478e-04 122.2p -3.291304e-04 122.30000000000001p -2.081553e-04 122.40000000000001p -1.706213e-04 122.49999999999999p -4.829149e-05 122.59999999999999p 1.101892e-04 122.7p 2.921933e-04 122.80000000000001p 4.844589e-04 122.90000000000001p 6.723484e-04 122.99999999999999p 8.397243e-04 123.09999999999999p 9.701835e-04 123.2p 1.049989e-03 123.3p 1.071960e-03 123.40000000000001p 1.038244e-03 123.49999999999999p 9.598703e-04 123.59999999999999p 8.529227e-04 123.7p 7.334209e-04 123.8p 6.133637e-04 123.90000000000001p 4.991973e-04 124.00000000000001p 3.925139e-04 124.09999999999999p 2.920257e-04 124.19999999999999p 1.957958e-04 124.3p 1.030177e-04 124.40000000000001p 1.501257e-05 124.50000000000001p -6.457519e-05 124.59999999999999p -1.302276e-04 124.69999999999999p -1.754443e-04 124.8p -1.939400e-04 124.90000000000001p -1.810921e-04 125.00000000000001p -1.354931e-04 125.10000000000001p -6.014895e-05 125.19999999999999p 3.738177e-05 125.3p 1.463136e-04 125.40000000000001p 2.550350e-04 125.5p 3.535686e-04 125.60000000000001p 4.351348e-04 125.69999999999999p 4.964440e-04 125.8p 5.369586e-04 125.90000000000001p 5.576924e-04 126p 5.601230e-04 126.10000000000001p 5.456067e-04 126.19999999999999p 5.154199e-04 126.3p 4.712858e-04 126.39999999999999p 4.160294e-04 126.5p 3.539250e-04 126.60000000000001p 2.904392e-04 126.70000000000002p 2.313809e-04 126.8p 1.817677e-04 126.89999999999999p 1.448229e-04 127p 1.214147e-04 127.10000000000001p 1.100451e-04 127.20000000000002p 1.073201e-04 127.29999999999998p 1.087291e-04 127.39999999999999p 1.095387e-04 127.5p 1.056308e-04 127.60000000000001p 9.416054e-05 127.7p 7.396657e-05 127.79999999999998p 4.571031e-05 127.89999999999999p 1.175814e-05 128p -2.416245e-05 128.09999999999999p -5.749005e-05 128.20000000000002p -8.348736e-05 128.30000000000001p -9.795809e-05 128.39999999999998p -9.792211e-05 128.5p -8.212283e-05 128.59999999999999p -5.124600e-05 128.70000000000002p -7.786807e-06 128.80000000000001p 4.439697e-05 128.89999999999998p 1.007096e-04 129p 1.564429e-04 129.09999999999999p 2.072584e-04 129.20000000000002p 2.494657e-04 129.30000000000001p 2.801224e-04 129.39999999999998p 2.970396e-04 129.5p 2.987882e-04 129.59999999999999p 2.847779e-04 129.69999999999999p 2.554220e-04 129.80000000000001p 2.123280e-04 129.90000000000001p 1.584001e-04 130p 9.773676e-05 130.09999999999999p 3.526865e-05 130.19999999999999p -2.381498e-05 130.30000000000001p -7.471709e-05 130.40000000000001p -1.136065e-04 130.5p -1.380024e-04 130.59999999999999p -1.469306e-04 130.69999999999999p -1.408750e-04 130.80000000000001p -1.215774e-04 130.90000000000001p -9.174079e-05 131p -5.467727e-05 131.09999999999999p -1.393393e-05 131.19999999999999p 2.707134e-05 131.30000000000001p 6.536142e-05 131.40000000000001p 9.860869e-05 131.5p 1.252019e-04 131.59999999999999p 1.441728e-04 131.69999999999999p 1.550447e-04 131.80000000000001p 1.577038e-04 131.90000000000001p 1.523792e-04 132p 1.397364e-04 132.09999999999999p 1.210009e-04 132.19999999999999p 9.798994e-05 132.30000000000001p 7.296739e-05 132.40000000000001p 4.832433e-05 132.5p 2.617147e-05 132.60000000000002p 7.975384e-06 132.69999999999999p -5.637045e-06 132.79999999999998p -1.483566e-05 132.90000000000001p -2.031781e-05 133p -2.291225e-05 133.10000000000002p -2.321115e-05 133.19999999999999p -2.137634e-05 133.29999999999998p -1.718881e-05 133.40000000000001p -1.030048e-05 133.5p -5.639974e-07 133.60000000000002p 1.170158e-05 133.69999999999999p 2.560659e-05 133.79999999999998p 3.977294e-05 133.90000000000001p 5.256356e-05 134p 6.238507e-05 134.09999999999999p 6.798440e-05 134.20000000000002p 6.867382e-05 134.29999999999998p 6.444229e-05 134.40000000000001p 5.593532e-05 134.5p 4.430982e-05 134.59999999999999p 3.099535e-05 134.70000000000002p 1.741590e-05 134.79999999999998p 4.742031e-06 134.90000000000001p -6.260666e-06 135p -1.524861e-05 135.09999999999999p -2.219175e-05 135.20000000000002p -2.719407e-05 135.29999999999998p -3.032015e-05 135.40000000000001p -3.149519e-05 135.5p -3.050937e-05 135.59999999999999p -2.711397e-05 135.70000000000002p -2.116346e-05 135.80000000000001p -1.274450e-05 135.89999999999998p -2.242478e-06 136p 9.679561e-06 136.09999999999999p 2.218274e-05 136.20000000000002p 3.440038e-05 136.30000000000001p 4.558302e-05 136.39999999999998p 5.519442e-05 136.5p 6.293300e-05 136.59999999999999p 6.868154e-05 136.70000000000002p 7.241316e-05 136.80000000000001p 7.409389e-05 136.89999999999998p 7.361874e-05 137p 7.080237e-05 137.09999999999999p 6.542562e-05 137.19999999999999p 5.732200e-05 137.30000000000001p 4.647858e-05 137.40000000000001p 3.312350e-05 137.5p 1.777677e-05 137.59999999999999p 1.248389e-06 137.69999999999999p -1.542225e-05 137.80000000000001p -3.108031e-05 137.90000000000001p -4.460487e-05 138p -5.506361e-05 138.09999999999999p -6.183572e-05 138.19999999999999p -6.466974e-05 138.30000000000001p -6.366038e-05 138.40000000000001p -5.915602e-05 138.5p -5.163368e-05 138.59999999999999p -4.158979e-05 138.69999999999999p -2.948533e-05 138.80000000000001p -1.575858e-05 138.90000000000001p -8.881102e-07 139p 1.453297e-05 139.09999999999999p 2.975630e-05 139.19999999999999p 4.390298e-05 139.30000000000001p 5.605950e-05 139.40000000000001p 6.542024e-05 139.5p 7.142931e-05 139.59999999999999p 7.387146e-05 139.69999999999999p 7.287957e-05 139.80000000000001p 6.885907e-05 139.90000000000001p 6.236081e-05 140p 5.394980e-05 140.10000000000002p 4.411287e-05 140.19999999999999p 3.322781e-05 140.29999999999998p 2.159208e-05 140.40000000000001p 9.489486e-06 140.5p -2.736013e-06 140.60000000000002p -1.462921e-05 140.69999999999999p -2.561661e-05 140.79999999999998p -3.505163e-05 140.90000000000001p -4.230501e-05 141p -4.687882e-05 141.10000000000002p -4.851162e-05 141.19999999999999p -4.724054e-05 141.29999999999998p -4.339657e-05 141.40000000000001p -3.753045e-05 141.5p -3.029142e-05 141.59999999999999p -2.229799e-05 141.70000000000002p -1.404125e-05 141.79999999999998p -5.847029e-06 141.90000000000001p 2.100559e-06 142p 9.693735e-06 142.09999999999999p 1.682589e-05 142.20000000000002p 2.333837e-05 142.29999999999998p 2.900882e-05 142.40000000000001p 3.358283e-05 142.5p 3.683329e-05 142.59999999999999p 3.862211e-05 142.70000000000002p 3.893948e-05 142.79999999999998p 3.790603e-05 142.90000000000001p 3.573852e-05 143p 3.269247e-05 143.09999999999999p 2.900225e-05 143.20000000000002p 2.483737e-05 143.30000000000001p 2.028648e-05 143.39999999999998p 1.537080e-05 143.5p 1.007983e-05 143.59999999999999p 4.417196e-06 143.70000000000002p -1.557009e-06 143.80000000000001p -7.699034e-06 143.89999999999998p -1.377656e-05 144p -1.948764e-05 144.09999999999999p -2.449898e-05 144.20000000000002p -2.849418e-05 144.30000000000001p -3.121950e-05 144.39999999999998p -3.251534e-05 144.5p -3.232597e-05 144.59999999999999p -3.068720e-05 144.69999999999999p -2.769909e-05 144.80000000000001p -2.349581e-05 144.90000000000001p -1.822487e-05 145p -1.204315e-05 145.09999999999999p -5.129823e-06 145.19999999999999p 2.291931e-06 145.30000000000001p 9.936297e-06 145.40000000000001p 1.745151e-05 145.5p 2.443866e-05 145.59999999999999p 3.049152e-05 145.69999999999999p 3.524810e-05 145.80000000000001p 3.843947e-05 145.90000000000001p 3.992134e-05 146p 3.967985e-05 146.09999999999999p 3.781127e-05 146.19999999999999p 3.448471e-05 146.30000000000001p 2.990153e-05 146.40000000000001p 2.426505e-05 146.5p 1.776898e-05 146.59999999999999p 1.060556e-05 146.69999999999999p 2.987268e-06 146.80000000000001p -4.828549e-06 146.90000000000001p -1.252402e-05 147p -1.972314e-05 147.09999999999999p -2.601636e-05 147.19999999999999p -3.100495e-05 147.30000000000001p -3.435606e-05 147.40000000000001p -3.585481e-05 147.5p -3.543922e-05 147.60000000000002p -3.320737e-05 147.69999999999999p -2.939446e-05 147.79999999999998p -2.432687e-05 147.90000000000001p -1.836730e-05 148p -1.186710e-05 148.10000000000002p -5.137557e-06 148.19999999999999p 1.556210e-06 148.29999999999998p 7.984081e-06 148.40000000000001p 1.393344e-05 148.5p 1.919736e-05 148.60000000000002p 2.357633e-05 148.69999999999999p 2.689431e-05 148.79999999999998p 2.902331e-05 148.90000000000001p 2.990605e-05 149p 2.956752e-05 149.09999999999999p 2.810979e-05 149.20000000000002p 2.569156e-05 149.29999999999998p 2.249898e-05 149.40000000000001p 1.871701e-05 149.5p 1.450939e-05 149.59999999999999p 1.001173e-05 149.70000000000002p 5.337220e-06 149.79999999999998p 5.907453e-07 149.90000000000001p -4.115165e-06 150p -8.648857e-06 150.09999999999999p -1.285710e-05 150.20000000000002p -1.657308e-05 150.29999999999998p -1.963308e-05 150.40000000000001p -2.189720e-05 150.5p -2.326826e-05 150.59999999999999p -2.370335e-05 150.70000000000002p -2.321482e-05 150.80000000000001p -2.186084e-05 150.89999999999998p -1.972920e-05 151p -1.692004e-05 151.09999999999999p -1.353342e-05 151.20000000000002p -9.665501e-06 151.30000000000001p -5.413588e-06 151.39999999999998p -8.870529e-07 151.5p 3.781361e-06 151.59999999999999p 8.429368e-06 151.70000000000002p 1.286795e-05 151.80000000000001p 1.689381e-05 151.89999999999998p 2.030880e-05 152p 2.294128e-05 152.09999999999999p 2.466376e-05 152.19999999999999p 2.540248e-05 152.30000000000001p 2.513753e-05 152.40000000000001p 2.389493e-05 152.5p 2.173472e-05 152.59999999999999p 1.873981e-05 152.69999999999999p 1.500922e-05 152.80000000000001p 1.065764e-05 152.90000000000001p 5.820269e-06 153p 6.599649e-07 153.09999999999999p -4.627398e-06 153.19999999999999p -9.813340e-06 153.30000000000001p -1.464544e-05 153.40000000000001p -1.886453e-05 153.5p -2.222828e-05 153.59999999999999p -2.453675e-05 153.69999999999999p -2.565467e-05 153.80000000000001p -2.552552e-05 153.90000000000001p -2.417467e-05 154p -2.170136e-05 154.09999999999999p -1.826273e-05 154.19999999999999p -1.405452e-05 154.30000000000001p -9.293343e-06 154.40000000000001p -4.203875e-06 154.5p 9.884407e-07 154.59999999999999p 6.060947e-06 154.69999999999999p 1.079690e-05 154.80000000000001p 1.499118e-05 154.90000000000001p 1.846006e-05 155p 2.105403e-05 155.10000000000002p 2.267072e-05 155.19999999999999p 2.326421e-05 155.29999999999998p 2.284757e-05 155.40000000000001p 2.148765e-05 155.5p 1.929349e-05 155.60000000000002p 1.640159e-05 155.69999999999999p 1.296178e-05 155.79999999999998p 9.127069e-06 155.90000000000001p 5.048691e-06 156p 8.757400e-07 156.10000000000002p -3.242735e-06 156.19999999999999p -7.156141e-06 156.29999999999998p -1.071379e-05 156.40000000000001p -1.377072e-05 156.5p -1.619753e-05 156.59999999999999p -1.789239e-05 156.70000000000002p -1.879208e-05 156.79999999999998p -1.887921e-05 156.90000000000001p -1.818324e-05 157p -1.677486e-05 157.09999999999999p -1.475522e-05 157.20000000000002p -1.224259e-05 157.29999999999998p -9.360050e-06 157.40000000000001p -6.226784e-06 157.5p -2.954356e-06 157.59999999999999p 3.526421e-07 157.70000000000002p 3.593481e-06 157.79999999999998p 6.668298e-06 157.90000000000001p 9.477408e-06 158p 1.192395e-05 158.09999999999999p 1.391949e-05 158.20000000000002p 1.539094e-05 158.30000000000001p 1.628671e-05 158.39999999999998p 1.658038e-05 158.5p 1.627079e-05 158.59999999999999p 1.537916e-05 158.70000000000002p 1.394436e-05 158.80000000000001p 1.201812e-05 158.89999999999998p 9.661852e-06 159p 6.945734e-06 159.09999999999999p 3.950048e-06 159.20000000000002p 7.676103e-07 159.30000000000001p -2.494220e-06 159.39999999999998p -5.713573e-06 159.5p -8.757261e-06 159.59999999999999p -1.148742e-05 159.69999999999999p -1.377098e-05 159.80000000000001p -1.549040e-05 159.90000000000001p -1.655389e-05 160p -1.690320e-05 160.09999999999999p -1.651775e-05 160.19999999999999p -1.541475e-05 160.30000000000001p -1.364599e-05 160.40000000000001p -1.129250e-05 160.5p -8.458624e-06 160.59999999999999p -5.266564e-06 160.69999999999999p -1.851900e-06 160.80000000000001p 1.640371e-06 160.90000000000001p 5.060044e-06 161p 8.257049e-06 161.09999999999999p 1.108837e-05 161.19999999999999p 1.342617e-05 161.30000000000001p 1.516618e-05 161.40000000000001p 1.623474e-05 161.5p 1.659327e-05 161.59999999999999p 1.623927e-05 161.69999999999999p 1.520397e-05 161.80000000000001p 1.354746e-05 161.90000000000001p 1.135270e-05 162p 8.719736e-06 162.09999999999999p 5.761080e-06 162.19999999999999p 2.598500e-06 162.30000000000001p -6.393179e-07 162.40000000000001p -3.819152e-06 162.5p -6.806692e-06 162.60000000000002p -9.471729e-06 162.69999999999999p -1.169513e-05 162.79999999999998p -1.337686e-05 162.90000000000001p -1.444390e-05 163p -1.485625e-05 163.10000000000002p -1.461013e-05 163.19999999999999p -1.373720e-05 163.29999999999998p -1.230034e-05 163.40000000000001p -1.038672e-05 163.5p -8.099680e-06 163.60000000000002p -5.550935e-06 163.69999999999999p -2.854231e-06 163.79999999999998p -1.208646e-07 163.90000000000001p 2.543168e-06 164p 5.039122e-06 164.09999999999999p 7.277359e-06 164.20000000000002p 9.179642e-06 164.29999999999998p 1.068193e-05 164.40000000000001p 1.173726e-05 164.5p 1.231797e-05 164.59999999999999p 1.241662e-05 164.70000000000002p 1.204533e-05 164.79999999999998p 1.123344e-05 164.90000000000001p 1.002422e-05 165p 8.471393e-06 165.09999999999999p 6.635989e-06 165.20000000000002p 4.584322e-06 165.29999999999998p 2.386872e-06 165.40000000000001p 1.178735e-07 165.5p -2.145026e-06 165.59999999999999p -4.321690e-06 165.70000000000002p -6.331448e-06 165.80000000000001p -8.096230e-06 165.89999999999998p -9.544635e-06 166p -1.061634e-05 166.09999999999999p -1.126617e-05 166.20000000000002p -1.146703e-05 166.30000000000001p -1.121144e-05 166.39999999999998p -1.051135e-05 166.5p -9.396759e-06 166.59999999999999p -7.913383e-06 166.70000000000002p -6.120145e-06 166.80000000000001p -4.086753e-06 166.89999999999998p -1.891554e-06 167p 3.804872e-07 167.09999999999999p 2.640041e-06 167.19999999999999p 4.796227e-06 167.30000000000001p 6.760182e-06 167.40000000000001p 8.449260e-06 167.5p 9.791484e-06 167.59999999999999p 1.072967e-05 167.69999999999999p 1.122459e-05 167.80000000000001p 1.125687e-05 167.90000000000001p 1.082729e-05 168p 9.955912e-06 168.09999999999999p 8.680266e-06 168.19999999999999p 7.053151e-06 168.30000000000001p 5.140410e-06 168.40000000000001p 3.018846e-06 168.5p 7.741716e-07 168.59999999999999p -1.501284e-06 168.69999999999999p -3.711460e-06 168.80000000000001p -5.760290e-06 168.90000000000001p -7.556277e-06 169p -9.017651e-06 169.09999999999999p -1.007758e-05 169.19999999999999p -1.068869e-05 169.30000000000001p -1.082636e-05 169.40000000000001p -1.049007e-05 169.5p -9.702961e-06 169.59999999999999p -8.509454e-06 169.69999999999999p -6.971687e-06 169.80000000000001p -5.165169e-06 169.90000000000001p -3.174330e-06 170p -1.088302e-06 170.10000000000002p 1.002881e-06 170.19999999999999p 3.011720e-06 170.29999999999998p 4.856447e-06 170.40000000000001p 6.464080e-06 170.5p 7.773311e-06 170.60000000000002p 8.737036e-06 170.69999999999999p 9.324257e-06 170.79999999999998p 9.521067e-06 170.90000000000001p 9.330563e-06 171p 8.771700e-06 171.10000000000002p 7.877321e-06 171.19999999999999p 6.691695e-06 171.29999999999998p 5.267947e-06 171.40000000000001p 3.665664e-06 171.5p 1.948808e-06 171.59999999999999p 1.838913e-07 171.70000000000002p -1.561746e-06 171.79999999999998p -3.221787e-06 171.90000000000001p -4.733048e-06 172p -6.037902e-06 172.09999999999999p -7.086847e-06 172.20000000000002p -7.840978e-06 172.29999999999998p -8.274004e-06 172.40000000000001p -8.373516e-06 172.5p -8.141317e-06 172.59999999999999p -7.592797e-06 172.70000000000002p -6.755525e-06 172.79999999999998p -5.667317e-06 172.90000000000001p -4.374115e-06 173p -2.927907e-06 173.09999999999999p -1.384848e-06 173.20000000000002p 1.964601e-07 173.30000000000001p 1.756603e-06 173.39999999999998p 3.237067e-06 173.5p 4.582123e-06 173.59999999999999p 5.740870e-06 173.70000000000002p 6.669325e-06 173.80000000000001p 7.332364e-06 173.89999999999998p 7.705281e-06 174p 7.774794e-06 174.09999999999999p 7.539430e-06 174.20000000000002p 7.009322e-06 174.30000000000001p 6.205547e-06 174.39999999999998p 5.159177e-06 174.5p 3.910176e-06 174.59999999999999p 2.506213e-06 174.69999999999999p 1.001365e-06 174.80000000000001p -5.453871e-07 174.90000000000001p -2.071991e-06 175p -3.515571e-06 175.09999999999999p -4.815088e-06 175.19999999999999p -5.914306e-06 175.30000000000001p -6.764822e-06 175.40000000000001p -7.328865e-06 175.5p -7.581563e-06 175.59999999999999p -7.512402e-06 175.69999999999999p -7.125761e-06 175.80000000000001p -6.440500e-06 175.90000000000001p -5.488715e-06 176p -4.313870e-06 176.09999999999999p -2.968496e-06 176.19999999999999p -1.511671e-06 176.30000000000001p -6.376735e-09 176.40000000000001p 1.483167e-06 176.5p 2.894187e-06 176.59999999999999p 4.167991e-06 176.69999999999999p 5.252488e-06 176.80000000000001p 6.104462e-06 176.90000000000001p 6.691435e-06 177p 6.992970e-06 177.09999999999999p 7.001305e-06 177.19999999999999p 6.721285e-06 177.30000000000001p 6.169658e-06 177.40000000000001p 5.373866e-06 177.5p 4.370494e-06 177.60000000000002p 3.203529e-06 177.69999999999999p 1.922535e-06 177.79999999999998p 5.807890e-07 177.90000000000001p -7.666340e-07 178p -2.064864e-06 178.10000000000002p -3.261334e-06 178.19999999999999p -4.307948e-06 178.29999999999998p -5.163216e-06 178.40000000000001p -5.794195e-06 178.5p -6.178057e-06 178.60000000000002p -6.303112e-06 178.69999999999999p -6.169155e-06 178.79999999999998p -5.787136e-06 178.90000000000001p -5.178193e-06 179p -4.372201e-06 179.09999999999999p -3.406022e-06 179.20000000000002p -2.321620e-06 179.29999999999998p -1.164183e-06 179.40000000000001p 1.966470e-08 179.5p 1.183549e-06 179.59999999999999p 2.282932e-06 179.70000000000002p 3.276603e-06 179.79999999999998p 4.128088e-06 179.90000000000001p 4.806904e-06 180p 5.289616e-06 180.09999999999999p 5.560604e-06 180.20000000000002p 5.612493e-06 180.29999999999998p 5.446214e-06 180.40000000000001p 5.070735e-06 180.5p 4.502507e-06 180.59999999999999p 3.764719e-06 180.70000000000002p 2.886411e-06 180.80000000000001p 1.901515e-06 180.89999999999998p 8.478055e-07 181p -2.342487e-07 181.09999999999999p -1.302765e-06 181.20000000000002p -2.315895e-06 181.30000000000001p -3.233413e-06 181.39999999999998p -4.018407e-06 181.5p -4.638963e-06 181.59999999999999p -5.069709e-06 181.70000000000002p -5.293096e-06 181.80000000000001p -5.300290e-06 181.90000000000001p -5.091601e-06 182p -4.676445e-06 182.09999999999999p -4.072847e-06 182.19999999999999p -3.306568e-06 182.30000000000001p -2.409926e-06 182.40000000000001p -1.420400e-06 182.5p -3.790719e-07 182.59999999999999p 6.710443e-07 182.69999999999999p 1.686745e-06 182.80000000000001p 2.626408e-06 182.90000000000001p 3.451734e-06 183p 4.129374e-06 183.09999999999999p 4.632361e-06 183.19999999999999p 4.941246e-06 183.30000000000001p 5.044870e-06 183.40000000000001p 4.940728e-06 183.5p 4.634939e-06 183.59999999999999p 4.141826e-06 183.69999999999999p 3.483201e-06 183.80000000000001p 2.687386e-06 183.90000000000001p 1.788045e-06 184p 8.228589e-07 184.09999999999999p -1.679410e-07 184.19999999999999p -1.143148e-06 184.30000000000001p -2.062257e-06 184.40000000000001p -2.887181e-06 184.5p -3.583952e-06 184.59999999999999p -4.124285e-06 184.69999999999999p -4.486915e-06 184.80000000000001p -4.658581e-06 184.90000000000001p -4.634577e-06 185p -4.418843e-06 185.10000000000002p -4.023573e-06 185.19999999999999p -3.468424e-06 185.29999999999998p -2.779388e-06 185.40000000000001p -1.987435e-06 185.5p -1.127025e-06 185.60000000000002p -2.345633e-07 185.69999999999999p 6.531279e-07 185.79999999999998p 1.500287e-06 185.90000000000001p 2.273593e-06 186p 2.943420e-06 186.10000000000002p 3.484912e-06 186.19999999999999p 3.878858e-06 186.29999999999998p 4.112303e-06 186.40000000000001p 4.178887e-06 186.5p 4.078893e-06 186.59999999999999p 3.819033e-06 186.70000000000002p 3.411991e-06 186.79999999999998p 2.875783e-06 186.90000000000001p 2.232972e-06 187p 1.509783e-06 187.09999999999999p 7.351356e-07 187.20000000000002p -6.037730e-08 187.29999999999998p -8.455751e-07 187.40000000000001p -1.589815e-06 187.5p -2.264139e-06 187.59999999999999p -2.842412e-06 187.70000000000002p -3.302382e-06 187.79999999999998p -3.626614e-06 187.90000000000001p -3.803221e-06 188p -3.826352e-06 188.09999999999999p -3.696396e-06 188.20000000000002p -3.419896e-06 188.30000000000001p -3.009202e-06 188.39999999999998p -2.481878e-06 188.5p -1.859928e-06 188.59999999999999p -1.168877e-06 188.70000000000002p -4.367397e-07 188.80000000000001p 3.070683e-07 188.89999999999998p 1.032871e-06 189p 1.711877e-06 189.09999999999999p 2.317301e-06 189.20000000000002p 2.825417e-06 189.30000000000001p 3.216501e-06 189.40000000000001p 3.475611e-06 189.5p 3.593165e-06 189.59999999999999p 3.565296e-06 189.69999999999999p 3.393965e-06 189.80000000000001p 3.086840e-06 189.90000000000001p 2.656959e-06 190p 2.122205e-06 190.09999999999999p 1.504606e-06 190.19999999999999p 8.294914e-07 190.30000000000001p 1.245241e-07 190.40000000000001p -5.813779e-07 190.5p -1.259200e-06 190.59999999999999p -1.881034e-06 190.69999999999999p -2.421284e-06 190.80000000000001p -2.857805e-06 190.90000000000001p -3.172911e-06 191p -3.354189e-06 191.09999999999999p -3.395061e-06 191.19999999999999p -3.295045e-06 191.30000000000001p -3.059725e-06 191.40000000000001p -2.700418e-06 191.5p -2.233572e-06 191.59999999999999p -1.679957e-06 191.69999999999999p -1.063680e-06 191.80000000000001p -4.110929e-07 191.90000000000001p 2.503620e-07 192p 8.933163e-07 192.09999999999999p 1.491612e-06 192.19999999999999p 2.021362e-06 192.30000000000001p 2.461894e-06 192.40000000000001p 2.796548e-06 192.5p 3.013276e-06 192.60000000000002p 3.105039e-06 192.69999999999999p 3.069985e-06 192.79999999999998p 2.911397e-06 192.90000000000001p 2.637445e-06 193p 2.260751e-06 193.10000000000002p 1.797808e-06 193.19999999999999p 1.268271e-06 193.29999999999998p 6.941548e-07 193.40000000000001p 9.896739e-08 193.5p -4.932125e-07 193.60000000000002p -1.058673e-06 193.69999999999999p -1.575001e-06 193.79999999999998p -2.021978e-06 193.90000000000001p -2.382389e-06 194p -2.642714e-06 194.09999999999999p -2.793658e-06 194.20000000000002p -2.830494e-06 194.29999999999998p -2.753192e-06 194.40000000000001p -2.566340e-06 194.5p -2.278870e-06 194.59999999999999p -1.903603e-06 194.70000000000002p -1.456650e-06 194.79999999999998p -9.567100e-07 194.90000000000001p -4.242869e-07 195p 1.191364e-07 195.09999999999999p 6.519372e-07 195.20000000000002p 1.153183e-06 195.29999999999998p 1.603422e-06 195.40000000000001p 1.985415e-06 195.5p 2.284769e-06 195.59999999999999p 2.490465e-06 195.70000000000002p 2.595244e-06 195.80000000000001p 2.595851e-06 195.89999999999998p 2.493113e-06 196p 2.291876e-06 196.09999999999999p 2.000789e-06 196.20000000000002p 1.631949e-06 196.30000000000001p 1.200441e-06 196.39999999999998p 7.237566e-07 196.5p 2.211369e-07 196.59999999999999p -2.871659e-07 196.70000000000002p -7.806761e-07 196.80000000000001p -1.239510e-06 196.90000000000001p -1.645191e-06 197p -1.981423e-06 197.09999999999999p -2.234790e-06 197.19999999999999p -2.395338e-06 197.30000000000001p -2.457006e-06 197.40000000000001p -2.417883e-06 197.5p -2.280275e-06 197.59999999999999p -2.050582e-06 197.69999999999999p -1.738986e-06 197.80000000000001p -1.358992e-06 197.90000000000001p -9.268162e-07 198p -4.606826e-07 198.09999999999999p 1.996214e-08 198.19999999999999p 4.952673e-07 198.30000000000001p 9.458055e-07 198.40000000000001p 1.353372e-06 198.5p 1.701724e-06 198.59999999999999p 1.977228e-06 198.69999999999999p 2.169393e-06 198.80000000000001p 2.271262e-06 198.90000000000001p 2.279646e-06 199p 2.195208e-06 199.09999999999999p 2.022374e-06 199.19999999999999p 1.769111e-06 199.30000000000001p 1.446556e-06 199.40000000000001p 1.068533e-06 199.5p 6.509759e-07 199.59999999999999p 2.112697e-07 199.69999999999999p -2.324589e-07 199.80000000000001p -6.620803e-07 199.90000000000001p -1.060203e-06)

I_WL1 0 WL1 pwl(0 0 50p 0 51p -100u 60p -100u 61p 0 70p 0 71p +100u 80p +100u 81p 0 90p 0 91p +100u 100p +100u 101p 0 110p 0 111p 0 120p 0 121p 0 200p 0)
I_BL1 0 BL1 pwl(0 0 50p 0 51p -100u 60p -100u 61p 0 70p 0 71p 0 80p 0 81p 0 90p 0 91p +100u 100p +100u 101p 0 110p 0 111p 0 120p 0 121p 0 200p 0)
I_SE1 0 SE1 pwl(0 0 50p 0 51p 0 60p 0 61p 0 70p 0 71p +100u 80p +100u 81p 0 90p 0 91p 0 100p 0 101p 0 110p 0 111p 0 120p 0 121p 0 200p 0)
I_WL2 0 WL2 pwl(0 0 50p 0 51p -100u 60p -100u 61p 0 70p 0 71p +100u 80p +100u 81p 0 90p 0 91p +100u 100p +100u 101p 0 110p 0 111p +100u 120p +100u 121p 0 200p 0)
I_BL2 0 BL2 pwl(0 0 50p 0 51p -100u 60p -100u 61p 0 70p 0 71p 0 80p 0 81p 0 90p 0 91p +100u 100p +100u 101p 0 110p 0 111p 0 120p 0 121p 0 200p 0)
I_SE2 0 SE2 pwl(0 0 50p 0 51p 0 60p 0 61p 0 70p 0 71p +100u 80p +100u 81p 0 90p 0 91p 0 100p 0 101p 0 110p 0 111p +100u 120p +100u 121p 0 200p 0)
I_WL3 0 WL3 pwl(0 0 50p 0 51p -100u 60p -100u 61p 0 70p 0 71p +100u 80p +100u 81p 0 90p 0 91p +100u 100p +100u 101p 0 110p 0 111p +100u 120p +100u 121p 0 200p 0)
I_BL3 0 BL3 pwl(0 0 50p 0 51p -100u 60p -100u 61p 0 70p 0 71p 0 80p 0 81p 0 90p 0 91p +100u 100p +100u 101p 0 110p 0 111p 0 120p 0 121p 0 200p 0)
I_SE3 0 SE3 pwl(0 0 50p 0 51p 0 60p 0 61p 0 70p 0 71p +100u 80p +100u 81p 0 90p 0 91p 0 100p 0 101p 0 110p 0 111p +100u 120p +100u 121p 0 200p 0)
I_WL4 0 WL4 pwl(0 0 50p 0 51p -100u 60p -100u 61p 0 70p 0 71p +100u 80p +100u 81p 0 90p 0 91p +100u 100p +100u 101p 0 110p 0 111p +100u 120p +100u 121p 0 200p 0)
I_BL4 0 BL4 pwl(0 0 50p 0 51p -100u 60p -100u 61p 0 70p 0 71p 0 80p 0 81p 0 90p 0 91p +100u 100p +100u 101p 0 110p 0 111p 0 120p 0 121p 0 200p 0)
I_SE4 0 SE4 pwl(0 0 50p 0 51p 0 60p 0 61p 0 70p 0 71p +100u 80p +100u 81p 0 90p 0 91p 0 100p 0 101p 0 110p 0 111p +100u 120p +100u 121p 0 200p 0)

.tran 0.1p 200p

.print I(I_WL1) I(I_BL1) I(I_SE1)
.print P(B_JM1|XBVM1) V(B_JM1|XBVM1) I(B_JM1|XBVM1)
.print P(B_JM2|XBVM1) V(B_JM2|XBVM1) I(B_JM2|XBVM1)
.print P(B_JS1|XBVM1) V(B_JS1|XBVM1) I(B_JS1|XBVM1)
.print P(B_JS2|XBVM1) V(B_JS2|XBVM1) I(B_JS2|XBVM1)
.print I(L_M1|XBVM1) V(L_M1|XBVM1)
.print I(L_M2|XBVM1) V(L_M2|XBVM1)
.print I(L_M3|XBVM1) V(L_M3|XBVM1)
.print I(L_PM|XBVM1) V(L_PM|XBVM1)
.print I(L_S1|XBVM1) V(L_S1|XBVM1)
.print I(L_S2|XBVM1) V(L_S2|XBVM1)
.print I(L_S3|XBVM1) V(L_S3|XBVM1)
.print I(R_S|XBVM1) V(R_S|XBVM1)
.print I(L_PSL|XBVM1) V(L_PSL|XBVM1)
.print I(R_SL|XBVM1) V(R_SL|XBVM1)
.print I(L_SL|XBVM1) V(L_SL|XBVM1)
.print I(I_WL2) I(I_BL2) I(I_SE2)
.print P(B_JM1|XBVM2) V(B_JM1|XBVM2) I(B_JM1|XBVM2)
.print P(B_JM2|XBVM2) V(B_JM2|XBVM2) I(B_JM2|XBVM2)
.print P(B_JS1|XBVM2) V(B_JS1|XBVM2) I(B_JS1|XBVM2)
.print P(B_JS2|XBVM2) V(B_JS2|XBVM2) I(B_JS2|XBVM2)
.print I(L_M1|XBVM2) V(L_M1|XBVM2)
.print I(L_M2|XBVM2) V(L_M2|XBVM2)
.print I(L_M3|XBVM2) V(L_M3|XBVM2)
.print I(L_PM|XBVM2) V(L_PM|XBVM2)
.print I(L_S1|XBVM2) V(L_S1|XBVM2)
.print I(L_S2|XBVM2) V(L_S2|XBVM2)
.print I(L_S3|XBVM2) V(L_S3|XBVM2)
.print I(R_S|XBVM2) V(R_S|XBVM2)
.print I(L_PSL|XBVM2) V(L_PSL|XBVM2)
.print I(R_SL|XBVM2) V(R_SL|XBVM2)
.print I(L_SL|XBVM2) V(L_SL|XBVM2)
.print I(I_WL3) I(I_BL3) I(I_SE3)
.print P(B_JM1|XBVM3) V(B_JM1|XBVM3) I(B_JM1|XBVM3)
.print P(B_JM2|XBVM3) V(B_JM2|XBVM3) I(B_JM2|XBVM3)
.print P(B_JS1|XBVM3) V(B_JS1|XBVM3) I(B_JS1|XBVM3)
.print P(B_JS2|XBVM3) V(B_JS2|XBVM3) I(B_JS2|XBVM3)
.print I(L_M1|XBVM3) V(L_M1|XBVM3)
.print I(L_M2|XBVM3) V(L_M2|XBVM3)
.print I(L_M3|XBVM3) V(L_M3|XBVM3)
.print I(L_PM|XBVM3) V(L_PM|XBVM3)
.print I(L_S1|XBVM3) V(L_S1|XBVM3)
.print I(L_S2|XBVM3) V(L_S2|XBVM3)
.print I(L_S3|XBVM3) V(L_S3|XBVM3)
.print I(R_S|XBVM3) V(R_S|XBVM3)
.print I(L_PSL|XBVM3) V(L_PSL|XBVM3)
.print I(R_SL|XBVM3) V(R_SL|XBVM3)
.print I(L_SL|XBVM3) V(L_SL|XBVM3)
.print I(I_WL4) I(I_BL4) I(I_SE4)
.print P(B_JM1|XBVM4) V(B_JM1|XBVM4) I(B_JM1|XBVM4)
.print P(B_JM2|XBVM4) V(B_JM2|XBVM4) I(B_JM2|XBVM4)
.print P(B_JS1|XBVM4) V(B_JS1|XBVM4) I(B_JS1|XBVM4)
.print P(B_JS2|XBVM4) V(B_JS2|XBVM4) I(B_JS2|XBVM4)
.print I(L_M1|XBVM4) V(L_M1|XBVM4)
.print I(L_M2|XBVM4) V(L_M2|XBVM4)
.print I(L_M3|XBVM4) V(L_M3|XBVM4)
.print I(L_PM|XBVM4) V(L_PM|XBVM4)
.print I(L_S1|XBVM4) V(L_S1|XBVM4)
.print I(L_S2|XBVM4) V(L_S2|XBVM4)
.print I(L_S3|XBVM4) V(L_S3|XBVM4)
.print I(R_S|XBVM4) V(R_S|XBVM4)
.print I(L_PSL|XBVM4) V(L_PSL|XBVM4)
.print I(R_SL|XBVM4) V(R_SL|XBVM4)
.print I(L_SL|XBVM4) V(L_SL|XBVM4)
.print V(COMMON_SL)
.print P(B_JSL1) V(B_JSL1) I(B_JSL1)
.print P(B_JSL2) V(B_JSL2) I(B_JSL2)
.print P(B_JSL3) V(B_JSL3) I(B_JSL3)
.print P(B_JSL4) V(B_JSL4) I(B_JSL4)
.print P(B_JSL5) V(B_JSL5) I(B_JSL5)
.print P(B_JSL6) V(B_JSL6) I(B_JSL6)
.print P(B_JSL7) V(B_JSL7) I(B_JSL7)
.print P(B_JSL8) V(B_JSL8) I(B_JSL8)
.print V(QBIN)
.print I(V_REPLAY)
.end
