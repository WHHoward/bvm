* QB-Q2C frozen topology with uniform junction scale
.subckt BQ IN OUT IB
Lin IN 1 0.8p
L0 4 OUT 1.323p
L1 2 3 3.91p
L2 3 4 3.91p
BJs 1 2 jjmit area=0.275
BJL1 2 0 jjmit area=0.198
RJ1 2 0 33
BJL2 4 0 jjmit area=0.297
RJ2 4 0 22
RB IB 3 6
.ends BQ
