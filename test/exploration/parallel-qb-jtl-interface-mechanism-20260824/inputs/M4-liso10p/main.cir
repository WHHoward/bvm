* QB-Q0 scaled standalone fixture; IIN=68.4 uA.
.include jjmit.cir
.include bq_cell.cir

XBQ IN OUT IBIAS BQ
R_LOAD OUT 0 10
I_IBIAS 0 IBIAS pwl(0p 0 1p 35u 2p 35u 300p 35u)
I_IN 0 IN pulse(0 68.4u 10p 1p 1p 5p 50p)

.tran 0.1p 300p
.print P(BJs|XBQ) V(BJs|XBQ) I(BJs|XBQ)
.print P(BJL1|XBQ) V(BJL1|XBQ) I(BJL1|XBQ)
.print P(BJL2|XBQ) V(BJL2|XBQ) I(BJL2|XBQ)
.print I(I_IN) I(I_IBIAS) V(IN) V(OUT) I(R_LOAD)
.print I(Lin|XBQ) I(L0|XBQ) I(L1|XBQ) I(L2|XBQ) I(RB|XBQ) I(RJ1|XBQ) I(RJ2|XBQ)
L_ISO OUT JTL_IN 10p
.include JTL.cir
XJTL1 JTL_IN   JTL_MID THmitll_JTL
XJTL2 JTL_MID  JTL_OUT THmitll_JTL
R_TERM JTL_OUT 0 1

.print P(B1|XJTL1) V(B1|XJTL1) I(B1|XJTL1) P(B2|XJTL1) V(B2|XJTL1) I(B2|XJTL1)
.print P(B1|XJTL2) V(B1|XJTL2) I(B1|XJTL2) P(B2|XJTL2) V(B2|XJTL2) I(B2|XJTL2)
.print I(L1|XJTL1) I(L2|XJTL1) I(L3|XJTL1) I(L4|XJTL1) I(IB1|XJTL1) I(RB1|XJTL1) I(RB2|XJTL1)
.print I(L1|XJTL2) I(L2|XJTL2) I(L3|XJTL2) I(L4|XJTL2) I(IB1|XJTL2) I(RB1|XJTL2) I(RB2|XJTL2)
.print V(JTL_MID) V(JTL_OUT) I(R_TERM) I(L1|XJTL1)
.end
