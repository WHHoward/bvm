* SFQ Generator — I-optimized for T1 I input
* Model: jjmit area=3.5 (IC=350μA). .include jjmit.cir first.
* L_OUT=0.3pH

.subckt sfq_gen_i TRIG OUT V_BIAS

B0 N_J 0 jjmit area=3.5

R_BIAS V_BIAS N_J 6.8
R_TRIG TRIG N_J 5
L_OUT N_J OUT 0.3pH

.ends sfq_gen_i
