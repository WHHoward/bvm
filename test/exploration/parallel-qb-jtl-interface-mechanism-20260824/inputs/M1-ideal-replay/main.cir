.include jjmit.cir
.include JTL.cir
V_REPLAY JTL_IN 0 pwl(0p 0 0.1p 9.096886e-07 0.2p 3.601949e-06 0.3p 8.448067e-06 0.4p 1.531759e-05 0.5p 2.376983e-05 0.6p 3.325609e-05 0.7p 4.325942e-05 0.8p 5.336239e-05 0.9p 6.326039e-05 1p 7.274415e-05 1.1p 8.076161e-05 1.2p 8.633732e-05 1.3p 8.901883e-05 1.4p 8.886798e-05 1.5p 8.626865e-05 1.6p 8.172885e-05 1.7p 7.574715e-05 1.8p 6.875054e-05 1.9p 6.108422e-05 2p 5.302919e-05 2.1p 4.482773e-05 2.2p 3.670406e-05 2.3p 2.88748e-05 2.4p 2.154847e-05 2.5p 1.491682e-05 2.6p 9.141841e-06 2.7p 4.342569e-06 2.8p 5.84778e-07 2.9p -2.124203e-06 3p -3.834798e-06 3.1p -4.648819e-06 3.2p -4.70852e-06 3.3p -4.182639e-06 3.4p -3.251228e-06 3.5p -2.090964e-06 3.6p -8.623886e-07 3.7p 2.999149e-07 3.8p 1.293628e-06 3.9p 2.051384e-06 4p 2.540102e-06 4.1p 2.757532e-06 4.2p 2.726767e-06 4.3p 2.489532e-06 4.4p 2.099041e-06 4.5p 1.613152e-06 4.6p 1.088337e-06 4.7p 5.748788e-07 4.8p 1.134806e-07 4.9p -2.666564e-07 5p -5.483906e-07 5.1p -7.260271e-07 5.2p -8.038012e-07 5.3p -7.937551e-07 5.4p -7.133052e-07 5.5p -5.827703e-07 5.6p -4.23086e-07 5.7p -2.538741e-07 5.8p -9.197247e-08 5.9p 4.952659e-08 6p 1.617376e-07 6.1p 2.399912e-07 6.2p 2.834731e-07 6.3p 2.945902e-07 6.4p 2.781712e-07 6.5p 2.405984e-07 6.6p 1.889633e-07 6.7p 1.303124e-07 6.8p 7.103512e-08 6.9p 1.642105e-08 7p -2.960591e-08 7.1p -6.458469e-08 7.2p -8.746799e-08 7.3p -9.845794e-08 7.4p -9.876174e-08 7.5p -9.030346e-08 7.6p -7.542516e-08 7.7p -5.66056e-08 7.8p -3.621797e-08 7.9p -1.63409e-08 8p 1.370308e-09 8.1p 1.575199e-08 8.2p 2.614477e-08 8.3p 3.235975e-08 8.4p 3.460947e-08 8.5p 3.341621e-08 8.6p 2.950979e-08 8.7p 2.372573e-08 8.8p 1.691264e-08 8.9p 9.855295e-09 9p 3.217348e-09 9.1p -2.494959e-09 9.2p -6.948625e-09 9.3p -9.981648e-09 9.4p -1.158617e-08 9.5p -1.188114e-08 9.6p -1.107886e-08 9.7p -9.449316e-09 9.8p -7.286057e-09 9.9p -4.876099e-09 10p -2.475931e-09 10.1p 7.059329e-08 10.2p 4.526341e-07 10.3p 1.596625e-06 10.4p 4.131675e-06 10.5p 8.751539e-06 10.6p 1.60707e-05 10.7p 2.649283e-05 10.8p 4.012549e-05 10.9p 5.675753e-05 11p 7.589917e-05 11.1p 9.680084e-05 11.2p 0.0001184715 11.3p 0.0001397454 11.4p 0.0001594101 11.5p 0.0001763681 11.6p 0.0001897875 11.7p 0.0001992042 11.8p 0.0002045565 11.9p 0.0002061547 12p 0.0002046021 12.1p 0.0002006901 12.2p 0.0001952923 12.3p 0.0001892714 12.4p 0.0001834122 12.5p 0.0001783819 12.6p 0.000174715 12.7p 0.0001728188 12.8p 0.0001729924 12.9p 0.0001754528 13p 0.0001803636 13.1p 0.0001878624 13.2p 0.0001980847 13.3p 0.0002111829 13.4p 0.0002273394 13.5p 0.0002467738 13.6p 0.0002697431 13.7p 0.0002965351 13.8p 0.0003274533 13.9p 0.0003627944 14p 0.0004028163 14.1p 0.0004476963 14.2p 0.0004974763 14.3p 0.0005519874 14.4p 0.0006107431 14.5p 0.0006727873 14.6p 0.0007364936 14.7p 0.0007993388 14.9p 0.0009069981 15p 0.000941811 15.1p 0.000956956 15.2p 0.0009485316 15.3p 0.0009151062 15.4p 0.0008584076 15.5p 0.0007832173 15.6p 0.0006964745 15.7p 0.00060591 15.8p 0.0005186562 15.9p 0.0004402069 16p 0.0003739054 16.1p 0.0003208781 16.2p 0.0002803128 16.3p 0.0002499684 16.4p 0.0002267855 16.5p 0.0002074716 16.6p 0.0001889722 16.7p 0.0001687841 16.8p 0.0001451104 16.9p 0.0001168905 17p 8.37495e-05 17.1p 4.598132e-05 17.2p 4.558732e-06 17.3p -3.889361e-05 17.4p -8.220713e-05 17.5p -0.0001228682 17.6p -0.0001582888 17.7p -0.000186113 17.8p -0.0002045113 17.9p -0.0002124179 18p -0.0002096694 18.1p -0.0001970225 18.2p -0.000176049 18.3p -0.0001489307 18.4p -0.0001181903 18.5p -8.640444e-05 18.6p -5.59407e-05 18.7p -2.875079e-05 18.8p -6.238121e-06 18.9p 1.079561e-05 19p 2.213195e-05 19.1p 2.806063e-05 19.2p 2.926688e-05 19.3p 2.670056e-05 19.4p 2.144457e-05 19.5p 1.459581e-05 19.6p 7.167599e-06 19.7p 1.839308e-08 19.8p -6.192344e-06 19.9p -1.102263e-05 20p -1.424434e-05 20.1p -1.582202e-05 20.2p -1.587923e-05 20.3p -1.465743e-05 20.4p -1.247233e-05 20.5p -9.671727e-06 20.6p -6.598282e-06 20.7p -3.559542e-06 20.8p -8.065714e-07 20.9p 1.478462e-06 21p 3.186256e-06 21.1p 4.277069e-06 21.2p 4.771793e-06 21.3p 4.739215e-06 21.4p 4.281346e-06 21.5p 3.518468e-06 21.6p 2.575298e-06 21.7p 1.569287e-06 21.8p 6.016936e-07 21.9p -2.483003e-07 22p -9.264625e-07 22.1p -1.403687e-06 22.2p -1.67394e-06 22.3p -1.750571e-06 22.4p -1.661595e-06 22.5p -1.444555e-06 22.6p -1.141482e-06 22.7p -7.943791e-07 22.8p -4.415275e-07 22.9p -1.147942e-07 23p 1.6201e-07 23.1p 3.737634e-07 23.2p 5.137869e-07 23.3p 5.828996e-07 23.4p 5.879863e-07 23.5p 5.402915e-07 23.6p 4.536413e-07 23.7p 3.427604e-07 23.8p 2.218177e-07 23.9p 1.032838e-07 24p -2.853565e-09 24.1p -8.951447e-08 24.2p -1.526188e-07 24.3p -1.908984e-07 24.4p -2.054971e-07 24.5p -1.994312e-07 24.6p -1.769842e-07 24.7p -1.431001e-07 24.8p -1.028292e-07 24.9p -6.086521e-08 25p -2.119776e-08 25.1p 1.310994e-08 25.2p 4.002175e-08 25.3p 5.852075e-08 25.4p 6.851332e-08 25.5p 7.066952e-08 25.6p 6.622545e-08 25.7p 5.677186e-08 25.8p 4.405003e-08 25.9p 2.97715e-08 26p 1.547327e-08 26.1p 2.414572e-09 26.2p -8.483173e-09 26.3p -1.665582e-08 26.4p -2.188109e-08 26.5p -2.423589e-08 26.6p -2.403521e-08 26.7p -2.176116e-08 26.8p -1.799025e-08 26.9p -1.332563e-08 27p -8.33926e-09 27.1p -3.527399e-09 27.2p 7.192366e-10 27.3p 4.130581e-09 27.4p 6.558996e-09 27.5p 7.96998e-09 27.6p 8.424632e-09 27.7p 8.056904e-09 27.8p 7.048596e-09 27.9p 5.604702e-09 28p 3.931186e-09 28.1p 2.216733e-09 28.2p 6.193146e-10 28.3p -7.420905e-10 28.4p -1.790856e-09 28.5p -2.491737e-09 28.6p -2.846438e-09 28.7p -2.88675e-09 28.8p -2.666287e-09 28.9p -2.251812e-09 29p -1.714985e-09 29.1p -1.125182e-09 29.2p -5.438154e-10 29.3p -2.039542e-11 29.4p 4.096575e-10 29.5p 7.255595e-10 29.6p 9.203273e-10 29.7p 9.988825e-10 29.8p 9.754553e-10 29.9p 8.706427e-10 30p 7.084429e-10 30.1p 5.135296e-10 30.2p 3.089632e-10 30.3p 1.144594e-10 30.4p -5.47339e-11 30.5p -1.883632e-10 30.6p -2.811613e-10 30.7p -3.324036e-10 30.8p -3.451458e-10 30.9p -3.252682e-10 31p -2.804464e-10 31.1p -2.191502e-10 31.2p -1.497564e-10 31.3p -7.982975e-11 31.4p -1.560663e-11 31.5p 3.831119e-11 31.6p 7.906324e-11 31.7p 1.054651e-10 31.8p 1.178074e-10 31.9p 1.175626e-10 32p 1.070405e-10 32.1p 8.903326e-11 32.2p 6.648265e-11 32.3p 4.219456e-11 32.4p 1.861732e-11 32.5p -2.308234e-12 32.6p -1.922695e-11 32.7p -3.13818e-11 32.8p -3.857166e-11 32.9p -4.10679e-11 33p -3.950463e-11 33.1p -3.47571e-11 33.2p -2.782103e-11 33.3p -1.970327e-11 33.4p -1.133137e-11 33.5p -3.486568e-12 33.6p 3.238191e-12 33.7p 8.456108e-12 33.8p 1.198298e-11 33.9p 1.381661e-11 34p 1.41038e-11 34.1p 1.310048e-11 34.2p 1.112937e-11 34.3p 8.539455e-12 34.4p 5.67062e-12 34.5p 2.82546e-12 34.6p 2.49469e-13 34.7p -1.880122e-12 34.8p -3.45749e-12 34.9p -4.444536e-12 35p -4.861912e-12 35.1p -4.776544e-12 35.2p -4.287318e-12 35.3p -3.510615e-12 35.4p -2.566882e-12 35.5p -1.569346e-12 35.6p -6.153703e-13 35.7p 2.191979e-13 35.8p 8.828008e-13 35.9p 1.348258e-12 36p 1.610721e-12 36.1p 1.684046e-12 36.2p 1.596186e-12 36.3p 1.384155e-12 36.4p 1.089145e-12 36.5p 7.521383e-13 36.6p 4.103697e-13 36.7p 9.46958e-14 36.8p -1.719015e-13 36.9p -3.749379e-13 37p -5.081456e-13 37.1p -5.725199e-13 37.2p -5.749205e-13 37.3p -5.26414e-13 37.4p -4.405004e-13 37.5p -3.315285e-13 37.6p -2.132656e-13 37.7p -9.778035e-14 37.8p 5.30314e-15 37.9p 8.917124e-14 38p 1.499699e-13 38.1p 1.865504e-13 38.2p 2.001009e-13 38.3p 1.936118e-13 38.4p 1.713118e-13 38.5p 1.380241e-13 38.6p 9.866165e-14 38.7p 5.780182e-14 38.8p 1.928554e-14 38.9p -1.391225e-14 39p -3.986234e-14 39.1p -5.758478e-14 39.2p -6.703353e-14 39.3p -6.887725e-14 39.4p -6.433922e-14 39.5p -5.498254e-14 39.6p -4.249528e-14 39.7p -2.854795e-14 39.8p -1.463351e-14 39.9p -1.957712e-15 40p 8.580608e-15 40.1p 1.64553e-14 40.2p 2.145371e-14 40.3p 2.365915e-14 40.4p 2.33895e-14 40.5p 2.11161e-14 40.6p 1.739798e-14 40.7p 1.282926e-14 40.8p 7.964576e-15 40.9p 3.286237e-15 41p -8.35261e-16 41.1p -4.125883e-15 41.2p -6.460667e-15 41.3p -7.802347e-15 41.4p -8.216689e-15 41.5p -7.833039e-15 41.6p -6.833356e-15 41.7p -5.414947e-15 41.8p -3.775117e-15 41.9p -2.10021e-15 42p -5.480715e-16 42.1p 7.826462e-16 42.2p 1.788906e-15 42.3p 2.457553e-15 42.4p 2.784203e-15 42.5p 2.810511e-15 42.6p 2.582513e-15 42.7p 2.174748e-15 42.8p 1.655176e-15 42.9p 1.076413e-15 43p 5.064181e-16 43.1p 2.192286e-18 43.2p -4.165344e-16 43.3p -7.103007e-16 43.4p -8.900682e-16 43.5p -9.580291e-16 43.6p -9.339139e-16 43.7p -8.35261e-16 43.8p -6.708396e-16 43.9p -4.866875e-16 44p -2.893818e-16 44.1p -1.052297e-16 44.2p 6.138401e-17 44.3p 1.885366e-16 44.4p 2.718435e-16 44.5p 3.200738e-16 44.6p 3.332275e-16 44.7p 3.178815e-16 44.8p 2.740358e-16 44.9p 2.126518e-16 45p 1.446909e-16 45.1p 7.453773e-17 45.2p 1.315372e-17 45.3p -3.946115e-17 45.4p -7.89223e-17 45.5p -1.07422e-16 45.6p -1.139989e-16 45.7p -1.118066e-16 45.8p -1.052297e-16 45.9p -8.769145e-17 46p -6.35763e-17 46.1p -4.165344e-17 46.2p -1.753829e-17 46.3p 4.384572e-18 46.4p 1.973058e-17 46.5p 3.726887e-17 46.6p 4.165344e-17 46.7p 4.603801e-17 46.8p 4.603801e-17 46.9p 3.946115e-17 47p 3.069201e-17 47.1p 2.849972e-17 47.2p 1.753829e-17 47.3p 1.315372e-17 47.4p 4.384572e-18 47.5p 2.192286e-18 47.6p 0 47.7p -8.769145e-18 47.8p -8.769145e-18 47.9p -1.753829e-17 48p -1.753829e-17 48.1p -1.753829e-17 48.2p -1.315372e-17 48.3p -4.384572e-18 48.4p -4.384572e-18 48.5p 0 48.6p 4.384572e-18 48.7p 6.576859e-18 48.8p 6.576859e-18 48.9p 4.384572e-18 49p 2.192286e-18 49.1p 4.384572e-18 49.2p 8.769145e-18 49.3p 1.315372e-17 49.4p 1.096143e-17 49.5p 6.576859e-18 49.6p 1.096143e-17 49.7p 4.384572e-18 49.8p 4.384572e-18 49.9p -2.192286e-18 50p -4.384572e-18 50.1p -4.384572e-18 50.2p -2.192286e-18 50.3p -4.384572e-18 50.4p -2.192286e-18 50.5p 4.384572e-18 50.6p 6.576859e-18 50.7p 6.576859e-18 50.8p 4.384572e-18 50.9p -2.192286e-18 51p 0 51.1p 0 51.2p 0 51.3p 0 51.4p 0 51.5p 0 51.6p 0 51.7p 0 51.8p 0 51.9p 0 52p 0 52.1p 0 52.2p 0 52.3p 0 52.4p 0 52.5p 0 52.6p 0 52.7p 0 52.8p 0 52.9p 0 53p 0 53.1p 0 53.2p 0 53.3p 0 53.4p 0 53.5p 0 53.6p 0 53.7p 0 53.8p 0 53.9p 0 54p 0 54.1p 0 54.2p 0 54.3p 0 54.4p 0 54.5p 0 54.6p 0 54.7p 0 54.8p 0 54.9p 0 55p 0 55.1p 0 55.2p 0 55.3p 0 55.4p 0 55.5p 0 55.6p 0 55.7p 0 55.8p 0 55.9p 0 56p 0 56.1p 0 56.2p 0 56.3p 0 56.4p 0 56.5p 0 56.6p 0 56.7p 0 56.8p 0 56.9p 0 57p 0 57.1p 0 57.2p 0 57.3p 0 57.4p 0 57.5p 0 57.6p 0 57.7p 0 57.8p 0 57.9p 0 58p 0 58.1p 0 58.2p 0 58.3p 0 58.4p 0 58.5p 0 58.6p 0 58.7p 0 58.8p 0 58.9p 0 59p 0 59.1p 0 59.2p 0 59.3p 0 59.4p 0 59.5p 0 59.6p 0 59.7p 0 59.8p 0 59.9p 0 60p 0 60.1p 7.088784e-08 60.2p 4.511178e-07 60.3p 1.59376e-06 60.4p 4.127958e-06 60.5p 8.747451e-06 60.6p 1.606666e-05 60.7p 2.648919e-05 60.8p 4.012249e-05 60.9p 5.67553e-05 61p 7.589777e-05 61.1p 9.680023e-05 61.2p 0.0001184716 61.3p 0.000139746 61.4p 0.0001594111 61.5p 0.0001763694 61.6p 0.0001897889 61.7p 0.0001992055 61.8p 0.0002045577 61.9p 0.0002061558 62p 0.000204603 62.1p 0.0002006909 62.2p 0.0001952929 62.3p 0.0001892718 62.4p 0.0001834126 62.5p 0.0001783822 62.6p 0.0001747152 62.7p 0.0001728189 62.8p 0.0001729925 62.9p 0.0001754529 63p 0.0001803638 63.1p 0.0001878626 63.2p 0.000198085 63.3p 0.0002111833 63.4p 0.0002273398 63.5p 0.0002467743 63.6p 0.0002697437 63.7p 0.0002965358 63.8p 0.0003274541 63.9p 0.0003627953 64p 0.0004028173 64.1p 0.0004476974 64.2p 0.0004974776 64.3p 0.0005519888 64.4p 0.0006107446 64.5p 0.0006727889 64.6p 0.0007364952 64.7p 0.0007993403 64.8p 0.0008577272 64.9p 0.0009069992 65p 0.0009418116 65.1p 0.0009569561 65.2p 0.0009485311 65.3p 0.000915105 65.4p 0.0008584059 65.5p 0.0007832152 65.6p 0.0006964723 65.7p 0.0006059077 65.8p 0.0005186541 65.9p 0.000440205 66p 0.0003739039 66.1p 0.0003208769 66.2p 0.0002803119 66.3p 0.0002499678 66.4p 0.0002267851 66.5p 0.0002074713 66.6p 0.000188972 66.7p 0.0001687839 66.8p 0.0001451102 66.9p 0.0001168904 67p 8.374931e-05 67.1p 4.598112e-05 67.2p 4.558517e-06 67.3p -3.889384e-05 67.4p -8.220736e-05 67.5p -0.0001228684 67.6p -0.0001582891 67.7p -0.0001861133 67.8p -0.0002045115 67.9p -0.0002124182 68p -0.0002096697 68.1p -0.0001970228 68.2p -0.0001760493 68.3p -0.000148931 68.4p -0.0001181905 68.5p -8.640462e-05 68.6p -5.594086e-05 68.7p -2.875093e-05 68.8p -6.238226e-06 68.9p 1.079553e-05 69p 2.213189e-05 69.1p 2.806059e-05 69.2p 2.926685e-05 69.3p 2.670054e-05 69.4p 2.144456e-05 69.5p 1.45958e-05 69.6p 7.167597e-06 69.7p 1.839137e-08 69.8p -6.192346e-06 69.9p -1.102263e-05 70p -1.424434e-05 70.1p -1.582203e-05 70.2p -1.587923e-05 70.3p -1.465744e-05 70.4p -1.247234e-05 70.5p -9.671735e-06 70.6p -6.598289e-06 70.7p -3.559548e-06 70.8p -8.06576e-07 70.9p 1.478459e-06 71p 3.186254e-06 71.1p 4.277068e-06 71.2p 4.771793e-06 71.3p 4.739216e-06 71.4p 4.281347e-06 71.5p 3.518469e-06 71.6p 2.575299e-06 71.7p 1.569289e-06 71.8p 6.016947e-07 71.9p -2.482995e-07 72p -9.26462e-07 72.1p -1.403686e-06 72.2p -1.67394e-06 72.3p -1.750571e-06 72.4p -1.661596e-06 72.5p -1.444556e-06 72.6p -1.141483e-06 72.7p -7.943798e-07 72.8p -4.415281e-07 72.9p -1.147946e-07 73p 1.620097e-07 73.1p 3.737632e-07 73.2p 5.137868e-07 73.3p 5.828997e-07 73.4p 5.879864e-07 73.5p 5.402917e-07 73.6p 4.536415e-07 73.7p 3.427606e-07 73.8p 2.218178e-07 73.9p 1.03284e-07 74p -2.853444e-09 74.1p -8.951439e-08 74.2p -1.526187e-07 74.3p -1.908984e-07 74.4p -2.054972e-07 74.5p -1.994313e-07 74.6p -1.769843e-07 74.7p -1.431002e-07 74.8p -1.028293e-07 74.9p -6.086528e-08 75p -2.119781e-08 75.1p 1.31099e-08 75.2p 4.002172e-08 75.3p 5.852074e-08 75.4p 6.851333e-08 75.5p 7.066953e-08 75.6p 6.622547e-08 75.7p 5.677188e-08 75.8p 4.405005e-08 75.9p 2.977152e-08 76p 1.547329e-08 76.1p 2.414588e-09 76.2p -8.483163e-09 76.3p -1.665582e-08 76.4p -2.188109e-08 76.5p -2.423589e-08 76.6p -2.403522e-08 76.7p -2.176117e-08 76.8p -1.799026e-08 76.9p -1.332563e-08 77p -8.339268e-09 77.1p -3.527406e-09 77.2p 7.192318e-10 77.3p 4.130578e-09 77.4p 6.558994e-09 77.5p 7.969981e-09 77.6p 8.424634e-09 77.7p 8.056906e-09 77.8p 7.048599e-09 77.9p 5.604705e-09 78p 3.931189e-09 78.1p 2.216736e-09 78.2p 6.193166e-10 78.3p -7.420891e-10 78.4p -1.790855e-09 78.5p -2.491737e-09 78.6p -2.846438e-09 78.7p -2.886751e-09 78.8p -2.666288e-09 78.9p -2.251813e-09 79p -1.714986e-09 79.1p -1.125182e-09 79.2p -5.438162e-10 79.3p -2.039603e-11 79.4p 4.096571e-10 79.5p 7.255593e-10 79.6p 9.203273e-10 79.7p 9.988827e-10 79.8p 9.754555e-10 79.9p 8.70643e-10 80p 7.084432e-10 80.1p 5.135299e-10 80.2p 3.089636e-10 80.3p 1.144597e-10 80.4p -5.47337e-11 80.5p -1.883631e-10 80.6p -2.811612e-10 80.7p -3.324036e-10 80.8p -3.451458e-10 80.9p -3.252684e-10 81p -2.804465e-10 81.1p -2.191503e-10 81.2p -1.497565e-10 81.3p -7.982986e-11 81.4p -1.560669e-11 81.5p 3.831114e-11 81.6p 7.906323e-11 81.7p 1.054651e-10 81.8p 1.178075e-10 81.9p 1.175627e-10 82p 1.070406e-10 82.1p 8.903329e-11 82.2p 6.648267e-11 82.3p 4.219457e-11 82.4p 1.861733e-11 82.5p -2.308227e-12 82.6p -1.922693e-11 82.7p -3.138179e-11 82.8p -3.857164e-11 82.9p -4.106788e-11 83p -3.950462e-11 83.1p -3.47571e-11 83.2p -2.782104e-11 83.3p -1.970327e-11 83.4p -1.133137e-11 83.5p -3.486564e-12 83.6p 3.2382e-12 83.7p 8.456113e-12 83.8p 1.1983e-11 83.9p 1.381661e-11 84p 1.410381e-11 84.1p 1.31005e-11 84.2p 1.112938e-11 84.3p 8.539455e-12 84.4p 5.670611e-12 84.5p 2.825445e-12 84.6p 2.49469e-13 84.7p -1.880122e-12 84.8p -3.457476e-12 84.9p -4.444527e-12 85p -4.861912e-12 85.1p -4.776544e-12 85.2p -4.287318e-12 85.3p -3.510631e-12 85.4p -2.566895e-12 85.5p -1.569366e-12 85.6p -6.153967e-13 85.7p 2.191716e-13 85.8p 8.827898e-13 85.9p 1.348252e-12 86p 1.610725e-12 86.1p 1.684062e-12 86.2p 1.596208e-12 86.3p 1.384183e-12 86.4p 1.089176e-12 86.5p 7.521646e-13 86.6p 4.103872e-13 86.7p 9.471553e-14 86.8p -1.718928e-13 86.9p -3.749467e-13 87p -5.081369e-13 87.1p -5.725199e-13 87.2p -5.749314e-13 87.3p -5.264161e-13 87.4p -4.405092e-13 87.5p -3.315482e-13 87.6p -2.132656e-13 87.7p -9.777596e-14 87.8p 5.287794e-15 87.9p 8.916028e-14 88p 1.499611e-13 88.1p 1.86546e-13 88.2p 2.001075e-13 88.3p 1.936271e-13 88.4p 1.713272e-13 88.5p 1.38057e-13 88.6p 9.868357e-14 88.7p 5.781497e-14 88.8p 1.92965e-14 88.9p -1.391225e-14 89p -3.986453e-14 89.1p -5.758697e-14 89.2p -6.704011e-14 89.3p -6.888602e-14 89.4p -6.433483e-14 89.5p -5.497815e-14 89.6p -4.248651e-14 89.7p -2.853918e-14 89.8p -1.462255e-14 89.9p -1.94675e-15 90p 8.602531e-15 90.1p 1.646845e-14 90.2p 2.145371e-14 90.3p 2.366792e-14 90.4p 2.340046e-14 90.5p 2.112925e-14 90.6p 1.740237e-14 90.7p 1.282487e-14 90.8p 7.94923e-15 90.9p 3.27966e-15 91p -8.330688e-16 91.1p -4.121498e-15 91.2p -6.449706e-15 91.3p -7.791385e-15 91.4p -8.207919e-15 91.5p -7.822077e-15 91.6p -6.822395e-15 91.7p -5.401793e-15 91.8p -3.770732e-15 91.9p -2.10021e-15 92p -5.612253e-16 92.1p 7.541464e-16 92.2p 1.762598e-15 92.3p 2.429053e-15 92.4p 2.77105e-15 92.5p 2.797357e-15 92.6p 2.573744e-15 92.7p 2.170363e-15 92.8p 1.652984e-15 92.9p 1.091759e-15 93p 5.173795e-16 93.1p 8.769145e-18 93.2p -3.946115e-16 93.3p -7.015316e-16 93.4p -8.856836e-16 93.5p -9.646059e-16 93.6p -9.382985e-16 93.7p -8.374533e-16 93.8p -6.883779e-16 93.9p -4.910721e-16 94p -2.893818e-16 94.1p -1.052297e-16 94.2p 7.015316e-17 94.3p 1.973058e-16 94.4p 2.806126e-16 94.5p 3.244584e-16 94.6p 3.332275e-16 94.7p 2.937663e-16 94.8p 2.499206e-16 94.9p 1.973058e-16 95p 1.359217e-16 95.1p 8.769145e-17 95.2p 2.630743e-17 95.3p -2.630743e-17 95.4p -7.015316e-17 95.5p -9.646059e-17 95.6p -1.052297e-16 95.7p -1.052297e-16 95.8p -1.052297e-16 95.9p -8.769145e-17 96p -7.015316e-17 96.1p -3.946115e-17 96.2p -1.753829e-17 96.3p 8.769145e-18 96.4p 1.753829e-17 96.5p 3.069201e-17 96.6p 4.384572e-17 96.7p 4.384572e-17 96.8p 3.507658e-17 96.9p 3.507658e-17 97p 3.507658e-17 97.1p 2.630743e-17 97.2p 1.753829e-17 97.3p 4.384572e-18 97.4p 4.384572e-18 97.5p -8.769145e-18 97.6p -8.769145e-18 97.7p 4.384572e-18 97.8p 0 97.9p 0 98p 0 98.1p 0 98.2p 0 98.3p 0 98.4p 0 98.5p 0 98.6p 0 98.7p 0 98.8p 0 98.9p 0 99p 0 99.1p 0 99.2p 0 99.3p 0 99.4p 0 99.5p 0 99.6p 0 99.7p 0 99.8p 0 99.9p 0 100p 0 100.1p 0 100.2p 0 100.3p 0 100.4p 0 100.5p 0 100.6p 0 100.7p 0 100.8p 0 100.9p 0 101p 0 101.1p 0 101.2p 0 101.3p 0 101.4p 0 101.5p 0 101.6p 0 101.7p 0 101.8p 0 101.9p 0 102p 0 102.1p 0 102.2p 0 102.3p 0 102.4p 0 102.5p 0 102.6p 0 102.7p 0 102.8p 0 102.9p 0 103p 0 103.1p 0 103.2p 0 103.3p 0 103.4p 0 103.5p 0 103.6p 0 103.7p 0 103.8p 0 103.9p 0 104p 0 104.1p 0 104.2p 0 104.3p 0 104.4p 0 104.5p 0 104.6p 0 104.7p 0 104.8p 0 104.9p 0 105p 0 105.1p 0 105.2p 0 105.3p 0 105.4p 0 105.5p 0 105.6p 0 105.7p 0 105.8p 0 105.9p 0 106p 0 106.1p 0 106.2p 0 106.3p 0 106.4p 0 106.5p 0 106.6p 0 106.7p 0 106.8p 0 106.9p 0 107p 0 107.1p 0 107.2p 0 107.3p 0 107.4p 0 107.5p 0 107.6p 0 107.7p 0 107.8p 0 107.9p 0 108p 0 108.1p 0 108.2p 0 108.3p 0 108.4p 0 108.5p 0 108.6p 0 108.7p 0 108.8p 0 108.9p 0 109p 0 109.1p 0 109.2p 0 109.3p 0 109.4p 0 109.5p 0 109.6p 0 109.7p 0 109.8p 0 109.9p 0 110p 0 110.1p 7.088784e-08 110.2p 4.511178e-07 110.3p 1.59376e-06 110.4p 4.127958e-06 110.5p 8.747451e-06 110.6p 1.606666e-05 110.7p 2.648919e-05 110.8p 4.012249e-05 110.9p 5.67553e-05 111p 7.589777e-05 111.1p 9.680023e-05 111.2p 0.0001184716 111.3p 0.000139746 111.4p 0.0001594111 111.5p 0.0001763694 111.6p 0.0001897889 111.7p 0.0001992055 111.8p 0.0002045577 111.9p 0.0002061558 112p 0.000204603 112.1p 0.0002006909 112.2p 0.0001952929 112.3p 0.0001892718 112.4p 0.0001834126 112.5p 0.0001783822 112.6p 0.0001747152 112.7p 0.0001728189 112.8p 0.0001729925 112.9p 0.0001754529 113p 0.0001803638 113.1p 0.0001878626 113.2p 0.000198085 113.3p 0.0002111833 113.4p 0.0002273398 113.5p 0.0002467743 113.6p 0.0002697437 113.7p 0.0002965358 113.8p 0.0003274541 113.9p 0.0003627953 114p 0.0004028173 114.1p 0.0004476974 114.2p 0.0004974776 114.3p 0.0005519888 114.4p 0.0006107446 114.5p 0.0006727889 114.6p 0.0007364952 114.7p 0.0007993403 114.8p 0.0008577272 114.9p 0.0009069992 115p 0.0009418116 115.1p 0.0009569561 115.2p 0.0009485311 115.3p 0.000915105 115.4p 0.0008584059 115.5p 0.0007832152 115.6p 0.0006964723 115.7p 0.0006059077 115.8p 0.0005186541 115.9p 0.000440205 116p 0.0003739039 116.1p 0.0003208769 116.2p 0.0002803119 116.3p 0.0002499678 116.4p 0.0002267851 116.5p 0.0002074713 116.6p 0.000188972 116.7p 0.0001687839 116.8p 0.0001451102 116.9p 0.0001168904 117p 8.374931e-05 117.1p 4.598112e-05 117.2p 4.558517e-06 117.3p -3.889384e-05 117.4p -8.220736e-05 117.5p -0.0001228684 117.6p -0.0001582891 117.7p -0.0001861133 117.8p -0.0002045115 117.9p -0.0002124182 118p -0.0002096697 118.1p -0.0001970228 118.2p -0.0001760493 118.3p -0.000148931 118.4p -0.0001181905 118.5p -8.640462e-05 118.6p -5.594086e-05 118.7p -2.875093e-05 118.8p -6.238226e-06 118.9p 1.079553e-05 119p 2.213189e-05 119.1p 2.806059e-05 119.2p 2.926685e-05 119.3p 2.670054e-05 119.4p 2.144456e-05 119.5p 1.45958e-05 119.6p 7.167597e-06 119.7p 1.839137e-08 119.8p -6.192346e-06 119.9p -1.102263e-05 120p -1.424434e-05 120.1p -1.582203e-05 120.2p -1.587923e-05 120.3p -1.465744e-05 120.4p -1.247234e-05 120.5p -9.671735e-06 120.6p -6.598289e-06 120.7p -3.559548e-06 120.8p -8.06576e-07 120.9p 1.478459e-06 121p 3.186254e-06 121.1p 4.277068e-06 121.2p 4.771793e-06 121.3p 4.739216e-06 121.4p 4.281347e-06 121.5p 3.518469e-06 121.6p 2.575299e-06 121.7p 1.569289e-06 121.8p 6.016947e-07 121.9p -2.482995e-07 122p -9.26462e-07 122.1p -1.403686e-06 122.2p -1.67394e-06 122.3p -1.750571e-06 122.4p -1.661596e-06 122.5p -1.444556e-06 122.6p -1.141483e-06 122.7p -7.943798e-07 122.8p -4.415281e-07 122.9p -1.147946e-07 123p 1.620097e-07 123.1p 3.737632e-07 123.2p 5.137868e-07 123.3p 5.828997e-07 123.4p 5.879864e-07 123.5p 5.402917e-07 123.6p 4.536415e-07 123.7p 3.427606e-07 123.8p 2.218178e-07 123.9p 1.03284e-07 124p -2.853444e-09 124.1p -8.951439e-08 124.2p -1.526187e-07 124.3p -1.908984e-07 124.4p -2.054972e-07 124.5p -1.994313e-07 124.6p -1.769843e-07 124.7p -1.431002e-07 124.8p -1.028293e-07 124.9p -6.086528e-08 125p -2.119781e-08 125.1p 1.31099e-08 125.2p 4.002172e-08 125.3p 5.852074e-08 125.4p 6.851333e-08 125.5p 7.066953e-08 125.6p 6.622547e-08 125.7p 5.677188e-08 125.8p 4.405005e-08 125.9p 2.977152e-08 126p 1.547329e-08 126.1p 2.414588e-09 126.2p -8.483163e-09 126.3p -1.665582e-08 126.4p -2.188109e-08 126.5p -2.423589e-08 126.6p -2.403522e-08 126.7p -2.176117e-08 126.8p -1.799026e-08 126.9p -1.332563e-08 127p -8.339268e-09 127.1p -3.527406e-09 127.2p 7.192318e-10 127.3p 4.130578e-09 127.4p 6.558994e-09 127.5p 7.969981e-09 127.6p 8.424634e-09 127.7p 8.056906e-09 127.8p 7.048599e-09 127.9p 5.604705e-09 128p 3.931189e-09 128.1p 2.216736e-09 128.2p 6.193166e-10 128.3p -7.420891e-10 128.4p -1.790855e-09 128.5p -2.491737e-09 128.6p -2.846438e-09 128.7p -2.886751e-09 128.8p -2.666288e-09 128.9p -2.251813e-09 129p -1.714986e-09 129.1p -1.125182e-09 129.2p -5.438161e-10 129.3p -2.0396e-11 129.4p 4.096571e-10 129.5p 7.255594e-10 129.6p 9.203273e-10 129.7p 9.988827e-10 129.8p 9.754556e-10 129.9p 8.706431e-10 130p 7.084432e-10 130.1p 5.135299e-10 130.2p 3.089635e-10 130.3p 1.144597e-10 130.4p -5.47337e-11 130.5p -1.88363e-10 130.6p -2.811612e-10 130.7p -3.324036e-10 130.8p -3.451458e-10 130.9p -3.252684e-10 131p -2.804465e-10 131.1p -2.191503e-10 131.2p -1.497565e-10 131.3p -7.982985e-11 131.4p -1.560669e-11 131.5p 3.831116e-11 131.6p 7.906323e-11 131.7p 1.054651e-10 131.8p 1.178074e-10 131.9p 1.175627e-10 132p 1.070406e-10 132.1p 8.903329e-11 132.2p 6.648267e-11 132.3p 4.219459e-11 132.4p 1.861734e-11 132.5p -2.308227e-12 132.6p -1.922695e-11 132.7p -3.138181e-11 132.8p -3.857166e-11 132.9p -4.10679e-11 133p -3.950462e-11 133.1p -3.475711e-11 133.2p -2.782106e-11 133.3p -1.970328e-11 133.4p -1.13314e-11 133.5p -3.486577e-12 133.6p 3.238186e-12 133.7p 8.456108e-12 133.8p 1.198299e-11 133.9p 1.381662e-11 134p 1.41038e-11 134.1p 1.310049e-11 134.2p 1.112937e-11 134.3p 8.539472e-12 134.4p 5.670607e-12 134.5p 2.825454e-12 134.6p 2.49469e-13 134.7p -1.8801e-12 134.8p -3.457455e-12 134.9p -4.444509e-12 135p -4.861912e-12 135.1p -4.776553e-12 135.2p -4.28734e-12 135.3p -3.510617e-12 135.4p -2.566887e-12 135.5p -1.569344e-12 135.6p -6.153616e-13 135.7p 2.192155e-13 135.8p 8.828117e-13 135.9p 1.348265e-12 136p 1.610734e-12 136.1p 1.68407e-12 136.2p 1.596204e-12 136.3p 1.384148e-12 136.4p 1.08915e-12 136.5p 7.521471e-13 136.6p 4.103653e-13 136.7p 9.469361e-14 136.8p -1.718884e-13 136.9p -3.749336e-13 137p -5.081325e-13 137.1p -5.725112e-13 137.2p -5.749139e-13 137.3p -5.264293e-13 137.4p -4.405355e-13 137.5p -3.315526e-13 137.6p -2.132919e-13 137.7p -9.777158e-14 137.8p 5.287794e-15 137.9p 8.917343e-14 138p 1.499918e-13 138.1p 1.865636e-13 138.2p 2.001119e-13 138.3p 1.936139e-13 138.4p 1.713359e-13 138.5p 1.380351e-13 138.6p 9.867919e-14 138.7p 5.779305e-14 138.8p 1.926143e-14 138.9p -1.392102e-14 139p -3.98733e-14 139.1p -5.756944e-14 139.2p -6.702257e-14 139.3p -6.885532e-14 139.4p -6.431291e-14 139.5p -5.496061e-14 139.6p -4.248651e-14 139.7p -2.853041e-14 139.8p -1.462693e-14 139.9p -1.94675e-15 140p 8.593762e-15 140.1p 1.645968e-14 140.2p 2.14581e-14 140.3p 2.364161e-14 140.4p 2.338292e-14 140.5p 2.112049e-14 140.6p 1.740237e-14 140.7p 1.283803e-14 140.8p 7.962383e-15 140.9p 3.297198e-15 141p -8.374533e-16 141.1p -4.134652e-15 141.2p -6.46286e-15 141.3p -7.817693e-15 141.4p -8.221073e-15 141.5p -7.835231e-15 141.6p -6.81801e-15 141.7p -5.414947e-15 141.8p -3.783886e-15 141.9p -2.117748e-15 142p -5.74379e-16 142.1p 7.366082e-16 142.2p 1.775752e-15 142.3p 2.442207e-15 142.4p 2.775434e-15 142.5p 2.806126e-15 142.6p 2.578129e-15 142.7p 2.179132e-15 142.8p 1.666138e-15 142.9p 1.07422e-15 143p 5.086104e-16 143.1p -1.315372e-17 143.2p -4.296881e-16 143.3p -7.103007e-16 143.4p -9.207602e-16 143.5p -9.821442e-16 143.6p -9.602214e-16 143.7p -8.418379e-16 143.8p -6.66455e-16 143.9p -4.910721e-16 144p -2.806126e-16 144.1p -7.89223e-17 144.2p 9.646059e-17 144.3p 2.323823e-16 144.4p 3.025355e-16 144.5p 3.595349e-16 144.6p 3.419966e-16 144.7p 3.244584e-16 144.8p 2.630743e-16 144.9p 2.14844e-16 145p 1.446909e-16 145.1p 7.015316e-17 145.2p 1.753829e-17 145.3p -3.507658e-17 145.4p -6.576859e-17 145.5p -1.052297e-16 145.6p -1.139989e-16 145.7p -8.769145e-17 145.8p -7.015316e-17 145.9p -6.576859e-17 146p -5.261487e-17 146.1p -3.507658e-17 146.2p -3.069201e-17 146.3p 0 146.4p 1.753829e-17 146.5p 4.384572e-17 146.6p 2.630743e-17 146.7p 5.699944e-17 146.8p 5.261487e-17 146.9p 5.699944e-17 147p 4.384572e-17 147.1p 1.753829e-17 147.2p 2.192286e-17 147.3p 0 147.4p 8.769145e-18 147.5p -8.769145e-18 147.6p -2.630743e-17 147.7p -1.315372e-17 147.8p -2.630743e-17 147.9p 0 148p 4.384572e-18 148.1p 0 148.2p 0 148.3p 0 148.4p 0 148.5p 0 148.6p 0 148.7p 0 148.8p 0 148.9p 0 149p 0 149.1p 0 149.2p 0 149.3p 0 149.4p 0 149.5p 0 149.6p 0 149.7p 0 149.8p 0 149.9p 0 150p 0 150.1p 0 150.2p 0 150.3p 0 150.4p 0 150.5p 0 150.6p 0 150.7p 0 150.8p 0 150.9p 0 151p 0 151.1p 0 151.2p 0 151.3p 0 151.4p 0 151.5p 0 151.6p 0 151.7p 0 151.8p 0 151.9p 0 152p 0 152.1p 0 152.2p 0 152.3p 0 152.4p 0 152.5p 0 152.6p 0 152.7p 0 152.8p 0 152.9p 0 153p 0 153.1p 0 153.2p 0 153.3p 0 153.4p 0 153.5p 0 153.6p 0 153.7p 0 153.8p 0 153.9p 0 154p 0 154.1p 0 154.2p 0 154.3p 0 154.4p 0 154.5p 0 154.6p 0 154.7p 0 154.8p 0 154.9p 0 155p 0 155.1p 0 155.2p 0 155.3p 0 155.4p 0 155.5p 0 155.6p 0 155.7p 0 155.8p 0 155.9p 0 156p 0 156.1p 0 156.2p 0 156.3p 0 156.4p 0 156.5p 0 156.6p 0 156.7p 0 156.8p 0 156.9p 0 157p 0 157.1p 0 157.2p 0 157.3p 0 157.4p 0 157.5p 0 157.6p 0 157.7p 0 157.8p 0 157.9p 0 158p 0 158.1p 0 158.2p 0 158.3p 0 158.4p 0 158.5p 0 158.6p 0 158.7p 0 158.8p 0 158.9p 0 159p 0 159.1p 0 159.2p 0 159.3p 0 159.4p 0 159.5p 0 159.6p 0 159.7p 0 159.8p 0 159.9p 0 160p 0 160.1p 7.088784e-08 160.2p 4.511178e-07 160.3p 1.59376e-06 160.4p 4.127958e-06 160.5p 8.747451e-06 160.6p 1.606666e-05 160.7p 2.648919e-05 160.8p 4.012249e-05 160.9p 5.67553e-05 161p 7.589777e-05 161.1p 9.680023e-05 161.2p 0.0001184716 161.3p 0.000139746 161.4p 0.0001594111 161.5p 0.0001763694 161.6p 0.0001897889 161.7p 0.0001992055 161.8p 0.0002045577 161.9p 0.0002061558 162p 0.000204603 162.1p 0.0002006909 162.2p 0.0001952929 162.3p 0.0001892718 162.4p 0.0001834126 162.5p 0.0001783822 162.6p 0.0001747152 162.7p 0.0001728189 162.8p 0.0001729925 162.9p 0.0001754529 163p 0.0001803638 163.1p 0.0001878626 163.2p 0.000198085 163.3p 0.0002111833 163.4p 0.0002273398 163.5p 0.0002467743 163.6p 0.0002697437 163.7p 0.0002965358 163.8p 0.0003274541 163.9p 0.0003627953 164p 0.0004028173 164.1p 0.0004476974 164.2p 0.0004974776 164.3p 0.0005519888 164.4p 0.0006107446 164.5p 0.0006727889 164.6p 0.0007364952 164.7p 0.0007993403 164.8p 0.0008577272 164.9p 0.0009069992 165p 0.0009418116 165.1p 0.0009569561 165.2p 0.0009485311 165.3p 0.000915105 165.4p 0.0008584059 165.5p 0.0007832152 165.6p 0.0006964723 165.7p 0.0006059077 165.8p 0.0005186541 165.9p 0.000440205 166p 0.0003739039 166.1p 0.0003208769 166.2p 0.0002803119 166.3p 0.0002499678 166.4p 0.0002267851 166.5p 0.0002074713 166.6p 0.000188972 166.7p 0.0001687839 166.8p 0.0001451102 166.9p 0.0001168904 167p 8.374931e-05 167.1p 4.598112e-05 167.2p 4.558517e-06 167.3p -3.889384e-05 167.4p -8.220736e-05 167.5p -0.0001228684 167.6p -0.0001582891 167.7p -0.0001861133 167.8p -0.0002045115 167.9p -0.0002124182 168p -0.0002096697 168.1p -0.0001970228 168.2p -0.0001760493 168.3p -0.000148931 168.4p -0.0001181905 168.5p -8.640462e-05 168.6p -5.594086e-05 168.7p -2.875093e-05 168.8p -6.238226e-06 168.9p 1.079553e-05 169p 2.213189e-05 169.1p 2.806059e-05 169.2p 2.926685e-05 169.3p 2.670054e-05 169.4p 2.144456e-05 169.5p 1.45958e-05 169.6p 7.167597e-06 169.7p 1.839137e-08 169.8p -6.192346e-06 169.9p -1.102263e-05 170p -1.424434e-05 170.1p -1.582203e-05 170.2p -1.587923e-05 170.3p -1.465744e-05 170.4p -1.247234e-05 170.5p -9.671735e-06 170.6p -6.598289e-06 170.7p -3.559548e-06 170.8p -8.06576e-07 170.9p 1.478459e-06 171p 3.186254e-06 171.1p 4.277068e-06 171.2p 4.771793e-06 171.3p 4.739216e-06 171.4p 4.281347e-06 171.5p 3.518469e-06 171.6p 2.575299e-06 171.7p 1.569289e-06 171.8p 6.016947e-07 171.9p -2.482995e-07 172p -9.26462e-07 172.1p -1.403686e-06 172.2p -1.67394e-06 172.3p -1.750571e-06 172.4p -1.661596e-06 172.5p -1.444556e-06 172.6p -1.141483e-06 172.7p -7.943798e-07 172.8p -4.415281e-07 172.9p -1.147946e-07 173p 1.620097e-07 173.1p 3.737632e-07 173.2p 5.137868e-07 173.3p 5.828997e-07 173.4p 5.879864e-07 173.5p 5.402917e-07 173.6p 4.536415e-07 173.7p 3.427606e-07 173.8p 2.218178e-07 173.9p 1.03284e-07 174p -2.853444e-09 174.1p -8.951439e-08 174.2p -1.526187e-07 174.3p -1.908984e-07 174.4p -2.054972e-07 174.5p -1.994313e-07 174.6p -1.769843e-07 174.7p -1.431002e-07 174.8p -1.028293e-07 174.9p -6.086528e-08 175p -2.119781e-08 175.1p 1.31099e-08 175.2p 4.002172e-08 175.3p 5.852074e-08 175.4p 6.851333e-08 175.5p 7.066953e-08 175.6p 6.622547e-08 175.7p 5.677188e-08 175.8p 4.405005e-08 175.9p 2.977152e-08 176p 1.547329e-08 176.1p 2.414588e-09 176.2p -8.483163e-09 176.3p -1.665582e-08 176.4p -2.188109e-08 176.5p -2.423589e-08 176.6p -2.403522e-08 176.7p -2.176117e-08 176.8p -1.799026e-08 176.9p -1.332563e-08 177p -8.339268e-09 177.1p -3.527406e-09 177.2p 7.192318e-10 177.3p 4.130578e-09 177.4p 6.558994e-09 177.5p 7.969981e-09 177.6p 8.424634e-09 177.7p 8.056906e-09 177.8p 7.048599e-09 177.9p 5.604705e-09 178p 3.931189e-09 178.1p 2.216736e-09 178.2p 6.193166e-10 178.3p -7.420891e-10 178.4p -1.790855e-09 178.5p -2.491737e-09 178.6p -2.846438e-09 178.7p -2.886751e-09 178.8p -2.666288e-09 178.9p -2.251813e-09 179p -1.714986e-09 179.1p -1.125182e-09 179.2p -5.438161e-10 179.3p -2.039601e-11 179.4p 4.096572e-10 179.5p 7.255594e-10 179.6p 9.203273e-10 179.7p 9.988827e-10 179.8p 9.754555e-10 179.9p 8.70643e-10 180p 7.084432e-10 180.1p 5.135299e-10 180.2p 3.089635e-10 180.3p 1.144597e-10 180.4p -5.473372e-11 180.5p -1.883631e-10 180.6p -2.811612e-10 180.7p -3.324036e-10 180.8p -3.451458e-10 180.9p -3.252683e-10 181p -2.804465e-10 181.1p -2.191503e-10 181.2p -1.497565e-10 181.3p -7.982985e-11 181.4p -1.560669e-11 181.5p 3.831115e-11 181.6p 7.906324e-11 181.7p 1.054651e-10 181.8p 1.178075e-10 181.9p 1.175627e-10 182p 1.070406e-10 182.1p 8.903335e-11 182.2p 6.648269e-11 182.3p 4.219458e-11 182.4p 1.861735e-11 182.5p -2.308232e-12 182.6p -1.922695e-11 182.7p -3.138181e-11 182.8p -3.857166e-11 182.9p -4.10679e-11 183p -3.950464e-11 183.1p -3.475713e-11 183.2p -2.782107e-11 183.3p -1.970329e-11 183.4p -1.13314e-11 183.5p -3.486577e-12 183.6p 3.238182e-12 183.7p 8.456104e-12 183.8p 1.198298e-11 183.9p 1.381659e-11 184p 1.410381e-11 184.1p 1.310049e-11 184.2p 1.112939e-11 184.3p 8.539472e-12 184.4p 5.670646e-12 184.5p 2.825471e-12 184.6p 2.494822e-13 184.7p -1.880113e-12 184.8p -3.457481e-12 184.9p -4.444536e-12 185p -4.861912e-12 185.1p -4.776536e-12 185.2p -4.287331e-12 185.3p -3.510622e-12 185.4p -2.566922e-12 185.5p -1.569361e-12 185.6p -6.153923e-13 185.7p 2.191935e-13 185.8p 8.828073e-13 185.9p 1.348265e-12 186p 1.610725e-12 186.1p 1.684027e-12 186.2p 1.59616e-12 186.3p 1.384157e-12 186.4p 1.089172e-12 186.5p 7.521646e-13 186.6p 4.104047e-13 186.7p 9.470676e-14 186.8p -1.718928e-13 186.9p -3.749336e-13 187p -5.081369e-13 187.1p -5.725199e-13 187.2p -5.749227e-13 187.3p -5.263942e-13 187.4p -4.404741e-13 187.5p -3.315351e-13 187.6p -2.132481e-13 187.7p -9.780227e-14 187.8p 5.279025e-15 187.9p 8.914713e-14 188p 1.499611e-13 188.1p 1.865372e-13 188.2p 2.001031e-13 188.3p 1.936403e-13 188.4p 1.713316e-13 188.5p 1.380702e-13 188.6p 9.869672e-14 188.7p 5.784128e-14 188.8p 1.931843e-14 188.9p -1.388156e-14 189p -3.984699e-14 189.1p -5.75782e-14 189.2p -6.703134e-14 189.3p -6.888163e-14 189.4p -6.434798e-14 189.5p -5.499131e-14 189.6p -4.249528e-14 189.7p -2.855234e-14 189.8p -1.462693e-14 189.9p -1.94675e-15 190p 8.602531e-15 190.1p 1.646845e-14 190.2p 2.144933e-14 190.3p 2.365038e-14 190.4p 2.340485e-14 190.5p 2.110733e-14 190.6p 1.741552e-14 190.7p 1.28468e-14 190.8p 7.988691e-15 190.9p 3.323506e-15 191p -8.067613e-16 191.1p -4.112729e-15 191.2p -6.445321e-15 191.3p -7.787001e-15 191.4p -8.181612e-15 191.5p -7.804539e-15 191.6p -6.839933e-15 191.7p -5.454408e-15 191.8p -3.823347e-15 191.9p -2.139671e-15 192p -5.963018e-16 192.1p 7.541464e-16 192.2p 1.797675e-15 192.3p 2.46413e-15 192.4p 2.806126e-15 192.5p 2.858741e-15 192.6p 2.657051e-15 192.7p 2.227363e-15 192.8p 1.692445e-15 192.9p 1.087374e-15 193p 4.998413e-16 193.1p -3.507658e-17 193.2p -4.559955e-16 193.3p -7.629156e-16 193.4p -9.470676e-16 193.5p -9.821442e-16 193.6p -9.470676e-16 193.7p -8.593762e-16 193.8p -7.015316e-16 193.9p -4.998413e-16 194p -2.893818e-16 194.1p -7.89223e-17 194.2p 8.769145e-17 194.3p 2.367669e-16 194.4p 3.156892e-16 194.5p 3.507658e-16 194.6p 3.683041e-16 194.7p 3.507658e-16 194.8p 3.156892e-16 194.9p 2.630743e-16 195p 1.753829e-16 195.1p 7.015316e-17 195.2p 0 195.3p -5.261487e-17 195.4p -8.769145e-17 195.5p -1.052297e-16 195.6p -1.052297e-16 195.7p -8.769145e-17 195.8p -7.015316e-17 195.9p -5.261487e-17 196p -2.630743e-17 196.1p -8.769145e-18 196.2p 1.753829e-17 196.3p 0 196.4p 0 196.5p 0 196.6p 0 196.7p 0 196.8p 0 196.9p 0 197p 0 197.1p 0 197.2p 0 197.3p 0 197.4p 0 197.5p 0 197.6p 0 197.7p 0 197.8p 0 197.9p 0 198p 0 198.1p 0 198.2p 0 198.3p 0 198.4p 0 198.5p 0 198.6p 0 198.7p 0 198.8p 0 198.9p 0 199p 0 199.1p 0 199.2p 0 199.3p 0 199.4p 0 199.5p 0 199.6p 0 199.7p 0 199.8p 0 199.9p 0 200p 0 200.1p 0 200.2p 0 200.3p 0 200.4p 0 200.5p 0 200.6p 0 200.7p 0 200.8p 0 200.9p 0 201p 0 201.1p 0 201.2p 0 201.3p 0 201.4p 0 201.5p 0 201.6p 0 201.7p 0 201.8p 0 201.9p 0 202p 0 202.1p 0 202.2p 0 202.3p 0 202.4p 0 202.5p 0 202.6p 0 202.7p 0 202.8p 0 202.9p 0 203p 0 203.1p 0 203.2p 0 203.3p 0 203.4p 0 203.5p 0 203.6p 0 203.7p 0 203.8p 0 203.9p 0 204p 0 204.1p 0 204.2p 0 204.3p 0 204.4p 0 204.5p 0 204.6p 0 204.7p 0 204.8p 0 204.9p 0 205p 0 205.1p 0 205.2p 0 205.3p 0 205.4p 0 205.5p 0 205.6p 0 205.7p 0 205.8p 0 205.9p 0 206p 0 206.1p 0 206.2p 0 206.3p 0 206.4p 0 206.5p 0 206.6p 0 206.7p 0 206.8p 0 206.9p 0 207p 0 207.1p 0 207.2p 0 207.3p 0 207.4p 0 207.5p 0 207.6p 0 207.7p 0 207.8p 0 207.9p 0 208p 0 208.1p 0 208.2p 0 208.3p 0 208.4p 0 208.5p 0 208.6p 0 208.7p 0 208.8p 0 208.9p 0 209p 0 209.1p 0 209.2p 0 209.3p 0 209.4p 0 209.5p 0 209.6p 0 209.7p 0 209.8p 0 209.9p 0 210p 0 210.1p 7.088784e-08 210.2p 4.511178e-07 210.3p 1.59376e-06 210.4p 4.127958e-06 210.5p 8.747451e-06 210.6p 1.606666e-05 210.7p 2.648919e-05 210.8p 4.012249e-05 210.9p 5.67553e-05 211p 7.589777e-05 211.1p 9.680023e-05 211.2p 0.0001184716 211.3p 0.000139746 211.4p 0.0001594111 211.5p 0.0001763694 211.6p 0.0001897889 211.7p 0.0001992055 211.8p 0.0002045577 211.9p 0.0002061558 212p 0.000204603 212.1p 0.0002006909 212.2p 0.0001952929 212.3p 0.0001892718 212.4p 0.0001834126 212.5p 0.0001783822 212.6p 0.0001747152 212.7p 0.0001728189 212.8p 0.0001729925 212.9p 0.0001754529 213p 0.0001803638 213.1p 0.0001878626 213.2p 0.000198085 213.3p 0.0002111833 213.4p 0.0002273398 213.5p 0.0002467743 213.6p 0.0002697437 213.7p 0.0002965358 213.8p 0.0003274541 213.9p 0.0003627953 214p 0.0004028173 214.1p 0.0004476974 214.2p 0.0004974776 214.3p 0.0005519888 214.4p 0.0006107446 214.5p 0.0006727889 214.6p 0.0007364952 214.7p 0.0007993403 214.8p 0.0008577272 214.9p 0.0009069992 215p 0.0009418116 215.1p 0.0009569561 215.2p 0.0009485311 215.3p 0.000915105 215.4p 0.0008584059 215.5p 0.0007832152 215.6p 0.0006964723 215.7p 0.0006059077 215.8p 0.0005186541 215.9p 0.000440205 216p 0.0003739039 216.1p 0.0003208769 216.2p 0.0002803119 216.3p 0.0002499678 216.4p 0.0002267851 216.5p 0.0002074713 216.6p 0.000188972 216.7p 0.0001687839 216.8p 0.0001451102 216.9p 0.0001168904 217p 8.374931e-05 217.1p 4.598112e-05 217.2p 4.558517e-06 217.3p -3.889384e-05 217.4p -8.220736e-05 217.5p -0.0001228684 217.6p -0.0001582891 217.7p -0.0001861133 217.8p -0.0002045115 217.9p -0.0002124182 218p -0.0002096697 218.1p -0.0001970228 218.2p -0.0001760493 218.3p -0.000148931 218.4p -0.0001181905 218.5p -8.640462e-05 218.6p -5.594086e-05 218.7p -2.875093e-05 218.8p -6.238226e-06 218.9p 1.079553e-05 219p 2.213189e-05 219.1p 2.806059e-05 219.2p 2.926685e-05 219.3p 2.670054e-05 219.4p 2.144456e-05 219.5p 1.45958e-05 219.6p 7.167597e-06 219.7p 1.839137e-08 219.8p -6.192346e-06 219.9p -1.102263e-05 220p -1.424434e-05 220.1p -1.582203e-05 220.2p -1.587923e-05 220.3p -1.465744e-05 220.4p -1.247234e-05 220.5p -9.671735e-06 220.6p -6.598289e-06 220.7p -3.559548e-06 220.8p -8.06576e-07 220.9p 1.478459e-06 221p 3.186254e-06 221.1p 4.277068e-06 221.2p 4.771793e-06 221.3p 4.739216e-06 221.4p 4.281347e-06 221.5p 3.518469e-06 221.6p 2.575299e-06 221.7p 1.569289e-06 221.8p 6.016947e-07 221.9p -2.482995e-07 222p -9.26462e-07 222.1p -1.403686e-06 222.2p -1.67394e-06 222.3p -1.750571e-06 222.4p -1.661596e-06 222.5p -1.444556e-06 222.6p -1.141483e-06 222.7p -7.943798e-07 222.8p -4.415281e-07 222.9p -1.147946e-07 223p 1.620097e-07 223.1p 3.737632e-07 223.2p 5.137868e-07 223.3p 5.828997e-07 223.4p 5.879864e-07 223.5p 5.402917e-07 223.6p 4.536415e-07 223.7p 3.427606e-07 223.8p 2.218178e-07 223.9p 1.03284e-07 224p -2.853444e-09 224.1p -8.951439e-08 224.2p -1.526187e-07 224.3p -1.908984e-07 224.4p -2.054972e-07 224.5p -1.994313e-07 224.6p -1.769843e-07 224.7p -1.431002e-07 224.8p -1.028293e-07 224.9p -6.086528e-08 225p -2.119781e-08 225.1p 1.31099e-08 225.2p 4.002172e-08 225.3p 5.852074e-08 225.4p 6.851333e-08 225.5p 7.066953e-08 225.6p 6.622547e-08 225.7p 5.677188e-08 225.8p 4.405005e-08 225.9p 2.977152e-08 226p 1.547329e-08 226.1p 2.414588e-09 226.2p -8.483163e-09 226.3p -1.665582e-08 226.4p -2.188109e-08 226.5p -2.423589e-08 226.6p -2.403522e-08 226.7p -2.176117e-08 226.8p -1.799026e-08 226.9p -1.332563e-08 227p -8.339267e-09 227.1p -3.527406e-09 227.2p 7.192318e-10 227.3p 4.130578e-09 227.4p 6.558994e-09 227.5p 7.969981e-09 227.6p 8.424634e-09 227.7p 8.056906e-09 227.8p 7.048599e-09 227.9p 5.604705e-09 228p 3.931189e-09 228.1p 2.216736e-09 228.2p 6.193166e-10 228.3p -7.420891e-10 228.4p -1.790855e-09 228.5p -2.491737e-09 228.6p -2.846438e-09 228.7p -2.886751e-09 228.8p -2.666288e-09 228.9p -2.251813e-09 229p -1.714986e-09 229.1p -1.125183e-09 229.2p -5.438161e-10 229.3p -2.039601e-11 229.4p 4.096571e-10 229.5p 7.255594e-10 229.6p 9.203273e-10 229.7p 9.988827e-10 229.8p 9.754556e-10 229.9p 8.706431e-10 230p 7.084432e-10 230.1p 5.1353e-10 230.2p 3.089636e-10 230.3p 1.144597e-10 230.4p -5.473371e-11 230.5p -1.88363e-10 230.6p -2.811612e-10 230.7p -3.324036e-10 230.8p -3.451458e-10 230.9p -3.252684e-10 231p -2.804465e-10 231.1p -2.191503e-10 231.2p -1.497565e-10 231.3p -7.982983e-11 231.4p -1.56067e-11 231.5p 3.831114e-11 231.6p 7.906322e-11 231.7p 1.054651e-10 231.8p 1.178074e-10 231.9p 1.175627e-10 232p 1.070406e-10 232.1p 8.903331e-11 232.2p 6.648268e-11 232.3p 4.219461e-11 232.4p 1.861737e-11 232.5p -2.308206e-12 232.6p -1.922693e-11 232.7p -3.13818e-11 232.8p -3.857168e-11 232.9p -4.10679e-11 233p -3.950463e-11 233.1p -3.47571e-11 233.2p -2.782104e-11 233.3p -1.970328e-11 233.4p -1.133139e-11 233.5p -3.486594e-12 233.6p 3.238165e-12 233.7p 8.456078e-12 233.8p 1.198298e-11 233.9p 1.381661e-11 234p 1.410382e-11 234.1p 1.310051e-11 234.2p 1.11294e-11 234.3p 8.539437e-12 234.4p 5.67062e-12 234.5p 2.825436e-12 234.6p 2.494471e-13 234.7p -1.880131e-12 234.8p -3.457463e-12 234.9p -4.444518e-12 235p -4.861912e-12 235.1p -4.776544e-12 235.2p -4.287305e-12 235.3p -3.510604e-12 235.4p -2.566869e-12 235.5p -1.569326e-12 235.6p -6.153572e-13 235.7p 2.192111e-13 235.8p 8.828073e-13 235.9p 1.348256e-12 236p 1.610717e-12 236.1p 1.684044e-12 236.2p 1.596168e-12 236.3p 1.384157e-12 236.4p 1.089163e-12 236.5p 7.521734e-13 236.6p 4.10396e-13 236.7p 9.475061e-14 236.8p -1.718752e-13 236.9p -3.749336e-13 237p -5.081369e-13 237.1p -5.725112e-13 237.2p -5.749314e-13 237.3p -5.263942e-13 237.4p -4.404741e-13 237.5p -3.315175e-13 237.6p -2.132656e-13 237.7p -9.777596e-14 237.8p 5.314102e-15 237.9p 8.921728e-14 238p 1.500225e-13 238.1p 1.865899e-13 238.2p 2.00147e-13 238.3p 1.936578e-13 238.4p 1.713403e-13 238.5p 1.380263e-13 238.6p 9.866165e-14 238.7p 5.778866e-14 238.8p 1.926581e-14 238.9p -1.39254e-14 239p -3.986453e-14 239.1p -5.75782e-14 239.2p -6.70138e-14 239.3p -6.885532e-14 239.4p -6.433045e-14 239.5p -5.498254e-14 239.6p -4.249528e-14 239.7p -2.85348e-14 239.8p -1.46094e-14 239.9p -1.937981e-15 240p 8.602531e-15 240.1p 1.645092e-14 240.2p 2.143179e-14 240.3p 2.362408e-14 240.4p 2.333469e-14 240.5p 2.108102e-14 240.6p 1.738044e-14 240.7p 1.28468e-14 240.8p 7.988691e-15 240.9p 3.314737e-15 241p -8.155305e-16 241.1p -4.068883e-15 241.2p -6.419014e-15 241.3p -7.769462e-15 241.4p -8.190381e-15 241.5p -7.804539e-15 241.6p -6.822395e-15 241.7p -5.419331e-15 241.8p -3.770732e-15 241.9p -2.104595e-15 242p -5.43687e-16 242.1p 7.716847e-16 242.2p 1.771367e-15 242.3p 2.472899e-15 242.4p 2.823665e-15 242.5p 2.841203e-15 242.6p 2.613205e-15 242.7p 2.192286e-15 242.8p 1.657368e-15 242.9p 1.104912e-15 243p 5.349178e-16 243.1p 3.507658e-17 243.2p -4.033807e-16 243.3p -7.190699e-16 243.4p -8.944528e-16 243.5p -9.909134e-16 243.6p -9.646059e-16 243.7p -8.50607e-16 243.8p -6.839933e-16 243.9p -4.82303e-16 244p -2.630743e-16 244.1p -7.89223e-17 244.2p 7.015316e-17 244.3p 1.929212e-16 244.4p 2.718435e-16 244.5p 3.156892e-16 244.6p 3.332275e-16 244.7p 3.332275e-16 244.8p 2.981509e-16 244.9p 2.279978e-16 245p 1.666138e-16 245.1p 6.138401e-17 245.2p 0 245.3p -5.261487e-17 245.4p -8.769145e-17 245.5p -1.052297e-16 245.6p -1.052297e-16 245.7p -1.052297e-16 245.8p -8.769145e-17 245.9p -7.015316e-17 246p -5.261487e-17 246.1p -6.138401e-17 246.2p -2.630743e-17 246.3p -8.769145e-18 246.4p 1.753829e-17 246.5p 1.753829e-17 246.6p 3.507658e-17 246.7p 3.507658e-17 246.8p 4.384572e-17 246.9p 3.507658e-17 247p 3.507658e-17 247.1p 1.753829e-17 247.2p 1.753829e-17 247.3p 8.769145e-18 247.4p 1.753829e-17 247.5p 3.507658e-17 247.6p 5.261487e-17 247.7p 4.384572e-17 247.8p 4.384572e-17 247.9p 4.384572e-17 248p 2.630743e-17 248.1p 4.384572e-17 248.2p 1.753829e-17 248.3p -1.753829e-17 248.4p -8.769145e-18 248.5p -1.753829e-17 248.6p -2.630743e-17 248.7p -1.753829e-17 248.8p -1.753829e-17 248.9p -1.753829e-17 249p -1.753829e-17 249.1p -1.753829e-17 249.2p 0 249.3p 1.753829e-17 249.4p 2.630743e-17 249.5p 2.630743e-17 249.6p 1.753829e-17 249.7p 8.769145e-18 249.8p 1.753829e-17 249.9p 3.507658e-17 250p 5.261487e-17 250.1p 4.384572e-17 250.2p 4.384572e-17 250.3p 4.384572e-17 250.4p 2.630743e-17 250.5p 4.384572e-17 250.6p 1.753829e-17 250.7p -1.753829e-17 250.8p -8.769145e-18 250.9p -1.753829e-17 251p -2.630743e-17 251.1p -1.753829e-17 251.2p -1.753829e-17 251.3p -1.753829e-17 251.4p -1.753829e-17 251.5p -1.753829e-17 251.6p 0 251.7p 1.753829e-17 251.8p 2.630743e-17 251.9p 2.630743e-17 252p 1.753829e-17 252.1p 8.769145e-18 252.2p 1.753829e-17 252.3p 3.507658e-17 252.4p 5.261487e-17 252.5p 4.384572e-17 252.6p 4.384572e-17 252.7p 4.384572e-17 252.8p 2.630743e-17 252.9p 4.384572e-17 253p 1.753829e-17 253.1p -1.753829e-17 253.2p -8.769145e-18 253.3p -1.753829e-17 253.4p -2.630743e-17 253.5p -1.753829e-17 253.6p -1.753829e-17 253.7p -1.753829e-17 253.8p -1.753829e-17 253.9p -1.753829e-17 254p 0 254.1p 1.753829e-17 254.2p 2.630743e-17 254.3p 2.630743e-17 254.4p 1.753829e-17 254.5p 8.769145e-18 254.6p 1.753829e-17 254.7p 3.507658e-17 254.8p 5.261487e-17 254.9p 4.384572e-17 255p 4.384572e-17 255.1p 4.384572e-17 255.2p 2.630743e-17 255.3p 4.384572e-17 255.4p 1.753829e-17 255.5p -1.753829e-17 255.6p -8.769145e-18 255.7p -1.753829e-17 255.8p -2.630743e-17 255.9p -1.753829e-17 256p -1.753829e-17 256.1p -1.753829e-17 256.2p -1.753829e-17 256.3p -1.753829e-17 256.4p 0 256.5p 1.753829e-17 256.6p 2.630743e-17 256.7p 2.630743e-17 256.8p 1.753829e-17 256.9p 8.769145e-18 257p 1.753829e-17 257.1p 3.507658e-17 257.2p 5.261487e-17 257.3p 4.384572e-17 257.4p 4.384572e-17 257.5p 4.384572e-17 257.6p 2.630743e-17 257.7p 4.384572e-17 257.8p 1.753829e-17 257.9p -1.753829e-17 258p -8.769145e-18 258.1p -1.753829e-17 258.2p -2.630743e-17 258.3p -1.753829e-17 258.4p -1.753829e-17 258.5p -1.753829e-17 258.6p -1.753829e-17 258.7p -1.753829e-17 258.8p 0 258.9p 1.753829e-17 259p 2.630743e-17 259.1p 2.630743e-17 259.2p 1.753829e-17 259.3p 8.769145e-18 259.4p 1.753829e-17 259.5p 3.507658e-17 259.6p 5.261487e-17 259.7p 4.384572e-17 259.8p 4.384572e-17 259.9p 4.384572e-17 260p 2.630743e-17 260.1p 7.088784e-08 260.2p 4.511178e-07 260.3p 1.59376e-06 260.4p 4.127958e-06 260.5p 8.747451e-06 260.6p 1.606666e-05 260.7p 2.648919e-05 260.8p 4.012249e-05 260.9p 5.67553e-05 261p 7.589777e-05 261.1p 9.680023e-05 261.2p 0.0001184716 261.3p 0.000139746 261.4p 0.0001594111 261.5p 0.0001763694 261.6p 0.0001897889 261.7p 0.0001992055 261.8p 0.0002045577 261.9p 0.0002061558 262p 0.000204603 262.1p 0.0002006909 262.2p 0.0001952929 262.3p 0.0001892718 262.4p 0.0001834126 262.5p 0.0001783822 262.6p 0.0001747152 262.7p 0.0001728189 262.8p 0.0001729925 262.9p 0.0001754529 263p 0.0001803638 263.1p 0.0001878626 263.2p 0.000198085 263.3p 0.0002111833 263.4p 0.0002273398 263.5p 0.0002467743 263.6p 0.0002697437 263.7p 0.0002965358 263.8p 0.0003274541 263.9p 0.0003627953 264p 0.0004028173 264.1p 0.0004476974 264.2p 0.0004974776 264.3p 0.0005519888 264.4p 0.0006107446 264.5p 0.0006727889 264.6p 0.0007364952 264.7p 0.0007993403 264.8p 0.0008577272 264.9p 0.0009069992 265p 0.0009418116 265.1p 0.0009569561 265.2p 0.0009485311 265.3p 0.000915105 265.4p 0.0008584059 265.5p 0.0007832152 265.6p 0.0006964723 265.7p 0.0006059077 265.8p 0.0005186541 265.9p 0.000440205 266p 0.0003739039 266.1p 0.0003208769 266.2p 0.0002803119 266.3p 0.0002499678 266.4p 0.0002267851 266.5p 0.0002074713 266.6p 0.000188972 266.7p 0.0001687839 266.8p 0.0001451102 266.9p 0.0001168904 267p 8.374931e-05 267.1p 4.598112e-05 267.2p 4.558517e-06 267.3p -3.889384e-05 267.4p -8.220736e-05 267.5p -0.0001228684 267.6p -0.0001582891 267.7p -0.0001861133 267.8p -0.0002045115 267.9p -0.0002124182 268p -0.0002096697 268.1p -0.0001970228 268.2p -0.0001760493 268.3p -0.000148931 268.4p -0.0001181905 268.5p -8.640462e-05 268.6p -5.594086e-05 268.7p -2.875093e-05 268.8p -6.238226e-06 268.9p 1.079553e-05 269p 2.213189e-05 269.1p 2.806059e-05 269.2p 2.926685e-05 269.3p 2.670054e-05 269.4p 2.144456e-05 269.5p 1.45958e-05 269.6p 7.167597e-06 269.7p 1.839137e-08 269.8p -6.192346e-06 269.9p -1.102263e-05 270p -1.424434e-05 270.1p -1.582203e-05 270.2p -1.587923e-05 270.3p -1.465744e-05 270.4p -1.247234e-05 270.5p -9.671735e-06 270.6p -6.598289e-06 270.7p -3.559548e-06 270.8p -8.06576e-07 270.9p 1.478459e-06 271p 3.186254e-06 271.1p 4.277068e-06 271.2p 4.771793e-06 271.3p 4.739216e-06 271.4p 4.281347e-06 271.5p 3.518469e-06 271.6p 2.575299e-06 271.7p 1.569289e-06 271.8p 6.016947e-07 271.9p -2.482995e-07 272p -9.26462e-07 272.1p -1.403686e-06 272.2p -1.67394e-06 272.3p -1.750571e-06 272.4p -1.661596e-06 272.5p -1.444556e-06 272.6p -1.141483e-06 272.7p -7.943798e-07 272.8p -4.415281e-07 272.9p -1.147946e-07 273p 1.620097e-07 273.1p 3.737632e-07 273.2p 5.137868e-07 273.3p 5.828997e-07 273.4p 5.879864e-07 273.5p 5.402917e-07 273.6p 4.536415e-07 273.7p 3.427606e-07 273.8p 2.218178e-07 273.9p 1.03284e-07 274p -2.853444e-09 274.1p -8.951439e-08 274.2p -1.526187e-07 274.3p -1.908984e-07 274.4p -2.054972e-07 274.5p -1.994313e-07 274.6p -1.769843e-07 274.7p -1.431002e-07 274.8p -1.028293e-07 274.9p -6.086528e-08 275p -2.119781e-08 275.1p 1.31099e-08 275.2p 4.002172e-08 275.3p 5.852074e-08 275.4p 6.851333e-08 275.5p 7.066953e-08 275.6p 6.622547e-08 275.7p 5.677188e-08 275.8p 4.405005e-08 275.9p 2.977152e-08 276p 1.547329e-08 276.1p 2.414588e-09 276.2p -8.483163e-09 276.3p -1.665582e-08 276.4p -2.188109e-08 276.5p -2.423589e-08 276.6p -2.403522e-08 276.7p -2.176117e-08 276.8p -1.799026e-08 276.9p -1.332563e-08 277p -8.339268e-09 277.1p -3.527406e-09 277.2p 7.192318e-10 277.3p 4.130578e-09 277.4p 6.558994e-09 277.5p 7.969981e-09 277.6p 8.424634e-09 277.7p 8.056906e-09 277.8p 7.048599e-09 277.9p 5.604705e-09 278p 3.931189e-09 278.1p 2.216736e-09 278.2p 6.193167e-10 278.3p -7.42089e-10 278.4p -1.790855e-09 278.5p -2.491737e-09 278.6p -2.846438e-09 278.7p -2.886751e-09 278.8p -2.666288e-09 278.9p -2.251813e-09 279p -1.714986e-09 279.1p -1.125183e-09 279.2p -5.438162e-10 279.3p -2.039607e-11 279.4p 4.096571e-10 279.5p 7.255594e-10 279.6p 9.203273e-10 279.7p 9.988827e-10 279.8p 9.754555e-10 279.9p 8.70643e-10 280p 7.084432e-10 280.1p 5.135299e-10 280.2p 3.089636e-10 280.3p 1.144597e-10 280.4p -5.473369e-11 280.5p -1.883631e-10 280.6p -2.811612e-10 280.7p -3.324035e-10 280.8p -3.451458e-10 280.9p -3.252683e-10 281p -2.804464e-10 281.1p -2.191503e-10 281.2p -1.497565e-10 281.3p -7.982986e-11 281.4p -1.560668e-11 281.5p 3.831113e-11 281.6p 7.906324e-11 281.7p 1.054651e-10 281.8p 1.178075e-10 281.9p 1.175627e-10 282p 1.070406e-10 282.1p 8.903335e-11 282.2p 6.648269e-11 282.3p 4.219458e-11 282.4p 1.861732e-11 282.5p -2.308267e-12 282.6p -1.922696e-11 282.7p -3.138179e-11 282.8p -3.857166e-11 282.9p -4.10679e-11 283p -3.950464e-11 283.1p -3.475713e-11 283.2p -2.782105e-11 283.3p -1.970328e-11 283.4p -1.133137e-11 283.5p -3.486603e-12 283.6p 3.238182e-12 283.7p 8.456095e-12 283.8p 1.198298e-11 283.9p 1.381664e-11 284p 1.41038e-11 284.1p 1.310049e-11 284.2p 1.112939e-11 284.3p 8.539472e-12 284.4p 5.670629e-12 284.5p 2.825471e-12 284.6p 2.494734e-13 284.7p -1.88014e-12 284.8p -3.45749e-12 284.9p -4.444553e-12 285p -4.861921e-12 285.1p -4.776501e-12 285.2p -4.287287e-12 285.3p -3.510569e-12 285.4p -2.566799e-12 285.5p -1.569309e-12 285.6p -6.153309e-13 285.7p 2.19176e-13 285.8p 8.828073e-13 285.9p 1.348238e-12 286p 1.610699e-12 286.1p 1.684062e-12 286.2p 1.596177e-12 286.3p 1.384201e-12 286.4p 1.089172e-12 286.5p 7.521822e-13 286.6p 4.10396e-13 286.7p 9.474184e-14 286.8p -1.718752e-13 286.9p -3.749336e-13 287p -5.081193e-13 287.1p -5.725112e-13 287.2p -5.749402e-13 287.3p -5.264556e-13 287.4p -4.405531e-13 287.5p -3.315789e-13 287.6p -2.132919e-13 287.7p -9.778473e-14 287.8p 5.305333e-15 287.9p 8.914713e-14 288p 1.499524e-13 288.1p 1.865372e-13 288.2p 2.001207e-13 288.3p 1.936052e-13 288.4p 1.712877e-13 288.5p 1.380351e-13 288.6p 9.867919e-14 288.7p 5.784128e-14 288.8p 1.93272e-14 288.9p -1.389033e-14 289p -3.981192e-14 289.1p -5.754313e-14 289.2p -6.705765e-14 289.3p -6.88904e-14 289.4p -6.435675e-14 289.5p -5.503515e-14 289.6p -4.253035e-14 289.7p -2.855234e-14 289.8p -1.464447e-14 289.9p -1.929212e-15 290p 8.6113e-15 290.1p 1.649476e-14 290.2p 2.146687e-14 290.3p 2.372931e-14 290.4p 2.340485e-14 290.5p 2.113364e-14 290.6p 1.739798e-14 290.7p 1.282049e-14 290.8p 7.927307e-15 290.9p 3.270891e-15 291p -8.769145e-16 291.1p -4.156575e-15 291.2p -6.506705e-15 291.3p -7.857154e-15 291.4p -8.242996e-15 291.5p -7.822077e-15 291.6p -6.787318e-15 291.7p -5.401793e-15 291.8p -3.744425e-15 291.9p -2.104595e-15 292p -5.261487e-16 292.1p 7.89223e-16 292.2p 1.771367e-15 292.3p 2.472899e-15 292.4p 2.753511e-15 292.5p 2.788588e-15 292.6p 2.604436e-15 292.7p 2.192286e-15 292.8p 1.683676e-15 292.9p 1.13122e-15 293p 5.699944e-16 293.1p 3.507658e-17 293.2p -3.858424e-16 293.3p -6.927624e-16 293.4p -8.769145e-16 293.5p -9.996825e-16 293.6p -9.646059e-16 293.7p -8.330688e-16 293.8p -6.489167e-16 293.9p -4.559955e-16 294p -2.279978e-16 294.1p -5.261487e-17 294.2p 8.769145e-17 294.3p 2.192286e-16 294.4p 2.893818e-16 294.5p 3.244584e-16 294.6p 2.981509e-16 294.7p 2.981509e-16 294.8p 2.630743e-16 294.9p 2.279978e-16 295p 1.490755e-16 295.1p 1.22768e-16 295.2p 3.507658e-17 295.3p 0 295.4p -3.507658e-17 295.5p -9.646059e-17 295.6p -1.052297e-16 295.7p -1.052297e-16 295.8p -1.22768e-16 295.9p -1.052297e-16 296p -9.646059e-17 296.1p -5.261487e-17 296.2p -3.507658e-17 296.3p 0 296.4p 4.384572e-17 296.5p 7.015316e-17 296.6p 7.89223e-17 296.7p 7.015316e-17 296.8p 7.015316e-17 296.9p 7.015316e-17 297p 3.507658e-17 297.1p 3.507658e-17 297.2p 1.753829e-17 297.3p -3.507658e-17 297.4p -2.630743e-17 297.5p 0 297.6p -1.753829e-17 297.7p 8.769145e-18 297.8p 0 297.9p 0 298p 0 298.1p 0 298.2p 0 298.3p 0 298.4p 0 298.5p 0 298.6p 0 298.7p 0 298.8p 0 298.9p 0 299p 0 299.1p 0 299.2p 0 299.3p 0 299.4p 0 299.5p 0 299.6p 0 299.7p 0 299.8p 0 299.9p 0)
XJTL1 JTL_IN JTL_MID THmitll_JTL
XJTL2 JTL_MID JTL_OUT THmitll_JTL
R_TERM JTL_OUT 0 1
.tran 0.1p 300p
.print I(V_REPLAY) V(JTL_IN) V(JTL_MID) V(JTL_OUT)
.print P(B1|XJTL1) V(B1|XJTL1) I(B1|XJTL1) P(B2|XJTL1) V(B2|XJTL1) I(B2|XJTL1)
.print P(B1|XJTL2) V(B1|XJTL2) I(B1|XJTL2) P(B2|XJTL2) V(B2|XJTL2) I(B2|XJTL2)
.print I(L1|XJTL1) I(L2|XJTL1) I(L3|XJTL1) I(L4|XJTL1) I(IB1|XJTL1) I(RB1|XJTL1) I(RB2|XJTL1)
.print I(L1|XJTL2) I(L2|XJTL2) I(L3|XJTL2) I(L4|XJTL2) I(IB1|XJTL2) I(RB1|XJTL2) I(RB2|XJTL2)
.print V(JTL_MID) V(JTL_OUT) I(R_TERM) I(L1|XJTL1)
.end
