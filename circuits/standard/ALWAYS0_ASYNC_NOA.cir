* ALWAYS0_ASYNC_NOA — ColdFlux RSFQ Standard Cell
* Source: IARPA SuperTools/ColdFlux Cell Library v3.0
* MIT-LL SFQ Process | JoSIM-compatible
* Ports: q
* Junctions: 1 total
*   B1: area=B1
*
* Bias: 2.6mV DC bias line (resistors calculated per ColdFlux methodology)
* Usage: .include circuits/standard/ALWAYS0_ASYNC_NOA.cir
*        .model jjmit jj(rtype=1, vg=2.8m, cap=0.07p, r0=160, rn=16, icrit=0.1m)
*
.subckt THmitll_ALWAYS0_ASYNC_NOA q
.param Phi0=2.067833848E-15
.param B0=1
.param Ic0=0.0001
.param IcRs=100u*6.859904418
.param B0Rs=IcRs/Ic0*B0
.param Rsheet=2
.param Lsheet=1.13e-12
.param LP=0.5p
.param IC=2.5
.param LB=2p
.param BiasCoef=0.7
.param B1=IC
.param IB1=B1*Ic0*BiasCoef
.param LB1=LB
.param L1=Phi0/(2*B1*Ic0)
.param L2=Phi0/(4*B1*Ic0)
.param R1=2
.param LP1=LP
.param RB1=B0Rs/B1
.param LRB1=(RB1/Rsheet)*Lsheet+LP
B1 2 3 jjmit area=B1
IB1 0 4 pwl(0 0 5p IB1)
LB1 4 2 7.52E-013
LP1 3 0 4.232E-013
L1 1 2 4.162E-012
L2 2 q 2.078E-012
R1 1 0 R1
RB1 2 102 RB1
LRB1 102 0 LRB1
.ends
