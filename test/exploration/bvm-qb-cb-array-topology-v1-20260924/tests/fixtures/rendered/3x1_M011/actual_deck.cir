* RENDER_FIXTURE_ONLY — not JoSIM experiment evidence
* Generated top-level deck; component parameters live only in source snapshots.
.title BVM array -> QB/CB/sJTL topology fixture
.include "snapshot/sources/bvm_cell_0923.cir"
.include "snapshot/sources/BQ_0923.cir"
.include "snapshot/sources/CB_0923.cir"
.include "snapshot/sources/sJTL_0923.cir"
.include "stimulus.inc"

XBVM1 WL1 BL1 SE1 BVM1_SL BVM
XBQ1 BVM1_SL QB1_RAW BQ
XQBCB1 QB1_RAW MERGE1 CB
XBVM2 WL2 BL2 SE2 BVM2_SL BVM
XBQ2 BVM2_SL MERGE1 BQ
XSJTL2_01 MERGE1 L2_01 sJTL
XSJTL2_02 L2_01 L2_02 sJTL
XSJTL2_03 L2_02 L2_03 sJTL
XPOSTCB2 L2_03 MERGE3 CB
XBVM3 WL3 BL3 SE3 BVM3_SL BVM
XBQ3 BVM3_SL QB3_RAW BQ
XQBCB3 QB3_RAW MERGE3 CB
XSJTL3_01 MERGE3 FINAL_OUT sJTL

R_TERM FINAL_OUT 0 2
.print I(I_WL1)
.print I(I_BL1)
.print I(I_SE1)
.print P(B_JM1|XBVM1)
.print V(B_JM1|XBVM1)
.print I(B_JM1|XBVM1)
.print P(B_JM2|XBVM1)
.print V(B_JM2|XBVM1)
.print I(B_JM2|XBVM1)
.print P(B_JS1|XBVM1)
.print V(B_JS1|XBVM1)
.print I(B_JS1|XBVM1)
.print P(B_JS2|XBVM1)
.print V(B_JS2|XBVM1)
.print I(B_JS2|XBVM1)
.print I(L_M1|XBVM1)
.print V(L_M1|XBVM1)
.print I(L_M2|XBVM1)
.print V(L_M2|XBVM1)
.print I(L_M3|XBVM1)
.print V(L_M3|XBVM1)
.print I(L_PM|XBVM1)
.print V(L_PM|XBVM1)
.print I(L_SL|XBVM1)
.print V(L_SL|XBVM1)
.print I(R_SL|XBVM1)
.print V(R_SL|XBVM1)
.print V(BVM1_SL)
.print P(BJ1|XBQ1)
.print V(BJ1|XBQ1)
.print I(BJ1|XBQ1)
.print P(BJ2|XBQ1)
.print V(BJ2|XBQ1)
.print I(BJ2|XBQ1)
.print P(BJ3|XBQ1)
.print V(BJ3|XBQ1)
.print I(BJ3|XBQ1)
.print I(LIN|XBQ1)
.print V(LIN|XBQ1)
.print I(L1|XBQ1)
.print V(L1|XBQ1)
.print I(L2|XBQ1)
.print V(L2|XBQ1)
.print I(L3|XBQ1)
.print V(L3|XBQ1)
.print V(QB1_RAW)
.print I(I_WL2)
.print I(I_BL2)
.print I(I_SE2)
.print P(B_JM1|XBVM2)
.print V(B_JM1|XBVM2)
.print I(B_JM1|XBVM2)
.print P(B_JM2|XBVM2)
.print V(B_JM2|XBVM2)
.print I(B_JM2|XBVM2)
.print P(B_JS1|XBVM2)
.print V(B_JS1|XBVM2)
.print I(B_JS1|XBVM2)
.print P(B_JS2|XBVM2)
.print V(B_JS2|XBVM2)
.print I(B_JS2|XBVM2)
.print I(L_M1|XBVM2)
.print V(L_M1|XBVM2)
.print I(L_M2|XBVM2)
.print V(L_M2|XBVM2)
.print I(L_M3|XBVM2)
.print V(L_M3|XBVM2)
.print I(L_PM|XBVM2)
.print V(L_PM|XBVM2)
.print I(L_SL|XBVM2)
.print V(L_SL|XBVM2)
.print I(R_SL|XBVM2)
.print V(R_SL|XBVM2)
.print V(BVM2_SL)
.print P(BJ1|XBQ2)
.print V(BJ1|XBQ2)
.print I(BJ1|XBQ2)
.print P(BJ2|XBQ2)
.print V(BJ2|XBQ2)
.print I(BJ2|XBQ2)
.print P(BJ3|XBQ2)
.print V(BJ3|XBQ2)
.print I(BJ3|XBQ2)
.print I(LIN|XBQ2)
.print V(LIN|XBQ2)
.print I(L1|XBQ2)
.print V(L1|XBQ2)
.print I(L2|XBQ2)
.print V(L2|XBQ2)
.print I(L3|XBQ2)
.print V(L3|XBQ2)
.print V(MERGE1)
.print I(I_WL3)
.print I(I_BL3)
.print I(I_SE3)
.print P(B_JM1|XBVM3)
.print V(B_JM1|XBVM3)
.print I(B_JM1|XBVM3)
.print P(B_JM2|XBVM3)
.print V(B_JM2|XBVM3)
.print I(B_JM2|XBVM3)
.print P(B_JS1|XBVM3)
.print V(B_JS1|XBVM3)
.print I(B_JS1|XBVM3)
.print P(B_JS2|XBVM3)
.print V(B_JS2|XBVM3)
.print I(B_JS2|XBVM3)
.print I(L_M1|XBVM3)
.print V(L_M1|XBVM3)
.print I(L_M2|XBVM3)
.print V(L_M2|XBVM3)
.print I(L_M3|XBVM3)
.print V(L_M3|XBVM3)
.print I(L_PM|XBVM3)
.print V(L_PM|XBVM3)
.print I(L_SL|XBVM3)
.print V(L_SL|XBVM3)
.print I(R_SL|XBVM3)
.print V(R_SL|XBVM3)
.print V(BVM3_SL)
.print P(BJ1|XBQ3)
.print V(BJ1|XBQ3)
.print I(BJ1|XBQ3)
.print P(BJ2|XBQ3)
.print V(BJ2|XBQ3)
.print I(BJ2|XBQ3)
.print P(BJ3|XBQ3)
.print V(BJ3|XBQ3)
.print I(BJ3|XBQ3)
.print I(LIN|XBQ3)
.print V(LIN|XBQ3)
.print I(L1|XBQ3)
.print V(L1|XBQ3)
.print I(L2|XBQ3)
.print V(L2|XBQ3)
.print I(L3|XBQ3)
.print V(L3|XBQ3)
.print V(QB3_RAW)
.print P(BJ1|XQBCB1)
.print V(BJ1|XQBCB1)
.print I(BJ1|XQBCB1)
.print P(BJ2|XQBCB1)
.print V(BJ2|XQBCB1)
.print I(BJ2|XQBCB1)
.print I(L1|XQBCB1)
.print V(L1|XQBCB1)
.print I(L2|XQBCB1)
.print V(L2|XQBCB1)
.print I(L3|XQBCB1)
.print V(L3|XQBCB1)
.print I(L4|XQBCB1)
.print V(L4|XQBCB1)
.print P(BJ1|XPOSTCB2)
.print V(BJ1|XPOSTCB2)
.print I(BJ1|XPOSTCB2)
.print P(BJ2|XPOSTCB2)
.print V(BJ2|XPOSTCB2)
.print I(BJ2|XPOSTCB2)
.print I(L1|XPOSTCB2)
.print V(L1|XPOSTCB2)
.print I(L2|XPOSTCB2)
.print V(L2|XPOSTCB2)
.print I(L3|XPOSTCB2)
.print V(L3|XPOSTCB2)
.print I(L4|XPOSTCB2)
.print V(L4|XPOSTCB2)
.print V(MERGE3)
.print P(BJ1|XSJTL2_01)
.print V(BJ1|XSJTL2_01)
.print I(BJ1|XSJTL2_01)
.print I(L1|XSJTL2_01)
.print V(L1|XSJTL2_01)
.print I(L2|XSJTL2_01)
.print V(L2|XSJTL2_01)
.print V(L2_01)
.print P(BJ1|XSJTL2_02)
.print V(BJ1|XSJTL2_02)
.print I(BJ1|XSJTL2_02)
.print I(L1|XSJTL2_02)
.print V(L1|XSJTL2_02)
.print I(L2|XSJTL2_02)
.print V(L2|XSJTL2_02)
.print V(L2_02)
.print P(BJ1|XSJTL2_03)
.print V(BJ1|XSJTL2_03)
.print I(BJ1|XSJTL2_03)
.print I(L1|XSJTL2_03)
.print V(L1|XSJTL2_03)
.print I(L2|XSJTL2_03)
.print V(L2|XSJTL2_03)
.print V(L2_03)
.print P(BJ1|XQBCB3)
.print V(BJ1|XQBCB3)
.print I(BJ1|XQBCB3)
.print P(BJ2|XQBCB3)
.print V(BJ2|XQBCB3)
.print I(BJ2|XQBCB3)
.print I(L1|XQBCB3)
.print V(L1|XQBCB3)
.print I(L2|XQBCB3)
.print V(L2|XQBCB3)
.print I(L3|XQBCB3)
.print V(L3|XQBCB3)
.print I(L4|XQBCB3)
.print V(L4|XQBCB3)
.print V(FINAL_OUT)
.print P(BJ1|XSJTL3_01)
.print V(BJ1|XSJTL3_01)
.print I(BJ1|XSJTL3_01)
.print I(L1|XSJTL3_01)
.print V(L1|XSJTL3_01)
.print I(L2|XSJTL3_01)
.print V(L2|XSJTL3_01)
.print V(R_TERM)
.print I(R_TERM)
.tran 0.01p 200p
.end
