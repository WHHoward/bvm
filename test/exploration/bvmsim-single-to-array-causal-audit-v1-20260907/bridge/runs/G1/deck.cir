* SINGLE -> ARRAY CAUSAL BRIDGE G1
* source_class=HISTORICAL_BVMSIM_JM2_CONNECTED_VARIANT
* unique change under test: single sensing boundary -> shared 12-JSL boundary
* protocol=G0 single S1 protocol
* canonical BVM is not used; BVM variant is bvm_jm2_connected.cir

.include ../../../../../circuits/models/jjmit.cir
.include ../../../../../test/exploration/bvmsim-jm2-connected-single-ab-v1-20260903/variants/bvm_jm2_connected.cir
.include ../../../../../BVMSim/BQ.cir
.include ../../../../../BVMSim/library_josim/jtl2.cir

XBVM1 WL1 BL1 SE1 COMMON_SL BVM

B_JSL01 COMMON_SL COL01 jjmit area=5.0
B_JSL02 COL01 COL02 jjmit area=5.0
B_JSL03 COL02 COL03 jjmit area=5.0
B_JSL04 COL03 COL04 jjmit area=5.0
B_JSL05 COL04 COL05 jjmit area=5.0
B_JSL06 COL05 COL06 jjmit area=5.0
B_JSL07 COL06 COL07 jjmit area=5.0
B_JSL08 COL07 COL08 jjmit area=5.0
B_JSL09 COL08 COL09 jjmit area=5.0
B_JSL10 COL09 COL10 jjmit area=5.0
B_JSL11 COL10 COL11 jjmit area=5.0
B_JSL12 COL11 QBIN jjmit area=5.0

XBQ1 QBIN QBOUT BQ
xjtl1_1 QBOUT JTL1_OUT jtl
xjtl1_2 JTL1_OUT JTL2_OUT jtl
xjtl1_3 JTL2_OUT JTL3_OUT jtl
xjtl1_4 JTL3_OUT JTL4_OUT jtl
xjtl1_5 JTL4_OUT JTL5_OUT jtl
xjtl1_6 JTL5_OUT JTL6_OUT jtl
R_TERM JTL6_OUT 0 10

I_WL1 0 WL1 pwl(0 0 50p 0 51p +100u 60p +100u 61p 0 70p 0 71p 100u 80p 100u 81p 0 200p 0)
I_BL1 0 BL1 pwl(0 0 50p 0 51p +100u 60p +100u 61p 0 70p 0 71p 0 80p 0 81p 0 200p 0)
I_SE1 0 SE1 pwl(0 0 50p 0 51p 0 60p 0 61p 0 70p 0 71p 100u 80p 100u 81p 0 200p 0)

.tran 0.1p 200p

.print I(I_WL1) I(I_BL1) I(I_SE1) P(B_JM1|XBVM1) V(B_JM1|XBVM1) I(B_JM1|XBVM1) P(B_JM2|XBVM1) V(B_JM2|XBVM1)
.print I(B_JM2|XBVM1) P(B_JS1|XBVM1) V(B_JS1|XBVM1) I(B_JS1|XBVM1) P(B_JS2|XBVM1) V(B_JS2|XBVM1) I(B_JS2|XBVM1) I(L_M1|XBVM1)
.print V(L_M1|XBVM1) I(L_M2|XBVM1) V(L_M2|XBVM1) I(L_M3|XBVM1) V(L_M3|XBVM1) I(L_PM|XBVM1) V(L_PM|XBVM1) I(R_JM1|XBVM1)
.print V(R_JM1|XBVM1) I(L_S1|XBVM1) V(L_S1|XBVM1) I(L_S2|XBVM1) V(L_S2|XBVM1) I(R_S|XBVM1) V(R_S|XBVM1) I(L_S3|XBVM1)
.print V(L_S3|XBVM1) I(R_SE|XBVM1) V(R_SE|XBVM1) I(L_PSE|XBVM1) V(L_PSE|XBVM1) I(L_PSL|XBVM1) V(L_PSL|XBVM1) I(R_SL|XBVM1)
.print V(R_SL|XBVM1) I(L_SL|XBVM1) V(L_SL|XBVM1) V(COMMON_SL) V(QBIN) V(QBOUT) P(B_JSL01) V(B_JSL01)
.print I(B_JSL01) P(B_JSL02) V(B_JSL02) I(B_JSL02) P(B_JSL03) V(B_JSL03) I(B_JSL03) P(B_JSL04)
.print V(B_JSL04) I(B_JSL04) P(B_JSL05) V(B_JSL05) I(B_JSL05) P(B_JSL06) V(B_JSL06) I(B_JSL06)
.print P(B_JSL07) V(B_JSL07) I(B_JSL07) P(B_JSL08) V(B_JSL08) I(B_JSL08) P(B_JSL09) V(B_JSL09)
.print I(B_JSL09) P(B_JSL10) V(B_JSL10) I(B_JSL10) P(B_JSL11) V(B_JSL11) I(B_JSL11) P(B_JSL12)
.print V(B_JSL12) I(B_JSL12) I(LIN|XBQ1) I(L1|XBQ1) I(L2|XBQ1) I(L3|XBQ1) I(RJ1|XBQ1) I(RJ2|XBQ1)
.print I(IB|XBQ1) P(BJS|XBQ1) V(BJS|XBQ1) I(BJS|XBQ1) P(BJ1|XBQ1) V(BJ1|XBQ1) I(BJ1|XBQ1) P(BJ2|XBQ1)
.print V(BJ2|XBQ1) I(BJ2|XBQ1) V(JTL1_OUT) V(JTL2_OUT) V(JTL3_OUT) V(JTL4_OUT) V(JTL5_OUT) V(JTL6_OUT)
.print I(R_TERM) P(B01|XJTL1_1) V(B01|XJTL1_1) P(B02|XJTL1_1) V(B02|XJTL1_1) P(B01|XJTL1_2) V(B01|XJTL1_2) P(B02|XJTL1_2)
.print V(B02|XJTL1_2) P(B01|XJTL1_3) V(B01|XJTL1_3) P(B02|XJTL1_3) V(B02|XJTL1_3) P(B01|XJTL1_4) V(B01|XJTL1_4) P(B02|XJTL1_4)
.print V(B02|XJTL1_4) P(B01|XJTL1_5) V(B01|XJTL1_5) P(B02|XJTL1_5) V(B02|XJTL1_5) P(B01|XJTL1_6) V(B01|XJTL1_6) P(B02|XJTL1_6)
.print V(B02|XJTL1_6)
.end
