* BVM_JSL_READ_WIDTH_TO_QB_SFQ_V1 Phase-C wstar12-logical0-read: exact current replay
* source snapshot=wstar12-logical0-read.csv; no scaling/rectify/hold/resample
.include jjmit.cir
.include bq_cell.cir
XBQ IN OUT IBIAS BQ
I_REPLAY 0 IN pwl(0p 0 0.012500000000000001p 0 0.025000000000000001p 0 0.037499999999999999p 0 0.050000000000000003p 0 0.0625p 0 0.074999999999999997p 0 0.087500000000000008p 0 0.10000000000000001p 0 0.1125p 0 0.125p 0 0.13749999999999998p 0 0.14999999999999999p 0 0.16249999999999998p 0 0.17500000000000002p 0 0.1875p 0 0.20000000000000001p 0 0.21249999999999999p 0
+ 0.22500000000000001p 0 0.23749999999999999p 0 0.25p 0 0.26250000000000001p 0 0.27499999999999997p 0 0.28749999999999998p 0 0.29999999999999999p 0 0.3125p 0 0.32499999999999996p 0 0.33749999999999997p 0 0.35000000000000003p 0 0.36250000000000004p 0 0.375p 0 0.38750000000000001p 0 0.40000000000000002p 0 0.41250000000000003p 0 0.42499999999999999p 0 0.4375p 0
+ 0.45000000000000001p 0 0.46250000000000002p 0 0.47499999999999998p 0 0.48749999999999999p 0 0.5p 0 0.51249999999999996p 0 0.52500000000000002p 0 0.53749999999999998p 0 0.54999999999999993p 0 0.5625p 0 0.57499999999999996p 0 0.58750000000000002p 0 0.59999999999999998p 0 0.61249999999999993p 0 0.625p 0 0.63749999999999996p 0 0.64999999999999991p 0 0.66249999999999998p 0
+ 0.67499999999999993p 0 0.6875p 0 0.70000000000000007p 0 0.71250000000000002p 0 0.72500000000000009p 0 0.73750000000000004p 0 0.75p 0 0.76250000000000007p 0 0.77500000000000002p 0 0.78749999999999998p 0 0.80000000000000004p 0 0.8125p 0 0.82500000000000007p 0 0.83750000000000002p 0 0.84999999999999998p 0 0.86250000000000004p 0 0.875p 0 0.88749999999999996p 0
+ 0.90000000000000002p 0 0.91249999999999998p 0 0.92500000000000004p 0 0.9375p 0 0.94999999999999996p 0 0.96250000000000002p 0 0.97499999999999998p 0 0.98749999999999993p 0 1p 0 1.0125p 0 1.0249999999999999p 0 1.0374999999999999p 0 1.05p 0 1.0625p 0 1.075p 0 1.0874999999999999p 0 1.0999999999999999p 0 1.1125p 0
+ 1.125p 0 1.1375p 0 1.1499999999999999p 0 1.1624999999999999p 0 1.175p 0 1.1875p 0 1.2p 0 1.2124999999999999p 0 1.2249999999999999p 0 1.2374999999999998p 0 1.25p 0 1.2625p 0 1.2749999999999999p 0 1.2874999999999999p 0 1.2999999999999998p 0 1.3125p 0 1.325p 0 1.3374999999999999p 0
+ 1.3499999999999999p 0 1.3624999999999998p 0 1.375p 0 1.3875000000000002p 0 1.4000000000000001p 0 1.4125000000000001p 0 1.425p 0 1.4375p 0 1.4500000000000002p 0 1.4625000000000001p 0 1.4750000000000001p 0 1.4875p 0 1.5p 0 1.5125000000000002p 0 1.5250000000000001p 0 1.5375000000000001p 0 1.55p 0 1.5625p 0
+ 1.575p 0 1.5875000000000001p 0 1.6000000000000001p 0 1.6125p 0 1.625p 0 1.6375p 0 1.6500000000000001p 0 1.6625000000000001p 0 1.675p 0 1.6875p 0 1.7p 0 1.7125000000000001p 0 1.7250000000000001p 0 1.7375p 0 1.75p 0 1.7625p 0 1.7749999999999999p 0 1.7875000000000001p 0
+ 1.8p 0 1.8125p 0 1.825p 0 1.8375000000000001p 0 1.8625000000000003p 0 1.875p 0 1.8875000000000002p 0 1.8999999999999999p 0 1.9125000000000001p 0 1.925p 0 1.9375000000000002p 0 1.95p 0 1.9625000000000001p 0 1.9749999999999999p 0 1.9875000000000003p 0 2p 0 2.0125000000000002p 0 2.0249999999999999p 0
+ 2.0375000000000001p 0 2.0499999999999998p 0 2.0625p 0 2.0749999999999997p 0 2.0875000000000004p 0 2.1000000000000001p 0 2.1125000000000003p 0 2.125p 0 2.1375000000000002p 0 2.1499999999999999p 0 2.1625000000000001p 0 2.1749999999999998p 0 2.1875p 0 2.1999999999999997p 0 2.2124999999999999p 0 2.2250000000000001p 0 2.2375000000000003p 0 2.25p 0
+ 2.2625000000000002p 0 2.2749999999999999p 0 2.2875000000000001p 0 2.2999999999999998p 0 2.3125p 0 2.3249999999999997p 0 2.3374999999999999p 0 2.3500000000000001p 0 2.3625000000000003p 0 2.375p 0 2.3875000000000002p 0 2.3999999999999999p 0 2.4125000000000001p 0 2.4249999999999998p 0 2.4375p 0 2.4499999999999997p 0 2.4624999999999999p 0 2.4749999999999996p 0
+ 2.4875000000000003p 0 2.5p 0 2.5125000000000002p 0 2.5249999999999999p 0 2.5375000000000001p 0 2.5499999999999998p 0 2.5625p 0 2.5749999999999997p 0 2.5874999999999999p 0 2.5999999999999996p 0 2.6124999999999998p 0 2.625p 0 2.6375000000000002p 0 2.6499999999999999p 0 2.6625000000000001p 0 2.6749999999999998p 0 2.6875p 0 2.6999999999999997p 0
+ 2.7124999999999999p 0 2.7249999999999996p 0 2.7374999999999998p 0 2.75p 0 2.7625000000000002p 0 2.7750000000000004p 0 2.7875000000000001p 0 2.8000000000000003p 0 2.8125p 0 2.8250000000000002p 0 2.8374999999999999p 0 2.8500000000000001p 0 2.8624999999999998p 0 2.875p 0 2.8875000000000002p 0 2.9000000000000004p 0 2.9125000000000001p 0 2.9250000000000003p 0
+ 2.9375p 0 2.9500000000000002p 0 2.9624999999999999p 0 2.9750000000000001p 0 2.9874999999999998p 0 3p 0 3.0124999999999997p 0 3.0250000000000004p 0 3.0375000000000001p 0 3.0500000000000003p 0 3.0625p 0 3.0750000000000002p 0 3.0874999999999999p 0 3.1000000000000001p 0 3.1124999999999998p 0 3.125p 0 3.1374999999999997p 0 3.1499999999999999p 0
+ 3.1625000000000001p 0 3.1750000000000003p 0 3.1875p 0 3.2000000000000002p 0 3.2124999999999999p 0 3.2250000000000001p 0 3.2374999999999998p 0 3.25p 0 3.2624999999999997p 0 3.2749999999999999p 0 3.2875000000000001p 0 3.3000000000000003p 0 3.3125p 0 3.3250000000000002p 0 3.3374999999999999p 0 3.3500000000000001p 0 3.3624999999999998p 0 3.375p 0
+ 3.3874999999999997p 0 3.3999999999999999p 0 3.4124999999999996p 0 3.4250000000000003p 0 3.4375p 0 3.4500000000000002p 0 3.4624999999999999p 0 3.4750000000000001p 0 3.4874999999999998p 0 3.5p 0 3.5124999999999997p 0 3.5249999999999999p 0 3.5374999999999996p 0 3.5499999999999998p 0 3.5625p 0 3.5750000000000002p 0 3.5874999999999999p 0 3.6000000000000001p 0
+ 3.6124999999999998p 0 3.625p 0 3.6374999999999997p 0 3.6499999999999999p 0 3.6624999999999996p 0 3.6750000000000003p 0 3.6875p 0 3.7000000000000002p 0 3.7124999999999999p 0 3.7250000000000005p 0 3.7375000000000003p 0 3.75p 0 3.7624999999999997p 0 3.7750000000000004p 0 3.7875000000000001p 0 3.7999999999999998p 0 3.8124999999999996p 0 3.8250000000000002p 0
+ 3.8375000000000004p 0 3.8500000000000001p 0 3.8624999999999998p 0 3.8750000000000004p 0 3.8875000000000002p 0 3.8999999999999999p 0 3.9124999999999996p 0 3.9250000000000003p 0 3.9375p 0 3.9499999999999997p 0 3.9624999999999999p 0 3.9750000000000005p 0 3.9875000000000003p 0 4p 0 4.0124999999999993p 0 4.0250000000000004p 0 4.0375000000000005p 0 4.0499999999999998p 0
+ 4.0625p 0 4.0750000000000002p 0 4.0875000000000004p 0 4.0999999999999996p 0 4.1124999999999998p 0 4.125p 0 4.1375000000000002p 0 4.1499999999999995p 0 4.1624999999999996p 0 4.1750000000000007p 0 4.1875p 0 4.2000000000000002p 0 4.2124999999999995p 0 4.2250000000000005p 0 4.2374999999999998p 0 4.25p 0 4.2624999999999993p 0 4.2750000000000004p 0
+ 4.2874999999999996p 0 4.2999999999999998p 0 4.3125p 0 4.3250000000000002p 0 4.3375000000000004p 0 4.3499999999999996p 0 4.3624999999999998p 0 4.375p 0 4.3875000000000002p 0 4.3999999999999995p 0 4.4124999999999996p 0 4.4249999999999998p 0 4.4375p 0 4.4500000000000002p 0 4.4624999999999995p 0 4.4750000000000005p 0 4.4874999999999998p 0 4.5p 0
+ 4.5124999999999993p 0 4.5250000000000004p 0 4.5374999999999996p 0 4.5499999999999998p 0 4.5625p 0 4.5750000000000002p 0 4.5875000000000004p 0 4.5999999999999996p 0 4.6125000000000007p 0 4.625p 0 4.6375000000000002p 0 4.6499999999999995p 0 4.6625000000000005p 0 4.6749999999999998p 0 4.6875p 0 4.7000000000000002p 0 4.7125000000000004p 0 4.7250000000000005p 0
+ 4.7374999999999998p 0 4.75p 0 4.7625000000000002p 0 4.7750000000000004p 0 4.7874999999999996p 0 4.7999999999999998p 0 4.8125p 0 4.8250000000000002p 0 4.8375000000000004p 0 4.8499999999999996p 0 4.8625000000000007p 0 4.875p 0 4.8875000000000002p 0 4.8999999999999995p 0 4.9125000000000005p 0 4.9249999999999998p 0 4.9375p 0 4.9499999999999993p 0
+ 4.9625000000000004p 0 4.9750000000000005p 0 4.9874999999999998p 0 5p 0 5.0125000000000002p 0 5.0250000000000004p 0 5.0374999999999996p 0 5.0499999999999998p 0 5.0625p 0 5.0750000000000002p 0 5.0874999999999995p 0 5.0999999999999996p 0 5.1125000000000007p 0 5.125p 0 5.1375000000000002p 0 5.1499999999999995p 0 5.1625000000000005p 0 5.1749999999999998p 0
+ 5.1875p 0 5.1999999999999993p 0 5.2125000000000004p 0 5.2249999999999996p 0 5.2374999999999998p 0 5.25p 0 5.2625000000000002p 0 5.2750000000000004p 0 5.2874999999999996p 0 5.2999999999999998p 0 5.3125p 0 5.3250000000000002p 0 5.3374999999999995p 0 5.3499999999999996p 0 5.3624999999999998p 0 5.375p 0 5.3875000000000002p 0 5.3999999999999995p 0
+ 5.4125000000000005p 0 5.4249999999999998p 0 5.4375p 0 5.4499999999999993p 0 5.4625000000000004p 0 5.4749999999999996p 0 5.4874999999999998p 0 5.5p 0 5.5125000000000002p 0 5.5250000000000004p 0 5.5374999999999996p 0 5.5500000000000007p 0 5.5625p 0 5.5750000000000002p 0 5.5874999999999995p 0 5.6000000000000005p 0 5.6124999999999998p 0 5.625p 0
+ 5.6375000000000002p 0 5.6500000000000004p 0 5.6625000000000005p 0 5.6749999999999998p 0 5.6875p 0 5.7000000000000002p 0 5.7125000000000004p 0 5.7249999999999996p 0 5.7374999999999998p 0 5.75p 0 5.7625000000000002p 0 5.7750000000000004p 0 5.7874999999999996p 0 5.8000000000000007p 0 5.8125p 0 5.8250000000000002p 0 5.8374999999999995p 0 5.8500000000000005p 0
+ 5.8624999999999998p 0 5.875p 0 5.8874999999999993p 0 5.9000000000000004p 0 5.9125000000000005p 0 5.9249999999999998p 0 5.9375p 0 5.9500000000000002p 0 5.9625000000000004p 0 5.9749999999999996p 0 5.9874999999999998p 0 6p 0 6.0125000000000002p 0 6.0249999999999995p 0 6.0374999999999996p 0 6.0500000000000007p 0 6.0625p 0 6.0750000000000002p 0
+ 6.0874999999999995p 0 6.1000000000000005p 0 6.1124999999999998p 0 6.125p 0 6.1374999999999993p 0 6.1500000000000004p 0 6.1624999999999996p 0 6.1749999999999998p 0 6.1875p 0 6.2000000000000002p 0 6.2125000000000004p 0 6.2249999999999996p 0 6.2374999999999998p 0 6.25p 0 6.2625000000000002p 0 6.2749999999999995p 0 6.2874999999999996p 0 6.2999999999999998p 0
+ 6.3125p 0 6.3250000000000002p 0 6.3374999999999995p 0 6.3500000000000005p 0 6.3624999999999998p 0 6.375p 0 6.3875000000000002p 0 6.4000000000000004p 0 6.4124999999999996p 0 6.4249999999999998p 0 6.4375p 0 6.4500000000000002p 0 6.4625000000000004p 0 6.4749999999999996p 0 6.4875000000000007p 0 6.5p 0 6.5125000000000002p 0 6.5249999999999995p 0
+ 6.5375000000000005p 0 6.5499999999999998p 0 6.5625p 0 6.5750000000000002p 0 6.5875000000000004p 0 6.6000000000000005p 0 6.6124999999999998p 0 6.625p 0 6.6375000000000002p 0 6.6500000000000004p 0 6.6624999999999996p 0 6.6749999999999998p 0 6.6875p 0 6.7000000000000002p 0 6.7125000000000004p 0 6.7249999999999996p 0 6.7375000000000007p 0 6.75p 0
+ 6.7625000000000002p 0 6.7749999999999995p 0 6.7875000000000005p 0 6.7999999999999998p 0 6.8125p 0 6.8249999999999993p 0 6.8375000000000004p 0 6.8500000000000005p 0 6.8624999999999998p 0 6.875p 0 6.8875000000000002p 0 6.9000000000000004p 0 6.9124999999999996p 0 6.9249999999999998p 0 6.9375p 0 6.9500000000000002p 0 6.9624999999999995p 0 6.9749999999999996p 0
+ 6.9874999999999998p 0 7p 0 7.0125000000000002p 0 7.0249999999999995p 0 7.0375000000000005p 0 7.0499999999999998p 0 7.0625p 0 7.0749999999999993p 0 7.0875000000000004p 0 7.0999999999999996p 0 7.1124999999999998p 0 7.125p 0 7.1375000000000002p 0 7.1500000000000004p 0 7.1624999999999996p 0 7.1749999999999998p 0 7.1875p 0 7.2000000000000002p 0
+ 7.2124999999999995p 0 7.2249999999999996p 0 7.2374999999999998p 0 7.25p 0 7.2625000000000002p 0 7.2749999999999995p 0 7.2874999999999996p 0 7.2999999999999998p 0 7.3125000000000009p 0 7.3249999999999993p 0 7.3375000000000004p 0 7.3500000000000005p 0 7.3624999999999998p 0 7.375p 0 7.3874999999999993p 0 7.4000000000000004p 0 7.4125000000000005p 0 7.4249999999999998p 0
+ 7.4375p 0 7.4500000000000011p 0 7.4624999999999995p 0 7.4750000000000005p 0 7.4874999999999989p 0 7.5p 0 7.5125000000000002p 0 7.5249999999999995p 0 7.5375000000000005p 0 7.5500000000000007p 0 7.5625p 0 7.5750000000000002p 0 7.5874999999999995p 0 7.5999999999999996p 0 7.6125000000000007p 0 7.6249999999999991p 0 7.6375000000000002p 0 7.6500000000000004p 0
+ 7.6624999999999996p 0 7.6750000000000007p 0 7.6874999999999991p 0 7.7000000000000002p 0 7.7125000000000004p 0 7.7249999999999996p 0 7.7374999999999998p 0 7.7500000000000009p 0 7.7624999999999993p 0 7.7750000000000004p 0 7.7874999999999996p 0 7.7999999999999998p 0 7.8125000000000009p 0 7.8249999999999993p 0 7.8375000000000004p 0 7.8500000000000005p 0 7.8624999999999998p 0 7.875p 0
+ 7.8874999999999993p 0 7.8999999999999995p 0 7.9125000000000005p 0 7.9249999999999998p 0 7.9375p 0 7.9500000000000011p 0 7.9624999999999995p 0 7.9750000000000005p 0 7.9874999999999989p 0 8p 0 8.0125000000000011p 0 8.0249999999999986p 0 8.0374999999999996p 0 8.0500000000000007p 0 8.0625p 0 8.0750000000000011p 0 8.0874999999999986p 0 8.0999999999999996p 0
+ 8.1125000000000007p 0 8.125p 0 8.1374999999999993p 0 8.1500000000000004p 0 8.1624999999999996p 0 8.1750000000000007p 0 8.1875p 0 8.1999999999999993p 0 8.2125000000000004p 0 8.2249999999999996p 0 8.2375000000000007p 0 8.25p 0 8.2624999999999993p 0 8.2750000000000004p 0 8.2875000000000014p 0 8.2999999999999989p 0 8.3125p 0 8.3249999999999993p 0
+ 8.3375000000000004p 0 8.3500000000000014p 0 8.3624999999999989p 0 8.375p 0 8.3875000000000011p 0 8.4000000000000004p 0 8.4124999999999996p 0 8.4249999999999989p 0 8.4375p 0 8.4500000000000011p 0 8.4625000000000004p 0 8.4749999999999996p 0 8.4875000000000007p 0 8.5p 0 8.5125000000000011p 0 8.5249999999999986p 0 8.5374999999999996p 0 8.5500000000000007p 0
+ 8.5625p 0 8.5749999999999993p 0 8.5875000000000004p 0 8.5999999999999996p 0 8.6125000000000007p 0 8.625p 0 8.6374999999999993p 0 8.6500000000000004p 0 8.6624999999999996p 0 8.6750000000000007p 0 8.6875p 0 8.6999999999999993p 0 8.7125000000000004p 0 8.7249999999999996p 0 8.7375000000000007p 0 8.75p 0 8.7624999999999993p 0 8.7750000000000004p 0
+ 8.7875000000000014p 0 8.7999999999999989p 0 8.8125p 0 8.8249999999999993p 0 8.8375000000000004p 0 8.8499999999999996p 0 8.8624999999999989p 0 8.875p 0 8.8875000000000011p 0 8.9000000000000004p 0 8.9124999999999996p 0 8.9249999999999989p 0 8.9375p 0 8.9500000000000011p 0 8.9624999999999986p 0 8.9749999999999996p 0 8.9875000000000007p 0 9p 0
+ 9.0125000000000011p 0 9.0249999999999986p 0 9.0374999999999996p 0 9.0500000000000007p 0 9.0625p 0 9.0749999999999993p 0 9.0875000000000004p 0 9.0999999999999996p 0 9.1125000000000007p 0 9.125p 0 9.1374999999999993p 0 9.1500000000000004p 0 9.1624999999999996p 0 9.1750000000000007p 0 9.1875p 0 9.1999999999999993p 0 9.2125000000000004p 0 9.2250000000000014p 0
+ 9.2374999999999989p 0 9.25p 0 9.2624999999999993p 0 9.2750000000000004p 0 9.2875000000000014p 0 9.2999999999999989p 0 9.3125p 0 9.3250000000000011p 0 9.3375000000000004p 0 9.3499999999999996p 0 9.3624999999999989p 0 9.375p 0 9.3875000000000011p 0 9.4000000000000004p 0 9.4124999999999996p 0 9.4250000000000007p 0 9.4375p 0 9.4500000000000011p 0
+ 9.4624999999999986p 0 9.4749999999999996p 0 9.4875000000000007p 0 9.5p 0 9.5124999999999993p 0 9.5250000000000004p 0 9.5374999999999996p 0 9.5500000000000007p 0 9.5625p 0 9.5749999999999993p 0 9.5875000000000004p 0 9.5999999999999996p 0 9.6125000000000007p 0 9.625p 0 9.6374999999999993p 0 9.6500000000000004p 0 9.6624999999999996p 0 9.6750000000000007p 0
+ 9.6875p 0 9.6999999999999993p 0 9.7125000000000004p 0 9.7250000000000014p 0 9.7374999999999989p 0 9.75p 0 9.7624999999999993p 0 9.7750000000000004p 0 9.7874999999999996p 0 9.7999999999999989p 0 9.8125p 0 9.8250000000000011p 0 9.8375000000000004p 0 9.8499999999999996p 0 9.8624999999999989p 0 9.875p 0 9.8875000000000011p 0 9.8999999999999986p 0
+ 9.9124999999999996p 0 9.9250000000000007p 0 9.9375p 0 9.9500000000000011p 0 9.9624999999999986p 0 9.9749999999999996p 0 9.9875000000000007p 0 10p -5.0939030000000001e-20 10.012499999999999p -3.9412170000000001e-07 10.025p -7.5903300000000002e-07 10.0375p -1.093568e-06 10.050000000000001p -1.3984240000000001e-06 10.0625p -1.674946e-06 10.074999999999999p -1.9247099999999998e-06 10.0875p -2.1493770000000001e-06 10.1p -2.3506340000000001e-06 10.112500000000001p -2.53017e-06 10.125p -2.6896609999999998e-06
+ 10.137499999999999p -2.8307610000000001e-06 10.15p -2.9550909999999998e-06 10.162500000000001p -3.064236e-06 10.174999999999999p -3.1597340000000001e-06 10.1875p -3.243074e-06 10.199999999999999p -3.3156870000000001e-06 10.2125p -3.378946e-06 10.225000000000001p -3.4341599999999998e-06 10.237499999999999p -3.4825690000000001e-06 10.25p -3.5253450000000001e-06 10.262500000000001p -3.5635880000000002e-06 10.275p -3.598327e-06 10.2875p -3.6305140000000002e-06 10.299999999999999p -3.6610289999999999e-06 10.3125p -3.6906770000000001e-06 10.325000000000001p -3.7201889999999999e-06 10.3375p -3.7502250000000002e-06 10.35p -3.7813710000000002e-06
+ 10.362500000000001p -3.814146e-06 10.375p -3.8489980000000003e-06 10.387500000000001p -3.8863109999999996e-06 10.399999999999999p -3.9264049999999997e-06 10.4125p -3.9695379999999996e-06 10.425000000000001p -4.0159129999999997e-06 10.4375p -4.0656749999999998e-06 10.449999999999999p -4.118919e-06 10.4625p -4.1756899999999998e-06 10.475p -4.235987e-06 10.487500000000001p -4.2997679999999999e-06 10.5p -4.3669529999999996e-06 10.512499999999999p -4.4374250000000001e-06 10.525p -4.5110340000000002e-06 10.5375p -4.587604e-06 10.550000000000001p -4.666931e-06 10.5625p -4.7487909999999997e-06 10.574999999999999p -4.8329389999999999e-06
+ 10.5875p -4.919114e-06 10.6p -5.0070429999999998e-06 10.612500000000001p -5.0964419999999999e-06 10.625p -5.1870200000000002e-06 10.637499999999999p -5.2784789999999996e-06 10.65p -5.3705209999999996e-06 10.662500000000001p -5.4628469999999998e-06 10.674999999999999p -5.5551600000000004e-06 10.6875p -5.6471660000000002e-06 10.699999999999999p -5.7385780000000002e-06 10.7125p -5.8291169999999996e-06 10.725p -5.9185110000000003e-06 10.737499999999999p -6.0065010000000002e-06 10.75p -6.0928390000000004e-06 10.762500000000001p -6.1772900000000003e-06 10.775p -6.2596339999999998e-06 10.7875p -6.3396640000000003e-06 10.799999999999999p -6.4171900000000003e-06
+ 10.8125p -6.4920370000000002e-06 10.825000000000001p -6.5640500000000003e-06 10.837499999999999p -6.6330870000000003e-06 10.85p -6.6990249999999998e-06 10.862500000000001p -6.7617580000000003e-06 10.875p -6.8211989999999998e-06 10.887500000000001p -6.8772760000000004e-06 10.899999999999999p -6.9299359999999996e-06 10.9125p -6.9791410000000003e-06 10.925000000000001p -7.0248720000000004e-06 10.9375p -7.0671240000000003e-06 10.949999999999999p -7.1059089999999996e-06 10.9625p -7.1412520000000001e-06 10.975p -7.1731960000000001e-06 10.987500000000001p -7.2017949999999999e-06 11p -7.2271179999999999e-06 11.012499999999999p -6.8551239999999996e-06 11.025p -6.5092380000000001e-06
+ 11.0375p -6.1907279999999998e-06 11.050000000000001p -5.8990130000000003e-06 11.0625p -5.6328690000000001e-06 11.074999999999999p -5.3908530000000001e-06 11.0875p -5.1714430000000003e-06 11.100000000000001p -4.9730999999999999e-06 11.112499999999999p -4.794286e-06 11.125p -4.6334829999999999e-06 11.137499999999999p -4.4892000000000001e-06 11.15p -4.3599800000000001e-06 11.162500000000001p -4.244409e-06 11.174999999999999p -4.1411190000000004e-06 11.1875p -4.0487919999999999e-06 11.200000000000001p -3.9661699999999998e-06 11.2125p -3.8920530000000002e-06 11.225p -3.8253030000000003e-06 11.237499999999999p -3.7648489999999998e-06 11.25p -3.7096890000000002e-06
+ 11.262500000000001p -3.6588859999999999e-06 11.275p -3.6115749999999998e-06 11.2875p -3.5669620000000001e-06 11.300000000000001p -3.52432e-06 11.3125p -3.482995e-06 11.325000000000001p -3.4423999999999999e-06 11.337499999999999p -3.4020140000000002e-06 11.35p -3.3613840000000001e-06 11.362500000000001p -3.3201199999999999e-06 11.375p -3.2778950000000001e-06 11.387499999999999p -3.2344400000000002e-06 11.4p -3.1895440000000001e-06 11.4125p -3.1430490000000001e-06 11.425000000000001p -3.0948500000000001e-06 11.4375p -3.0448890000000002e-06 11.449999999999999p -2.9931530000000002e-06 11.4625p -2.9396729999999999e-06 11.475p -2.8845169999999999e-06
+ 11.487500000000001p -2.8277890000000002e-06 11.5p -2.769626e-06 11.512499999999999p -2.7101929999999999e-06 11.525p -2.6496820000000002e-06 11.5375p -2.5883069999999998e-06 11.550000000000001p -2.5263019999999999e-06 11.5625p -2.4639190000000001e-06 11.574999999999999p -2.401423e-06 11.5875p -2.3390879999999999e-06 11.600000000000001p -2.2772e-06 11.612499999999999p -2.2160480000000001e-06 11.625p -2.155925e-06 11.637499999999999p -2.0971280000000001e-06 11.65p -2.039947e-06 11.6625p -1.9846750000000002e-06 11.674999999999999p -1.9315960000000002e-06 11.6875p -1.880989e-06 11.700000000000001p -1.8331240000000001e-06
+ 11.7125p -1.7882610000000001e-06 11.725p -1.74665e-06 11.737499999999999p -1.7085259999999999e-06 11.75p -1.674115e-06 11.762500000000001p -1.643623e-06 11.774999999999999p -1.617247e-06 11.7875p -1.595163e-06 11.800000000000001p -1.577534e-06 11.8125p -1.5645049999999999e-06 11.825000000000001p -1.5562039999999999e-06 11.8375p -1.5527420000000001e-06 11.85p -1.554212e-06 11.862500000000001p -1.5606890000000001e-06 11.875p -1.572233e-06 11.887499999999999p -1.5888829999999999e-06 11.9p -1.610665e-06 11.9125p -1.637585e-06 11.925000000000001p -1.6696329999999999e-06
+ 11.9375p -1.7067840000000001e-06 11.949999999999999p -1.748997e-06 11.9625p -1.796214e-06 11.975p -1.848364e-06 11.987500000000001p -1.905362e-06 12p -1.9671089999999998e-06 12.012499999999999p -2.0334899999999998e-06 12.025p -2.1043829999999999e-06 12.037500000000001p -2.1796510000000002e-06 12.049999999999999p -2.2591449999999999e-06 12.0625p -2.342707e-06 12.074999999999999p -2.4301689999999998e-06 12.0875p -2.5213549999999999e-06 12.100000000000001p -2.6160780000000001e-06 12.112499999999999p -2.7141450000000002e-06 12.125p -2.815355e-06 12.137500000000001p -2.919501e-06 12.15p -3.02637e-06
+ 12.1625p -3.1357439999999998e-06 12.174999999999999p -3.2474e-06 12.1875p -3.361111e-06 12.200000000000001p -3.4766470000000001e-06 12.2125p -3.5937750000000002e-06 12.225p -3.712261e-06 12.237500000000001p -3.8318670000000003e-06 12.25p -3.9523560000000001e-06 12.262500000000001p -4.0734900000000002e-06 12.274999999999999p -4.1950289999999998e-06 12.2875p -4.3167370000000001e-06 12.300000000000001p -4.4383749999999997e-06 12.3125p -4.5597090000000002e-06 12.324999999999999p -4.6805049999999998e-06 12.3375p -4.8005299999999996e-06 12.35p -4.9195570000000002e-06 12.362500000000001p -5.0373589999999998e-06 12.375p -5.1537149999999997e-06
+ 12.387499999999999p -5.2684040000000004e-06 12.4p -5.381213e-06 12.4125p -5.4919319999999999e-06 12.425000000000001p -5.6003560000000003e-06 12.4375p -5.7062840000000003e-06 12.449999999999999p -5.809521e-06 12.4625p -5.9098779999999998e-06 12.475p -6.0071709999999997e-06 12.487500000000001p -6.1012239999999999e-06 12.5p -6.1918639999999998e-06 12.512499999999999p -6.2789290000000003e-06 12.525p -6.3622580000000002e-06 12.537500000000001p -6.4417030000000004e-06 12.549999999999999p -6.5171169999999997e-06 12.5625p -6.5883659999999998e-06 12.574999999999999p -6.6553179999999997e-06 12.5875p -6.717852e-06 12.6p -6.7758539999999998e-06
+ 12.612499999999999p -6.8292169999999996e-06 12.625p -6.8778410000000001e-06 12.637500000000001p -6.9216349999999998e-06 12.65p -6.9605160000000001e-06 12.6625p -6.9944070000000003e-06 12.674999999999999p -7.0232419999999998e-06 12.6875p -7.0469619999999998e-06 12.700000000000001p -7.0655130000000001e-06 12.712499999999999p -7.0788529999999999e-06 12.725p -7.0869470000000001e-06 12.737500000000001p -7.0897659999999998e-06 12.75p -7.0872919999999997e-06 12.762500000000001p -7.0795120000000001e-06 12.775p -7.0664239999999996e-06 12.7875p -7.0480309999999999e-06 12.800000000000001p -7.0243459999999998e-06 12.8125p -6.9953879999999996e-06 12.824999999999999p -6.9611860000000004e-06
+ 12.8375p -6.9217740000000001e-06 12.85p -6.8771940000000002e-06 12.862500000000001p -6.8274979999999998e-06 12.875p -6.7727429999999997e-06 12.887499999999999p -6.712993e-06 12.9p -6.6483189999999998e-06 12.9125p -6.5788020000000001e-06 12.925000000000001p -6.5045250000000002e-06 12.9375p -6.4255819999999999e-06 12.949999999999999p -6.3420700000000002e-06 12.9625p -6.2540949999999996e-06 12.975000000000001p -6.161768e-06 12.987499999999999p -6.0652059999999997e-06 13p -5.9645320000000003e-06 13.012499999999999p -5.8598740000000001e-06 13.025p -5.751366e-06 13.037500000000001p -5.6391480000000004e-06 13.049999999999999p -5.523363e-06
+ 13.0625p -5.4041609999999998e-06 13.075000000000001p -5.281694e-06 13.0875p -5.1561209999999996e-06 13.1p -5.0276029999999998e-06 13.112499999999999p -4.8963040000000001e-06 13.125p -4.7623960000000002e-06 13.137500000000001p -4.6260479999999999e-06 13.15p -4.487437e-06 13.1625p -4.3467399999999997e-06 13.175000000000001p -4.2041379999999999e-06 13.1875p -4.059812e-06 13.200000000000001p -3.9139470000000002e-06 13.212499999999999p -3.766729e-06 13.225p -3.6183440000000001e-06 13.237500000000001p -3.4689789999999998e-06 13.25p -3.3188240000000001e-06 13.262499999999999p -3.1680669999999999e-06 13.275p -3.0168960000000002e-06
+ 13.2875p -2.8654999999999999e-06 13.300000000000001p -2.7140659999999999e-06 13.3125p -2.5627800000000001e-06 13.324999999999999p -2.4118290000000001e-06 13.3375p -2.2613950000000001e-06 13.35p -2.111661e-06 13.362500000000001p -1.9628070000000001e-06 13.375p -1.815009e-06 13.387499999999999p -1.6684420000000001e-06 13.4p -1.5232789999999999e-06 13.4125p -1.3796859999999999e-06 13.425000000000001p -1.23783e-06 13.4375p -1.0978699999999999e-06 13.449999999999999p -9.5996460000000004e-07 13.4625p -8.2426589999999996e-07 13.475000000000001p -6.9092239999999997e-07 13.487499999999999p -5.6007779999999998e-07 13.5p -4.3187109999999998e-07
+ 13.512499999999999p -3.0643620000000002e-07 13.525p -1.8390190000000001e-07 13.5375p -6.4391720000000002e-08 13.549999999999999p 5.1976279999999998e-08 13.5625p 1.6508949999999999e-07 13.575000000000001p 2.7484110000000001e-07 13.5875p 3.811297e-07 13.6p 4.8385989999999995e-07 13.612499999999999p 5.829421e-07 13.625p 6.7829239999999999e-07 13.637500000000001p 7.6983310000000003e-07 13.649999999999999p 8.5749209999999998e-07 13.6625p 9.4120329999999999e-07 13.675000000000001p 1.020906e-06 13.6875p 1.096547e-06 13.700000000000001p 1.1680760000000001e-06 13.7125p 1.235452e-06 13.725p 1.2986360000000001e-06
+ 13.737500000000001p 1.3575970000000001e-06 13.75p 1.4123090000000001e-06 13.762499999999999p 1.4627509999999999e-06 13.775p 1.5089070000000001e-06 13.7875p 1.550767e-06 13.800000000000001p 1.588325e-06 13.8125p 1.621582e-06 13.824999999999999p 1.650542e-06 13.8375p 1.675212e-06 13.85p 1.6956079999999999e-06 13.862500000000001p 1.7117470000000001e-06 13.875p 1.72365e-06 13.887499999999999p 1.731345e-06 13.9p 1.7348600000000001e-06 13.912500000000001p 1.7342310000000001e-06 13.924999999999999p 1.729494e-06 13.9375p 1.7206910000000001e-06 13.949999999999999p 1.7078669999999999e-06
+ 13.9625p 1.691069e-06 13.975p 1.6703469999999999e-06 13.987499999999999p 1.6457570000000001e-06 14p 1.617355e-06 14.012500000000001p 1.5852000000000001e-06 14.025p 1.549356e-06 14.0375p 1.509888e-06 14.049999999999999p 1.4668629999999999e-06 14.0625p 1.4203509999999999e-06 14.075000000000001p 1.3704250000000001e-06 14.0875p 1.31716e-06 14.1p 1.2606339999999999e-06 14.112500000000001p 1.2009250000000001e-06 14.125p 1.1381149999999999e-06 14.137500000000001p 1.072289e-06 14.149999999999999p 1.003532e-06 14.1625p 9.3193229999999999e-07 14.175000000000001p 8.5757980000000005e-07
+ 14.1875p 7.8056689999999999e-07 14.199999999999999p 7.009877e-07 14.2125p 6.1893839999999998e-07 14.225p 5.3451719999999995e-07 14.237500000000001p 4.4782440000000002e-07 14.25p 3.5896209999999997e-07 14.262499999999999p 2.6803450000000002e-07 14.275p 1.751477e-07 14.2875p 8.0409679999999994e-08 14.300000000000001p -1.6069480000000001e-08 14.3125p -1.141779e-07 14.324999999999999p -2.1380190000000001e-07 14.3375p -3.1482569999999999e-07 14.35p -4.1713189999999999e-07 14.362500000000001p -5.2060129999999999e-07 14.375p -6.2511289999999995e-07 14.387499999999999p -7.3054390000000004e-07 14.4p -8.3677019999999998e-07
+ 14.412500000000001p -9.4366579999999999e-07 14.424999999999999p -1.0511030000000001e-06 14.4375p -1.158954e-06 14.449999999999999p -1.267088e-06 14.4625p -1.3753739999999999e-06 14.475p -1.48368e-06 14.487499999999999p -1.591871e-06 14.5p -1.699815e-06 14.512500000000001p -1.807376e-06 14.525p -1.9144190000000001e-06 14.5375p -2.020808e-06 14.549999999999999p -2.1264070000000001e-06 14.562500000000002p -2.23108e-06 14.574999999999999p -2.3346909999999998e-06 14.587499999999999p -2.437104e-06 14.6p -2.5381840000000001e-06 14.612500000000001p -2.6377979999999999e-06 14.625000000000002p -2.73581e-06
+ 14.637499999999999p -2.8320900000000001e-06 14.649999999999999p -2.926506e-06 14.6625p -3.0189290000000002e-06 14.675000000000001p -3.1092319999999998e-06 14.687500000000002p -3.197288e-06 14.700000000000001p -3.2829750000000001e-06 14.712499999999999p -3.3661720000000001e-06 14.725p -3.4467610000000002e-06 14.737500000000001p -3.524628e-06 14.75p -3.5996600000000002e-06 14.762500000000001p -3.671748e-06 14.774999999999999p -3.74079e-06 14.7875p -3.8066819999999998e-06 14.800000000000001p -3.8693289999999997e-06 14.8125p -3.928639e-06 14.825000000000001p -3.9845230000000001e-06 14.837499999999999p -4.0368970000000004e-06 14.85p -4.0856840000000001e-06
+ 14.862499999999999p -4.1308089999999999e-06 14.875p -4.1722060000000002e-06 14.887500000000001p -4.2098099999999998e-06 14.900000000000002p -4.2435640000000002e-06 14.9125p -4.273416e-06 14.924999999999999p -4.2993219999999998e-06 14.9375p -4.3212399999999996e-06 14.950000000000001p -4.3391359999999998e-06 14.962500000000002p -4.3529829999999998e-06 14.974999999999998p -4.3627590000000003e-06 14.987499999999999p -4.368448e-06 15p -4.3700410000000002e-06 15.012500000000001p -4.3675339999999998e-06 15.025p -4.3609330000000003e-06 15.037499999999998p -4.3502460000000003e-06 15.049999999999999p -4.3354900000000004e-06 15.0625p -4.316687e-06 15.075000000000001p -4.293866e-06
+ 15.0875p -4.267064e-06 15.100000000000001p -4.2363219999999998e-06 15.112499999999999p -4.2016870000000002e-06 15.125p -4.1632140000000002e-06 15.137499999999999p -4.1209629999999996e-06 15.15p -4.0750010000000002e-06 15.162500000000001p -4.0253999999999996e-06 15.174999999999999p -3.9722379999999996e-06 15.1875p -3.9155979999999998e-06 15.199999999999999p -3.8555709999999998e-06 15.2125p -3.79225e-06 15.225000000000001p -3.7257350000000001e-06 15.237499999999999p -3.6561329999999999e-06 15.249999999999998p -3.5835519999999998e-06 15.262499999999999p -3.5081069999999999e-06 15.275p -3.4299169999999998e-06 15.287500000000001p -3.3491069999999998e-06 15.300000000000001p -3.265803e-06
+ 15.312499999999998p -3.180138e-06 15.324999999999999p -3.0922459999999998e-06 15.3375p -3.0022670000000002e-06 15.350000000000001p -2.910341e-06 15.362500000000001p -2.8166150000000001e-06 15.374999999999998p -2.721236e-06 15.387499999999999p -2.624353e-06 15.4p -2.52612e-06 15.4125p -2.426691e-06 15.425000000000001p -2.3262209999999998e-06 15.437499999999998p -2.2248689999999999e-06 15.449999999999999p -2.122792e-06 15.4625p -2.0201509999999999e-06 15.475p -1.917106e-06 15.487500000000001p -1.8138159999999999e-06 15.500000000000002p -1.7104430000000001e-06 15.512499999999999p -1.6071480000000001e-06 15.524999999999999p -1.5040900000000001e-06
+ 15.5375p -1.4014269999999999e-06 15.550000000000001p -1.2993199999999999e-06 15.562500000000002p -1.1979250000000001e-06 15.574999999999999p -1.097396e-06 15.587499999999999p -9.978887000000001e-07 15.6p -8.9955400000000004e-07 15.612500000000001p -8.0254150000000003e-07 15.625000000000002p -7.069982e-07 15.637500000000001p -6.1306849999999998e-07 15.649999999999999p -5.2089369999999998e-07 15.6625p -4.3061190000000003e-07 15.675000000000001p -3.42358e-07 15.6875p -2.5626320000000001e-07 15.700000000000001p -1.7245510000000001e-07 15.712499999999999p -9.1057149999999994e-08 15.725p -1.218882e-08 15.737500000000001p 6.4034730000000004e-08 15.75p 1.3750270000000001e-07
+ 15.762500000000001p 2.0810909999999999e-07 15.774999999999999p 2.757522e-07 15.7875p 3.4033560000000002e-07 15.799999999999999p 4.0176740000000002e-07 15.8125p 4.5996110000000002e-07 15.825000000000001p 5.148349e-07 15.837500000000002p 5.6631259999999995e-07 15.85p 6.1432310000000003e-07 15.862499999999999p 6.588006e-07 15.875p 6.9968470000000003e-07 15.887500000000001p 7.3692030000000004e-07 15.900000000000002p 7.7045799999999998e-07 15.912499999999998p 8.0025349999999997e-07 15.924999999999999p 8.2626819999999998e-07 15.9375p 8.4846880000000001e-07 15.950000000000001p 8.6682770000000001e-07 15.9625p 8.8132230000000004e-07 15.974999999999998p 8.9193580000000004e-07
+ 15.987499999999999p 8.9865659999999998e-07 16p 9.0147830000000002e-07 16.012499999999999p 9.0039990000000005e-07 16.025000000000002p 8.9542569999999998e-07 16.037500000000001p 8.8656489999999995e-07 16.049999999999997p 8.7383189999999999e-07 16.0625p 8.5724639999999999e-07 16.074999999999999p 8.3683250000000003e-07 16.087500000000002p 8.1261960000000001e-07 16.100000000000001p 7.8464179999999998e-07 16.112499999999997p 7.5293760000000005e-07 16.125p 7.1755039999999998e-07 16.137499999999999p 6.7852799999999997e-07 16.150000000000002p 6.3592269999999999e-07 16.162500000000001p 5.8979100000000002e-07 16.174999999999997p 5.4019349999999996e-07 16.1875p 4.8719509999999998e-07 16.199999999999999p 4.3086469999999998e-07
+ 16.212499999999999p 3.7127499999999999e-07 16.225000000000001p 3.0850250000000001e-07 16.237500000000001p 2.426273e-07 16.25p 1.737332e-07 16.262499999999999p 1.019073e-07 16.274999999999999p 2.724012e-08 16.287500000000001p -5.0174640000000002e-08 16.300000000000001p -1.3024019999999999e-07 16.3125p -2.1285689999999999e-07 16.324999999999999p -2.979221e-07 16.337499999999999p -3.8533059999999998e-07 16.350000000000001p -4.7497449999999999e-07 16.362500000000001p -5.6674359999999999e-07 16.375p -6.6052539999999999e-07 16.387499999999999p -7.5620510000000003e-07 16.399999999999999p -8.5366599999999999e-07 16.412500000000001p -9.5278950000000004e-07 16.425000000000001p -1.053455e-06
+ 16.4375p -1.1555420000000001e-06 16.449999999999999p -1.258925e-06 16.462499999999999p -1.3634820000000001e-06 16.475000000000001p -1.4690850000000001e-06 16.487500000000001p -1.575609e-06 16.5p -1.6829260000000001e-06 16.512499999999999p -1.7909089999999999e-06 16.524999999999999p -1.8994279999999999e-06 16.537500000000001p -2.0083560000000002e-06 16.550000000000001p -2.1175640000000001e-06 16.5625p -2.226924e-06 16.575000000000003p -2.3363060000000001e-06 16.587499999999999p -2.4455819999999999e-06 16.599999999999998p -2.5546270000000002e-06 16.612500000000001p -2.6633119999999999e-06 16.625p -2.7715110000000002e-06 16.637500000000003p -2.8791009999999999e-06 16.649999999999999p -2.9859559999999999e-06
+ 16.662499999999998p -3.0919559999999998e-06 16.675000000000001p -3.1969779999999999e-06 16.6875p -3.3009029999999999e-06 16.700000000000003p -3.4036139999999999e-06 16.712499999999999p -3.5049940000000002e-06 16.724999999999998p -3.60493e-06 16.737500000000001p -3.7033089999999998e-06 16.75p -3.800021e-06 16.762499999999999p -3.8949590000000003e-06 16.775000000000002p -3.9880179999999998e-06 16.787499999999998p -4.0790929999999996e-06 16.800000000000001p -4.1680840000000004e-06 16.8125p -4.254894e-06 16.824999999999999p -4.339427e-06 16.837500000000002p -4.4215890000000001e-06 16.849999999999998p -4.501291e-06 16.862500000000001p -4.5784449999999998e-06 16.875p -4.6529669999999999e-06
+ 16.887499999999999p -4.724775e-06 16.900000000000002p -4.7937899999999999e-06 16.912499999999998p -4.8599370000000002e-06 16.925000000000001p -4.9231439999999999e-06 16.9375p -4.9833399999999996e-06 16.949999999999999p -5.04046e-06 16.962500000000002p -5.0944400000000001e-06 16.975000000000001p -5.1452210000000003e-06 16.987499999999997p -5.1927469999999997e-06 17p -5.2369650000000001e-06 17.012499999999999p -5.277826e-06 17.025000000000002p -5.3152840000000002e-06 17.037500000000001p -5.3492959999999996e-06 17.049999999999997p -5.379826e-06 17.0625p -5.406837e-06 17.074999999999999p -5.4303009999999997e-06 17.087500000000002p -5.4501900000000001e-06 17.100000000000001p -5.4664809999999998e-06
+ 17.112499999999997p -5.4791569999999999e-06 17.125p -5.4882030000000001e-06 17.137499999999999p -5.4936089999999998e-06 17.149999999999999p -5.4953690000000001e-06 17.162500000000001p -5.4934819999999999e-06 17.175000000000001p -5.4879509999999999e-06 17.1875p -5.4787840000000004e-06 17.199999999999999p -5.4659929999999999e-06 17.212499999999999p -5.449595e-06 17.225000000000001p -5.4296100000000003e-06 17.237500000000001p -5.4060660000000001e-06 17.25p -5.378991e-06 17.262499999999999p -5.3484219999999997e-06 17.274999999999999p -5.3143979999999998e-06 17.287500000000001p -5.2769640000000003e-06 17.300000000000001p -5.2361679999999999e-06 17.3125p -5.1920649999999999e-06 17.324999999999999p -5.1447120000000004e-06
+ 17.337499999999999p -5.0941710000000001e-06 17.350000000000001p -5.0405110000000004e-06 17.362500000000001p -4.9838009999999999e-06 17.375p -4.9241169999999998e-06 17.387499999999999p -4.8615400000000002e-06 17.399999999999999p -4.7961510000000001e-06 17.412500000000001p -4.7280390000000003e-06 17.425000000000001p -4.6572960000000002e-06 17.4375p -4.5840139999999996e-06 17.449999999999999p -4.5082939999999999e-06 17.462499999999999p -4.4302350000000003e-06 17.475000000000001p -4.3499429999999998e-06 17.487500000000001p -4.267524e-06 17.5p -4.18309e-06 17.512500000000003p -4.0967519999999998e-06 17.524999999999999p -4.0086260000000003e-06 17.537499999999998p -3.9188280000000004e-06 17.550000000000001p -3.827478e-06
+ 17.5625p -3.7346959999999999e-06 17.575000000000003p -3.6406049999999998e-06 17.587499999999999p -3.545326e-06 17.599999999999998p -3.448986e-06 17.612500000000001p -3.3517079999999998e-06 17.625p -3.2536180000000001e-06 17.637500000000003p -3.154843e-06 17.649999999999999p -3.0555070000000002e-06 17.662499999999998p -2.9557380000000001e-06 17.675000000000001p -2.8556600000000002e-06 17.6875p -2.7553979999999999e-06 17.699999999999999p -2.655076e-06 17.712500000000002p -2.5548169999999999e-06 17.724999999999998p -2.4547430000000001e-06 17.737500000000001p -2.3549749999999998e-06 17.75p -2.25563e-06 17.762499999999999p -2.1568269999999999e-06 17.775000000000002p -2.0586789999999999e-06
+ 17.787499999999998p -1.9613000000000002e-06 17.800000000000001p -1.8647999999999999e-06 17.8125p -1.769288e-06 17.824999999999999p -1.674867e-06 17.837500000000002p -1.5816419999999999e-06 17.849999999999998p -1.489712e-06 17.862500000000001p -1.399173e-06 17.875p -1.3101200000000001e-06 17.887499999999999p -1.2226430000000001e-06 17.900000000000002p -1.136828e-06 17.912500000000001p -1.0527600000000001e-06 17.924999999999997p -9.7051929999999999e-07 17.9375p -8.9018259999999995e-07 17.949999999999999p -8.1182319999999999e-07 17.962500000000002p -7.3551110000000002e-07 17.975000000000001p -6.6131229999999996e-07 17.987499999999997p -5.892894e-07 18p -5.195015e-07
+ 18.012499999999999p -4.5200379999999999e-07 18.025000000000002p -3.8684790000000001e-07 18.037500000000001p -3.2408199999999998e-07 18.049999999999997p -2.6375039999999998e-07 18.0625p -2.058941e-07 18.074999999999999p -1.5055030000000001e-07 18.087499999999999p -9.7752819999999997e-08 18.100000000000001p -4.7532030000000001e-08 18.112500000000001p 8.5157969999999998e-11 18.125p 4.5075220000000002e-08 18.137499999999999p 8.7417919999999997e-08 18.149999999999999p 1.2709629999999999e-07 18.162500000000001p 1.640966e-07 18.175000000000001p 1.984081e-07 18.1875p 2.3002339999999999e-07 18.199999999999999p 2.5893779999999997e-07 18.212499999999999p 2.8514970000000001e-07 18.225000000000001p 3.0866039999999998e-07
+ 18.237500000000001p 3.2947390000000001e-07 18.25p 3.4759689999999999e-07 18.262499999999999p 3.6303900000000003e-07 18.274999999999999p 3.7581199999999998e-07 18.287500000000001p 3.8593070000000001e-07 18.300000000000001p 3.9341189999999998e-07 18.3125p 3.982751e-07 18.324999999999999p 4.005422e-07 18.337499999999999p 4.002372e-07 18.350000000000001p 3.9738630000000001e-07 18.362500000000001p 3.9201799999999998e-07 18.375p 3.8416309999999999e-07 18.387499999999999p 3.7385399999999998e-07 18.399999999999999p 3.6112549999999999e-07 18.412500000000001p 3.4601449999999998e-07 18.425000000000001p 3.2855940000000002e-07 18.4375p 3.0880089999999999e-07 18.450000000000003p 2.8678139999999997e-07
+ 18.462499999999999p 2.6254529999999998e-07 18.474999999999998p 2.3613869999999999e-07 18.487500000000001p 2.0760940000000001e-07 18.5p 1.7700710000000001e-07 18.512500000000003p 1.4438319999999999e-07 18.524999999999999p 1.097909e-07 18.537499999999998p 7.3284950000000001e-08 18.550000000000001p 3.4921789999999999e-08 18.5625p -5.2404440000000002e-09 18.575000000000003p -4.7142019999999999e-08 18.587499999999999p -9.0721579999999995e-08 18.599999999999998p -1.359162e-07 18.612500000000001p -1.8266139999999999e-07 18.625p -2.3089120000000001e-07 18.637499999999999p -2.8053799999999999e-07 18.650000000000002p -3.3153289999999999e-07 18.662499999999998p -3.838052e-07 18.675000000000001p -4.3728330000000002e-07
+ 18.6875p -4.9189359999999998e-07 18.699999999999999p -5.4756170000000004e-07 18.712500000000002p -6.0421160000000002e-07 18.724999999999998p -6.6176590000000003e-07 18.737500000000001p -7.2014630000000002e-07 18.75p -7.7927310000000004e-07 18.762499999999999p -8.3906559999999998e-07 18.775000000000002p -8.9944180000000003e-07 18.787499999999998p -9.6031909999999998e-07 18.800000000000001p -1.0216140000000001e-06 18.8125p -1.0832409999999999e-06 18.824999999999999p -1.145115e-06 18.837500000000002p -1.20715e-06 18.850000000000001p -1.26926e-06 18.862499999999997p -1.3313569999999999e-06 18.875p -1.393353e-06 18.887499999999999p -1.455161e-06 18.900000000000002p -1.516692e-06
+ 18.912500000000001p -1.577857e-06 18.924999999999997p -1.6385690000000001e-06 18.9375p -1.6987389999999999e-06 18.949999999999999p -1.758279e-06 18.962500000000002p -1.817101e-06 18.975000000000001p -1.8751189999999999e-06 18.987499999999997p -1.9322439999999998e-06 19p -1.9883929999999999e-06 19.012499999999999p -2.0434790000000001e-06 19.024999999999999p -2.0974180000000001e-06 19.037500000000001p -2.1501279999999999e-06 19.050000000000001p -2.2015259999999999e-06 19.0625p -2.251534e-06 19.074999999999999p -2.3000710000000001e-06 19.087499999999999p -2.3470620000000002e-06 19.100000000000001p -2.3924300000000001e-06 19.112500000000001p -2.436104e-06 19.125p -2.4780109999999999e-06
+ 19.137499999999999p -2.518082e-06 19.149999999999999p -2.5562530000000002e-06 19.162500000000001p -2.592457e-06 19.175000000000001p -2.6266340000000001e-06 19.1875p -2.6587259999999999e-06 19.199999999999999p -2.688676e-06 19.212499999999999p -2.716432e-06 19.225000000000001p -2.7419439999999999e-06 19.237500000000001p -2.7651649999999999e-06 19.25p -2.7860530000000001e-06 19.262499999999999p -2.8045660000000001e-06 19.274999999999999p -2.8206690000000001e-06 19.287500000000001p -2.8343289999999999e-06 19.300000000000001p -2.8455160000000001e-06 19.3125p -2.8542050000000001e-06 19.324999999999999p -2.8603739999999999e-06 19.337499999999999p -2.8640049999999999e-06 19.350000000000001p -2.8650830000000001e-06
+ 19.362500000000001p -2.8635990000000002e-06 19.375p -2.8595450000000001e-06 19.387500000000003p -2.85292e-06 19.399999999999999p -2.8437239999999998e-06 19.412499999999998p -2.8319630000000002e-06 19.425000000000001p -2.8176459999999999e-06 19.4375p -2.800786e-06 19.450000000000003p -2.781401e-06 19.462499999999999p -2.7595119999999999e-06 19.474999999999998p -2.735143e-06 19.487500000000001p -2.708323e-06 19.5p -2.6790850000000001e-06 19.512500000000003p -2.6474650000000002e-06 19.524999999999999p -2.6135020000000001e-06 19.537499999999998p -2.5772410000000001e-06 19.550000000000001p -2.5387279999999999e-06 19.5625p -2.498012e-06 19.574999999999999p -2.4551489999999999e-06
+ 19.587500000000002p -2.4101949999999999e-06 19.599999999999998p -2.3632090000000001e-06 19.612500000000001p -2.3142549999999998e-06 19.625p -2.2633980000000002e-06 19.637499999999999p -2.210706e-06 19.650000000000002p -2.156252e-06 19.662499999999998p -2.1001079999999998e-06 19.675000000000001p -2.04235e-06 19.6875p -1.9830560000000002e-06 19.699999999999999p -1.9223070000000002e-06 19.712500000000002p -1.860185e-06 19.724999999999998p -1.796772e-06 19.737500000000001p -1.7321549999999999e-06 19.75p -1.66642e-06 19.762499999999999p -1.5996549999999999e-06 19.775000000000002p -1.531949e-06 19.787500000000001p -1.463392e-06 19.799999999999997p -1.3940750000000001e-06
+ 19.8125p -1.324088e-06 19.824999999999999p -1.253524e-06 19.837500000000002p -1.182474e-06 19.850000000000001p -1.11103e-06 19.862499999999997p -1.0392839999999999e-06 19.875p -9.6732860000000002e-07 19.887499999999999p -8.9525389999999999e-07 19.900000000000002p -8.2315080000000005e-07 19.912500000000001p -7.511094e-07 19.924999999999997p -6.7921869999999996e-07 19.9375p -6.0756670000000003e-07 19.949999999999999p -5.362405e-07 19.962499999999999p -4.6532570000000002e-07 19.975000000000001p -3.949064e-07 19.987500000000001p -3.2506529999999998e-07 20p -2.5588349999999998e-07 20.012499999999999p 2.066816e-07 20.024999999999999p 6.3922069999999997e-07
+ 20.037500000000001p 1.0404930000000001e-06 20.050000000000001p 1.4111219999999999e-06 20.0625p 1.7523829999999999e-06 20.074999999999999p 2.065785e-06 20.087499999999999p 2.352923e-06 20.100000000000001p 2.6154220000000002e-06 20.112500000000001p 2.8549119999999999e-06 20.125p 3.073014e-06 20.137499999999999p 3.2713290000000001e-06 20.149999999999999p 3.4514289999999998e-06 20.162500000000001p 3.6148539999999999e-06 20.175000000000001p 3.7631009999999998e-06 20.1875p 3.8976179999999998e-06 20.199999999999999p 4.0198050000000004e-06 20.212499999999999p 4.1310020000000004e-06 20.225000000000001p 4.2324910000000001e-06 20.237500000000001p 4.3254890000000003e-06 20.25p 4.4111510000000003e-06
+ 20.262499999999999p 4.4905590000000002e-06 20.274999999999999p 4.5647279999999996e-06 20.287500000000001p 4.6346039999999997e-06 20.300000000000001p 4.7010609999999997e-06 20.3125p 4.7649020000000004e-06 20.325000000000003p 4.8268579999999996e-06 20.337499999999999p 4.8875939999999998e-06 20.349999999999998p 4.947703e-06 20.362500000000001p 5.0077130000000001e-06 20.375p 5.068083e-06 20.387500000000003p 5.1292129999999997e-06 20.399999999999999p 5.1914379999999997e-06 20.412499999999998p 5.2550350000000004e-06 20.425000000000001p 5.3202250000000004e-06 20.4375p 5.3871749999999998e-06 20.450000000000003p 5.4560010000000002e-06 20.462499999999999p 5.5267699999999998e-06 20.474999999999998p 5.5995060000000001e-06
+ 20.487500000000001p 5.67419e-06 20.5p 5.7507650000000002e-06 20.512499999999999p 5.829136e-06 20.525000000000002p 5.9091790000000002e-06 20.537499999999998p 5.9907379999999999e-06 20.550000000000001p 6.0736310000000004e-06 20.5625p 6.1576540000000004e-06 20.574999999999999p 6.2425820000000001e-06 20.587500000000002p 6.3281700000000003e-06 20.599999999999998p 6.414163e-06 20.612500000000001p 6.5002890000000002e-06 20.625p 6.5862709999999998e-06 20.637499999999999p 6.6718229999999998e-06 20.650000000000002p 6.7566520000000004e-06 20.662499999999998p 6.8404679999999999e-06 20.675000000000001p 6.922977e-06 20.6875p 7.0038870000000003e-06 20.699999999999999p 7.0829119999999999e-06
+ 20.712500000000002p 7.1597700000000001e-06 20.725000000000001p 7.2341849999999999e-06 20.737499999999997p 7.3058929999999998e-06 20.75p 7.374637e-06 20.762499999999999p 7.4401729999999998e-06 20.775000000000002p 7.5022690000000004e-06 20.787500000000001p 7.5607070000000003e-06 20.799999999999997p 7.6152819999999997e-06 20.8125p 7.6658069999999995e-06 20.824999999999999p 7.7121089999999999e-06 20.837500000000002p 7.7540310000000004e-06 20.850000000000001p 7.7914359999999998e-06 20.862499999999997p 7.8242009999999998e-06 20.875p 7.8522219999999993e-06 20.887499999999999p 7.8754159999999996e-06 20.899999999999999p 7.8937140000000003e-06 20.912500000000001p 7.9070659999999996e-06 20.925000000000001p 7.9154429999999998e-06
+ 20.9375p 7.9188299999999999e-06 20.949999999999999p 7.9172340000000007e-06 20.962499999999999p 7.9106780000000002e-06 20.975000000000001p 7.8992000000000005e-06 20.987500000000001p 7.8828589999999999e-06 21p 7.86173e-06 21.012499999999999p 7.4417799999999999e-06 21.024999999999999p 7.0464470000000002e-06 21.037500000000001p 6.6770200000000003e-06 21.050000000000001p 6.3329379999999997e-06 21.0625p 6.013004e-06 21.074999999999999p 5.7158070000000004e-06 21.087499999999999p 5.4398629999999998e-06 21.100000000000001p 5.1836730000000003e-06 21.112500000000001p 4.9457480000000004e-06 21.125p 4.7246219999999998e-06 21.137499999999999p 4.5188629999999997e-06 21.149999999999999p 4.3270780000000003e-06
+ 21.162500000000001p 4.1479219999999999e-06 21.175000000000001p 3.9801030000000001e-06 21.1875p 3.8223839999999996e-06 21.199999999999999p 3.6735929999999999e-06 21.212499999999999p 3.5326209999999998e-06 21.225000000000001p 3.3984310000000002e-06 21.237500000000001p 3.2700520000000002e-06 21.25p 3.1465899999999998e-06 21.262500000000003p 3.0272209999999999e-06 21.274999999999999p 2.9111989999999999e-06 21.287499999999998p 2.7978480000000002e-06 21.300000000000001p 2.6865699999999998e-06 21.3125p 2.5768379999999998e-06 21.325000000000003p 2.4681990000000001e-06 21.337499999999999p 2.360268e-06 21.349999999999998p 2.2527289999999998e-06 21.362500000000001p 2.1453349999999999e-06 21.375p 2.0378970000000001e-06
+ 21.387500000000003p 1.9302920000000002e-06 21.399999999999999p 1.8224530000000001e-06 21.412499999999998p 1.714366e-06 21.425000000000001p 1.606069e-06 21.4375p 1.4976479999999999e-06 21.449999999999999p 1.389233e-06 21.462500000000002p 1.2809939999999999e-06 21.474999999999998p 1.173138e-06 21.487500000000001p 1.0659029999999999e-06 21.5p 9.5955860000000005e-07 21.512499999999999p 8.5439849999999999e-07 21.525000000000002p 7.5073840000000003e-07 21.537499999999998p 6.489121e-07 21.550000000000001p 5.4926809999999998e-07 21.5625p 4.5216609999999999e-07 21.574999999999999p 3.5797379999999999e-07 21.587500000000002p 2.6706359999999999e-07 21.599999999999998p 1.7980980000000001e-07
+ 21.612500000000001p 9.6585260000000004e-08 21.625p 1.7759230000000001e-08 21.637499999999999p -5.6305719999999998e-08 21.650000000000002p -1.252559e-07 21.662500000000001p -1.887486e-07 21.674999999999997p -2.4645479999999998e-07 21.6875p -2.9806019999999999e-07 21.699999999999999p -3.4326760000000001e-07 21.712500000000002p -3.8179840000000001e-07 21.725000000000001p -4.1339360000000001e-07 21.737499999999997p -4.378158e-07 21.75p -4.5484940000000002e-07 21.762499999999999p -4.6430219999999998e-07 21.775000000000002p -4.6600579999999999e-07 21.787500000000001p -4.5981640000000001e-07 21.799999999999997p -4.4561500000000001e-07 21.8125p -4.2330830000000002e-07 21.824999999999999p -3.9282819999999999e-07
+ 21.837499999999999p -3.5413250000000002e-07 21.850000000000001p -3.0720429999999998e-07 21.862500000000001p -2.5205230000000002e-07 21.875p -1.887104e-07 21.887499999999999p -1.1723700000000001e-07 21.899999999999999p -3.7715140000000002e-08 21.912500000000001p 4.9748439999999998e-08 21.925000000000001p 1.450239e-07 21.9375p 2.4795879999999999e-07 21.949999999999999p 3.5837909999999997e-07 21.962499999999999p 4.7608969999999999e-07 21.975000000000001p 6.0087589999999997e-07 21.987500000000001p 7.3250329999999998e-07 22p 8.7072e-07 22.012499999999999p 1.0152569999999999e-06 22.024999999999999p 1.1658280000000001e-06 22.037500000000001p 1.3221330000000001e-06 22.050000000000001p 1.483858e-06
+ 22.0625p 1.6506769999999999e-06 22.074999999999999p 1.82225e-06 22.087499999999999p 1.9982280000000001e-06 22.100000000000001p 2.1782530000000001e-06 22.112500000000001p 2.3619580000000001e-06 22.125p 2.5489689999999999e-06 22.137499999999999p 2.7389059999999999e-06 22.149999999999999p 2.931386e-06 22.162500000000001p 3.1260179999999999e-06 22.175000000000001p 3.3224129999999999e-06 22.1875p 3.520178e-06 22.200000000000003p 3.718921e-06 22.212499999999999p 3.9182479999999997e-06 22.224999999999998p 4.117769e-06 22.237500000000001p 4.3170959999999996e-06 22.25p 4.5158430000000002e-06 22.262500000000003p 4.7136320000000001e-06 22.274999999999999p 4.9100859999999998e-06
+ 22.287499999999998p 5.1048370000000002e-06 22.300000000000001p 5.2975230000000001e-06 22.3125p 5.4877900000000004e-06 22.325000000000003p 5.6752910000000001e-06 22.337499999999999p 5.8596910000000004e-06 22.349999999999998p 6.0406619999999998e-06 22.362500000000001p 6.2178869999999996e-06 22.375p 6.3910600000000003e-06 22.387499999999999p 6.5598880000000002e-06 22.400000000000002p 6.724087e-06 22.412499999999998p 6.8833870000000003e-06 22.425000000000001p 7.0375290000000001e-06 22.4375p 7.1862680000000001e-06 22.449999999999999p 7.329373e-06 22.462500000000002p 7.4666239999999996e-06 22.474999999999998p 7.5978159999999999e-06 22.487500000000001p 7.7227559999999996e-06 22.5p 7.8412670000000004e-06
+ 22.512499999999999p 7.9531830000000005e-06 22.525000000000002p 8.0583539999999998e-06 22.537499999999998p 8.1566409999999996e-06 22.550000000000001p 8.2479210000000002e-06 22.5625p 8.3320820000000002e-06 22.574999999999999p 8.4090280000000002e-06 22.587500000000002p 8.4786720000000007e-06 22.600000000000001p 8.5409440000000002e-06 22.612499999999997p 8.5957830000000001e-06 22.625p 8.6431420000000002e-06 22.637499999999999p 8.6829850000000004e-06 22.650000000000002p 8.7152889999999993e-06 22.662500000000001p 8.7400400000000004e-06 22.674999999999997p 8.7572359999999999e-06 22.6875p 8.7668860000000008e-06 22.699999999999999p 8.7690080000000005e-06 22.712500000000002p 8.7636300000000007e-06 22.725000000000001p 8.7507900000000003e-06
+ 22.737500000000001p 8.7305330000000008e-06 22.75p 8.7029159999999997e-06 22.762499999999999p 8.6680000000000007e-06 22.774999999999999p 8.6258559999999995e-06 22.787500000000001p 8.5765630000000006e-06 22.800000000000001p 8.5202050000000005e-06 22.8125p 8.4568729999999998e-06 22.824999999999999p 8.3866670000000003e-06 22.837499999999999p 8.3096889999999993e-06 22.850000000000001p 8.2260480000000002e-06 22.862500000000001p 8.1358609999999995e-06 22.875p 8.039246e-06 22.887499999999999p 7.9363280000000005e-06 22.899999999999999p 7.8272369999999997e-06 22.912500000000001p 7.7121050000000006e-06 22.925000000000001p 7.5910709999999999e-06 22.9375p 7.4642770000000003e-06 22.949999999999999p 7.3318669999999998e-06
+ 22.962499999999999p 7.1939909999999996e-06 22.975000000000001p 7.050802e-06 22.987500000000001p 6.9024549999999998e-06 23p 6.7491110000000004e-06 23.012499999999999p 6.5909309999999997e-06 23.024999999999999p 6.4280829999999997e-06 23.037500000000001p 6.2607360000000002e-06 23.050000000000001p 6.0890609999999998e-06 23.0625p 5.9132350000000003e-06 23.074999999999999p 5.7334360000000002e-06 23.087499999999999p 5.549847e-06 23.100000000000001p 5.3626519999999999e-06 23.112500000000001p 5.17204e-06 23.125p 4.9782019999999997e-06 23.137500000000003p 4.7813329999999997e-06 23.149999999999999p 4.5816320000000004e-06 23.162499999999998p 4.3792980000000001e-06 23.175000000000001p 4.1745359999999997e-06
+ 23.1875p 3.9675539999999999e-06 23.200000000000003p 3.7585629999999999e-06 23.212499999999999p 3.5477750000000001e-06 23.224999999999998p 3.3354089999999999e-06 23.237500000000001p 3.121682e-06 23.25p 2.9068190000000002e-06 23.262500000000003p 2.6910449999999999e-06 23.274999999999999p 2.4745869999999998e-06 23.287499999999998p 2.2576760000000002e-06 23.300000000000001p 2.0405460000000002e-06 23.3125p 1.823431e-06 23.324999999999999p 1.606569e-06 23.337500000000002p 1.390199e-06 23.349999999999998p 1.1745609999999999e-06 23.362500000000001p 9.5989760000000009e-07 23.375p 7.4645060000000002e-07 23.387499999999999p 5.344638e-07 23.400000000000002p 3.2418100000000001e-07
+ 23.412499999999998p 1.15846e-07 23.425000000000001p -9.0297609999999994e-08 23.4375p -2.9400719999999998e-07 23.449999999999999p -4.9504110000000004e-07 23.462500000000002p -6.9315900000000002e-07 23.474999999999998p -8.8812280000000003e-07 23.487500000000001p -1.0796959999999999e-06 23.5p -1.267647e-06 23.512499999999999p -1.4517429999999999e-06 23.525000000000002p -1.6317599999999999e-06 23.537500000000001p -1.807474e-06 23.549999999999997p -1.9786680000000002e-06 23.5625p -2.1451279999999999e-06 23.574999999999999p -2.3066469999999999e-06 23.587500000000002p -2.4630220000000001e-06 23.600000000000001p -2.614057e-06 23.612499999999997p -2.7595640000000001e-06 23.625p -2.8993579999999998e-06
+ 23.637499999999999p -3.0332660000000002e-06 23.650000000000002p -3.1611199999999998e-06 23.662500000000001p -3.2827599999999999e-06 23.675000000000001p -3.3980349999999998e-06 23.6875p -3.5068020000000001e-06 23.699999999999999p -3.6089279999999998e-06 23.712499999999999p -3.7042890000000002e-06 23.725000000000001p -3.7927690000000001e-06 23.737500000000001p -3.8742640000000002e-06 23.75p -3.9486770000000004e-06 23.762499999999999p -4.015925e-06 23.774999999999999p -4.0759320000000003e-06 23.787500000000001p -4.1286349999999996e-06 23.800000000000001p -4.173978e-06 23.8125p -4.2119189999999997e-06 23.824999999999999p -4.2424259999999997e-06 23.837499999999999p -4.2654769999999996e-06 23.850000000000001p -4.2810610000000004e-06
+ 23.862500000000001p -4.2891789999999996e-06 23.875p -4.2898409999999996e-06 23.887499999999999p -4.2830689999999999e-06 23.899999999999999p -4.2688959999999998e-06 23.912500000000001p -4.2473659999999997e-06 23.925000000000001p -4.2185320000000004e-06 23.9375p -4.1824589999999997e-06 23.949999999999999p -4.1392220000000003e-06 23.962499999999999p -4.0889069999999999e-06 23.975000000000001p -4.0316079999999999e-06 23.987500000000001p -3.9674310000000001e-06 24p -3.8964929999999999e-06 24.012499999999999p -3.8189169999999998e-06 24.024999999999999p -3.734838e-06 24.037500000000001p -3.6444000000000002e-06 24.050000000000001p -3.547755e-06 24.0625p -3.4450640000000001e-06 24.075000000000003p -3.3364969999999999e-06
+ 24.087499999999999p -3.2222319999999999e-06 24.099999999999998p -3.1024550000000002e-06 24.112500000000001p -2.977359e-06 24.125p -2.8471440000000002e-06 24.137500000000003p -2.7120189999999999e-06 24.149999999999999p -2.5721969999999998e-06 24.162499999999998p -2.4278989999999998e-06 24.175000000000001p -2.2793509999999999e-06 24.1875p -2.1267860000000002e-06 24.200000000000003p -1.9704400000000001e-06 24.212499999999999p -1.8105559999999999e-06 24.224999999999998p -1.647381e-06 24.237500000000001p -1.481164e-06 24.25p -1.3121610000000001e-06 24.262499999999999p -1.1406280000000001e-06 24.275000000000002p -9.6682579999999999e-07 24.287499999999998p -7.9101749999999998e-07 24.300000000000001p -6.1346769999999997e-07
+ 24.3125p -4.3444239999999999e-07 24.324999999999999p -2.5420920000000001e-07 24.337500000000002p -7.3036000000000006e-08 24.349999999999998p 1.088089e-07 24.362500000000001p 2.9105730000000001e-07 24.375p 4.7344199999999999e-07 24.387499999999999p 6.5569639999999999e-07 24.400000000000002p 8.3755590000000005e-07 24.412499999999998p 1.018757e-06 24.425000000000001p 1.1990409999999999e-06 24.4375p 1.378148e-06 24.449999999999999p 1.555824e-06 24.462500000000002p 1.73182e-06 24.475000000000001p 1.9058870000000001e-06 24.487499999999997p 2.077783e-06 24.5p 2.2472709999999999e-06 24.512499999999999p 2.4141190000000002e-06 24.525000000000002p 2.5780990000000001e-06
+ 24.537500000000001p 2.7389900000000001e-06 24.549999999999997p 2.8965769999999999e-06 24.5625p 3.0506519999999998e-06 24.574999999999999p 3.2010130000000001e-06 24.587500000000002p 3.347466e-06 24.600000000000001p 3.4898219999999998e-06 24.612500000000001p 3.6279009999999998e-06 24.625p 3.7615319999999999e-06 24.637499999999999p 3.8905500000000004e-06 24.649999999999999p 4.0147970000000002e-06 24.662500000000001p 4.1341269999999996e-06 24.675000000000001p 4.2483989999999996e-06 24.6875p 4.3574809999999999e-06 24.699999999999999p 4.4612510000000001e-06 24.712499999999999p 4.5595930000000004e-06 24.725000000000001p 4.6524020000000002e-06 24.737500000000001p 4.739581e-06 24.75p 4.8210400000000003e-06
+ 24.762499999999999p 4.8966989999999998e-06 24.774999999999999p 4.9664870000000001e-06 24.787500000000001p 5.0303400000000002e-06 24.800000000000001p 5.0882039999999999e-06 24.8125p 5.140032e-06 24.824999999999999p 5.1857859999999996e-06 24.837499999999999p 5.2254349999999999e-06 24.850000000000001p 5.2589590000000003e-06 24.862500000000001p 5.2863410000000002e-06 24.875p 5.3075770000000002e-06 24.887499999999999p 5.3226660000000002e-06 24.899999999999999p 5.331618e-06 24.912500000000001p 5.3344479999999998e-06 24.925000000000001p 5.3311789999999999e-06 24.9375p 5.3218399999999999e-06 24.949999999999999p 5.3064679999999999e-06 24.962499999999999p 5.2851060000000002e-06 24.975000000000001p 5.257804e-06
+ 24.987500000000001p 5.2246160000000004e-06 25p 5.1856050000000003e-06 25.012500000000003p 5.1408379999999998e-06 25.024999999999999p 5.0903880000000001e-06 25.037499999999998p 5.0343339999999999e-06 25.050000000000001p 4.9727599999999998e-06 25.0625p 4.9057560000000002e-06 25.075000000000003p 4.8334159999999998e-06 25.087499999999999p 4.7558399999999997e-06 25.099999999999998p 4.673131e-06 25.112500000000001p 4.5854000000000002e-06 25.125p 4.4927600000000002e-06 25.137500000000003p 4.3953290000000002e-06 25.149999999999999p 4.293229e-06 25.162499999999998p 4.1865870000000001e-06 25.175000000000001p 4.0755350000000001e-06 25.1875p 3.9602069999999998e-06 25.199999999999999p 3.8407420000000002e-06
+ 25.212500000000002p 3.7172839999999999e-06 25.224999999999998p 3.589979e-06 25.237500000000001p 3.4589780000000001e-06 25.25p 3.3244349999999998e-06 25.262499999999999p 3.1865089999999999e-06 25.275000000000002p 3.0453599999999998e-06 25.287499999999998p 2.9011539999999999e-06 25.300000000000001p 2.7540580000000001e-06 25.3125p 2.6042439999999999e-06 25.324999999999999p 2.4518879999999999e-06 25.337500000000002p 2.2971660000000001e-06 25.349999999999998p 2.1402599999999998e-06 25.362500000000001p 1.981353e-06 25.375p 1.820632e-06 25.387499999999999p 1.6582850000000001e-06 25.400000000000002p 1.494505e-06 25.412500000000001p 1.3294849999999999e-06 25.424999999999997p 1.1634219999999999e-06
+ 25.4375p 9.9651270000000002e-07 25.449999999999999p 8.2895850000000004e-07 25.462500000000002p 6.6096069999999996e-07 25.475000000000001p 4.9272250000000005e-07 25.487499999999997p 3.2444820000000001e-07 25.5p 1.5634359999999999e-07 25.512499999999999p -1.1385239999999999e-08 25.525000000000002p -1.785313e-07 25.537500000000001p -3.4488730000000001e-07 25.550000000000001p -5.1024619999999999e-07 25.5625p -6.7440069999999995e-07 25.574999999999999p -8.3714440000000002e-07 25.587499999999999p -9.9827159999999993e-07 25.600000000000001p -1.1575769999999999e-06 25.612500000000001p -1.314859e-06 25.625p -1.4699140000000001e-06 25.637499999999999p -1.6225440000000001e-06 25.649999999999999p -1.7725500000000001e-06
+ 25.662500000000001p -1.9197399999999999e-06 25.675000000000001p -2.06392e-06 25.6875p -2.2049019999999999e-06 25.699999999999999p -2.3425029999999999e-06 25.712499999999999p -2.476541e-06 25.725000000000001p -2.6068390000000002e-06 25.737500000000001p -2.733225e-06 25.75p -2.8555329999999999e-06 25.762499999999999p -2.9736000000000002e-06 25.774999999999999p -3.0872700000000001e-06 25.787500000000001p -3.1963920000000002e-06 25.800000000000001p -3.3008210000000002e-06 25.8125p -3.400419e-06 25.824999999999999p -3.495053e-06 25.837499999999999p -3.5845990000000001e-06 25.850000000000001p -3.6689370000000001e-06 25.862500000000001p -3.7479569999999998e-06 25.875p -3.8215550000000002e-06
+ 25.887499999999999p -3.8896360000000001e-06 25.899999999999999p -3.9521099999999997e-06 25.912500000000001p -4.008897e-06 25.925000000000001p -4.0599249999999999e-06 25.9375p -4.1051300000000003e-06 25.950000000000003p -4.1444560000000004e-06 25.962499999999999p -4.1778559999999999e-06 25.974999999999998p -4.2052900000000004e-06 25.987500000000001p -4.2267279999999996e-06 26p -4.2421490000000003e-06 26.012500000000003p -4.2515389999999999e-06 26.024999999999999p -4.2548929999999997e-06 26.037499999999998p -4.2522170000000004e-06 26.050000000000001p -4.2435229999999997e-06 26.0625p -4.2288320000000001e-06 26.075000000000003p -4.2081740000000003e-06 26.087499999999999p -4.1815889999999998e-06 26.099999999999998p -4.1491230000000002e-06
+ 26.112500000000001p -4.1108319999999997e-06 26.125p -4.0667800000000001e-06 26.137499999999999p -4.0170389999999998e-06 26.150000000000002p -3.9616889999999996e-06 26.162499999999998p -3.9008180000000001e-06 26.175000000000001p -3.8345219999999996e-06 26.1875p -3.7629060000000002e-06 26.199999999999999p -3.6860789999999998e-06 26.212500000000002p -3.6041610000000001e-06 26.224999999999998p -3.5172759999999999e-06 26.237500000000001p -3.4255589999999998e-06 26.25p -3.3291469999999998e-06 26.262499999999999p -3.2281870000000001e-06 26.275000000000002p -3.1228310000000002e-06 26.287499999999998p -3.0132370000000002e-06 26.300000000000001p -2.8995680000000001e-06 26.3125p -2.7819949999999999e-06 26.324999999999999p -2.660692e-06
+ 26.337500000000002p -2.5358380000000001e-06 26.350000000000001p -2.4076180000000001e-06 26.362499999999997p -2.2762220000000001e-06 26.375p -2.141841e-06 26.387499999999999p -2.0046740000000002e-06 26.400000000000002p -1.864919e-06 26.412500000000001p -1.7227809999999999e-06 26.424999999999997p -1.5784659999999999e-06 26.4375p -1.432183e-06 26.449999999999999p -1.2841440000000001e-06 26.462500000000002p -1.1345600000000001e-06 26.475000000000001p -9.8364679999999993e-07 26.487500000000001p -8.3161989999999999e-07 26.5p -6.7869579999999997e-07 26.512499999999999p -5.2509159999999998e-07 26.524999999999999p -3.7102419999999999e-07 26.537500000000001p -2.1671070000000001e-07 26.550000000000001p -6.2367390000000004e-08
+ 26.5625p 9.1790310000000003e-08 26.574999999999999p 2.4554820000000001e-07 26.587499999999999p 3.986938e-07 26.600000000000001p 5.5101630000000004e-07 26.612500000000001p 7.0230750000000003e-07 26.625p 8.5236160000000002e-07 26.637499999999999p 1.000976e-06 26.649999999999999p 1.14795e-06 26.662500000000001p 1.2930890000000001e-06 26.675000000000001p 1.4361990000000001e-06 26.6875p 1.5770939999999999e-06 26.699999999999999p 1.715588e-06 26.712499999999999p 1.8515040000000001e-06 26.725000000000001p 1.9846660000000002e-06 26.737500000000001p 2.1149050000000002e-06 26.75p 2.2420580000000002e-06 26.762499999999999p 2.3659660000000002e-06 26.774999999999999p 2.486476e-06
+ 26.787500000000001p 2.6034430000000001e-06 26.800000000000001p 2.7167260000000001e-06 26.8125p 2.8261890000000001e-06 26.824999999999999p 2.931706e-06 26.837499999999999p 3.0331549999999998e-06 26.850000000000001p 3.1304210000000001e-06 26.862500000000001p 3.2233959999999998e-06 26.875p 3.311978e-06 26.887500000000003p 3.3960720000000001e-06 26.899999999999999p 3.4755910000000002e-06 26.912499999999998p 3.5504540000000001e-06 26.925000000000001p 3.6205860000000002e-06 26.9375p 3.6859210000000001e-06 26.950000000000003p 3.746397e-06 26.962499999999999p 3.801962e-06 26.974999999999998p 3.8525680000000001e-06 26.987500000000001p 3.8981750000000002e-06 27p 3.9387500000000002e-06
+ 27.012500000000003p 3.9742659999999997e-06 27.024999999999999p 4.0047029999999998e-06 27.037499999999998p 4.0300460000000004e-06 27.050000000000001p 4.0502889999999999e-06 27.0625p 4.0654299999999996e-06 27.074999999999999p 4.0754729999999997e-06 27.087500000000002p 4.0804300000000003e-06 27.099999999999998p 4.0803170000000004e-06 27.112500000000001p 4.0751570000000003e-06 27.125p 4.0649779999999999e-06 27.137499999999999p 4.0498139999999997e-06 27.150000000000002p 4.0297039999999998e-06 27.162499999999998p 4.0046919999999997e-06 27.175000000000001p 3.9748280000000004e-06 27.1875p 3.9401669999999997e-06 27.199999999999999p 3.900768e-06 27.212500000000002p 3.8566959999999997e-06 27.224999999999998p 3.8080199999999999e-06
+ 27.237500000000001p 3.7548130000000002e-06 27.25p 3.6971550000000002e-06 27.262499999999999p 3.635126e-06 27.275000000000002p 3.5688149999999998e-06 27.287500000000001p 3.4983119999999999e-06 27.299999999999997p 3.4237130000000001e-06 27.3125p 3.345116e-06 27.324999999999999p 3.2626240000000001e-06 27.337500000000002p 3.1763439999999999e-06 27.350000000000001p 3.0863859999999998e-06 27.362499999999997p 2.992864e-06 27.375p 2.895896e-06 27.387499999999999p 2.7956029999999998e-06 27.400000000000002p 2.6921090000000001e-06 27.412500000000001p 2.5855410000000001e-06 27.425000000000001p 2.4760309999999999e-06 27.4375p 2.3637119999999998e-06 27.449999999999999p 2.2487199999999999e-06
+ 27.462499999999999p 2.1311970000000002e-06 27.475000000000001p 2.0112829999999999e-06 27.487500000000001p 1.8891259999999999e-06 27.5p 1.7648719999999999e-06 27.512499999999999p 1.638673e-06 27.524999999999999p 1.5106810000000001e-06 27.537500000000001p 1.3810509999999999e-06 27.550000000000001p 1.249941e-06 27.5625p 1.117512e-06 27.574999999999999p 9.8392279999999993e-07 27.587499999999999p 8.4933849999999997e-07 27.600000000000001p 7.1392360000000001e-07 27.612500000000001p 5.7784470000000005e-07 27.625p 4.4126939999999997e-07 27.637499999999999p 3.043669e-07 27.649999999999999p 1.673071e-07 27.662500000000001p 3.0260759999999998e-08 27.675000000000001p -1.0660059999999999e-07
+ 27.6875p -2.4310530000000001e-07 27.699999999999999p -3.790811e-07 27.712499999999999p -5.143561e-07 27.725000000000001p -6.4875829999999997e-07 27.737500000000001p -7.8211639999999998e-07 27.75p -9.1425980000000005e-07 27.762499999999999p -1.045018e-06 27.774999999999999p -1.1742239999999999e-06 27.787500000000001p -1.301709e-06 27.800000000000001p -1.4273080000000001e-06 27.8125p -1.5508559999999999e-06 27.825000000000003p -1.6721940000000001e-06 27.837499999999999p -1.7911610000000001e-06 27.849999999999998p -1.907601e-06 27.862500000000001p -2.02136e-06 27.875p -2.132288e-06 27.887500000000003p -2.2402379999999999e-06 27.899999999999999p -2.3450669999999999e-06
+ 27.912499999999998p -2.4466340000000001e-06 27.925000000000001p -2.5448050000000001e-06 27.9375p -2.639449e-06 27.949999999999999p -2.7304390000000002e-06 27.962499999999999p -2.8176540000000001e-06 27.974999999999998p -2.9009769999999998e-06 27.987500000000001p -2.9802970000000002e-06 28p -3.055508e-06 28.012499999999999p -3.1265090000000001e-06 28.025000000000002p -3.1932059999999999e-06 28.037499999999998p -3.2555110000000001e-06 28.050000000000001p -3.3133410000000002e-06 28.0625p -3.3666199999999998e-06 28.074999999999999p -3.4152770000000001e-06 28.087500000000002p -3.4592510000000002e-06 28.099999999999998p -3.4984829999999998e-06 28.112500000000001p -3.5329250000000001e-06 28.125p -3.5625319999999998e-06
+ 28.137499999999999p -3.5872690000000001e-06 28.150000000000002p -3.6071059999999999e-06 28.162499999999998p -3.622022e-06 28.175000000000001p -3.6319989999999999e-06 28.1875p -3.6370309999999999e-06 28.199999999999999p -3.6371159999999999e-06 28.212500000000002p -3.6322600000000001e-06 28.225000000000001p -3.6224759999999998e-06 28.237499999999997p -3.6077830000000002e-06 28.25p -3.5882089999999998e-06 28.262499999999999p -3.5637869999999999e-06 28.275000000000002p -3.5345589999999999e-06 28.287500000000001p -3.5005720000000001e-06 28.299999999999997p -3.4618809999999999e-06 28.3125p -3.4185450000000001e-06 28.324999999999999p -3.3706340000000001e-06 28.337500000000002p -3.31822e-06 28.350000000000001p -3.261385e-06
+ 28.362500000000001p -3.2002150000000001e-06 28.375p -3.1348020000000001e-06 28.387499999999999p -3.0652459999999999e-06 28.399999999999999p -2.99165e-06 28.412500000000001p -2.914124e-06 28.425000000000001p -2.8327840000000002e-06 28.4375p -2.7477509999999999e-06 28.449999999999999p -2.659149e-06 28.462499999999999p -2.5671099999999998e-06 28.475000000000001p -2.4717680000000002e-06 28.487500000000001p -2.3732640000000001e-06 28.5p -2.27174e-06 28.512499999999999p -2.167346e-06 28.524999999999999p -2.060231e-06 28.537500000000001p -1.950552e-06 28.550000000000001p -1.838467e-06 28.5625p -1.7241369999999999e-06 28.574999999999999p -1.607727e-06
+ 28.587499999999999p -1.4894019999999999e-06 28.600000000000001p -1.369333e-06 28.612500000000001p -1.2476900000000001e-06 28.625p -1.124646e-06 28.637499999999999p -1.000376e-06 28.649999999999999p -8.7505360000000003e-07 28.662500000000001p -7.4885639999999996e-07 28.675000000000001p -6.219612e-07 28.6875p -4.9454529999999999e-07 28.699999999999999p -3.667862e-07 28.712499999999999p -2.3886099999999998e-07 28.725000000000001p -1.109466e-07 28.737500000000001p 1.678097e-08 28.75p 1.4414660000000001e-07 28.762500000000003p 2.7097660000000001e-07 28.774999999999999p 3.9709870000000002e-07 28.787499999999998p 5.2234249999999997e-07 28.800000000000001p 6.465395e-07
+ 28.8125p 7.6952389999999998e-07 28.825000000000003p 8.9113199999999996e-07 28.837499999999999p 1.011203e-06 28.849999999999998p 1.12958e-06 28.862500000000001p 1.246108e-06 28.875p 1.3606350000000001e-06 28.887499999999999p 1.4730159999999999e-06 28.899999999999999p 1.5831060000000001e-06 28.912499999999998p 1.6907669999999999e-06 28.925000000000001p 1.7958630000000001e-06 28.9375p 1.8982629999999999e-06 28.949999999999999p 1.9978420000000001e-06 28.962500000000002p 2.0944790000000001e-06 28.974999999999998p 2.1880559999999999e-06 28.987500000000001p 2.2784629999999999e-06 29p 2.3655940000000001e-06 29.012499999999999p 2.4493469999999998e-06 29.025000000000002p 2.529627e-06
+ 29.037499999999998p 2.6063419999999998e-06 29.050000000000001p 2.67941e-06 29.0625p 2.7487489999999999e-06 29.074999999999999p 2.8142859999999999e-06 29.087500000000002p 2.8759540000000001e-06 29.099999999999998p 2.9336900000000001e-06 29.112500000000001p 2.9874360000000001e-06 29.125000000000004p 3.0371410000000002e-06 29.137499999999999p 3.0827600000000001e-06 29.149999999999999p 3.1242539999999999e-06 29.162500000000001p 3.161586e-06 29.174999999999997p 3.1947300000000001e-06 29.187500000000004p 3.2236610000000001e-06 29.199999999999999p 3.2483630000000001e-06 29.212499999999999p 3.2688209999999999e-06 29.225000000000001p 3.2850299999999999e-06 29.237499999999997p 3.2969889999999999e-06 29.250000000000004p 3.3046999999999999e-06
+ 29.262499999999999p 3.308172e-06 29.274999999999999p 3.30742e-06 29.287500000000001p 3.3024610000000001e-06 29.299999999999997p 3.2933209999999998e-06 29.312500000000004p 3.280027e-06 29.324999999999999p 3.262613e-06 29.337499999999999p 3.2411160000000002e-06 29.350000000000001p 3.2155800000000001e-06 29.362499999999997p 3.1860500000000002e-06 29.375000000000004p 3.1525790000000002e-06 29.387499999999999p 3.1152210000000002e-06 29.400000000000002p 3.0740359999999999e-06 29.412500000000001p 3.029088e-06 29.424999999999997p 2.9804450000000001e-06 29.4375p 2.9281770000000002e-06 29.449999999999999p 2.8723590000000002e-06 29.462500000000002p 2.8130719999999999e-06 29.475000000000001p 2.750395e-06
+ 29.487499999999997p 2.6844169999999999e-06 29.5p 2.615225e-06 29.512499999999999p 2.5429120000000002e-06 29.525000000000002p 2.4675730000000002e-06 29.537500000000001p 2.3893079999999999e-06 29.549999999999997p 2.308217e-06 29.5625p 2.2244050000000002e-06 29.574999999999999p 2.1379790000000002e-06 29.587500000000002p 2.0490499999999999e-06 29.600000000000001p 1.9577290000000001e-06 29.612499999999997p 1.8641329999999999e-06 29.625p 1.7683779999999999e-06 29.637499999999999p 1.6705830000000001e-06 29.650000000000002p 1.570873e-06 29.662500000000001p 1.4693690000000001e-06 29.674999999999997p 1.3661989999999999e-06 29.6875p 1.2614910000000001e-06 29.699999999999999p 1.1553749999999999e-06
+ 29.712500000000002p 1.0479810000000001e-06 29.724999999999998p 9.3944389999999996e-07 29.737499999999997p 8.2989759999999996e-07 29.75p 7.1947810000000002e-07 29.762499999999999p 6.0832259999999999e-07 29.775000000000002p 4.9656920000000002e-07 29.787499999999998p 3.8435719999999999e-07 29.800000000000004p 2.7182639999999998e-07 29.8125p 1.591174e-07 29.824999999999999p 4.6371340000000001e-08 29.837500000000002p -6.6270370000000003e-08 29.849999999999998p -1.7866610000000001e-07 29.862500000000004p -2.9067429999999998e-07 29.875p -4.0215339999999998e-07 29.887499999999999p -5.1296209999999995e-07 29.900000000000002p -6.2295999999999996e-07 29.912499999999998p -7.3200680000000004e-07 29.925000000000004p -8.3996340000000001e-07
+ 29.9375p -9.4669170000000004e-07 29.949999999999996p -1.0520550000000001e-06 29.962500000000002p -1.1559170000000001e-06 29.974999999999998p -1.258144e-06 29.987500000000001p -1.3586049999999999e-06 30p -1.457168e-06 30.012499999999996p -1.553706e-06 30.025000000000002p -1.648093e-06 30.037499999999998p -1.740206e-06 30.050000000000001p -1.8299250000000001e-06 30.0625p -1.9171330000000001e-06 30.074999999999996p -2.001713e-06 30.087500000000002p -2.0835570000000001e-06 30.099999999999998p -2.1625559999999999e-06 30.112500000000001p -2.2386059999999998e-06 30.125p -2.311607e-06 30.137500000000003p -2.3814620000000002e-06 30.150000000000002p -2.448081e-06
+ 30.162499999999998p -2.5113750000000002e-06 30.175000000000001p -2.57126e-06 30.1875p -2.627658e-06 30.200000000000003p -2.6804959999999999e-06 30.212500000000002p -2.7297030000000002e-06 30.224999999999998p -2.7752160000000001e-06 30.237500000000001p -2.8169749999999998e-06 30.25p -2.8549270000000001e-06 30.262500000000003p -2.889022e-06 30.274999999999999p -2.919218e-06 30.287499999999998p -2.945477e-06 30.300000000000001p -2.9677649999999999e-06 30.3125p -2.986057e-06 30.325000000000003p -3.0003299999999999e-06 30.337499999999999p -3.01057e-06 30.349999999999998p -3.016766e-06 30.362500000000001p -3.018914e-06 30.375p -3.0170160000000001e-06
+ 30.387500000000003p -3.0110769999999999e-06 30.399999999999999p -3.0011130000000001e-06 30.412499999999998p -2.98714e-06 30.425000000000001p -2.969183e-06 30.4375p -2.947271e-06 30.450000000000003p -2.9214410000000002e-06 30.462499999999999p -2.8917319999999998e-06 30.474999999999998p -2.858191e-06 30.487500000000001p -2.8208690000000002e-06 30.499999999999996p -2.7798239999999999e-06 30.512500000000003p -2.7351179999999999e-06 30.524999999999999p -2.6868170000000001e-06 30.537500000000001p -2.634994e-06 30.550000000000001p -2.5797259999999999e-06 30.562499999999996p -2.521095e-06 30.575000000000003p -2.459187e-06 30.587499999999999p -2.3940939999999999e-06 30.600000000000001p -2.3259090000000001e-06
+ 30.612500000000001p -2.2547339999999999e-06 30.624999999999996p -2.180671e-06 30.637500000000003p -2.103828e-06 30.649999999999999p -2.0243159999999998e-06 30.662500000000001p -1.9422499999999999e-06 30.675000000000001p -1.8577480000000001e-06 30.687499999999996p -1.7709310000000001e-06 30.700000000000003p -1.6819229999999999e-06 30.712499999999999p -1.590851e-06 30.725000000000001p -1.4978460000000001e-06 30.737500000000001p -1.4030379999999999e-06 30.749999999999996p -1.3065619999999999e-06 30.762499999999999p -1.208555e-06 30.774999999999999p -1.1091549999999999e-06 30.787500000000001p -1.0085e-06 30.800000000000001p -9.0673210000000001e-07 30.812499999999996p -8.0399319999999995e-07 30.824999999999999p -7.0042610000000002e-07
+ 30.837499999999999p -5.9617459999999998e-07 30.850000000000001p -4.9138280000000004e-07 30.862500000000001p -3.8619500000000002e-07 30.874999999999996p -2.8075589999999998e-07 30.887499999999999p -1.752095e-07 30.899999999999999p -6.9699940000000003e-08 30.912500000000001p 3.562966e-08 30.925000000000001p 1.4063680000000001e-07 30.937500000000004p 2.4517999999999998e-07 30.949999999999999p 3.491192e-07 30.962499999999999p 4.523155e-07 30.975000000000001p 5.546318e-07 30.987500000000001p 6.5593280000000002e-07 31.000000000000004p 7.5608540000000003e-07 31.012499999999999p 8.5495840000000005e-07 31.024999999999999p 9.5242319999999996e-07 31.037500000000001p 1.048354e-06 31.049999999999997p 1.142627e-06
+ 31.062500000000004p 1.235122e-06 31.074999999999999p 1.325722e-06 31.087499999999999p 1.4143120000000001e-06 31.100000000000001p 1.500782e-06 31.112499999999997p 1.5850249999999999e-06 31.125000000000004p 1.666936e-06 31.137499999999999p 1.746417e-06 31.149999999999999p 1.82337e-06 31.162500000000001p 1.897704e-06 31.174999999999997p 1.9693310000000002e-06 31.187500000000004p 2.0381660000000001e-06 31.199999999999999p 2.1041310000000001e-06 31.212499999999999p 2.1671500000000001e-06 31.225000000000001p 2.2271510000000002e-06 31.237499999999997p 2.2840690000000001e-06 31.250000000000004p 2.337841e-06 31.262499999999999p 2.3884089999999999e-06 31.275000000000002p 2.4357210000000002e-06
+ 31.287500000000001p 2.4797280000000001e-06 31.299999999999997p 2.5203849999999998e-06 31.3125p 2.5576549999999999e-06 31.324999999999999p 2.5915020000000001e-06 31.337500000000002p 2.6218949999999999e-06 31.350000000000001p 2.6488099999999998e-06 31.362499999999997p 2.6722259999999999e-06 31.375p 2.6921250000000001e-06 31.387499999999999p 2.7084970000000001e-06 31.400000000000002p 2.721333e-06 31.412500000000001p 2.730631e-06 31.424999999999997p 2.7363930000000002e-06 31.4375p 2.7386229999999999e-06 31.449999999999999p 2.7373329999999999e-06 31.462500000000002p 2.7325370000000001e-06 31.475000000000001p 2.7242519999999998e-06 31.487499999999997p 2.7125030000000002e-06 31.5p 2.697316e-06
+ 31.512499999999999p 2.6787209999999998e-06 31.525000000000002p 2.6567540000000001e-06 31.537500000000001p 2.6314529999999999e-06 31.549999999999997p 2.6028599999999998e-06 31.5625p 2.5710219999999998e-06 31.574999999999999p 2.5359889999999999e-06 31.587500000000002p 2.4978130000000002e-06 31.599999999999998p 2.4565519999999999e-06 31.612499999999997p 2.4122660000000001e-06 31.625p 2.3650190000000001e-06 31.637499999999999p 2.3148770000000001e-06 31.650000000000002p 2.2619100000000002e-06 31.662499999999998p 2.2061910000000001e-06 31.675000000000004p 2.1477970000000001e-06 31.6875p 2.0868059999999998e-06 31.699999999999999p 2.023301e-06 31.712500000000002p 1.957364e-06 31.724999999999998p 1.8890850000000001e-06
+ 31.737500000000004p 1.818551e-06 31.75p 1.7458559999999999e-06 31.762499999999999p 1.671093e-06 31.775000000000002p 1.5943600000000001e-06 31.787499999999998p 1.515755e-06 31.800000000000004p 1.4353799999999999e-06 31.8125p 1.353336e-06 31.824999999999996p 1.2697290000000001e-06 31.837500000000002p 1.184666e-06 31.849999999999998p 1.0982539999999999e-06 31.862500000000001p 1.010603e-06 31.875p 9.2182389999999999e-07 31.887499999999996p 8.3202980000000004e-07 31.900000000000002p 7.4133410000000003e-07 31.912499999999998p 6.4985149999999995e-07 31.925000000000001p 5.5769769999999999e-07 31.9375p 4.6498919999999999e-07 31.949999999999996p 3.7184329999999998e-07
+ 31.962500000000002p 2.7837789999999999e-07 31.974999999999998p 1.847113e-07 31.987500000000001p 9.0962160000000002e-08 32p -2.7506770000000001e-09 32.012500000000003p -9.6308320000000001e-08 32.024999999999999p -1.895919e-07 32.037500000000001p -2.82483e-07 32.050000000000004p -3.7486320000000002e-07 32.0625p -4.6661490000000001e-07 32.075000000000003p -5.5762100000000001e-07 32.087499999999999p -6.4776529999999998e-07 32.099999999999994p -7.3693259999999998e-07 32.112500000000004p -8.2500870000000005e-07 32.125p -9.1188069999999998e-07 32.137500000000003p -9.9743720000000002e-07 32.149999999999999p -1.0815679999999999e-06 32.162499999999994p -1.1641650000000001e-06 32.175000000000004p -1.2451229999999999e-06
+ 32.1875p -1.3243359999999999e-06 32.200000000000003p -1.4017029999999999e-06 32.212499999999999p -1.477123e-06 32.224999999999994p -1.5505e-06 32.237500000000004p -1.6217380000000001e-06 32.25p -1.690746e-06 32.262500000000003p -1.757435e-06 32.274999999999999p -1.8217179999999999e-06 32.287499999999994p -1.883512e-06 32.300000000000004p -1.9427379999999998e-06 32.3125p -1.9993200000000002e-06 32.325000000000003p -2.0531840000000001e-06 32.337499999999999p -2.1042609999999999e-06 32.349999999999994p -2.152487e-06 32.362499999999997p -2.1977979999999999e-06 32.375p -2.240139e-06 32.387500000000003p -2.2794550000000002e-06 32.399999999999999p -2.315696e-06
+ 32.412500000000001p -2.3488170000000001e-06 32.424999999999997p -2.3787779999999998e-06 32.4375p -2.4055410000000002e-06 32.450000000000003p -2.4290739999999999e-06 32.462499999999999p -2.4493489999999999e-06 32.475000000000001p -2.4663430000000001e-06 32.487499999999997p -2.4800369999999999e-06 32.5p -2.4904159999999999e-06 32.512500000000003p -2.4974719999999999e-06 32.524999999999999p -2.5011979999999998e-06 32.537500000000001p -2.5015940000000002e-06 32.549999999999997p -2.4986640000000002e-06 32.5625p -2.4924180000000001e-06 32.575000000000003p -2.4828679999999999e-06 32.587499999999999p -2.4700320000000001e-06 32.600000000000001p -2.453932e-06 32.612499999999997p -2.4345959999999998e-06 32.625p -2.412055e-06
+ 32.637500000000003p -2.3863450000000001e-06 32.649999999999999p -2.357506e-06 32.662500000000001p -2.3255820000000002e-06 32.674999999999997p -2.2906230000000001e-06 32.6875p -2.2526810000000002e-06 32.700000000000003p -2.2118129999999999e-06 32.712499999999999p -2.1680799999999999e-06 32.725000000000001p -2.121548e-06 32.737499999999997p -2.0722849999999998e-06 32.75p -2.020362e-06 32.762500000000003p -1.9658580000000002e-06 32.774999999999999p -1.9088499999999999e-06 32.787500000000001p -1.849421e-06 32.799999999999997p -1.787659e-06 32.8125p -1.72365e-06 32.825000000000003p -1.6574889999999999e-06 32.837499999999999p -1.589269e-06 32.850000000000001p -1.5190889999999999e-06
+ 32.862499999999997p -1.4470469999999999e-06 32.875p -1.3732470000000001e-06 32.887500000000003p -1.2977929999999999e-06 32.899999999999999p -1.220791e-06 32.912500000000001p -1.14235e-06 32.924999999999997p -1.0625809999999999e-06 32.9375p -9.8159370000000007e-07 32.950000000000003p -8.9950280000000002e-07 32.962499999999999p -8.1642210000000005e-07 32.975000000000001p -7.3246669999999999e-07 32.987499999999997p -6.4775279999999995e-07 33p -5.6239720000000001e-07 33.012500000000003p -4.7651719999999999e-07 33.024999999999999p -3.9023039999999999e-07 33.037500000000001p -3.0365450000000001e-07 33.049999999999997p -2.1690720000000001e-07 33.0625p -1.3010610000000001e-07 33.075000000000003p -4.336837e-08
+ 33.087499999999999p 4.3189490000000001e-08 33.100000000000001p 1.294515e-07 33.112499999999997p 2.1530279999999999e-07 33.125p 3.0062930000000001e-07 33.137500000000003p 3.8531829999999999e-07 33.150000000000006p 4.6925839999999997e-07 33.162500000000001p 5.5233980000000005e-07 33.174999999999997p 6.3445420000000001e-07 33.1875p 7.1549529999999997e-07 33.199999999999996p 7.953586e-07 33.212500000000006p 8.7394189999999996e-07 33.225000000000001p 9.5114499999999996e-07 33.237499999999997p 1.0268700000000001e-06 33.25p 1.1010220000000001e-06 33.262499999999996p 1.1735089999999999e-06 33.275000000000006p 1.2442399999999999e-06 33.287500000000001p 1.3131279999999999e-06 33.299999999999997p 1.380089e-06
+ 33.3125p 1.445042e-06 33.324999999999996p 1.507908e-06 33.337500000000006p 1.5686140000000001e-06 33.350000000000001p 1.6270869999999999e-06 33.362499999999997p 1.683259e-06 33.375p 1.737066e-06 33.387499999999996p 1.7884450000000001e-06 33.400000000000006p 1.837339e-06 33.412500000000001p 1.8836939999999999e-06 33.424999999999997p 1.9274590000000001e-06 33.4375p 1.9685860000000001e-06 33.449999999999996p 2.0070340000000001e-06 33.462499999999999p 2.0427599999999999e-06 33.475000000000001p 2.0757310000000001e-06 33.487499999999997p 2.1059130000000002e-06 33.5p 2.133277e-06 33.512499999999996p 2.1577999999999999e-06 33.524999999999999p 2.179459e-06
+ 33.537500000000001p 2.1982380000000002e-06 33.550000000000004p 2.2141230000000001e-06 33.5625p 2.2271030000000001e-06 33.574999999999996p 2.2371729999999998e-06 33.587499999999999p 2.244329e-06 33.600000000000001p 2.2485740000000001e-06 33.612500000000004p 2.2499100000000001e-06 33.625p 2.248347e-06 33.637499999999996p 2.2438960000000001e-06 33.649999999999999p 2.2365710000000002e-06 33.662500000000001p 2.2263920000000002e-06 33.675000000000004p 2.213381e-06 33.6875p 2.1975620000000002e-06 33.699999999999996p 2.1789640000000001e-06 33.712499999999999p 2.1576190000000002e-06 33.725000000000001p 2.133562e-06 33.737500000000004p 2.1068310000000001e-06 33.75p 2.0774670000000002e-06
+ 33.762499999999996p 2.0455129999999999e-06 33.774999999999999p 2.011018e-06 33.787500000000001p 1.9740309999999999e-06 33.800000000000004p 1.934605e-06 33.8125p 1.892795e-06 33.824999999999996p 1.8486599999999999e-06 33.837499999999999p 1.802259e-06 33.850000000000001p 1.7536569999999999e-06 33.862500000000004p 1.70292e-06 33.875p 1.6501150000000001e-06 33.887500000000003p 1.5953129999999999e-06 33.899999999999999p 1.538586e-06 33.912500000000001p 1.4800100000000001e-06 33.925000000000004p 1.4196609999999999e-06 33.9375p 1.357619e-06 33.950000000000003p 1.2939630000000001e-06 33.962499999999999p 1.228778e-06 33.974999999999994p 1.1621470000000001e-06
+ 33.987500000000004p 1.0941560000000001e-06 34p 1.0248929999999999e-06 34.012500000000003p 9.5444720000000003e-07 34.024999999999999p 8.8290890000000004e-07 34.037499999999994p 8.1036989999999998e-07 34.050000000000004p 7.3692310000000003e-07 34.0625p 6.6266259999999999e-07 34.075000000000003p 5.8768320000000005e-07 34.087499999999999p 5.1208100000000004e-07 34.099999999999994p 4.3595240000000001e-07 34.112500000000004p 3.5939489999999998e-07 34.125p 2.8250619999999999e-07 34.137500000000003p 2.053845e-07 34.149999999999999p 1.281286e-07 34.162499999999994p 5.0837159999999999e-08 34.175000000000004p -2.6390909999999999e-08 34.1875p -1.034568e-07 34.200000000000003p -1.802617e-07
+ 34.212499999999999p -2.5670729999999997e-07 34.224999999999994p -3.3269549999999999e-07 34.237499999999997p -4.0812879999999998e-07 34.25p -4.8291029999999995e-07 34.262500000000003p -5.5694399999999996e-07 34.274999999999999p -6.3013469999999999e-07 34.287500000000001p -7.0238809999999997e-07 34.299999999999997p -7.7361130000000001e-07 34.3125p -8.4371249999999999e-07 34.325000000000003p -9.1260139999999995e-07 34.337499999999999p -9.8018910000000001e-07 34.350000000000001p -1.0463879999999999e-06 34.362499999999997p -1.111114e-06 34.375p -1.1742820000000001e-06 34.387500000000003p -1.235812e-06 34.399999999999999p -1.2956229999999999e-06 34.412500000000001p -1.3536390000000001e-06 34.424999999999997p -1.409784e-06
+ 34.4375p -1.463988e-06 34.450000000000003p -1.516179e-06 34.462499999999999p -1.5662900000000001e-06 34.475000000000001p -1.6142580000000001e-06 34.487499999999997p -1.6600209999999999e-06 34.5p -1.703521e-06 34.512500000000003p -1.7447020000000001e-06 34.524999999999999p -1.783511e-06 34.537500000000001p -1.8198999999999999e-06 34.549999999999997p -1.8538229999999999e-06 34.5625p -1.8852369999999999e-06 34.575000000000003p -1.9141040000000001e-06 34.587499999999999p -1.9403880000000002e-06 34.600000000000001p -1.9640569999999998e-06 34.612499999999997p -1.985083e-06 34.625p -2.0034409999999998e-06 34.637500000000003p -2.0191089999999999e-06 34.649999999999999p -2.0320709999999998e-06
+ 34.662500000000001p -2.0423119999999998e-06 34.674999999999997p -2.0498240000000001e-06 34.6875p -2.054599e-06 34.700000000000003p -2.0566360000000001e-06 34.712499999999999p -2.055935e-06 34.725000000000001p -2.0525030000000001e-06 34.737499999999997p -2.0463479999999998e-06 34.75p -2.0374830000000001e-06 34.762500000000003p -2.0259229999999999e-06 34.774999999999999p -2.0116910000000001e-06 34.787500000000001p -1.994809e-06 34.799999999999997p -1.9753040000000001e-06 34.8125p -1.9532089999999998e-06 34.825000000000003p -1.9285569999999999e-06 34.837499999999999p -1.901386e-06 34.850000000000001p -1.8717400000000001e-06 34.862499999999997p -1.8396609999999999e-06 34.875p -1.8051990000000001e-06
+ 34.887500000000003p -1.768404e-06 34.899999999999999p -1.729333e-06 34.912500000000001p -1.6880420000000001e-06 34.924999999999997p -1.6445910000000001e-06 34.9375p -1.5990460000000001e-06 34.950000000000003p -1.5514709999999999e-06 34.962499999999999p -1.5019359999999999e-06 34.975000000000001p -1.450512e-06 34.987499999999997p -1.3972740000000001e-06 35p -1.342298e-06 35.012500000000003p -1.285662e-06 35.025000000000006p -1.2274479999999999e-06 35.037500000000001p -1.1677380000000001e-06 35.049999999999997p -1.106617e-06 35.0625p -1.0441709999999999e-06 35.074999999999996p -9.8048770000000003e-07 35.087500000000006p -9.1565720000000004e-07 35.100000000000001p -8.4977009999999996e-07
+ 35.112499999999997p -7.8291830000000005e-07 35.125p -7.1519500000000002e-07 35.137499999999996p -6.4669400000000003e-07 35.150000000000006p -5.7751020000000003e-07 35.162500000000001p -5.0773900000000004e-07 35.174999999999997p -4.374763e-07 35.1875p -3.6681850000000001e-07 35.199999999999996p -2.9586190000000001e-07 35.212500000000006p -2.2470320000000001e-07 35.225000000000001p -1.5343890000000001e-07 35.237499999999997p -8.2165320000000004e-08 35.25p -1.0978410000000001e-08 35.262499999999996p 6.002634e-08 35.275000000000006p 1.307541e-07 35.287500000000001p 2.0111060000000001e-07 35.299999999999997p 2.7100280000000002e-07 35.3125p 3.403385e-07 35.324999999999996p 4.0902640000000002e-07
+ 35.337499999999999p 4.769769e-07 35.350000000000001p 5.4410159999999999e-07 35.362499999999997p 6.1031349999999995e-07 35.375p 6.7552729999999996e-07 35.387499999999996p 7.3965950000000003e-07 35.399999999999999p 8.0262849999999999e-07 35.412500000000001p 8.6435450000000005e-07 35.425000000000004p 9.2475979999999999e-07 35.4375p 9.8376879999999991e-07 35.449999999999996p 1.0413080000000001e-06 35.462499999999999p 1.097307e-06 35.475000000000001p 1.151697e-06 35.487500000000004p 1.204412e-06 35.5p 1.255388e-06 35.512499999999996p 1.304564e-06 35.524999999999999p 1.3518820000000001e-06 35.537500000000001p 1.397288e-06 35.550000000000004p 1.4407269999999999e-06
+ 35.5625p 1.4821510000000001e-06 35.574999999999996p 1.5215120000000001e-06 35.587499999999999p 1.5587659999999999e-06 35.600000000000001p 1.593873e-06 35.612500000000004p 1.6267949999999999e-06 35.625p 1.6574959999999999e-06 35.637499999999996p 1.685945e-06 35.649999999999999p 1.712113e-06 35.662500000000001p 1.7359739999999999e-06 35.675000000000004p 1.7575060000000001e-06 35.6875p 1.776688e-06 35.699999999999996p 1.793505e-06 35.712499999999999p 1.807944e-06 35.725000000000001p 1.819993e-06 35.737500000000004p 1.829646e-06 35.75p 1.8368980000000001e-06 35.762500000000003p 1.841749e-06 35.774999999999999p 1.844199e-06
+ 35.787500000000001p 1.8442550000000001e-06 35.800000000000004p 1.8419239999999999e-06 35.8125p 1.837216e-06 35.825000000000003p 1.8301460000000001e-06 35.837499999999999p 1.8207289999999999e-06 35.849999999999994p 1.808986e-06 35.862500000000004p 1.7949369999999999e-06 35.875p 1.778609e-06 35.887500000000003p 1.760028e-06 35.899999999999999p 1.7392250000000001e-06 35.912499999999994p 1.716232e-06 35.925000000000004p 1.691084e-06 35.9375p 1.663821e-06 35.950000000000003p 1.6344810000000001e-06 35.962499999999999p 1.6031069999999999e-06 35.974999999999994p 1.5697439999999999e-06 35.987500000000004p 1.5344399999999999e-06 36p 1.497243e-06
+ 36.012500000000003p 1.458206e-06 36.024999999999999p 1.4173819999999999e-06 36.037499999999994p 1.374826e-06 36.050000000000004p 1.3305969999999999e-06 36.0625p 1.2847529999999999e-06 36.075000000000003p 1.237355e-06 36.087499999999999p 1.1884680000000001e-06 36.099999999999994p 1.138155e-06 36.112499999999997p 1.0864840000000001e-06 36.125p 1.0335200000000001e-06 36.137500000000003p 9.7933509999999994e-07 36.149999999999999p 9.2399850000000003e-07 36.162500000000001p 8.6758239999999996e-07 36.174999999999997p 8.1016009999999999e-07 36.1875p 7.51806e-07 36.200000000000003p 6.925952e-07 36.212499999999999p 6.3260430000000002e-07 36.225000000000001p 5.7191049999999995e-07
+ 36.237499999999997p 5.1059180000000004e-07 36.25p 4.4872709999999998e-07 36.262500000000003p 3.8639569999999998e-07 36.274999999999999p 3.2367749999999998e-07 36.287500000000001p 2.6065300000000002e-07 36.299999999999997p 1.9740300000000001e-07 36.3125p 1.3400850000000001e-07 36.325000000000003p 7.0550569999999996e-08 36.337499999999999p 7.1106060000000001e-09 36.350000000000001p -5.6230190000000002e-08 36.362499999999997p -1.1939070000000001e-07 36.375p -1.8229e-07 36.387500000000003p -2.4484750000000001e-07 36.399999999999999p -3.0698299999999999e-07 36.412500000000001p -3.68617e-07 36.424999999999997p -4.2967029999999999e-07 36.4375p -4.9006459999999999e-07 36.450000000000003p -5.4972249999999999e-07
+ 36.462499999999999p -6.0856739999999999e-07 36.475000000000001p -6.6652380000000004e-07 36.487499999999997p -7.2351719999999996e-07 36.5p -7.794744e-07 36.512500000000003p -8.3432350000000001e-07 36.524999999999999p -8.879941e-07 36.537500000000001p -9.404173e-07 36.549999999999997p -9.9152560000000007e-07 36.5625p -1.0412540000000001e-06 36.575000000000003p -1.0895370000000001e-06 36.587499999999999p -1.136315e-06 36.600000000000001p -1.1815259999999999e-06 36.612499999999997p -1.2251130000000001e-06 36.625p -1.26702e-06 36.637500000000003p -1.307194e-06 36.649999999999999p -1.345583e-06 36.662500000000001p -1.3821390000000001e-06 36.674999999999997p -1.4168140000000001e-06
+ 36.6875p -1.449566e-06 36.700000000000003p -1.480353e-06 36.712499999999999p -1.509136e-06 36.725000000000001p -1.535879e-06 36.737499999999997p -1.560549e-06 36.75p -1.5831159999999999e-06 36.762500000000003p -1.6035519999999999e-06 36.774999999999999p -1.6218329999999999e-06 36.787500000000001p -1.637937e-06 36.799999999999997p -1.651844e-06 36.8125p -1.6635400000000001e-06 36.825000000000003p -1.673012e-06 36.837499999999999p -1.6802490000000001e-06 36.850000000000001p -1.685246e-06 36.862499999999997p -1.6879989999999999e-06 36.875p -1.688507e-06 36.887499999999996p -1.686774e-06 36.900000000000006p -1.6828030000000001e-06
+ 36.912500000000001p -1.6766050000000001e-06 36.924999999999997p -1.668192e-06 36.9375p -1.657577e-06 36.949999999999996p -1.644779e-06 36.962500000000006p -1.6298179999999999e-06 36.975000000000001p -1.6127189999999999e-06 36.987499999999997p -1.5935070000000001e-06 37p -1.5722130000000001e-06 37.012499999999996p -1.5488680000000001e-06 37.025000000000006p -1.5235089999999999e-06 37.037500000000001p -1.496172e-06 37.049999999999997p -1.4668990000000001e-06 37.0625p -1.4357310000000001e-06 37.074999999999996p -1.4027159999999999e-06 37.087500000000006p -1.3679010000000001e-06 37.100000000000001p -1.331336e-06 37.112499999999997p -1.2930749999999999e-06 37.125p -1.253173e-06
+ 37.137499999999996p -1.211686e-06 37.150000000000006p -1.1686740000000001e-06 37.162500000000001p -1.1241979999999999e-06 37.174999999999997p -1.0783220000000001e-06 37.1875p -1.0311110000000001e-06 37.199999999999996p -9.8263010000000005e-07 37.212499999999999p -9.3294890000000003e-07 37.225000000000001p -8.8213670000000003e-07 37.237499999999997p -8.3026469999999997e-07 37.25p -7.7740530000000002e-07 37.262499999999996p -7.2363210000000002e-07 37.274999999999999p -6.6901969999999996e-07 37.287500000000001p -6.1364369999999996e-07 37.300000000000004p -5.5758049999999995e-07 37.3125p -5.009074e-07 37.324999999999996p -4.4370209999999998e-07 37.337499999999999p -3.8604290000000002e-07 37.350000000000001p -3.2800859999999999e-07
+ 37.362500000000004p -2.6967800000000001e-07 37.375p -2.1113040000000001e-07 37.387499999999996p -1.5244489999999999e-07 37.399999999999999p -9.3700520000000006e-08 37.412500000000001p -3.4976330000000001e-08 37.425000000000004p 2.3649080000000001e-08 37.4375p 8.2097440000000005e-08 37.449999999999996p 1.40291e-07 37.462499999999999p 1.9815270000000001e-07 37.475000000000001p 2.5560619999999998e-07 37.487500000000004p 3.1257569999999998e-07 37.5p 3.6898680000000001e-07 37.512499999999996p 4.2476580000000002e-07 37.524999999999999p 4.7984019999999997e-07 37.537500000000001p 5.3413889999999997e-07 37.550000000000004p 5.8759190000000005e-07 37.5625p 6.4013059999999996e-07 37.574999999999996p 6.9168819999999995e-07
+ 37.587499999999999p 7.4219909999999998e-07 37.600000000000001p 7.9159970000000004e-07 37.612500000000004p 8.3982789999999998e-07 37.625p 8.8682359999999998e-07 37.637500000000003p 9.3252839999999997e-07 37.649999999999999p 9.7688620000000004e-07 37.662500000000001p 1.0198430000000001e-06 37.675000000000004p 1.0613450000000001e-06 37.6875p 1.1013440000000001e-06 37.700000000000003p 1.1397920000000001e-06 37.712499999999999p 1.176643e-06 37.724999999999994p 1.211853e-06 37.737500000000004p 1.2453819999999999e-06 37.75p 1.277192e-06 37.762500000000003p 1.3072449999999999e-06 37.774999999999999p 1.335509e-06 37.787499999999994p 1.361952e-06 37.800000000000004p 1.386546e-06
+ 37.8125p 1.4092650000000001e-06 37.825000000000003p 1.4300840000000001e-06 37.837499999999999p 1.448983e-06 37.849999999999994p 1.465944e-06 37.862500000000004p 1.48095e-06 37.875p 1.4939880000000001e-06 37.887500000000003p 1.505048e-06 37.899999999999999p 1.514121e-06 37.912499999999994p 1.521202e-06 37.925000000000004p 1.526287e-06 37.9375p 1.5293769999999999e-06 37.950000000000003p 1.5304739999999999e-06 37.962499999999999p 1.529581e-06 37.974999999999994p 1.5267060000000001e-06 37.987499999999997p 1.5218589999999999e-06 38p 1.5150520000000001e-06 38.012500000000003p 1.5062990000000001e-06 38.024999999999999p 1.4956159999999999e-06
+ 38.037500000000001p 1.4830240000000001e-06 38.049999999999997p 1.4685429999999999e-06 38.0625p 1.452197e-06 38.075000000000003p 1.4340130000000001e-06 38.087499999999999p 1.414019e-06 38.100000000000001p 1.3922439999999999e-06 38.112499999999997p 1.3687220000000001e-06 38.125p 1.343487e-06 38.137500000000003p 1.316575e-06 38.149999999999999p 1.288025e-06 38.162500000000001p 1.2578780000000001e-06 38.174999999999997p 1.226176e-06 38.1875p 1.1929630000000001e-06 38.200000000000003p 1.158285e-06 38.212499999999999p 1.1221889999999999e-06 38.225000000000001p 1.084724e-06 38.237499999999997p 1.0459419999999999e-06 38.25p 1.005895e-06
+ 38.262500000000003p 9.6463609999999992e-07 38.274999999999999p 9.2222069999999995e-07 38.287500000000001p 8.7870519999999996e-07 38.299999999999997p 8.341472e-07 38.3125p 7.8860569999999998e-07 38.325000000000003p 7.4214059999999995e-07 38.337499999999999p 6.9481279999999995e-07 38.350000000000001p 6.4668449999999998e-07 38.362499999999997p 5.9781839999999996e-07 38.375p 5.4827829999999996e-07 38.387500000000003p 4.9812860000000003e-07 38.399999999999999p 4.474344e-07 38.412500000000001p 3.9626140000000003e-07 38.424999999999997p 3.4467599999999998e-07 38.4375p 2.9274480000000001e-07 38.450000000000003p 2.4053479999999999e-07 38.462499999999999p 1.8811329999999999e-07 38.475000000000001p 1.3554799999999999e-07
+ 38.487499999999997p 8.2906469999999999e-08 38.5p 3.0256410000000001e-08 38.512500000000003p -2.233451e-08 38.524999999999999p -7.4798729999999994e-08 38.537500000000001p -1.2706889999999999e-07 38.549999999999997p -1.790781e-07 38.5625p -2.307594e-07 38.575000000000003p -2.820468e-07 38.587499999999999p -3.3287450000000001e-07 38.600000000000001p -3.831775e-07 38.612499999999997p -4.328914e-07 38.625p -4.8195260000000001e-07 38.637500000000003p -5.3029840000000005e-07 38.649999999999999p -5.7786700000000005e-07 38.662500000000001p -6.2459770000000004e-07 38.674999999999997p -6.7043090000000004e-07 38.6875p -7.1530799999999996e-07 38.700000000000003p -7.5917200000000004e-07
+ 38.712499999999999p -8.0196700000000005e-07 38.725000000000001p -8.4363849999999996e-07 38.737499999999997p -8.8413350000000001e-07 38.75p -9.2340079999999996e-07 38.762499999999996p -9.6139060000000001e-07 38.775000000000006p -9.9805470000000002e-07 38.787500000000001p -1.0333469999999999e-06 38.799999999999997p -1.0672229999999999e-06 38.8125p -1.0996400000000001e-06 38.824999999999996p -1.1305569999999999e-06 38.837500000000006p -1.159936e-06 38.850000000000001p -1.1877409999999999e-06 38.862499999999997p -1.2139360000000001e-06 38.875p -1.238489e-06 38.887499999999996p -1.2613709999999999e-06 38.900000000000006p -1.282554e-06 38.912500000000001p -1.3020110000000001e-06 38.924999999999997p -1.319721e-06
+ 38.9375p -1.335661e-06 38.949999999999996p -1.3498129999999999e-06 38.962500000000006p -1.3621620000000001e-06 38.975000000000001p -1.372694e-06 38.987499999999997p -1.3813969999999999e-06 39p -1.3882629999999999e-06 39.012499999999996p -1.3932860000000001e-06 39.025000000000006p -1.3964610000000001e-06 39.037500000000001p -1.3977880000000001e-06 39.049999999999997p -1.3972679999999999e-06 39.0625p -1.3949040000000001e-06 39.074999999999996p -1.390704e-06 39.087499999999999p -1.384675e-06 39.100000000000001p -1.3768290000000001e-06 39.112500000000004p -1.3671790000000001e-06 39.125p -1.3557420000000001e-06 39.137499999999996p -1.342535e-06 39.149999999999999p -1.3275809999999999e-06
+ 39.162500000000001p -1.3109020000000001e-06 39.175000000000004p -1.2925229999999999e-06 39.1875p -1.272473e-06 39.199999999999996p -1.2507810000000001e-06 39.212499999999999p -1.22748e-06 39.225000000000001p -1.202603e-06 39.237500000000004p -1.1761879999999999e-06 39.25p -1.1482719999999999e-06 39.262499999999996p -1.1188969999999999e-06 39.274999999999999p -1.0881039999999999e-06 39.287500000000001p -1.0559379999999999e-06 39.300000000000004p -1.0224440000000001e-06 39.3125p -9.8767010000000005e-07 39.324999999999996p -9.516659e-07 39.337499999999999p -9.1448200000000002e-07 39.350000000000001p -8.7617089999999997e-07 39.362500000000004p -8.367862e-07 39.375p -7.9638310000000001e-07
+ 39.387499999999996p -7.550179e-07 39.399999999999999p -7.1274820000000001e-07 39.412500000000001p -6.6963270000000005e-07 39.425000000000004p -6.2573080000000002e-07 39.4375p -5.811032e-07 39.449999999999996p -5.3581130000000004e-07 39.462499999999999p -4.8991700000000001e-07 39.475000000000001p -4.4348320000000001e-07 39.487500000000004p -3.9657320000000002e-07 39.5p -3.4925080000000002e-07 39.512500000000003p -3.0157999999999998e-07 39.524999999999999p -2.5362540000000002e-07 39.537500000000001p -2.054514e-07 39.550000000000004p -1.57123e-07 39.5625p -1.087047e-07 39.575000000000003p -6.0261220000000003e-08 39.587499999999999p -1.1857060000000001e-08 39.599999999999994p 3.644359e-08
+ 39.612500000000004p 8.4576859999999999e-08 39.625p 1.3247930000000001e-07 39.637500000000003p 1.8008810000000001e-07 39.649999999999999p 2.2734080000000001e-07 39.662499999999994p 2.7417599999999998e-07 39.675000000000004p 3.2053270000000003e-07 39.6875p 3.6635100000000002e-07 39.700000000000003p 4.1157189999999998e-07 39.712499999999999p 4.5613730000000001e-07 39.724999999999994p 4.999902e-07 39.737500000000004p 5.4307490000000005e-07 39.75p 5.8533689999999995e-07 39.762500000000003p 6.2672270000000004e-07 39.774999999999999p 6.6718070000000002e-07 39.787499999999994p 7.0666019999999999e-07 39.800000000000004p 7.4511219999999997e-07 39.8125p 7.8248940000000001e-07 39.825000000000003p 8.1874590000000005e-07
+ 39.837499999999999p 8.5383740000000002e-07 39.849999999999994p 8.8772150000000005e-07 39.862499999999997p 9.2035739999999996e-07 39.875p 9.5170619999999997e-07 39.887500000000003p 9.8173079999999998e-07 39.899999999999999p 1.010396e-06 39.912500000000001p 1.037668e-06 39.924999999999997p 1.0635160000000001e-06 39.9375p 1.0879110000000001e-06 39.950000000000003p 1.110824e-06 39.962499999999999p 1.1322309999999999e-06 39.975000000000001p 1.152108e-06 39.987499999999997p 1.1704339999999999e-06 40p 1.18719e-06 40.012500000000003p 1.2023590000000001e-06 40.024999999999999p 1.2159249999999999e-06 40.037500000000001p 1.2278759999999999e-06 40.049999999999997p 1.2382010000000001e-06
+ 40.0625p 1.2468920000000001e-06 40.075000000000003p 1.253941e-06 40.087499999999999p 1.2593449999999999e-06 40.100000000000001p 1.2631010000000001e-06 40.112499999999997p 1.265208e-06 40.125p 1.26567e-06 40.137500000000003p 1.264489e-06 40.149999999999999p 1.261673e-06 40.162500000000001p 1.2572279999999999e-06 40.174999999999997p 1.2511650000000001e-06 40.1875p 1.2434959999999999e-06 40.200000000000003p 1.2342359999999999e-06 40.212499999999999p 1.2234e-06 40.225000000000001p 1.2110060000000001e-06 40.237499999999997p 1.1970750000000001e-06 40.25p 1.1816269999999999e-06 40.262500000000003p 1.1646869999999999e-06 40.274999999999999p 1.146281e-06
+ 40.287500000000001p 1.126434e-06 40.299999999999997p 1.105177e-06 40.3125p 1.082539e-06 40.325000000000003p 1.0585530000000001e-06 40.337499999999999p 1.0332530000000001e-06 40.350000000000001p 1.006674e-06 40.362499999999997p 9.788536000000001e-07 40.375p 9.4982949999999996e-07 40.387500000000003p 9.1964170000000002e-07 40.399999999999999p 8.8833140000000001e-07 40.412500000000001p 8.55941e-07 40.424999999999997p 8.2251450000000004e-07 40.4375p 7.8809659999999997e-07 40.450000000000003p 7.5273360000000003e-07 40.462499999999999p 7.1647259999999996e-07 40.475000000000001p 6.7936189999999997e-07 40.487499999999997p 6.4145070000000001e-07 40.5p 6.0278930000000001e-07
+ 40.512500000000003p 5.6342859999999996e-07 40.524999999999999p 5.2342040000000003e-07 40.537500000000001p 4.8281739999999997e-07 40.549999999999997p 4.4167270000000001e-07 40.5625p 4.0004020000000001e-07 40.575000000000003p 3.579743e-07 40.587499999999999p 3.1552989999999998e-07 40.600000000000001p 2.727622e-07 40.612499999999997p 2.29727e-07 40.625p 1.8647989999999999e-07 40.637499999999996p 1.4307730000000001e-07 40.650000000000006p 9.957528e-08 40.662500000000001p 5.603021e-08 40.674999999999997p 1.249841e-08 40.6875p -3.0963890000000003e-08 40.699999999999996p -7.4300579999999997e-08 40.712500000000006p -1.1745580000000001e-07 40.725000000000001p -1.6037379999999999e-07
+ 40.737499999999997p -2.0299949999999999e-07 40.75p -2.4527799999999998e-07 40.762499999999996p -2.8715490000000001e-07 40.775000000000006p -3.285765e-07 40.787500000000001p -3.6948959999999999e-07 40.799999999999997p -4.0984179999999999e-07 40.8125p -4.4958129999999998e-07 40.824999999999996p -4.8865740000000003e-07 40.837500000000006p -5.2702009999999996e-07 40.850000000000001p -5.6462030000000001e-07 40.862499999999997p -6.0141020000000002e-07 40.875p -6.373429e-07 40.887499999999996p -6.7237269999999998e-07 40.900000000000006p -7.0645520000000005e-07 40.912500000000001p -7.3954710000000004e-07 40.924999999999997p -7.7160650000000002e-07 40.9375p -8.0259310000000001e-07 40.949999999999996p -8.3246779999999995e-07
+ 40.962499999999999p -8.6119309999999997e-07 40.975000000000001p -8.8873289999999998e-07 40.987500000000004p -9.1505309999999995e-07 41p -9.4012070000000003e-07 41.012499999999996p -9.6390489999999998e-07 41.024999999999999p -9.8637629999999999e-07 41.037500000000001p -1.0075070000000001e-06 41.050000000000004p -1.027272e-06 41.0625p -1.045648e-06 41.074999999999996p -1.0626110000000001e-06 41.087499999999999p -1.078143e-06 41.100000000000001p -1.0922239999999999e-06 41.112500000000004p -1.104839e-06 41.125p -1.1159739999999999e-06 41.137499999999996p -1.1256160000000001e-06 41.149999999999999p -1.1337559999999999e-06 41.162500000000001p -1.1403849999999999e-06 41.175000000000004p -1.145497e-06
+ 41.1875p -1.149087e-06 41.199999999999996p -1.1511549999999999e-06 41.212499999999999p -1.1516999999999999e-06 41.225000000000001p -1.1507249999999999e-06 41.237500000000004p -1.1482319999999999e-06 41.25p -1.14423e-06 41.262499999999996p -1.1387250000000001e-06 41.274999999999999p -1.131728e-06 41.287500000000001p -1.1232520000000001e-06 41.300000000000004p -1.1133110000000001e-06 41.3125p -1.1019199999999999e-06 41.324999999999996p -1.0890990000000001e-06 41.337499999999999p -1.074866e-06 41.350000000000001p -1.0592449999999999e-06 41.362500000000004p -1.0422580000000001e-06 41.375p -1.0239320000000001e-06 41.387500000000003p -1.0042930000000001e-06 41.399999999999999p -9.8337179999999996e-07
+ 41.412500000000001p -9.6119769999999992e-07 41.425000000000004p -9.3780350000000004e-07 41.4375p -9.1322319999999998e-07 41.450000000000003p -8.8749240000000004e-07 41.462499999999999p -8.6064809999999996e-07 41.474999999999994p -8.3272859999999997e-07 41.487500000000004p -8.0377370000000003e-07 41.5p -7.7382459999999999e-07 41.512500000000003p -7.4292370000000001e-07 41.524999999999999p -7.1111439999999999e-07 41.537499999999994p -6.7844150000000002e-07 41.550000000000004p -6.4495069999999996e-07 41.5625p -6.1068879999999996e-07 41.575000000000003p -5.7570329999999995e-07 41.587499999999999p -5.4004279999999995e-07 41.599999999999994p -5.0375659999999995e-07 41.612500000000004p -4.6689459999999998e-07 41.625p -4.2950760000000002e-07
+ 41.637500000000003p -3.9164669999999998e-07 41.649999999999999p -3.5336370000000001e-07 41.662499999999994p -3.147106e-07 41.675000000000004p -2.7574000000000001e-07 41.6875p -2.365045e-07 41.700000000000003p -1.970572e-07 41.712499999999999p -1.5745109999999999e-07 41.724999999999994p -1.177393e-07 41.737499999999997p -7.7974849999999994e-08 41.75p -3.8210790000000003e-08 41.762500000000003p 1.5000690000000001e-09 41.774999999999999p 4.1105169999999998e-08 41.787500000000001p 8.0552270000000006e-08 41.799999999999997p 1.197895e-07 41.8125p 1.587654e-07 41.825000000000003p 1.974292e-07 41.837499999999999p 2.3573060000000001e-07 41.850000000000001p 2.736198e-07
+ 41.862499999999997p 3.1104810000000001e-07 41.875p 3.479674e-07 41.887500000000003p 3.8433019999999999e-07 41.899999999999999p 4.2009040000000002e-07 41.912500000000001p 4.5520260000000001e-07 41.924999999999997p 4.8962230000000004e-07 41.9375p 5.2330639999999996e-07 41.950000000000003p 5.5621260000000004e-07 41.962499999999999p 5.8830009999999999e-07 41.975000000000001p 6.1952909999999995e-07 41.987499999999997p 6.4986119999999998e-07 42p 6.7925929999999996e-07 42.012500000000003p 7.0768760000000004e-07 42.024999999999999p 7.3511190000000003e-07 42.037500000000001p 7.6149930000000004e-07 42.049999999999997p 7.8681830000000003e-07 42.0625p 8.1103899999999996e-07 42.075000000000003p 8.3413329999999997e-07
+ 42.087499999999999p 8.5607419999999995e-07 42.100000000000001p 8.7683669999999995e-07 42.112499999999997p 8.9639720000000001e-07 42.125p 9.1473380000000001e-07 42.137500000000003p 9.3182639999999996e-07 42.149999999999999p 9.4765650000000001e-07 42.162500000000001p 9.622071e-07 42.174999999999997p 9.7546319999999994e-07 42.1875p 9.8741150000000007e-07 42.200000000000003p 9.9804019999999994e-07 42.212499999999999p 1.0073390000000001e-06 42.225000000000001p 1.0153010000000001e-06 42.237499999999997p 1.021919e-06 42.25p 1.0271869999999999e-06 42.262500000000003p 1.0311050000000001e-06 42.274999999999999p 1.0336689999999999e-06 42.287500000000001p 1.0348809999999999e-06 42.299999999999997p 1.0347419999999999e-06
+ 42.3125p 1.033257e-06 42.325000000000003p 1.0304319999999999e-06 42.337499999999999p 1.0262739999999999e-06 42.350000000000001p 1.020791e-06 42.362499999999997p 1.013994e-06 42.375p 1.0058960000000001e-06 42.387500000000003p 9.965103e-07 42.399999999999999p 9.8585229999999993e-07 42.412500000000001p 9.7393920000000001e-07 42.424999999999997p 9.6078940000000006e-07 42.4375p 9.4642299999999995e-07 42.450000000000003p 9.3086140000000001e-07 42.462499999999999p 9.1412760000000002e-07 42.475000000000001p 8.9624590000000005e-07 42.487499999999997p 8.7724209999999998e-07 42.5p 8.5714320000000003e-07 42.512499999999996p 8.3597770000000002e-07 42.525000000000006p 8.1377510000000004e-07
+ 42.537500000000001p 7.9056639999999998e-07 42.549999999999997p 7.6638359999999999e-07 42.5625p 7.4125990000000002e-07 42.574999999999996p 7.1522980000000005e-07 42.587500000000006p 6.8832840000000004e-07 42.600000000000001p 6.6059240000000004e-07 42.612499999999997p 6.3205910000000003e-07 42.625p 6.0276669999999998e-07 42.637499999999996p 5.727546e-07 42.650000000000006p 5.4206269999999997e-07 42.662500000000001p 5.1073179999999999e-07 42.674999999999997p 4.7880360000000001e-07 42.6875p 4.4632030000000002e-07 42.699999999999996p 4.133247e-07 42.712500000000006p 3.7986029999999999e-07 42.725000000000001p 3.4597119999999998e-07 42.737499999999997p 3.117016e-07 42.75p 2.7709670000000001e-07
+ 42.762499999999996p 2.4220150000000003e-07 42.775000000000006p 2.0706160000000001e-07 42.787500000000001p 1.7172289999999999e-07 42.799999999999997p 1.3623139999999999e-07 42.8125p 1.006331e-07 42.824999999999996p 6.4974459999999998e-08 42.837499999999999p 2.9301579999999998e-08 42.850000000000001p -6.339276e-09 42.862500000000004p -4.1901960000000001e-08 42.875p -7.7340470000000001e-08 42.887499999999996p -1.12609e-07 42.899999999999999p -1.4766210000000001e-07 42.912500000000001p -1.8245449999999999e-07 42.925000000000004p -2.1694140000000001e-07 42.9375p -2.5107830000000002e-07 42.949999999999996p -2.8482139999999998e-07 42.962499999999999p -3.181274e-07 42.975000000000001p -3.509534e-07
+ 42.987500000000004p -3.832574e-07 43p -4.149979e-07 43.012499999999996p -4.461345e-07 43.024999999999999p -4.7662720000000001e-07 43.037500000000001p -5.0643719999999998e-07 43.050000000000004p -5.3552640000000005e-07 43.0625p -5.6385789999999997e-07 43.074999999999996p -5.9139570000000003e-07 43.087499999999999p -6.181048e-07 43.100000000000001p -6.4395139999999999e-07 43.112500000000004p -6.689029e-07 43.125p -6.9292789999999995e-07 43.137499999999996p -7.1599619999999999e-07 43.149999999999999p -7.3807889999999998e-07 43.162500000000001p -7.5914839999999998e-07 43.175000000000004p -7.7917850000000003e-07 43.1875p -7.9814449999999999e-07 43.199999999999996p -8.16023e-07
+ 43.212499999999999p -8.3279219999999997e-07 43.225000000000001p -8.4843159999999996e-07 43.237500000000004p -8.6292239999999997e-07 43.25p -8.7624730000000003e-07 43.262500000000003p -8.8839049999999999e-07 43.274999999999999p -8.99338e-07 43.287499999999994p -9.0907709999999995e-07 43.300000000000004p -9.1759709999999997e-07 43.3125p -9.2488870000000001e-07 43.325000000000003p -9.3094430000000003e-07 43.337499999999999p -9.3575800000000001e-07 43.349999999999994p -9.3932550000000002e-07 43.362500000000004p -9.4164429999999999e-07 43.375p -9.4271359999999999e-07 43.387500000000003p -9.4253410000000001e-07 43.399999999999999p -9.4110830000000002e-07 43.412499999999994p -9.384404e-07 43.425000000000004p -9.3453620000000004e-07
+ 43.4375p -9.2940329999999995e-07 43.450000000000003p -9.230507e-07 43.462499999999999p -9.1548919999999996e-07 43.474999999999994p -9.0673129999999997e-07 43.487500000000004p -8.9679089999999995e-07 43.5p -8.8568359999999996e-07 43.512500000000003p -8.7342649999999996e-07 43.524999999999999p -8.600382e-07 43.537499999999994p -8.4553889999999997e-07 43.550000000000004p -8.2995019999999997e-07 43.5625p -8.1329510000000002e-07 43.575000000000003p -7.95598e-07 43.587499999999999p -7.7688479999999995e-07 43.599999999999994p -7.5718260000000002e-07 43.612499999999997p -7.365198e-07 43.625p -7.1492610000000005e-07 43.637500000000003p -6.9243229999999999e-07 43.649999999999999p -6.6907050000000001e-07
+ 43.662500000000001p -6.4487369999999995e-07 43.674999999999997p -6.1987620000000005e-07 43.6875p -5.9411299999999999e-07 43.700000000000003p -5.6762050000000001e-07 43.712499999999999p -5.4043549999999997e-07 43.725000000000001p -5.1259610000000001e-07 43.737499999999997p -4.8414089999999998e-07 43.75p -4.5510930000000001e-07 43.762500000000003p -4.2554150000000003e-07 43.774999999999999p -3.9547809999999998e-07 43.787500000000001p -3.6496060000000001e-07 43.799999999999997p -3.3403069999999998e-07 43.8125p -3.0273070000000001e-07 43.825000000000003p -2.7110329999999999e-07 43.837499999999999p -2.3919130000000002e-07 43.850000000000001p -2.070381e-07 43.862499999999997p -1.7468719999999999e-07 43.875p -1.42182e-07
+ 43.887500000000003p -1.0956630000000001e-07 43.899999999999999p -7.6883880000000004e-08 43.912500000000001p -4.4178279999999997e-08 43.924999999999997p -1.1493109999999999e-08 43.9375p 2.11282e-08 43.950000000000003p 5.3642470000000002e-08 43.962499999999999p 8.6006780000000006e-08 43.975000000000001p 1.181785e-07 43.987499999999997p 1.5011550000000001e-07 44p 1.81776e-07 44.012500000000003p 2.1311869999999999e-07 44.024999999999999p 2.44103e-07 44.037500000000001p 2.7468880000000002e-07 44.049999999999997p 3.0483660000000002e-07 44.0625p 3.3450770000000002e-07 44.075000000000003p 3.636642e-07 44.087499999999999p 3.9226899999999998e-07 44.100000000000001p 4.2028580000000002e-07
+ 44.112499999999997p 4.4767920000000001e-07 44.125p 4.7441469999999997e-07 44.137500000000003p 5.0045900000000005e-07 44.149999999999999p 5.2577969999999996e-07 44.162500000000001p 5.5034530000000005e-07 44.174999999999997p 5.7412580000000003e-07 44.1875p 5.9709190000000002e-07 44.200000000000003p 6.1921570000000003e-07 44.212499999999999p 6.4047060000000002e-07 44.225000000000001p 6.6083110000000004e-07 44.237499999999997p 6.8027290000000003e-07 44.25p 6.9877319999999996e-07 44.262500000000003p 7.1631030000000002e-07 44.274999999999999p 7.3286399999999996e-07 44.287500000000001p 7.4841530000000002e-07 44.299999999999997p 7.6294679999999997e-07 44.3125p 7.7644219999999997e-07 44.325000000000003p 7.888869e-07
+ 44.337499999999999p 8.0026750000000004e-07 44.350000000000001p 8.1057210000000003e-07 44.362499999999997p 8.1979030000000004e-07 44.375p 8.2791310000000003e-07 44.387499999999996p 8.3493289999999996e-07 44.400000000000006p 8.4084349999999999e-07 44.412500000000001p 8.4564040000000002e-07 44.424999999999997p 8.4932039999999995e-07 44.4375p 8.5188169999999995e-07 44.449999999999996p 8.5332399999999997e-07 44.462500000000006p 8.5364850000000004e-07 44.475000000000001p 8.5285759999999995e-07 44.487499999999997p 8.5095550000000003e-07 44.5p 8.479475e-07 44.512499999999996p 8.4384050000000003e-07 44.525000000000006p 8.3864259999999995e-07 44.537500000000001p 8.3236339999999997e-07 44.549999999999997p 8.2501380000000002e-07
+ 44.5625p 8.1660610000000005e-07 44.574999999999996p 8.0715379999999999e-07 44.587500000000006p 7.9667180000000002e-07 44.600000000000001p 7.8517630000000002e-07 44.612499999999997p 7.7268459999999997e-07 44.625p 7.5921520000000005e-07 44.637499999999996p 7.4478800000000004e-07 44.650000000000006p 7.2942399999999998e-07 44.662500000000001p 7.1314510000000002e-07 44.674999999999997p 6.9597470000000001e-07 44.6875p 6.7793690000000003e-07 44.699999999999996p 6.5905700000000005e-07 44.712499999999999p 6.3936140000000003e-07 44.725000000000001p 6.1887730000000005e-07 44.737500000000004p 5.9763290000000002e-07 44.75p 5.756574e-07 44.762499999999996p 5.5298070000000002e-07 44.774999999999999p 5.2963359999999999e-07
+ 44.787500000000001p 5.056477e-07 44.800000000000004p 4.8105529999999999e-07 44.8125p 4.5588929999999999e-07 44.824999999999996p 4.3018359999999999e-07 44.837499999999999p 4.0397240000000001e-07 44.850000000000001p 3.7729050000000003e-07 44.862500000000004p 3.5017350000000001e-07 44.875p 3.2265699999999998e-07 44.887499999999996p 2.9477760000000003e-07 44.899999999999999p 2.6657189999999999e-07 44.912500000000001p 2.38077e-07 44.925000000000004p 2.0933030000000001e-07 44.9375p 1.8036950000000001e-07 44.949999999999996p 1.5123229999999999e-07 44.962499999999999p 1.2195689999999999e-07 44.975000000000001p 9.2581380000000002e-08 44.987500000000004p 6.3143929999999997e-08 45p 3.36828e-08
+ 45.012499999999996p 4.2362129999999999e-09 45.024999999999999p -2.51577e-08 45.037500000000001p -5.4460920000000001e-08 45.050000000000004p -8.3635579999999994e-08 45.0625p -1.126441e-07 45.074999999999996p -1.4144900000000001e-07 45.087499999999999p -1.700133e-07 45.100000000000001p -1.983003e-07 45.112500000000004p -2.2627360000000001e-07 45.125p -2.538975e-07 45.137500000000003p -2.811365e-07 45.149999999999999p -3.0795590000000002e-07 45.162499999999994p -3.343213e-07 45.175000000000004p -3.6019920000000002e-07 45.1875p -3.8555670000000001e-07 45.200000000000003p -4.1036160000000001e-07 45.212499999999999p -4.345823e-07 45.224999999999994p -4.5818819999999998e-07
+ 45.237500000000004p -4.8114950000000003e-07 45.25p -5.0343719999999997e-07 45.262500000000003p -5.2502329999999998e-07 45.274999999999999p -5.4588059999999997e-07 45.287499999999994p -5.6598309999999996e-07 45.300000000000004p -5.8530569999999996e-07 45.3125p -6.038243e-07 45.325000000000003p -6.2151600000000002e-07 45.337499999999999p -6.3835889999999999e-07 45.349999999999994p -6.5433229999999999e-07 45.362500000000004p -6.6941670000000002e-07 45.375p -6.8359379999999996e-07 45.387500000000003p -6.9684640000000001e-07 45.399999999999999p -7.0915859999999998e-07 45.412499999999994p -7.205159e-07 45.425000000000004p -7.3090489999999995e-07 45.4375p -7.4031360000000003e-07 45.450000000000003p -7.4873129999999996e-07
+ 45.462499999999999p -7.5614850000000002e-07 45.475000000000001p -7.6255719999999997e-07 45.487499999999997p -7.6795069999999999e-07 45.5p -7.7232359999999995e-07 45.512500000000003p -7.7567209999999995e-07 45.524999999999999p -7.7799339999999999e-07 45.537500000000001p -7.7928629999999996e-07 45.549999999999997p -7.7955100000000004e-07 45.5625p -7.7878890000000003e-07 45.575000000000003p -7.7700300000000001e-07 45.587499999999999p -7.7419749999999997e-07 45.600000000000001p -7.7037790000000005e-07 45.612499999999997p -7.6555109999999999e-07 45.625p -7.5972560000000001e-07 45.637500000000003p -7.5291069999999998e-07 45.649999999999999p -7.4511759999999997e-07 45.662500000000001p -7.3635820000000005e-07 45.674999999999997p -7.266461e-07
+ 45.6875p -7.1599610000000005e-07 45.700000000000003p -7.0442400000000001e-07 45.712499999999999p -6.9194700000000002e-07 45.725000000000001p -6.7858339999999998e-07 45.737499999999997p -6.6435269999999999e-07 45.75p -6.4927559999999998e-07 45.762500000000003p -6.3337379999999998e-07 45.774999999999999p -6.1666990000000004e-07 45.787500000000001p -5.9918780000000002e-07 45.799999999999997p -5.8095240000000005e-07 45.8125p -5.6198939999999996e-07 45.825000000000003p -5.4232529999999996e-07 45.837499999999999p -5.2198800000000003e-07 45.850000000000001p -5.0100560000000004e-07 45.862499999999997p -4.7940750000000001e-07 45.875p -4.572236e-07 45.887500000000003p -4.3448460000000002e-07 45.899999999999999p -4.1122190000000001e-07
+ 45.912500000000001p -3.8746740000000001e-07 45.924999999999997p -3.6325379999999999e-07 45.9375p -3.3861430000000002e-07 45.950000000000003p -3.1358230000000001e-07 45.962499999999999p -2.881919e-07 45.975000000000001p -2.6247770000000003e-07 45.987499999999997p -2.364744e-07 46p -2.102171e-07 46.012500000000003p -1.8374119999999999e-07 46.024999999999999p -1.5708219999999999e-07 46.037500000000001p -1.302759e-07 46.049999999999997p -1.03358e-07 46.0625p -7.6364459999999996e-08 46.075000000000003p -4.9331119999999999e-08 46.087499999999999p -2.229381e-08 46.100000000000001p 4.7117339999999999e-09 46.112499999999997p 3.1649899999999997e-08 46.125p 5.8485289999999997e-08
+ 46.137500000000003p 8.5182730000000002e-08 46.149999999999999p 1.117073e-07 46.162500000000001p 1.3802450000000001e-07 46.174999999999997p 1.6410010000000001e-07 46.1875p 1.899003e-07 46.200000000000003p 2.1539179999999999e-07 46.212499999999999p 2.4054180000000003e-07 46.225000000000001p 2.6531809999999999e-07 46.237499999999997p 2.8968900000000002e-07 46.25p 3.1362350000000002e-07 46.262499999999996p 3.3709120000000002e-07 46.275000000000006p 3.6006239999999998e-07 46.287500000000001p 3.8250829999999998e-07 46.299999999999997p 4.0440069999999999e-07 46.3125p 4.257122e-07 46.324999999999996p 4.4641650000000001e-07 46.337500000000006p 4.664879e-07 46.350000000000001p 4.8590180000000005e-07
+ 46.362499999999997p 5.0463439999999996e-07 46.375p 5.2266289999999998e-07 46.387499999999996p 5.3996550000000002e-07 46.400000000000006p 5.5652159999999999e-07 46.412500000000001p 5.7231130000000002e-07 46.424999999999997p 5.8731599999999999e-07 46.4375p 6.0151820000000004e-07 46.449999999999996p 6.1490129999999998e-07 46.462500000000006p 6.2745000000000002e-07 46.475000000000001p 6.3914999999999995e-07 46.487499999999997p 6.4998839999999998e-07 46.5p 6.5995310000000005e-07 46.512499999999996p 6.6903350000000005e-07 46.525000000000006p 6.7721999999999997e-07 46.537500000000001p 6.8450410000000002e-07 46.549999999999997p 6.9087879999999999e-07 46.5625p 6.9633810000000004e-07 46.574999999999996p 7.0087709999999998e-07
+ 46.587499999999999p 7.0449230000000001e-07 46.600000000000001p 7.0718130000000001e-07 46.612500000000004p 7.0894300000000002e-07 46.625p 7.0977740000000004e-07 46.637499999999996p 7.0968580000000001e-07 46.649999999999999p 7.0867050000000002e-07 46.662500000000001p 7.067351e-07 46.675000000000004p 7.0388450000000005e-07 46.6875p 7.0012450000000002e-07 46.699999999999996p 6.9546229999999999e-07 46.712499999999999p 6.8990609999999995e-07 46.725000000000001p 6.8346530000000002e-07 46.737500000000004p 6.7615019999999996e-07 46.75p 6.6797260000000003e-07 46.762499999999996p 6.5894500000000003e-07 46.774999999999999p 6.4908110000000001e-07 46.787500000000001p 6.3839560000000003e-07 46.800000000000004p 6.2690439999999996e-07
+ 46.8125p 6.1462409999999998e-07 46.824999999999996p 6.0157240000000003e-07 46.837499999999999p 5.8776799999999997e-07 46.850000000000001p 5.7323049999999997e-07 46.862500000000004p 5.579803e-07 46.875p 5.4203879999999999e-07 46.887499999999996p 5.2542800000000001e-07 46.899999999999999p 5.0817110000000005e-07 46.912500000000001p 4.9029169999999995e-07 46.925000000000004p 4.7181430000000002e-07 46.9375p 4.5276409999999998e-07 46.949999999999996p 4.3316699999999998e-07 46.962499999999999p 4.130495e-07 46.975000000000001p 3.9243869999999998e-07 46.987500000000004p 3.7136239999999998e-07 47p 3.4984880000000001e-07 47.012500000000003p 3.2792669999999999e-07 47.024999999999999p 3.0562520000000002e-07
+ 47.037499999999994p 2.829741e-07 47.050000000000004p 2.600034e-07 47.0625p 2.3674340000000001e-07 47.075000000000003p 2.1322500000000001e-07 47.087499999999999p 1.89479e-07 47.099999999999994p 1.655368e-07 47.112500000000004p 1.4142969999999999e-07 47.125p 1.1718929999999999e-07 47.137500000000003p 9.284738e-08 47.149999999999999p 6.8435660000000002e-08 47.162499999999994p 4.3985969999999998e-08 47.175000000000004p 1.9530119999999999e-08 47.1875p -4.9001150000000003e-09 47.200000000000003p -2.9273059999999999e-08 47.212499999999999p -5.3557139999999999e-08 47.224999999999994p -7.7720969999999995e-08 47.237500000000004p -1.017333e-07 47.25p -1.255633e-07
+ 47.262500000000003p -1.4918029999999999e-07 47.274999999999999p -1.7255379999999999e-07 47.287499999999994p -1.9565389999999999e-07 47.300000000000004p -2.1845109999999999e-07 47.3125p -2.409161e-07 47.325000000000003p -2.630204e-07 47.337499999999999p -2.8473580000000001e-07 47.350000000000001p -3.0603460000000001e-07 47.362499999999997p -3.268898e-07 47.375p -3.4727509999999998e-07 47.387500000000003p -3.6716460000000002e-07 47.399999999999999p -3.8653330000000001e-07 47.412500000000001p -4.053569e-07 47.424999999999997p -4.2361169999999999e-07 47.4375p -4.4127500000000001e-07 47.450000000000003p -4.583246e-07 47.462499999999999p -4.7473950000000001e-07 47.475000000000001p -4.9049940000000005e-07
+ 47.487499999999997p -5.0558469999999995e-07 47.5p -5.19977e-07 47.512500000000003p -5.3365869999999997e-07 47.524999999999999p -5.4661329999999995e-07 47.537500000000001p -5.5882510000000005e-07 47.549999999999997p -5.7027939999999999e-07 47.5625p -5.8096279999999997e-07 47.575000000000003p -5.9086259999999999e-07 47.587499999999999p -5.9996730000000004e-07 47.600000000000001p -6.0826660000000003e-07 47.612499999999997p -6.1575100000000002e-07 47.625p -6.224123e-07 47.637500000000003p -6.2824330000000003e-07 47.649999999999999p -6.3323809999999996e-07 47.662500000000001p -6.3739169999999999e-07 47.674999999999997p -6.4070020000000005e-07 47.6875p -6.4316100000000002e-07 47.700000000000003p -6.4477270000000002e-07
+ 47.712499999999999p -6.4553469999999999e-07 47.725000000000001p -6.4544779999999996e-07 47.737499999999997p -6.4451389999999995e-07 47.75p -6.4273579999999996e-07 47.762500000000003p -6.401178e-07 47.774999999999999p -6.3666499999999996e-07 47.787500000000001p -6.3238370000000003e-07 47.799999999999997p -6.2728130000000005e-07 47.8125p -6.2136630000000004e-07 47.825000000000003p -6.146481e-07 47.837499999999999p -6.071376e-07 47.850000000000001p -5.9884610000000003e-07 47.862499999999997p -5.8978639999999995e-07 47.875p -5.7997220000000001e-07 47.887500000000003p -5.6941799999999997e-07 47.899999999999999p -5.5813939999999999e-07 47.912500000000001p -5.4615300000000003e-07 47.924999999999997p -5.3347609999999997e-07
+ 47.9375p -5.2012719999999999e-07 47.950000000000003p -5.0612520000000005e-07 47.962499999999999p -4.9149030000000005e-07 47.975000000000001p -4.762432e-07 47.987499999999997p -4.6040550000000001e-07 48p -4.4399949999999999e-07 48.012500000000003p -4.2704819999999998e-07 48.024999999999999p -4.0957529999999999e-07 48.037500000000001p -3.9160500000000002e-07 48.049999999999997p -3.7316240000000001e-07 48.0625p -3.542728e-07 48.075000000000003p -3.3496249999999999e-07 48.087499999999999p -3.1525779999999999e-07 48.100000000000001p -2.951857e-07 48.112499999999997p -2.7477369999999999e-07 48.125p -2.5404950000000001e-07 48.137499999999996p -2.3304130000000001e-07 48.150000000000006p -2.1177760000000001e-07
+ 48.162500000000001p -1.902869e-07 48.174999999999997p -1.6859829999999999e-07 48.1875p -1.4674079999999999e-07 48.199999999999996p -1.2474369999999999e-07 48.212500000000006p -1.0263649999999999e-07 48.225000000000001p -8.0448379999999996e-08 48.237499999999997p -5.8208949999999999e-08 48.25p -3.5947620000000003e-08 48.262499999999996p -1.3693779999999999e-08 48.275000000000006p 8.5232780000000006e-09 48.287500000000001p 3.0674400000000002e-08 48.299999999999997p 5.2730580000000003e-08 48.3125p 7.4663060000000004e-08 48.324999999999996p 9.6443290000000005e-08 48.337500000000006p 1.1804299999999999e-07 48.350000000000001p 1.3943430000000001e-07 48.362499999999997p 1.6058970000000001e-07 48.375p 1.8148189999999999e-07
+ 48.387499999999996p 2.0208409999999999e-07 48.400000000000006p 2.2237020000000001e-07 48.412500000000001p 2.4231429999999998e-07 48.424999999999997p 2.6189109999999999e-07 48.4375p 2.8107600000000002e-07 48.449999999999996p 2.998449e-07 48.462499999999999p 3.1817419999999999e-07 48.475000000000001p 3.360411e-07 48.487500000000004p 3.5342349999999999e-07 48.5p 3.7029979999999999e-07 48.512499999999996p 3.8664939999999998e-07 48.524999999999999p 4.0245229999999999e-07 48.537500000000001p 4.1768929999999998e-07 48.550000000000004p 4.3234189999999998e-07 48.5625p 4.4639249999999998e-07 48.574999999999996p 4.5982450000000002e-07 48.587499999999999p 4.7262200000000001e-07 48.600000000000001p 4.8476980000000003e-07
+ 48.612500000000004p 4.9625400000000002e-07 48.625p 5.0706119999999995e-07 48.637499999999996p 5.1717920000000004e-07 48.649999999999999p 5.2659660000000002e-07 48.662500000000001p 5.3530299999999996e-07 48.675000000000004p 5.4328890000000002e-07 48.6875p 5.5054590000000002e-07 48.699999999999996p 5.5706629999999997e-07 48.712499999999999p 5.6284360000000001e-07 48.725000000000001p 5.6787229999999999e-07 48.737500000000004p 5.7214770000000002e-07 48.75p 5.7566629999999999e-07 48.762499999999996p 5.7842530000000002e-07 48.774999999999999p 5.8042319999999997e-07 48.787500000000001p 5.8165930000000004e-07 48.800000000000004p 5.8213399999999999e-07 48.8125p 5.8184850000000005e-07 48.824999999999996p 5.8080509999999998e-07
+ 48.837499999999999p 5.7900710000000001e-07 48.850000000000001p 5.7645879999999995e-07 48.862500000000004p 5.7316520000000005e-07 48.875p 5.6913259999999997e-07 48.887500000000003p 5.6436780000000003e-07 48.899999999999999p 5.5887900000000001e-07 48.912499999999994p 5.5267490000000003e-07 48.925000000000004p 5.4576539999999999e-07 48.9375p 5.3816110000000002e-07 48.950000000000003p 5.2987350000000001e-07 48.962499999999999p 5.2091499999999995e-07 48.974999999999994p 5.1129870000000003e-07 48.987500000000004p 5.0103879999999998e-07 49p 4.9014979999999999e-07 49.012500000000003p 4.786475e-07 49.024999999999999p 4.6654819999999999e-07 49.037499999999994p 4.5386880000000001e-07 49.050000000000004p 4.406272e-07
+ 49.0625p 4.268417e-07 49.075000000000003p 4.1253149999999999e-07 49.087499999999999p 3.9771620000000002e-07 49.099999999999994p 3.8241619999999999e-07 49.112500000000004p 3.6665239999999999e-07 49.125p 3.504462e-07 49.137500000000003p 3.3381969999999998e-07 49.149999999999999p 3.1679519999999998e-07 49.162499999999994p 2.9939570000000001e-07 49.175000000000004p 2.8164459999999998e-07 49.1875p 2.6356569999999999e-07 49.200000000000003p 2.4518319999999999e-07 49.212499999999999p 2.2652139999999999e-07 49.225000000000001p 2.0760529999999999e-07 49.237499999999997p 1.8845989999999999e-07 49.25p 1.6911059999999999e-07 49.262500000000003p 1.49583e-07 49.274999999999999p 1.2990280000000001e-07
+ 49.287500000000001p 1.100958e-07 49.299999999999997p 9.0188190000000001e-08 49.3125p 7.0205990000000004e-08 49.325000000000003p 5.017538e-08 49.337499999999999p 3.0122539999999997e-08 49.350000000000001p 1.0073619999999999e-08 49.362499999999997p -9.9452540000000006e-09 49.375p -2.9908050000000002e-08 49.387500000000003p -4.9788839999999999e-08 49.399999999999999p -6.9561849999999996e-08 49.412500000000001p -8.9201489999999997e-08 49.424999999999997p -1.086824e-07 49.4375p -1.2797940000000001e-07 49.450000000000003p -1.470677e-07 49.462499999999999p -1.659226e-07 49.475000000000001p -1.8452010000000001e-07 49.487499999999997p -2.0283630000000001e-07 49.5p -2.208476e-07
+ 49.512500000000003p -2.3853130000000001e-07 49.524999999999999p -2.5586459999999997e-07 49.537500000000001p -2.7282560000000002e-07 49.549999999999997p -2.8939280000000002e-07 49.5625p -3.0554519999999999e-07 49.575000000000003p -3.2126229999999998e-07 49.587499999999999p -3.3652440000000002e-07 49.600000000000001p -3.5131240000000001e-07 49.612499999999997p -3.6560770000000002e-07 49.625p -3.7939239999999998e-07 49.637500000000003p -3.926495e-07 49.649999999999999p -4.053624e-07 49.662500000000001p -4.1751570000000001e-07 49.674999999999997p -4.2909419999999998e-07 49.6875p -4.4008400000000001e-07 49.700000000000003p -4.5047160000000002e-07 49.712499999999999p -4.6024460000000001e-07 49.725000000000001p -4.693913e-07
+ 49.737499999999997p -4.7790079999999995e-07 49.75p -4.8576319999999999e-07 49.762500000000003p -4.929693e-07 49.774999999999999p -4.9951100000000003e-07 49.787500000000001p -5.0538099999999996e-07 49.799999999999997p -5.1057280000000004e-07 49.8125p -5.1508090000000001e-07 49.825000000000003p -5.1890079999999996e-07 49.837499999999999p -5.2202880000000001e-07 49.850000000000001p -5.2446209999999997e-07 49.862499999999997p -5.2619900000000001e-07 49.875p -5.2723850000000001e-07 49.887500000000003p -5.2758079999999995e-07 49.899999999999999p -5.2722669999999998e-07 49.912500000000001p -5.2617829999999999e-07 49.924999999999997p -5.2443839999999997e-07 49.9375p -5.220107e-07 49.950000000000003p -5.1889980000000004e-07
+ 49.962499999999999p -5.1511140000000001e-07 49.975000000000001p -5.1065190000000005e-07 49.987499999999997p -5.055287e-07 50p -4.9974979999999997e-07 50.012499999999996p -4.9332459999999998e-07 50.025000000000006p -4.8626279999999995e-07 50.037500000000001p -4.7857509999999995e-07 50.049999999999997p -4.7027329999999999e-07 50.0625p -4.6136959999999999e-07 50.074999999999996p -4.518772e-07 50.087500000000006p -4.4180990000000002e-07 50.100000000000001p -4.3118249999999999e-07 50.112499999999997p -4.2001029999999999e-07 50.125p -4.0830929999999998e-07 50.137499999999996p -3.9609619999999999e-07 50.150000000000006p -3.8338850000000001e-07 50.162500000000001p -3.7020420000000001e-07 50.174999999999997p -3.5656169999999998e-07
+ 50.1875p -3.424804e-07 50.199999999999996p -3.2797980000000002e-07 50.212500000000006p -3.1308019999999998e-07 50.225000000000001p -2.978024e-07 50.237499999999997p -2.8216739999999998e-07 50.25p -2.6619690000000002e-07 50.262499999999996p -2.4991279999999999e-07 50.275000000000006p -2.3333750000000001e-07 50.287500000000001p -2.1649360000000001e-07 50.299999999999997p -1.9940419999999999e-07 50.3125p -1.820925e-07 50.324999999999996p -1.6458200000000001e-07 50.337499999999999p -1.468963e-07 50.350000000000001p -1.2905940000000001e-07 50.362500000000004p -1.110952e-07 50.375p -9.3027799999999993e-08 50.387499999999996p -7.4881449999999998e-08 50.399999999999999p -5.6680350000000001e-08
+ 50.412500000000001p -3.8448710000000003e-08 50.425000000000004p -2.0210750000000001e-08 50.4375p -1.990593e-09 50.449999999999996p 1.6187699999999999e-08 50.462499999999999p 3.4300189999999997e-08 50.475000000000001p 5.2323120000000003e-08 50.487500000000004p 7.0232890000000002e-08 50.5p 8.8006140000000006e-08 50.512499999999996p 1.056197e-07 50.524999999999999p 1.230508e-07 50.537500000000001p 1.4027689999999999e-07 50.550000000000004p 1.5727570000000001e-07 50.5625p 1.7402550000000001e-07 50.574999999999996p 1.9050480000000001e-07 50.587499999999999p 2.066925e-07 50.600000000000001p 2.225682e-07 50.612500000000004p 2.3811170000000001e-07 50.625p 2.5330329999999998e-07
+ 50.637499999999996p 2.6812409999999999e-07 50.649999999999999p 2.8255549999999999e-07 50.662500000000001p 2.965796e-07 50.675000000000004p 3.1017879999999998e-07 50.6875p 3.2333659999999998e-07 50.699999999999996p 3.3603680000000002e-07 50.712499999999999p 3.4826379999999999e-07 50.725000000000001p 3.6000300000000002e-07 50.737500000000004p 3.7123999999999998e-07 50.75p 3.8196159999999999e-07 50.762500000000003p 3.9215500000000001e-07 50.774999999999999p 4.018082e-07 50.787499999999994p 4.1091000000000002e-07 50.800000000000004p 4.1944990000000002e-07 50.8125p 4.2741819999999998e-07 50.825000000000003p 4.3480590000000002e-07 50.837499999999999p 4.4160490000000002e-07 50.849999999999994p 4.478078e-07
+ 50.862500000000004p 4.5340810000000002e-07 50.875p 4.5839989999999998e-07 50.887500000000003p 4.6277839999999999e-07 50.899999999999999p 4.665393e-07 50.912499999999994p 4.696794e-07 50.925000000000004p 4.7219609999999999e-07 50.9375p 4.740877e-07 50.950000000000003p 4.7535339999999998e-07 50.962499999999999p 4.7599309999999998e-07 50.974999999999994p 4.7600760000000001e-07 50.987500000000004p 4.7539830000000001e-07 51p 4.7416769999999999e-07 51.012500000000003p 4.7231880000000002e-07 51.024999999999999p 4.6985570000000002e-07 51.037499999999994p 4.6678310000000002e-07 51.050000000000004p 4.6310639999999999e-07 51.0625p 4.5883199999999999e-07 51.075000000000003p 4.5396680000000002e-07
+ 51.087499999999999p 4.485186e-07 51.100000000000001p 4.424959e-07 51.112499999999997p 4.3590799999999999e-07 51.125p 4.2876469999999999e-07 51.137500000000003p 4.2107660000000001e-07 51.149999999999999p 4.1285510000000002e-07 51.162500000000001p 4.0411209999999998e-07 51.174999999999997p 3.9486010000000002e-07 51.1875p 3.851125e-07 51.200000000000003p 3.7488290000000002e-07 51.212499999999999p 3.6418579999999999e-07 51.225000000000001p 3.5303609999999998e-07 51.237499999999997p 3.4144950000000002e-07 51.25p 3.2944189999999997e-07 51.262500000000003p 3.1702989999999998e-07 51.274999999999999p 3.0423049999999998e-07 51.287500000000001p 2.9106120000000003e-07 51.299999999999997p 2.7753999999999998e-07
+ 51.3125p 2.6368510000000001e-07 51.325000000000003p 2.4951540000000002e-07 51.337499999999999p 2.3504990000000001e-07 51.350000000000001p 2.203082e-07 51.362499999999997p 2.0530979999999999e-07 51.375p 1.9007500000000001e-07 51.387500000000003p 1.7462399999999999e-07 51.399999999999999p 1.5897730000000001e-07 51.412500000000001p 1.431558e-07 51.424999999999997p 1.271804e-07 51.4375p 1.110722e-07 51.450000000000003p 9.4852440000000003e-08 51.462499999999999p 7.8542479999999997e-08 51.475000000000001p 6.2163750000000006e-08 51.487499999999997p 4.5737719999999999e-08 51.5p 2.928589e-08 51.512500000000003p 1.2829769999999999e-08 51.524999999999999p -3.6091890000000001e-09
+ 51.537500000000001p -2.000958e-08 51.549999999999997p -3.635009e-08 51.5625p -5.2609499999999999e-08 51.575000000000003p -6.8766759999999999e-08 51.587499999999999p -8.480098e-08 51.600000000000001p -1.0069140000000001e-07 51.612499999999997p -1.164177e-07 51.625p -1.3195939999999999e-07 51.637500000000003p -1.472967e-07 51.649999999999999p -1.6241000000000001e-07 51.662500000000001p -1.7727970000000001e-07 51.674999999999997p -1.918871e-07 51.6875p -2.0621339999999999e-07 51.700000000000003p -2.2024039999999999e-07 51.712499999999999p -2.339503e-07 51.725000000000001p -2.4732579999999999e-07 51.737499999999997p -2.6034989999999998e-07 51.75p -2.7300630000000001e-07
+ 51.762500000000003p -2.852789e-07 51.774999999999999p -2.971525e-07 51.787500000000001p -3.086122e-07 51.799999999999997p -3.196437e-07 51.8125p -3.3023340000000001e-07 51.825000000000003p -3.4036810000000001e-07 51.837500000000006p -3.5003529999999997e-07 51.850000000000001p -3.5922330000000002e-07 51.862499999999997p -3.6792090000000001e-07 51.875p -3.7611749999999999e-07 51.887499999999996p -3.8380329999999999e-07 51.900000000000006p -3.9096909999999998e-07 51.912500000000001p -3.9760649999999998e-07 51.924999999999997p -4.0370769999999997e-07 51.9375p -4.0926559999999999e-07 51.949999999999996p -4.1427410000000001e-07 51.962500000000006p -4.1872739999999998e-07 51.975000000000001p -4.226208e-07
+ 51.987499999999997p -4.259503e-07 52p -4.287124e-07 52.012499999999996p -4.3090459999999998e-07 52.025000000000006p -4.3252509999999998e-07 52.037500000000001p -4.3357279999999998e-07 52.049999999999997p -4.3404749999999998e-07 52.0625p -4.3394970000000001e-07 52.074999999999996p -4.3328049999999999e-07 52.087500000000006p -4.3204190000000001e-07 52.100000000000001p -4.3023670000000001e-07 52.112499999999997p -4.278684e-07 52.125p -4.2494110000000001e-07 52.137499999999996p -4.2145990000000002e-07 52.150000000000006p -4.1743040000000002e-07 52.162500000000001p -4.1285910000000002e-07 52.174999999999997p -4.0775300000000001e-07 52.1875p -4.0211990000000001e-07 52.199999999999996p -3.9596839999999998e-07
+ 52.212499999999999p -3.8930760000000001e-07 52.225000000000001p -3.8214730000000002e-07 52.237500000000004p -3.7449810000000001e-07 52.25p -3.6637099999999999e-07 52.262499999999996p -3.5777769999999999e-07 52.274999999999999p -3.4873059999999998e-07 52.287500000000001p -3.3924249999999998e-07 52.300000000000004p -3.2932689999999998e-07 52.3125p -3.1899789999999999e-07 52.324999999999996p -3.082699e-07 52.337499999999999p -2.971579e-07 52.350000000000001p -2.8567739999999999e-07 52.362500000000004p -2.7384449999999999e-07 52.375p -2.6167549999999998e-07 52.387499999999996p -2.4918709999999999e-07 52.399999999999999p -2.3639669999999999e-07 52.412500000000001p -2.2332169999999999e-07 52.425000000000004p -2.0998e-07
+ 52.4375p -1.9638990000000001e-07 52.449999999999996p -1.8256990000000001e-07 52.462499999999999p -1.6853869999999999e-07 52.475000000000001p -1.5431529999999999e-07 52.487500000000004p -1.399189e-07 52.5p -1.2536910000000001e-07 52.512499999999996p -1.106852e-07 52.524999999999999p -9.5887019999999997e-08 52.537500000000001p -8.0994350000000003e-08 52.550000000000004p -6.6027049999999996e-08 52.5625p -5.1005059999999998e-08 52.574999999999996p -3.5948320000000001e-08 52.587499999999999p -2.0876780000000002e-08 52.600000000000001p -5.8103650000000001e-09 52.612500000000004p 9.2310630000000003e-09 52.625p 2.422772e-08 52.637500000000003p 3.9159940000000002e-08 52.649999999999999p 5.4008180000000001e-08
+ 52.662499999999994p 6.875306e-08 52.675000000000004p 8.3375390000000002e-08 52.6875p 9.7856190000000001e-08 52.700000000000003p 1.121767e-07 52.712499999999999p 1.2631849999999999e-07 52.724999999999994p 1.4026329999999999e-07 52.737500000000004p 1.5399320000000001e-07 52.75p 1.674907e-07 52.762500000000003p 1.8073859999999999e-07 52.774999999999999p 1.9372010000000001e-07 52.787499999999994p 2.064186e-07 52.800000000000004p 2.1881820000000001e-07 52.8125p 2.309032e-07 52.825000000000003p 2.4265859999999998e-07 52.837499999999999p 2.5406970000000002e-07 52.849999999999994p 2.6512240000000001e-07 52.862500000000004p 2.7580280000000001e-07 52.875p 2.8609809999999999e-07
+ 52.887500000000003p 2.9599539999999999e-07 52.899999999999999p 3.0548289999999999e-07 52.912499999999994p 3.1454899999999999e-07 52.925000000000004p 3.231829e-07 52.9375p 3.3137420000000002e-07 52.950000000000003p 3.3911329999999998e-07 52.962499999999999p 3.4639119999999998e-07 52.975000000000001p 3.5319940000000001e-07 52.987499999999997p 3.5953009999999998e-07 53p 3.6537609999999999e-07 53.012500000000003p 3.7073100000000001e-07 53.024999999999999p 3.7558890000000002e-07 53.037500000000001p 3.799447e-07 53.049999999999997p 3.8379379999999999e-07 53.0625p 3.8713240000000002e-07 53.075000000000003p 3.8995729999999998e-07 53.087499999999999p 3.9226609999999999e-07 53.100000000000001p 3.9405699999999999e-07
+ 53.112499999999997p 3.9532890000000001e-07 53.125p 3.960812e-07 53.137500000000003p 3.9631430000000001e-07 53.149999999999999p 3.9602900000000001e-07 53.162500000000001p 3.95227e-07 53.174999999999997p 3.9391039999999998e-07 53.1875p 3.9208219999999999e-07 53.200000000000003p 3.89746e-07 53.212499999999999p 3.8690590000000002e-07 53.225000000000001p 3.8356680000000003e-07 53.237499999999997p 3.7973430000000001e-07 53.25p 3.7541440000000002e-07 53.262500000000003p 3.7061390000000002e-07 53.274999999999999p 3.6534010000000001e-07 53.287500000000001p 3.5960099999999999e-07 53.299999999999997p 3.534051e-07 53.3125p 3.4676140000000001e-07 53.325000000000003p 3.3967970000000001e-07
+ 53.337499999999999p 3.3217019999999997e-07 53.350000000000001p 3.242434e-07 53.362499999999997p 3.1591080000000002e-07 53.375p 3.0718399999999998e-07 53.387500000000003p 2.9807529999999998e-07 53.399999999999999p 2.8859740000000002e-07 53.412500000000001p 2.787633e-07 53.424999999999997p 2.6858669999999999e-07 53.4375p 2.5808149999999998e-07 53.450000000000003p 2.4726219999999999e-07 53.462499999999999p 2.3614339999999999e-07 53.475000000000001p 2.2474029999999999e-07 53.487499999999997p 2.1306840000000001e-07 53.5p 2.0114329999999999e-07 53.512500000000003p 1.8898110000000001e-07 53.524999999999999p 1.7659819999999999e-07 53.537500000000001p 1.6401120000000001e-07 53.549999999999997p 1.5123680000000001e-07
+ 53.5625p 1.3829200000000001e-07 53.575000000000003p 1.2519409999999999e-07 53.587499999999999p 1.119604e-07 53.600000000000001p 9.86084e-08 53.612499999999997p 8.5155760000000001e-08 53.625p 7.1620180000000007e-08 53.637500000000003p 5.8019450000000003e-08 53.649999999999999p 4.4371409999999999e-08 53.662500000000001p 3.0693930000000001e-08 53.674999999999997p 1.700489e-08 53.6875p 3.3221219999999999e-09 53.700000000000003p -1.0336550000000001e-08 53.712500000000006p -2.3953380000000002e-08 53.725000000000001p -3.7510709999999998e-08 53.737499999999997p -5.0991000000000003e-08 53.75p -6.437683e-08 53.762499999999996p -7.7650940000000006e-08 53.775000000000006p -9.0796249999999995e-08
+ 53.787500000000001p -1.0379590000000001e-07 53.799999999999997p -1.166331e-07 53.8125p -1.292916e-07 53.824999999999996p -1.417552e-07 53.837500000000006p -1.5400789999999999e-07 53.850000000000001p -1.6603429999999999e-07 53.862499999999997p -1.7781900000000001e-07 53.875p -1.8934719999999999e-07 53.887499999999996p -2.0060429999999999e-07 53.900000000000006p -2.1157610000000001e-07 53.912500000000001p -2.222489e-07 53.924999999999997p -2.3260929999999999e-07 53.9375p -2.4264439999999998e-07 53.949999999999996p -2.5234180000000001e-07 53.962500000000006p -2.6168930000000001e-07 53.975000000000001p -2.7067550000000002e-07 53.987499999999997p -2.792894e-07 54p -2.8752039999999999e-07
+ 54.012499999999996p -2.9535849999999998e-07 54.025000000000006p -3.0279420000000002e-07 54.037500000000001p -3.0981860000000001e-07 54.049999999999997p -3.1642340000000002e-07 54.0625p -3.226006e-07 54.074999999999996p -3.2834310000000001e-07 54.087499999999999p -3.336443e-07 54.100000000000001p -3.3849800000000002e-07 54.112500000000004p -3.4289880000000002e-07 54.125p -3.4684190000000001e-07 54.137499999999996p -3.5032300000000001e-07 54.149999999999999p -3.5333839999999998e-07 54.162500000000001p -3.558852e-07 54.175000000000004p -3.5796099999999999e-07 54.1875p -3.5956399999999998e-07 54.199999999999996p -3.606931e-07 54.212499999999999p -3.6134770000000001e-07 54.225000000000001p -3.6152810000000003e-07
+ 54.237500000000004p -3.612349e-07 54.25p -3.6046939999999999e-07 54.262499999999996p -3.5923379999999999e-07 54.274999999999999p -3.5753050000000001e-07 54.287500000000001p -3.5536280000000002e-07 54.300000000000004p -3.5273460000000002e-07 54.3125p -3.496501e-07 54.324999999999996p -3.4611459999999998e-07 54.337499999999999p -3.4213340000000001e-07 54.350000000000001p -3.3771290000000001e-07 54.362500000000004p -3.328597e-07 54.375p -3.2758119999999998e-07 54.387499999999996p -3.2188509999999999e-07 54.399999999999999p -3.1577999999999999e-07 54.412500000000001p -3.0927470000000002e-07 54.425000000000004p -3.023785e-07 54.4375p -2.9510149999999998e-07 54.449999999999996p -2.87454e-07
+ 54.462499999999999p -2.7944690000000001e-07 54.475000000000001p -2.7109140000000002e-07 54.487500000000004p -2.6239940000000001e-07 54.5p -2.5338299999999999e-07 54.512500000000003p -2.4405470000000002e-07 54.524999999999999p -2.344275e-07 54.537499999999994p -2.2451480000000001e-07 54.550000000000004p -2.143302e-07 54.5625p -2.0388760000000001e-07 54.575000000000003p -1.932015e-07 54.587499999999999p -1.822863e-07 54.599999999999994p -1.7115690000000001e-07 54.612500000000004p -1.5982850000000001e-07 54.625p -1.4831640000000001e-07 54.637500000000003p -1.366361e-07 54.649999999999999p -1.2480330000000001e-07 54.662499999999994p -1.128339e-07 54.675000000000004p -1.0074400000000001e-07
+ 54.6875p -8.8549719999999999e-08 54.700000000000003p -7.6267270000000004e-08 54.712499999999999p -6.3913009999999995e-08 54.724999999999994p -5.1503310000000001e-08 54.737500000000004p -3.905458e-08 54.75p -2.6583240000000001e-08 54.762500000000003p -1.4105709999999999e-08 54.774999999999999p -1.6383580000000001e-09 54.787499999999994p 1.0802480000000001e-08 54.800000000000004p 2.3200559999999999e-08 54.8125p 3.5539740000000002e-08 54.825000000000003p 4.7803969999999999e-08 54.837499999999999p 5.9977379999999997e-08 54.850000000000001p 7.2044219999999997e-08 54.862499999999997p 8.3988950000000002e-08 54.875p 9.5796200000000004e-08 54.887500000000003p 1.074509e-07 54.899999999999999p 1.18938e-07
+ 54.912500000000001p 1.302431e-07 54.924999999999997p 1.4135160000000001e-07 54.9375p 1.522497e-07 54.950000000000003p 1.629234e-07 54.962499999999999p 1.7335940000000001e-07 54.975000000000001p 1.8354469999999999e-07 54.987499999999997p 1.9346650000000001e-07 55p 2.0311239999999999e-07 55.012500000000003p 2.124706e-07 55.024999999999999p 2.2152950000000001e-07 55.037500000000001p 2.3027799999999999e-07 55.049999999999997p 2.3870539999999999e-07 55.0625p 2.4680159999999999e-07 55.075000000000003p 2.5455660000000003e-07 55.087499999999999p 2.619613e-07 55.100000000000001p 2.6900689999999998e-07 55.112499999999997p 2.7568489999999998e-07 55.125p 2.8198770000000002e-07
+ 55.137500000000003p 2.879078e-07 55.149999999999999p 2.9343839999999998e-07 55.162500000000001p 2.985734e-07 55.174999999999997p 3.0330690000000001e-07 55.1875p 3.0763379999999998e-07 55.200000000000003p 3.1154949999999999e-07 55.212499999999999p 3.1504969999999998e-07 55.225000000000001p 3.1813089999999999e-07 55.237499999999997p 3.2079019999999999e-07 55.25p 3.2302500000000002e-07 55.262500000000003p 3.2483360000000001e-07 55.274999999999999p 3.2621450000000003e-07 55.287500000000001p 3.2716690000000002e-07 55.299999999999997p 3.2769069999999999e-07 55.3125p 3.2778619999999998e-07 55.325000000000003p 3.2745430000000002e-07 55.337499999999999p 3.266964e-07 55.350000000000001p 3.2551460000000002e-07
+ 55.362499999999997p 3.239113e-07 55.375p 3.2188960000000001e-07 55.387500000000003p 3.1945319999999998e-07 55.399999999999999p 3.1660620000000001e-07 55.412500000000001p 3.1335329999999999e-07 55.424999999999997p 3.0969960000000001e-07 55.4375p 3.0565079999999998e-07 55.450000000000003p 3.012131e-07 55.462499999999999p 2.9639329999999998e-07 55.475000000000001p 2.9119829999999999e-07 55.487499999999997p 2.8563590000000001e-07 55.5p 2.797142e-07 55.512500000000003p 2.7344149999999998e-07 55.524999999999999p 2.6682709999999998e-07 55.537500000000001p 2.5988010000000001e-07 55.549999999999997p 2.5261040000000001e-07 55.5625p 2.450282e-07 55.575000000000003p 2.3714409999999999e-07
+ 55.587500000000006p 2.289689e-07 55.600000000000001p 2.2051400000000001e-07 55.612499999999997p 2.1179110000000001e-07 55.625p 2.02812e-07 55.637499999999996p 1.93589e-07 55.650000000000006p 1.8413460000000001e-07 55.662500000000001p 1.7446180000000001e-07 55.674999999999997p 1.645835e-07 55.6875p 1.5451309999999999e-07 55.699999999999996p 1.4426409999999999e-07 55.712500000000006p 1.3385020000000001e-07 55.725000000000001p 1.232854e-07 55.737499999999997p 1.125838e-07 55.75p 1.017596e-07 55.762499999999996p 9.0827100000000002e-08 55.775000000000006p 7.9800889999999999e-08 55.787500000000001p 6.8695520000000001e-08 55.799999999999997p 5.752562e-08
+ 55.8125p 4.6305899999999999e-08 55.824999999999996p 3.5051099999999999e-08 55.837500000000006p 2.3775980000000001e-08 55.850000000000001p 1.249528e-08 55.862499999999997p 1.2237450000000001e-09 55.875p -1.002394e-08 55.887499999999996p -2.123315e-08 55.899999999999999p -3.2389329999999999e-08 55.912500000000001p -4.3478009999999997e-08 55.924999999999997p -5.4484869999999999e-08 55.9375p -6.5395699999999996e-08 55.949999999999996p -7.6196449999999994e-08 55.962499999999999p -8.6873220000000004e-08 55.975000000000001p -9.7412340000000002e-08 55.987500000000004p -1.078003e-07 56p -1.1802390000000001e-07 56.012499999999996p -1.2807000000000001e-07 56.024999999999999p -1.3792589999999999e-07
+ 56.037500000000001p -1.4757909999999999e-07 56.050000000000004p -1.570175e-07 56.0625p -1.66229e-07 56.074999999999996p -1.752021e-07 56.087499999999999p -1.8392560000000001e-07 56.100000000000001p -1.9238859999999999e-07 56.112500000000004p -2.0058059999999999e-07 56.125p -2.0849129999999999e-07 56.137499999999996p -2.16111e-07 56.149999999999999p -2.234304e-07 56.162500000000001p -2.3044040000000001e-07 56.175000000000004p -2.3713259999999999e-07 56.1875p -2.4349890000000001e-07 56.199999999999996p -2.4953149999999997e-07 56.212499999999999p -2.5522339999999998e-07 56.225000000000001p -2.6056780000000002e-07 56.237500000000004p -2.6555829999999998e-07 56.25p -2.7018920000000002e-07
+ 56.262499999999996p -2.7445529999999998e-07 56.274999999999999p -2.7835159999999998e-07 56.287500000000001p -2.8187399999999997e-07 56.300000000000004p -2.8501850000000001e-07 56.3125p -2.8778180000000002e-07 56.324999999999996p -2.901613e-07 56.337499999999999p -2.921545e-07 56.350000000000001p -2.9375969999999998e-07 56.362500000000004p -2.9497569999999998e-07 56.375p -2.9580170000000001e-07 56.387500000000003p -2.9623749999999999e-07 56.399999999999999p -2.962834e-07 56.412499999999994p -2.9594030000000002e-07 56.425000000000004p -2.9520930000000001e-07 56.4375p -2.9409250000000002e-07 56.450000000000003p -2.92592e-07 56.462499999999999p -2.9071079999999998e-07 56.474999999999994p -2.8845220000000001e-07
+ 56.487500000000004p -2.8582009999999999e-07 56.5p -2.8281869999999998e-07 56.512500000000003p -2.7945280000000002e-07 56.524999999999999p -2.7572780000000001e-07 56.537499999999994p -2.7164940000000002e-07 56.550000000000004p -2.6722370000000001e-07 56.5625p -2.6245739999999997e-07 56.575000000000003p -2.5735750000000001e-07 56.587499999999999p -2.5193159999999999e-07 56.599999999999994p -2.4618759999999999e-07 56.612500000000004p -2.4013379999999999e-07 56.625p -2.337789e-07 56.637500000000003p -2.27132e-07 56.649999999999999p -2.2020249999999999e-07 56.662499999999994p -2.1300029999999999e-07 56.675000000000004p -2.0553550000000001e-07 56.6875p -1.9781860000000001e-07 56.700000000000003p -1.8986030000000001e-07
+ 56.712499999999999p -1.8167170000000001e-07 56.725000000000001p -1.732641e-07 56.737499999999997p -1.6464930000000001e-07 56.75p -1.558389e-07 56.762500000000003p -1.468452e-07 56.774999999999999p -1.3768039999999999e-07 56.787500000000001p -1.2835699999999999e-07 56.799999999999997p -1.188877e-07 56.8125p -1.0928530000000001e-07 56.825000000000003p -9.9562789999999995e-08 56.837499999999999p -8.973331e-08 56.850000000000001p -7.9810039999999998e-08 56.862499999999997p -6.98063e-08 56.875p -5.973546e-08 56.887500000000003p -4.9610949999999997e-08 56.899999999999999p -3.9446230000000002e-08 56.912500000000001p -2.9254799999999999e-08 56.924999999999997p -1.905014e-08
+ 56.9375p -8.8457079999999998e-09 56.950000000000003p 1.345059e-09 56.962499999999999p 1.150878e-08 56.975000000000001p 2.1632159999999999e-08 56.987499999999997p 3.1701969999999999e-08 57p 4.1705100000000001e-08 57.012500000000003p 5.1628570000000001e-08 57.024999999999999p 6.1459510000000005e-08 57.037500000000001p 7.1185250000000005e-08 57.049999999999997p 8.0793260000000004e-08 57.0625p 9.0271209999999996e-08 57.075000000000003p 9.9606979999999993e-08 57.087499999999999p 1.087886e-07 57.100000000000001p 1.1780460000000001e-07 57.112499999999997p 1.2664330000000001e-07 57.125p 1.352936e-07 57.137500000000003p 1.4374480000000001e-07 57.149999999999999p 1.5198609999999999e-07
+ 57.162500000000001p 1.6000740000000001e-07 57.174999999999997p 1.6779849999999999e-07 57.1875p 1.7534999999999999e-07 57.200000000000003p 1.8265240000000001e-07 57.212499999999999p 1.8969689999999999e-07 57.225000000000001p 1.964749e-07 57.237499999999997p 2.029781e-07 57.25p 2.0919880000000001e-07 57.262500000000003p 2.1512939999999999e-07 57.274999999999999p 2.20763e-07 57.287500000000001p 2.2609289999999999e-07 57.299999999999997p 2.3111289999999999e-07 57.3125p 2.3581720000000001e-07 57.325000000000003p 2.4020040000000002e-07 57.337499999999999p 2.4425770000000001e-07 57.350000000000001p 2.4798449999999999e-07 57.362499999999997p 2.5137670000000001e-07 57.375p 2.5443080000000003e-07
+ 57.387500000000003p 2.5714360000000002e-07 57.399999999999999p 2.595124e-07 57.412500000000001p 2.6153489999999997e-07 57.424999999999997p 2.6320950000000003e-07 57.4375p 2.645347e-07 57.450000000000003p 2.6550959999999998e-07 57.462500000000006p 2.6613400000000002e-07 57.475000000000001p 2.6640769999999998e-07 57.487499999999997p 2.6633140000000003e-07 57.5p 2.6590589999999998e-07 57.512499999999996p 2.6513269999999999e-07 57.525000000000006p 2.6401359999999998e-07 57.537500000000001p 2.6255100000000001e-07 57.549999999999997p 2.6074749999999999e-07 57.5625p 2.5860639999999998e-07 57.574999999999996p 2.5613120000000002e-07 57.587500000000006p 2.53326e-07 57.600000000000001p 2.5019520000000001e-07
+ 57.612499999999997p 2.4674370000000003e-07 57.625p 2.4297680000000001e-07 57.637499999999996p 2.3890009999999999e-07 57.650000000000006p 2.3451970000000001e-07 57.662500000000001p 2.29842e-07 57.674999999999997p 2.2487379999999999e-07 57.6875p 2.1962230000000001e-07 57.699999999999996p 2.1409489999999999e-07 57.712500000000006p 2.082997e-07 57.725000000000001p 2.022446e-07 57.737499999999997p 1.9593829999999999e-07 57.75p 1.8938949999999999e-07 57.762499999999996p 1.8260729999999999e-07 57.774999999999999p 1.756012e-07 57.787500000000001p 1.6838079999999999e-07 57.799999999999997p 1.60956e-07 57.8125p 1.533369e-07 57.824999999999996p 1.4553400000000001e-07
+ 57.837499999999999p 1.375579e-07 57.850000000000001p 1.2941930000000001e-07 57.862500000000004p 1.2112920000000001e-07 57.875p 1.126989e-07 57.887499999999996p 1.041396e-07 57.899999999999999p 9.5462779999999995e-08 57.912500000000001p 8.6680109999999995e-08 57.925000000000004p 7.7803260000000002e-08 57.9375p 6.884405e-08 57.949999999999996p 5.9814379999999998e-08 57.962499999999999p 5.0726199999999998e-08 57.975000000000001p 4.1591530000000002e-08 57.987500000000004p 3.2422419999999999e-08 58p 2.3230949999999999e-08 58.012499999999996p 1.402919e-08 58.024999999999999p 4.8292070000000004e-09 58.037500000000001p -4.3569500000000003e-09 58.050000000000004p -1.3517289999999999e-08
+ 58.0625p -2.2639850000000001e-08 58.074999999999996p -3.1712779999999997e-08 58.087499999999999p -4.0724279999999998e-08 58.100000000000001p -4.9662680000000003e-08 58.112500000000004p -5.8516409999999998e-08 58.125p -6.727403e-08 58.137499999999996p -7.5924269999999999e-08 58.149999999999999p -8.4455990000000002e-08 58.162500000000001p -9.285826e-08 58.175000000000004p -1.011203e-07 58.1875p -1.092316e-07 58.199999999999996p -1.1718169999999999e-07 58.212499999999991p -1.249607e-07 58.225000000000001p -1.325585e-07 58.237500000000004p -1.3996569999999999e-07 58.250000000000007p -1.4717280000000001e-07 58.262499999999996p -1.5417089999999999e-07 58.274999999999999p -1.60951e-07
+ 58.287500000000001p -1.6750480000000001e-07 58.299999999999997p -1.7382419999999999e-07 58.3125p -1.799012e-07 58.325000000000003p -1.8572830000000001e-07 58.337499999999991p -1.9129850000000001e-07 58.349999999999994p -1.9660489999999999e-07 58.362500000000004p -2.01641e-07 58.375000000000007p -2.0640080000000001e-07 58.387499999999996p -2.108786e-07 58.399999999999999p -2.15069e-07 58.412500000000001p -2.1896719999999999e-07 58.424999999999997p -2.225685e-07 58.4375p -2.2586880000000001e-07 58.450000000000003p -2.2886449999999999e-07 58.462500000000006p -2.315521e-07 58.474999999999994p -2.3392879999999999e-07 58.487500000000004p -2.3599200000000001e-07 58.500000000000007p -2.3773970000000001e-07
+ 58.512499999999996p -2.3917019999999997e-07 58.524999999999999p -2.4028230000000001e-07 58.537500000000001p -2.410751e-07 58.549999999999997p -2.4154840000000001e-07 58.5625p -2.41702e-07 58.575000000000003p -2.4153659999999998e-07 58.587500000000006p -2.410528e-07 58.599999999999994p -2.4025209999999999e-07 58.612499999999997p -2.3913619999999999e-07 58.625000000000007p -2.3770720000000001e-07 58.637499999999996p -2.359675e-07 58.649999999999999p -2.339203e-07 58.662500000000001p -2.315687e-07 58.674999999999997p -2.2891670000000001e-07 58.6875p -2.2596820000000001e-07 58.700000000000003p -2.227278e-07 58.712500000000006p -2.192004e-07 58.724999999999994p -2.153913e-07
+ 58.737499999999997p -2.1130609999999999e-07 58.750000000000007p -2.069508e-07 58.762499999999996p -2.0233170000000001e-07 58.774999999999999p -1.974555e-07 58.787500000000001p -1.9232920000000001e-07 58.800000000000004p -1.8696e-07 58.8125p -1.813557e-07 58.825000000000003p -1.75524e-07 58.837500000000006p -1.694733e-07 58.849999999999994p -1.632119e-07 58.862499999999997p -1.5674869999999999e-07 58.875p -1.5009250000000001e-07 58.887499999999996p -1.4325269999999999e-07 58.899999999999999p -1.3623860000000001e-07 58.912500000000001p -1.290599e-07 58.925000000000004p -1.2172640000000001e-07 58.9375p -1.142482e-07 58.950000000000003p -1.066355e-07
+ 58.962500000000006p -9.8898580000000003e-08 58.974999999999994p -9.1047989999999999e-08 58.987499999999997p -8.3094350000000002e-08 59p -7.504838e-08 59.012499999999996p -6.6920930000000005e-08 59.024999999999999p -5.872289e-08 59.037500000000001p -5.0465259999999999e-08 59.050000000000004p -4.215908e-08 59.062499999999993p -3.3815419999999997e-08 59.075000000000003p -2.5445369999999999e-08 59.087500000000006p -1.7060060000000001e-08 59.099999999999994p -8.6705669999999996e-09 59.112499999999997p -2.8798630000000001e-10 59.125p 8.0766399999999995e-09 59.13750000000001p 1.6412320000000001e-08 59.149999999999999p 2.470812e-08 59.162500000000001p 3.2953180000000002e-08 59.175000000000004p 4.1136760000000003e-08
+ 59.187499999999993p 4.9248200000000003e-08 59.200000000000003p 5.7276970000000001e-08 59.212500000000006p 6.5212679999999994e-08 59.224999999999994p 7.3045070000000006e-08 59.237499999999997p 8.0764069999999997e-08 59.25p 8.8359770000000005e-08 59.262500000000003p 9.5822440000000004e-08 59.274999999999999p 1.031426e-07 59.287500000000001p 1.103108e-07 59.300000000000004p 1.173181e-07 59.312499999999993p 1.241556e-07 59.325000000000003p 1.3081469999999999e-07 59.337500000000006p 1.37287e-07 59.349999999999994p 1.4356449999999999e-07 59.362499999999997p 1.4963930000000001e-07 59.375p 1.555039e-07 59.387500000000003p 1.611511e-07 59.399999999999999p 1.665739e-07
+ 59.412500000000001p 1.7176590000000001e-07 59.425000000000004p 1.767205e-07 59.437499999999993p 1.8143200000000001e-07 59.449999999999996p 1.8589470000000001e-07 59.462500000000006p 1.901032e-07 59.474999999999994p 1.9405269999999999e-07 59.487499999999997p 1.9773850000000001e-07 59.5p 2.0115649999999999e-07 59.512500000000003p 2.043027e-07 59.524999999999999p 2.071736e-07 59.537500000000001p 2.0976609999999999e-07 59.550000000000004p 2.1207749999999999e-07 59.562499999999993p 2.141053e-07 59.574999999999996p 2.1584759999999999e-07 59.587500000000006p 2.1730269999999999e-07 59.600000000000009p 2.184693e-07 59.612499999999997p 2.1934670000000001e-07 59.625p 2.199342e-07
+ 59.637500000000003p 2.202318e-07 59.649999999999999p 2.2023980000000001e-07 59.662500000000001p 2.1995869999999999e-07 59.675000000000004p 2.193897e-07 59.687499999999993p 2.1853410000000001e-07 59.699999999999996p 2.173936e-07 59.712499999999999p 2.1597050000000001e-07 59.725000000000009p 2.1426720000000001e-07 59.737499999999997p 2.1228650000000001e-07 59.75p 2.1003170000000001e-07 59.762500000000003p 2.075064e-07 59.774999999999999p 2.0471440000000001e-07 59.787500000000001p 2.016599e-07 59.800000000000004p 1.983476e-07 59.812499999999993p 1.947824e-07 59.824999999999996p 1.9096950000000001e-07 59.837499999999999p 1.8691430000000001e-07 59.850000000000009p 1.826228e-07
+ 59.862499999999997p 1.7810110000000001e-07 59.875p 1.7335549999999999e-07 59.887500000000003p 1.683929e-07 59.899999999999991p 1.6322e-07 59.912500000000001p 1.578442e-07 59.925000000000004p 1.5227290000000001e-07 59.937500000000007p 1.465138e-07 59.949999999999996p 1.4057479999999999e-07 59.962499999999999p 1.344641e-07 59.975000000000001p 1.2819000000000001e-07 59.987499999999997p 1.2176120000000001e-07 60p 1.1518619999999999e-07 60.012500000000003p 1.08474e-07 60.024999999999991p 1.0163370000000001e-07 60.037500000000001p 9.4674409999999996e-08 60.050000000000004p 8.7605560000000002e-08 60.062500000000007p 8.0436580000000006e-08 60.074999999999996p 7.317706e-08
+ 60.087499999999999p 6.5836649999999997e-08 60.100000000000001p 5.8425120000000001e-08 60.112499999999997p 5.0952300000000002e-08 60.125p 4.3428080000000003e-08 60.137500000000003p 3.5862389999999999e-08 60.149999999999991p 2.8265209999999999e-08 60.162499999999994p 2.0646519999999999e-08 60.175000000000004p 1.301632e-08 60.187500000000007p 5.3846149999999996e-09 60.199999999999996p -2.2386289999999998e-09 60.212499999999999p -9.8434669999999992e-09 60.225000000000001p -1.742e-08 60.237499999999997p -2.495837e-08 60.25p -3.2448819999999997e-08 60.262500000000003p -3.988165e-08 60.275000000000006p -4.7247260000000003e-08 60.287499999999994p -5.4536159999999998e-08 60.300000000000004p -6.1738970000000005e-08
+ 60.312500000000007p -6.8846449999999998e-08 60.324999999999996p -7.5849499999999994e-08 60.337499999999999p -8.2739170000000005e-08 60.350000000000001p -8.9506670000000003e-08 60.362499999999997p -9.6143409999999994e-08 60.375p -1.02641e-07 60.387500000000003p -1.0899110000000001e-07 60.400000000000006p -1.151858e-07 60.412499999999994p -1.212173e-07 60.425000000000004p -1.2707809999999999e-07 60.437500000000007p -1.327607e-07 60.449999999999996p -1.3825810000000001e-07 60.462499999999999p -1.4356349999999999e-07 60.475000000000001p -1.4867039999999999e-07 60.487499999999997p -1.535723e-07 60.5p -1.5826339999999999e-07 60.512500000000003p -1.6273789999999999e-07 60.525000000000006p -1.6699040000000001e-07
+ 60.537499999999994p -1.710157e-07 60.549999999999997p -1.7480910000000001e-07 60.562500000000007p -1.7836590000000001e-07 60.574999999999996p -1.8168209999999999e-07 60.587499999999999p -1.847538e-07 60.600000000000001p -1.8757740000000001e-07 60.612499999999997p -1.9014969999999999e-07 60.625p -1.9246790000000001e-07 60.637500000000003p -1.945295e-07 60.650000000000006p -1.9633210000000001e-07 60.662499999999994p -1.9787410000000001e-07 60.674999999999997p -1.9915389999999999e-07 60.687500000000007p -2.001703e-07 60.699999999999996p -2.0092260000000001e-07 60.712499999999999p -2.0141020000000001e-07 60.725000000000001p -2.016332e-07 60.737500000000004p -2.0159169999999999e-07 60.75p -2.012863e-07
+ 60.762500000000003p -2.0071789999999999e-07 60.775000000000006p -1.998879e-07 60.787499999999994p -1.9879779999999999e-07 60.799999999999997p -1.9744959999999999e-07 60.8125p -1.958456e-07 60.824999999999996p -1.939884e-07 60.837499999999999p -1.91881e-07 60.850000000000001p -1.8952660000000001e-07 60.862500000000004p -1.869289e-07 60.875p -1.8409179999999999e-07 60.887500000000003p -1.8101940000000001e-07 60.900000000000006p -1.777163e-07 60.912499999999994p -1.7418720000000001e-07 60.924999999999997p -1.704374e-07 60.9375p -1.664721e-07 60.949999999999996p -1.6229699999999999e-07 60.962499999999999p -1.5791809999999999e-07 60.975000000000001p -1.5334139999999999e-07
+ 60.987500000000004p -1.4857340000000001e-07 60.999999999999993p -1.436208e-07 61.012500000000003p -1.3849050000000001e-07 61.025000000000006p -1.331895e-07 61.037499999999994p -1.2772510000000001e-07 61.049999999999997p -1.2210499999999999e-07 61.0625p -1.163366e-07 61.075000000000003p -1.1042809999999999e-07 61.087499999999999p -1.043873e-07 61.100000000000001p -9.8222559999999998e-08 61.112500000000004p -9.1942139999999995e-08 61.124999999999993p -8.5554549999999996e-08 61.137500000000003p -7.9068380000000006e-08 61.150000000000006p -7.2492370000000004e-08 61.162499999999994p -6.5835310000000006e-08 61.174999999999997p -5.9106119999999999e-08 61.1875p -5.2313759999999997e-08 61.200000000000003p -4.5467269999999999e-08
+ 61.212499999999999p -3.8575750000000001e-08 61.225000000000001p -3.1648320000000003e-08 61.237500000000004p -2.4694140000000001e-08 61.249999999999993p -1.772238e-08 61.262499999999996p -1.07422e-08 61.275000000000006p -3.7627770000000004e-09 61.287499999999994p 3.206758e-09 61.299999999999997p 1.0157299999999999e-08 61.3125p 1.7079780000000001e-08 61.325000000000003p 2.3965200000000001e-08 61.337499999999999p 3.0804629999999998e-08 61.350000000000001p 3.7589219999999997e-08 61.362500000000004p 4.4310200000000002e-08 61.374999999999993p 5.0958929999999997e-08 61.387499999999996p 5.7526850000000001e-08 61.400000000000006p 6.4005560000000003e-08 61.412500000000009p 7.0386780000000003e-08 61.424999999999997p 7.6662369999999994e-08
+ 61.4375p 8.2824359999999997e-08 61.450000000000003p 8.8864949999999999e-08 61.462499999999999p 9.4776509999999998e-08 61.475000000000001p 1.005516e-07 61.487500000000004p 1.0618300000000001e-07 61.499999999999993p 1.116636e-07 61.512499999999996p 1.1698660000000001e-07 61.524999999999999p 1.2214540000000001e-07 61.537500000000009p 1.271337e-07 61.549999999999997p 1.3194530000000001e-07 61.5625p 1.365742e-07 61.575000000000003p 1.41015e-07 61.587499999999999p 1.452622e-07 61.600000000000001p 1.4931060000000001e-07 61.612500000000004p 1.5315550000000001e-07 61.624999999999993p 1.567923e-07 61.637499999999996p 1.6021670000000001e-07 61.649999999999999p 1.6342469999999999e-07
+ 61.662500000000009p 1.664126e-07 61.674999999999997p 1.691771e-07 61.6875p 1.7171490000000001e-07 61.700000000000003p 1.7402339999999999e-07 61.712499999999991p 1.760999e-07 61.725000000000001p 1.7794239999999999e-07 61.737500000000004p 1.7954899999999999e-07 61.749999999999993p 1.8091800000000001e-07 61.762499999999996p 1.820482e-07 61.774999999999999p 1.8293880000000001e-07 61.787500000000009p 1.8358899999999999e-07 61.799999999999997p 1.8399860000000001e-07 61.8125p 1.8416759999999999e-07 61.825000000000003p 1.8409630000000001e-07 61.837499999999991p 1.837853e-07 61.850000000000001p 1.8323559999999999e-07 61.862500000000004p 1.8244839999999999e-07 61.875000000000007p 1.814253e-07
+ 61.887499999999996p 1.8016809999999999e-07 61.899999999999999p 1.786791e-07 61.912500000000001p 1.769606e-07 61.924999999999997p 1.750154e-07 61.9375p 1.7284659999999999e-07 61.950000000000003p 1.7045749999999999e-07 61.962499999999991p 1.6785170000000001e-07 61.975000000000001p 1.6503299999999999e-07 61.987500000000004p 1.620057e-07 62.000000000000007p 1.5877399999999999e-07 62.012499999999996p 1.5534280000000001e-07 62.024999999999999p 1.5171689999999999e-07 62.037500000000001p 1.4790139999999999e-07 62.049999999999997p 1.439018e-07 62.0625p 1.3972370000000001e-07 62.075000000000003p 1.3537279999999999e-07 62.087499999999991p 1.3085529999999999e-07 62.099999999999994p 1.2617749999999999e-07
+ 62.112500000000004p 1.213457e-07 62.125000000000007p 1.163665e-07 62.137499999999996p 1.112469e-07 62.149999999999999p 1.0599380000000001e-07 62.162500000000001p 1.006142e-07 62.174999999999997p 9.5115639999999994e-08 62.1875p 8.9505360000000002e-08 62.200000000000003p 8.3790969999999996e-08 62.212500000000006p 7.7980140000000006e-08 62.224999999999994p 7.2080660000000006e-08 62.237500000000004p 6.6100409999999995e-08 62.250000000000007p 6.0047360000000004e-08 62.262499999999996p 5.3929550000000003e-08 62.274999999999999p 4.7755099999999999e-08 62.287500000000001p 4.1532189999999999e-08 62.299999999999997p 3.5269040000000003e-08 62.3125p 2.897388e-08 62.325000000000003p 2.265501e-08
+ 62.337500000000006p 1.6320700000000001e-08 62.349999999999994p 9.9792649999999997e-09 62.362499999999997p 3.6389739999999999e-09 62.375000000000007p -2.6919029999999999e-09 62.387499999999996p -9.0051300000000003e-09 62.399999999999999p -1.5292509999999999e-08 62.412500000000001p -2.1545900000000001e-08 62.424999999999997p -2.7757219999999999e-08 62.4375p -3.3918449999999998e-08 62.450000000000003p -4.0021659999999997e-08 62.462500000000006p -4.6059020000000002e-08 62.474999999999994p -5.2022790000000001e-08 62.487499999999997p -5.790535e-08 62.500000000000007p -6.3699200000000004e-08 62.512499999999996p -6.9396970000000006e-08 62.524999999999999p -7.4991429999999998e-08 62.537500000000001p -8.0475499999999998e-08 62.550000000000004p -8.5842259999999999e-08
+ 62.5625p -9.1084959999999999e-08 62.575000000000003p -9.6197030000000001e-08 62.587500000000006p -1.0117210000000001e-07 62.599999999999994p -1.060039e-07 62.612499999999997p -1.106865e-07 62.625p -1.1521409999999999e-07 62.637499999999996p -1.1958110000000001e-07 62.649999999999999p -1.2378210000000001e-07 62.662500000000001p -1.278121e-07 62.675000000000004p -1.3166619999999999e-07 62.6875p -1.353396e-07 62.700000000000003p -1.38828e-07 62.712500000000006p -1.4212729999999999e-07 62.724999999999994p -1.452335e-07 62.737499999999997p -1.4814300000000001e-07 62.75p -1.5085249999999999e-07 62.762499999999996p -1.5335880000000001e-07 62.774999999999999p -1.556591e-07
+ 62.787500000000001p -1.5775099999999999e-07 62.800000000000004p -1.5963200000000001e-07 62.812499999999993p -1.6130020000000001e-07 62.825000000000003p -1.6275390000000001e-07 62.837500000000006p -1.6399179999999999e-07 62.849999999999994p -1.650126e-07 62.862499999999997p -1.6581549999999999e-07 62.875p -1.6639989999999999e-07 62.88750000000001p -1.667656e-07 62.899999999999999p -1.669127e-07 62.912500000000001p -1.6684130000000001e-07 62.925000000000004p -1.6655220000000001e-07 62.937499999999993p -1.660461e-07 62.950000000000003p -1.6532419999999999e-07 62.962500000000006p -1.64388e-07 62.974999999999994p -1.6323920000000001e-07 62.987499999999997p -1.6187980000000001e-07 63p -1.6031200000000001e-07
+ 63.012500000000003p -1.585385e-07 63.024999999999999p -1.565619e-07 63.037500000000001p -1.5438529999999999e-07 63.050000000000004p -1.5201209999999999e-07 63.062499999999993p -1.4944590000000001e-07 63.075000000000003p -1.4669039999999999e-07 63.087500000000006p -1.437497e-07 63.099999999999994p -1.406281e-07 63.112499999999997p -1.3733e-07 63.125p -1.338604e-07 63.137500000000003p -1.3022399999999999e-07 63.149999999999999p -1.26426e-07 63.162500000000001p -1.2247189999999999e-07 63.175000000000004p -1.183671e-07 63.187499999999993p -1.141175e-07 63.199999999999996p -1.0972880000000001e-07 63.212500000000006p -1.0520719999999999e-07 63.224999999999994p -1.0055899999999999e-07
+ 63.237499999999997p -9.5790509999999997e-08 63.25p -9.0908290000000002e-08 63.262500000000003p -8.591901e-08 63.274999999999999p -8.082947e-08 63.287500000000001p -7.5646580000000001e-08 63.300000000000004p -7.0377360000000004e-08 63.312499999999993p -6.5028930000000004e-08 63.324999999999996p -5.9608469999999998e-08 63.337500000000006p -5.4123279999999998e-08 63.350000000000009p -4.8580689999999997e-08 63.362499999999997p -4.2988110000000003e-08 63.375p -3.7352979999999997e-08 63.387500000000003p -3.1682800000000002e-08 63.399999999999999p -2.598508e-08 63.412500000000001p -2.0267350000000001e-08 63.425000000000004p -1.453715e-08 63.437499999999993p -8.8020170000000005e-09 63.449999999999996p -3.0694769999999999e-09
+ 63.462499999999999p 2.652968e-09 63.475000000000009p 8.357846e-09 63.487499999999997p 1.403773e-08 63.5p 1.9685240000000001e-08 63.512500000000003p 2.529306e-08 63.524999999999999p 3.0853949999999997e-08 63.537500000000001p 3.636074e-08 63.550000000000004p 4.180634e-08 63.562499999999993p 4.7183800000000003e-08 63.574999999999996p 5.2486220000000002e-08 63.587499999999999p 5.770685e-08 63.600000000000009p 6.283907e-08 63.612499999999997p 6.7876369999999997e-08 63.625p 7.2812399999999999e-08 63.637500000000003p 7.7640939999999994e-08 63.649999999999991p 8.2355939999999994e-08 63.662500000000001p 8.6951510000000006e-08 63.675000000000004p 9.1421929999999994e-08
+ 63.687500000000007p 9.5761670000000001e-08 63.699999999999996p 9.9965370000000001e-08 63.712499999999999p 1.040279e-07 63.725000000000001p 1.079442e-07 63.737499999999997p 1.117096e-07 63.75p 1.153195e-07 63.762500000000003p 1.187695e-07 63.774999999999991p 1.2205569999999999e-07 63.787500000000001p 1.2517400000000001e-07 63.800000000000004p 1.281208e-07 63.812500000000007p 1.3089260000000001e-07 63.824999999999996p 1.334864e-07 63.837499999999999p 1.3589910000000001e-07 63.850000000000001p 1.3812790000000001e-07 63.862499999999997p 1.401706e-07 63.875p 1.420247e-07 63.887500000000003p 1.436885e-07 63.899999999999991p 1.451601e-07
+ 63.912499999999994p 1.464381e-07 63.925000000000004p 1.4752129999999999e-07 63.937500000000007p 1.484088e-07 63.949999999999996p 1.4909990000000001e-07 63.962499999999999p 1.495941e-07 63.975000000000001p 1.498914e-07 63.987499999999997p 1.4999170000000001e-07 64p 1.4989549999999999e-07 64.012500000000003p 1.496033e-07 64.025000000000006p 1.491159e-07 64.037499999999994p 1.484346e-07 64.049999999999997p 1.475607e-07 64.0625p 1.464956e-07 64.075000000000003p 1.4524139999999999e-07 64.087500000000006p 1.4380019999999999e-07 64.100000000000009p 1.4217410000000001e-07 64.112499999999997p 1.4036579999999999e-07 64.125p 1.3837820000000001e-07
+ 64.137500000000003p 1.362141e-07 64.150000000000006p 1.33877e-07 64.162499999999994p 1.313702e-07 64.174999999999997p 1.286974e-07 64.1875p 1.2586250000000001e-07 64.199999999999989p 1.228695e-07 64.212500000000006p 1.197229e-07 64.225000000000009p 1.16427e-07 64.237499999999997p 1.129866e-07 64.25p 1.094064e-07 64.262500000000003p 1.056914e-07 64.275000000000006p 1.0184690000000001e-07 64.287499999999994p 9.7878170000000006e-08 64.299999999999997p 9.3790670000000003e-08 64.3125p 8.9590039999999996e-08 64.324999999999989p 8.5282029999999999e-08 64.337500000000006p 8.0872530000000001e-08 64.350000000000009p 7.6367549999999995e-08
+ 64.362499999999997p 7.1773209999999998e-08 64.375p 6.7095710000000001e-08 64.387500000000003p 6.2341369999999994e-08 64.400000000000006p 5.7516600000000003e-08 64.412499999999994p 5.2627869999999998e-08 64.424999999999997p 4.7681730000000003e-08 64.4375p 4.2684779999999997e-08 64.449999999999989p 3.76437e-08 64.462499999999991p 3.2565170000000002e-08 64.475000000000009p 2.7455939999999999e-08 64.487500000000011p 2.232278e-08 64.5p 1.7172450000000001e-08 64.512500000000003p 1.201176e-08 64.525000000000006p 6.847485e-09 64.537499999999994p 1.686405e-09 64.549999999999997p -3.4647209999999999e-09 64.5625p -8.5991599999999995e-09 64.574999999999989p -1.3710220000000001e-08
+ 64.587499999999991p -1.879124e-08 64.600000000000009p -2.383563e-08 64.612500000000011p -2.883686e-08 64.625p -3.3788459999999999e-08 64.637500000000003p -3.868403e-08 64.650000000000006p -4.3517289999999998e-08 64.662499999999994p -4.8282029999999998e-08 64.674999999999997p -5.2972130000000001e-08 64.6875p -5.7581619999999997e-08 64.699999999999989p -6.2104610000000001e-08 64.712499999999991p -6.6535369999999999e-08 64.724999999999994p -7.0868269999999996e-08 64.737500000000011p -7.5097840000000004e-08 64.75p -7.9218749999999996e-08 64.762500000000003p -8.3225829999999999e-08 64.775000000000006p -8.7114060000000001e-08 64.787499999999994p -9.0878599999999994e-08 64.799999999999997p -9.4514769999999996e-08
+ 64.8125p -9.8018079999999997e-08 64.825000000000003p -1.013842e-07 64.837499999999991p -1.0460899999999999e-07 64.849999999999994p -1.076887e-07 64.862500000000011p -1.106193e-07 64.875p -1.1339749999999999e-07 64.887500000000003p -1.160199e-07 64.900000000000006p -1.1848330000000001e-07 64.912499999999994p -1.2078500000000001e-07 64.924999999999997p -1.229223e-07 64.9375p -1.2489260000000001e-07 64.950000000000003p -1.266938e-07 64.962499999999991p -1.2832379999999999e-07 64.974999999999994p -1.2978099999999999e-07 64.987500000000011p -1.310638e-07 65p -1.3217079999999999e-07 65.012500000000003p -1.33101e-07 65.025000000000006p -1.338537e-07
+ 65.037499999999994p -1.3442810000000001e-07 65.049999999999997p -1.348239e-07 65.0625p -1.3504109999999999e-07 65.075000000000003p -1.3507970000000001e-07 65.087499999999991p -1.3493999999999999e-07 65.099999999999994p -1.346227e-07 65.112499999999997p -1.3412869999999999e-07 65.125p -1.3345879999999999e-07 65.137500000000003p -1.3261439999999999e-07 65.150000000000006p -1.315971e-07 65.162500000000009p -1.3040859999999999e-07 65.174999999999997p -1.2905070000000001e-07 65.1875p -1.275257e-07 65.200000000000003p -1.2583610000000001e-07 65.212499999999991p -1.2398430000000001e-07 65.224999999999994p -1.2197319999999999e-07 65.237499999999997p -1.198058e-07 65.25p -1.174853e-07
+ 65.262500000000003p -1.150152e-07 65.275000000000006p -1.123991e-07 65.287500000000009p -1.096406e-07 65.299999999999997p -1.067439e-07 65.3125p -1.03713e-07 65.325000000000003p -1.005523e-07 65.337499999999991p -9.7266240000000003e-08 65.349999999999994p -9.3859409999999999e-08 65.362499999999997p -9.0336600000000002e-08 65.375p -8.6702740000000002e-08 65.387500000000003p -8.2962889999999998e-08 65.400000000000006p -7.9122220000000003e-08 65.412500000000009p -7.5186039999999995e-08 65.424999999999997p -7.1159769999999996e-08 65.4375p -6.7048930000000005e-08 65.450000000000003p -6.2859139999999999e-08 65.462499999999991p -5.8596129999999999e-08 65.474999999999994p -5.4265680000000002e-08
+ 65.487499999999997p -4.9873679999999998e-08 65.5p -4.5426070000000002e-08 65.512500000000003p -4.0928839999999997e-08 65.525000000000006p -3.6388040000000001e-08 65.537500000000009p -3.1809780000000001e-08 65.549999999999997p -2.720019e-08 65.5625p -2.2565409999999999e-08 65.575000000000003p -1.791163e-08 65.587499999999991p -1.324503e-08 65.599999999999994p -8.571806e-09 65.612499999999997p -3.8981329999999998e-09 65.625p 7.6981919999999999e-10 65.637500000000003p 5.4259050000000004e-09 65.650000000000006p 1.006401e-08 65.662500000000009p 1.467806e-08 65.674999999999997p 1.926202e-08 65.6875p 2.3809910000000001e-08 65.700000000000003p 2.8315829999999999e-08
+ 65.712499999999991p 3.2773929999999997e-08 65.724999999999994p 3.7178450000000002e-08 65.737499999999997p 4.1523690000000002e-08 65.75p 4.5804079999999997e-08 65.762500000000003p 5.0014119999999999e-08 65.775000000000006p 5.4148430000000001e-08 65.787500000000009p 5.8201730000000001e-08 65.799999999999997p 6.2168879999999994e-08 65.8125p 6.6044850000000005e-08 65.825000000000003p 6.9824749999999998e-08 65.837499999999991p 7.3503820000000003e-08 65.849999999999994p 7.707745e-08 65.862499999999997p 8.0541179999999998e-08 65.875p 8.389071e-08 65.887500000000003p 8.7121890000000002e-08 65.900000000000006p 9.0230750000000002e-08 65.912500000000009p 9.3213479999999996e-08 65.924999999999997p 9.6066440000000003e-08
+ 65.9375p 9.8786189999999996e-08 65.950000000000003p 1.013695e-07 65.962500000000006p 1.038132e-07 65.974999999999994p 1.061144e-07 65.987499999999997p 1.082705e-07 66p 1.102789e-07 66.012499999999989p 1.121374e-07 66.025000000000006p 1.138438e-07 66.037500000000009p 1.153963e-07 66.049999999999997p 1.167932e-07 66.0625p 1.18033e-07 66.075000000000003p 1.191144e-07 66.087500000000006p 1.200364e-07 66.099999999999994p 1.2079810000000001e-07 66.112499999999997p 1.213989e-07 66.125p 1.218384e-07 66.137499999999989p 1.2211630000000001e-07 66.150000000000006p 1.222327e-07
+ 66.162500000000009p 1.221878e-07 66.174999999999997p 1.2198199999999999e-07 66.1875p 1.21616e-07 66.200000000000003p 1.2109059999999999e-07 66.212500000000006p 1.2040679999999999e-07 66.224999999999994p 1.1956590000000001e-07 66.237499999999997p 1.185693e-07 66.25p 1.174188e-07 66.262499999999989p 1.161162e-07 66.275000000000006p 1.146635e-07 66.287500000000009p 1.13063e-07 66.300000000000011p 1.113171e-07 66.3125p 1.094284e-07 66.325000000000003p 1.0739970000000001e-07 66.337500000000006p 1.05234e-07 66.349999999999994p 1.029344e-07 66.362499999999997p 1.005043e-07 66.375p 9.7947170000000005e-08
+ 66.387499999999989p 9.5266570000000004e-08 66.399999999999991p 9.2466310000000002e-08 66.412500000000009p 8.9550339999999994e-08 66.425000000000011p 8.6522739999999996e-08 66.4375p 8.3387730000000005e-08 66.450000000000003p 8.0149640000000004e-08 66.462500000000006p 7.6812960000000001e-08 66.474999999999994p 7.3382260000000005e-08 66.487499999999997p 6.9862269999999994e-08 66.5p 6.6257790000000003e-08 66.512499999999989p 6.2573720000000005e-08 66.524999999999991p 5.8815069999999997e-08 66.537500000000009p 5.4986940000000002e-08 66.550000000000011p 5.1094489999999998e-08 66.5625p 4.7142960000000001e-08 66.575000000000003p 4.313767e-08 66.587500000000006p 3.9083980000000001e-08 66.599999999999994p 3.498731e-08
+ 66.612499999999997p 3.085313e-08 66.625p 2.668694e-08 66.637500000000003p 2.2494279999999999e-08 66.649999999999991p 1.828069e-08 66.662499999999994p 1.405176e-08 66.675000000000011p 9.8130530000000003e-09 66.6875p 5.5701609999999996e-09 66.700000000000003p 1.328656e-09 66.712500000000006p -2.9058990000000002e-09 66.724999999999994p -7.127963e-09 66.737499999999997p -1.133202e-08 66.75p -1.55126e-08 66.762500000000003p -1.966425e-08 66.774999999999991p -2.3781589999999999e-08 66.787499999999994p -2.7859290000000001e-08 66.800000000000011p -3.1892070000000001e-08 66.8125p -3.5874750000000002e-08 66.825000000000003p -3.9802179999999999e-08
+ 66.837500000000006p -4.3669329999999998e-08 66.849999999999994p -4.7471250000000002e-08 66.862499999999997p -5.1203079999999998e-08 66.875p -5.4860049999999999e-08 66.887500000000003p -5.8437529999999999e-08 66.899999999999991p -6.1930979999999994e-08 66.912499999999994p -6.5335980000000004e-08 66.924999999999997p -6.8648240000000004e-08 66.9375p -7.1863589999999996e-08 66.950000000000003p -7.4978009999999995e-08 66.962500000000006p -7.7987609999999998e-08 66.974999999999994p -8.0888660000000001e-08 66.987499999999997p -8.3677559999999995e-08 67p -8.6350869999999995e-08 67.012500000000003p -8.8905310000000001e-08 67.024999999999991p -9.1337759999999997e-08 67.037499999999994p -9.3645289999999996e-08 67.049999999999997p -9.5825089999999995e-08
+ 67.0625p -9.7874569999999997e-08 67.075000000000003p -9.97913e-08 67.087500000000006p -1.0157300000000001e-07 67.100000000000009p -1.032176e-07 67.112499999999997p -1.0472329999999999e-07 67.125p -1.0608830000000001e-07 67.137500000000003p -1.0731110000000001e-07 67.149999999999991p -1.083904e-07 67.162499999999994p -1.093251e-07 67.174999999999997p -1.101142e-07 67.1875p -1.10757e-07 67.200000000000003p -1.112529e-07 67.212500000000006p -1.116015e-07 67.225000000000009p -1.118028e-07 67.237499999999997p -1.118566e-07 67.25p -1.117634e-07 67.262500000000003p -1.1152339999999999e-07 67.274999999999991p -1.111373e-07
+ 67.287499999999994p -1.1060579999999999e-07 67.299999999999997p -1.0993000000000001e-07 67.3125p -1.091111e-07 67.325000000000003p -1.081503e-07 67.337500000000006p -1.070493e-07 67.350000000000009p -1.0580979999999999e-07 67.362499999999997p -1.044337e-07 67.375p -1.02923e-07 67.387500000000003p -1.0128e-07 67.399999999999991p -9.9507230000000006e-08 67.412499999999994p -9.7607160000000006e-08 67.424999999999997p -9.5582570000000005e-08 67.4375p -9.3436390000000002e-08 67.450000000000003p -9.1171669999999998e-08 67.462500000000006p -8.879163e-08 67.475000000000009p -8.6299630000000006e-08 67.487499999999997p -8.3699180000000005e-08 67.5p -8.0993899999999998e-08
+ 67.512500000000003p -7.818757e-08 67.524999999999991p -7.528408e-08 67.537499999999994p -7.2287430000000002e-08 67.549999999999997p -6.9201760000000003e-08 67.5625p -6.6031299999999994e-08 67.575000000000003p -6.2780389999999996e-08 67.587500000000006p -5.9453459999999997e-08 67.600000000000009p -5.6055040000000001e-08 67.612499999999997p -5.258974e-08 67.625p -4.906225e-08 67.637500000000003p -4.547732e-08 67.649999999999991p -4.1839779999999999e-08 67.662499999999994p -3.8154519999999999e-08 67.674999999999997p -3.4426480000000001e-08 67.6875p -3.0660639999999997e-08 67.700000000000003p -2.6862009999999999e-08 67.712500000000006p -2.3035659999999999e-08 67.725000000000009p -1.9186669999999999e-08
+ 67.737499999999997p -1.5320139999999999e-08 67.75p -1.1441169999999999e-08 67.762500000000003p -7.5548819999999993e-09 67.775000000000006p -3.6663969999999999e-09 67.787499999999994p 2.1918120000000001e-10 67.799999999999997p 4.0967590000000003e-09 67.8125p 7.9612659999999997e-09 67.825000000000003p 1.180766e-08 67.837500000000006p 1.563093e-08 67.850000000000009p 1.942611e-08 67.862499999999997p 2.3188279999999999e-08 67.875p 2.6912579999999999e-08 67.887500000000003p 3.05942e-08 67.900000000000006p 3.4228400000000002e-08 67.912499999999994p 3.7810519999999999e-08 67.924999999999997p 4.1335969999999997e-08 67.9375p 4.4800249999999998e-08 67.949999999999989p 4.8198940000000001e-08
+ 67.962500000000006p 5.1527730000000003e-08 67.975000000000009p 5.4782400000000002e-08 67.987499999999997p 5.7958850000000002e-08 68p 6.105307e-08 68.012500000000003p 6.4061189999999995e-08 68.025000000000006p 6.6979440000000002e-08 68.037499999999994p 6.9804200000000005e-08 68.049999999999997p 7.2531960000000004e-08 68.0625p 7.5159350000000004e-08 68.074999999999989p 7.7683149999999996e-08 68.087500000000006p 8.0100269999999996e-08 68.100000000000009p 8.2407759999999995e-08 68.112499999999997p 8.4602850000000005e-08 68.125p 8.6682900000000004e-08 68.137500000000003p 8.8645429999999995e-08 68.150000000000006p 9.0488109999999998e-08 68.162499999999994p 9.2208789999999995e-08 68.174999999999997p 9.3805490000000003e-08
+ 68.1875p 9.5276359999999995e-08 68.199999999999989p 9.6619760000000004e-08 68.212499999999991p 9.7834190000000002e-08 68.225000000000009p 9.8918349999999998e-08 68.237500000000011p 9.9871090000000004e-08 68.25p 1.0069140000000001e-07 68.262500000000003p 1.013786e-07 68.275000000000006p 1.01932e-07 68.287499999999994p 1.0235110000000001e-07 68.299999999999997p 1.026358e-07 68.3125p 1.0278579999999999e-07 68.324999999999989p 1.028014e-07 68.337499999999991p 1.026827e-07 68.350000000000009p 1.024303e-07 68.362500000000011p 1.020446e-07 68.375p 1.015266e-07 68.387500000000003p 1.008771e-07 68.400000000000006p 1.0009739999999999e-07
+ 68.412499999999994p 9.9188570000000004e-08 68.424999999999997p 9.8152230000000005e-08 68.4375p 9.6989950000000001e-08 68.449999999999989p 9.5703529999999997e-08 68.462499999999991p 9.4294900000000006e-08 68.474999999999994p 9.2766159999999996e-08 68.487500000000011p 9.1119560000000003e-08 68.5p 8.9357509999999995e-08 68.512500000000003p 8.7482530000000006e-08 68.525000000000006p 8.5497329999999994e-08 68.537499999999994p 8.3404720000000001e-08 68.549999999999997p 8.1207660000000006e-08 68.5625p 7.8909240000000006e-08 68.575000000000003p 7.6512669999999999e-08 68.587499999999991p 7.4021290000000005e-08 68.599999999999994p 7.1438539999999994e-08 68.612500000000011p 6.8767990000000001e-08 68.625p 6.60133e-08
+ 68.637500000000003p 6.3178260000000002e-08 68.650000000000006p 6.0266719999999996e-08 68.662499999999994p 5.7282640000000002e-08 68.674999999999997p 5.4230080000000002e-08 68.6875p 5.1113149999999997e-08 68.700000000000003p 4.7936050000000003e-08 68.712499999999991p 4.4703070000000002e-08 68.724999999999994p 4.1418520000000001e-08 68.737500000000011p 3.8086810000000001e-08 68.75p 3.4712380000000002e-08 68.762500000000003p 3.1299710000000003e-08 68.775000000000006p 2.7853340000000001e-08 68.787499999999994p 2.437784e-08 68.799999999999997p 2.0877789999999999e-08 68.8125p 1.7357820000000001e-08 68.825000000000003p 1.382255e-08 68.837499999999991p 1.0276629999999999e-08 68.849999999999994p 6.7247009999999996e-09
+ 68.862499999999997p 3.1714109999999998e-09 68.875p -3.786058e-10 68.887500000000003p -3.9207260000000003e-09 68.900000000000006p -7.4503490000000001e-09 68.912500000000009p -1.09629e-08 68.924999999999997p -1.445383e-08 68.9375p -1.7918630000000001e-08 68.950000000000003p -2.1352850000000001e-08 68.962499999999991p -2.4752070000000001e-08 68.974999999999994p -2.8111930000000001e-08 68.987499999999997p -3.1428129999999997e-08 69p -3.4696440000000003e-08 69.012500000000003p -3.79127e-08 69.025000000000006p -4.1072820000000002e-08 69.037500000000009p -4.417281e-08 69.049999999999997p -4.7208739999999999e-08 69.0625p -5.0176800000000002e-08 69.075000000000003p -5.3073259999999998e-08
+ 69.087499999999991p -5.5894490000000001e-08 69.099999999999994p -5.8636970000000001e-08 69.112499999999997p -6.1297290000000003e-08 69.125p -6.3872160000000002e-08 69.137500000000003p -6.6358409999999996e-08 69.150000000000006p -6.8752970000000004e-08 69.162500000000009p -7.1052919999999995e-08 69.174999999999997p -7.3255460000000004e-08 69.1875p -7.5357930000000003e-08 69.200000000000003p -7.7357799999999999e-08 69.212499999999991p -7.9252680000000006e-08 69.224999999999994p -8.1040319999999999e-08 69.237499999999997p -8.2718619999999999e-08 69.25p -8.4285620000000002e-08 69.262500000000003p -8.5739530000000001e-08 69.275000000000006p -8.7078689999999996e-08 69.287500000000009p -8.8301590000000001e-08 69.299999999999997p -8.9406889999999999e-08
+ 69.3125p -9.0393419999999996e-08 69.325000000000003p -9.1260119999999996e-08 69.337499999999991p -9.2006140000000002e-08 69.349999999999994p -9.2630759999999994e-08 69.362499999999997p -9.3133430000000002e-08 69.375p -9.3513760000000002e-08 69.387500000000003p -9.3771530000000003e-08 69.400000000000006p -9.3906649999999996e-08 69.412500000000009p -9.3919219999999999e-08 69.424999999999997p -9.3809500000000004e-08 69.4375p -9.3577890000000004e-08 69.450000000000003p -9.322497e-08 69.462499999999991p -9.2751459999999996e-08 69.474999999999994p -9.2158239999999994e-08 69.487499999999997p -9.1446360000000006e-08 69.5p -9.061699e-08 69.512500000000003p -8.9671499999999997e-08 69.525000000000006p -8.8611359999999994e-08
+ 69.537500000000009p -8.7438209999999999e-08 69.549999999999997p -8.6153839999999994e-08 69.5625p -8.4760169999999994e-08 69.575000000000003p -8.3259249999999998e-08 69.587499999999991p -8.16533e-08 69.599999999999994p -7.9944639999999997e-08 69.612499999999997p -7.8135730000000006e-08 69.625p -7.6229150000000002e-08 69.637500000000003p -7.4227609999999996e-08 69.650000000000006p -7.2133950000000006e-08 69.662500000000009p -6.9951089999999998e-08 69.674999999999997p -6.7682090000000006e-08 69.6875p -6.5330099999999995e-08 69.700000000000003p -6.2898389999999997e-08 69.712500000000006p -6.0390300000000003e-08 69.724999999999994p -5.7809280000000002e-08 69.737499999999997p -5.5158870000000003e-08 69.75p -5.2442679999999999e-08
+ 69.762499999999989p -4.9664409999999999e-08 69.775000000000006p -4.6827820000000003e-08 69.787500000000009p -4.3936760000000001e-08 69.799999999999997p -4.0995109999999999e-08 69.8125p -3.8006830000000003e-08 69.825000000000003p -3.4975940000000002e-08 69.837500000000006p -3.1906469999999999e-08 69.849999999999994p -2.8802539999999999e-08 69.862499999999997p -2.5668259999999999e-08 69.875p -2.2507800000000001e-08 69.887499999999989p -1.9325339999999999e-08 69.900000000000006p -1.6125079999999999e-08 69.912500000000009p -1.2911249999999999e-08 69.924999999999997p -9.6880610000000001e-09 69.9375p -6.4597489999999998e-09 69.950000000000003p -3.2305359999999999e-09 69.962500000000006p -4.6365290000000001e-12 69.974999999999994p 3.2137480000000002e-09
+ 69.987499999999997p 6.4204350000000003e-09 70p 9.6112690000000006e-09 70.012499999999989p 1.278212e-08 70.025000000000006p 1.5928910000000001e-08 70.037500000000009p 1.9047580000000001e-08 70.050000000000011p 2.213413e-08 70.0625p 2.5184599999999998e-08 70.075000000000003p 2.8195110000000001e-08 70.087500000000006p 3.116182e-08 70.099999999999994p 3.408096e-08 70.112499999999997p 3.6948839999999997e-08 70.125p 3.9761839999999998e-08 70.137499999999989p 4.251641e-08 70.149999999999991p 4.520911e-08 70.162500000000009p 4.7836559999999999e-08 70.175000000000011p 5.0395500000000003e-08 70.1875p 5.2882740000000001e-08 70.200000000000003p 5.5295219999999997e-08
+ 70.212500000000006p 5.7629960000000001e-08 70.224999999999994p 5.9884100000000001e-08 70.237499999999997p 6.2054889999999994e-08 70.25p 6.4139709999999997e-08 70.262499999999989p 6.6136029999999994e-08 70.274999999999991p 6.8041459999999995e-08 70.287500000000009p 6.9853729999999998e-08 70.300000000000011p 7.1570699999999996e-08 70.3125p 7.3190349999999995e-08 70.325000000000003p 7.4710809999999999e-08 70.337500000000006p 7.613033e-08 70.349999999999994p 7.7447289999999998e-08 70.362499999999997p 7.8660230000000005e-08 70.375p 7.9767800000000006e-08 70.387500000000003p 8.0768809999999999e-08 70.399999999999991p 8.1662219999999998e-08 70.412499999999994p 8.2447109999999999e-08 70.425000000000011p 8.3122710000000003e-08
+ 70.4375p 8.3688410000000006e-08 70.450000000000003p 8.4143730000000002e-08 70.462500000000006p 8.4488330000000001e-08 70.474999999999994p 8.4722029999999999e-08 70.487499999999997p 8.4844789999999996e-08 70.5p 8.4856719999999994e-08 70.512500000000003p 8.4758050000000006e-08 70.524999999999991p 8.4549189999999999e-08 70.537499999999994p 8.4230660000000006e-08 70.550000000000011p 8.3803150000000001e-08 70.5625p 8.3267460000000001e-08 70.575000000000003p 8.2624560000000006e-08 70.587500000000006p 8.187553e-08 70.599999999999994p 8.1021609999999997e-08 70.612499999999997p 8.0064160000000006e-08 70.625p 7.9004670000000006e-08 70.637500000000003p 7.7844770000000006e-08 70.649999999999991p 7.6586210000000002e-08
+ 70.662499999999994p 7.5230869999999999e-08 70.674999999999997p 7.3780740000000001e-08 70.6875p 7.2237939999999995e-08 70.700000000000003p 7.06047e-08 70.712500000000006p 6.8883370000000001e-08 70.724999999999994p 6.7076410000000003e-08 70.737499999999997p 6.5186370000000004e-08 70.75p 6.3215920000000003e-08 70.762500000000003p 6.1167820000000004e-08 70.774999999999991p 5.9044930000000001e-08 70.787499999999994p 5.68502e-08 70.799999999999997p 5.4586660000000002e-08 70.8125p 5.2257430000000001e-08 70.825000000000003p 4.9865709999999998e-08 70.837500000000006p 4.7414760000000001e-08 70.850000000000009p 4.4907940000000002e-08 70.862499999999997p 4.2348640000000002e-08 70.875p 3.9740330000000003e-08
+ 70.887500000000003p 3.7086539999999999e-08 70.899999999999991p 3.4390829999999999e-08 70.912499999999994p 3.1656839999999999e-08 70.924999999999997p 2.8888220000000001e-08 70.9375p 2.608867e-08 70.950000000000003p 2.3261930000000001e-08 70.962500000000006p 2.0411750000000001e-08 70.975000000000009p 1.754192e-08 70.987499999999997p 1.465622e-08 71p 1.1758479999999999e-08 71.012500000000003p 8.8525069999999999e-09 71.024999999999991p 5.9421220000000004e-09 71.037499999999994p 3.0311409999999998e-09 71.049999999999997p 1.2337390000000001e-10 71.0625p -2.7773839999999998e-09 71.075000000000003p -5.6673559999999997e-09 71.087500000000006p -8.5427850000000001e-09 71.100000000000009p -1.139994e-08
+ 71.112499999999997p -1.423514e-08 71.125p -1.7044699999999998e-08 71.137500000000003p -1.982503e-08 71.149999999999991p -2.2572549999999999e-08 71.162499999999994p -2.528373e-08 71.174999999999997p -2.795513e-08 71.1875p -3.0583319999999999e-08 71.200000000000003p -3.316498e-08 71.212500000000006p -3.5696820000000001e-08 71.225000000000009p -3.8175669999999998e-08 71.237499999999997p -4.0598379999999999e-08 71.25p -4.2961919999999999e-08 71.262500000000003p -4.5263340000000002e-08 71.274999999999991p -4.7499759999999998e-08 71.287499999999994p -4.966842e-08 71.299999999999997p -5.1766620000000001e-08 71.3125p -5.3791779999999999e-08 71.325000000000003p -5.5741430000000001e-08
+ 71.337500000000006p -5.7613190000000002e-08 71.350000000000009p -5.9404779999999998e-08 71.362499999999997p -6.1114060000000006e-08 71.375p -6.2738970000000001e-08 71.387500000000003p -6.427758e-08 71.399999999999991p -6.5728080000000004e-08 71.412499999999994p -6.7088779999999995e-08 71.424999999999997p -6.8358109999999998e-08 71.4375p -6.9534620000000005e-08 71.450000000000003p -7.0616990000000006e-08 71.462500000000006p -7.1604020000000004e-08 71.475000000000009p -7.2494650000000003e-08 71.487499999999997p -7.3287939999999995e-08 71.5p -7.3983069999999997e-08 71.512500000000003p -7.4579389999999994e-08 71.525000000000006p -7.5076329999999996e-08 71.537499999999994p -7.5473479999999998e-08 71.549999999999997p -7.5770569999999999e-08
+ 71.5625p -7.5967440000000003e-08 71.575000000000003p -7.6064089999999994e-08 71.587500000000006p -7.6060609999999997e-08 71.600000000000009p -7.595726e-08 71.612499999999997p -7.5754420000000006e-08 71.625p -7.5452590000000002e-08 71.637500000000003p -7.5052409999999994e-08 71.650000000000006p -7.4554649999999996e-08 71.662499999999994p -7.3960189999999996e-08 71.674999999999997p -7.327006e-08 71.6875p -7.2485380000000006e-08 71.699999999999989p -7.1607420000000002e-08 71.712500000000006p -7.0637570000000002e-08 71.725000000000009p -6.9577329999999994e-08 71.737499999999997p -6.8428290000000002e-08 71.75p -6.7192210000000004e-08 71.762500000000003p -6.5870900000000003e-08 71.775000000000006p -6.4466329999999996e-08
+ 71.787499999999994p -6.2980530000000002e-08 71.799999999999997p -6.1415670000000006e-08 71.8125p -5.9773990000000006e-08 71.824999999999989p -5.8057839999999998e-08 71.837500000000006p -5.6269659999999998e-08 71.850000000000009p -5.4411990000000001e-08 71.862500000000011p -5.2487429999999997e-08 71.875p -5.0498679999999998e-08 71.887500000000003p -4.8448519999999998e-08 71.900000000000006p -4.6339790000000003e-08 71.912499999999994p -4.4175419999999998e-08 71.924999999999997p -4.195838e-08 71.9375p -3.9691739999999999e-08 71.949999999999989p -3.7378579999999999e-08 71.962499999999991p -3.5022069999999997e-08 71.975000000000009p -3.2625419999999998e-08 71.987500000000011p -3.0191879999999998e-08 72p -2.7724740000000002e-08
+ 72.012500000000003p -2.5227340000000001e-08 72.025000000000006p -2.2703040000000001e-08 72.037499999999994p -2.0155220000000001e-08 72.049999999999997p -1.758729e-08 72.0625p -1.5002689999999999e-08 72.074999999999989p -1.2404859999999999e-08 72.087499999999991p -9.7972560000000005e-09 72.100000000000009p -7.1833240000000004e-09 72.112500000000011p -4.5665259999999999e-09 72.125p -1.9503119999999999e-09 72.137500000000003p 6.618758e-10 72.150000000000006p 3.2666079999999999e-09 72.162499999999994p 5.8604760000000004e-09 72.174999999999997p 8.4400910000000007e-09 72.1875p 1.100209e-08 72.199999999999989p 1.3543160000000001e-08 72.212499999999991p 1.605999e-08 72.224999999999994p 1.8549329999999999e-08
+ 72.237500000000011p 2.1007979999999999e-08 72.25p 2.3432770000000002e-08 72.262500000000003p 2.5820600000000002e-08 72.275000000000006p 2.816841e-08 72.287499999999994p 3.0473220000000002e-08 72.299999999999997p 3.2732099999999997e-08 72.3125p 3.4942180000000001e-08 72.325000000000003p 3.710068e-08 72.337499999999991p 3.9204889999999997e-08 72.349999999999994p 4.1252160000000002e-08 72.362500000000011p 4.3239949999999999e-08 72.375p 4.5165790000000001e-08 72.387500000000003p 4.7027290000000001e-08 72.400000000000006p 4.882215e-08 72.412499999999994p 5.0548189999999998e-08 72.424999999999997p 5.2203299999999997e-08 72.4375p 5.3785480000000002e-08 72.450000000000003p 5.5292810000000003e-08
+ 72.462499999999991p 5.6723510000000002e-08 72.474999999999994p 5.8075870000000002e-08 72.487500000000011p 5.9348299999999999e-08 72.5p 6.0539330000000003e-08 72.512500000000003p 6.1647590000000005e-08 72.525000000000006p 6.2671810000000006e-08 72.537499999999994p 6.3610859999999995e-08 72.549999999999997p 6.4463709999999994e-08 72.5625p 6.5229440000000003e-08 72.575000000000003p 6.5907250000000003e-08 72.587499999999991p 6.649647e-08 72.599999999999994p 6.6996530000000003e-08 72.612499999999997p 6.7406990000000006e-08 72.625p 6.7727529999999998e-08 72.637500000000003p 6.7957930000000003e-08 72.650000000000006p 6.8098109999999994e-08 72.662500000000009p 6.8148109999999998e-08 72.674999999999997p 6.8108059999999996e-08
+ 72.6875p 6.7978249999999995e-08 72.700000000000003p 6.7759040000000004e-08 72.712499999999991p 6.7450950000000004e-08 72.724999999999994p 6.7054589999999996e-08 72.737499999999997p 6.6570679999999998e-08 72.75p 6.6000079999999994e-08 72.762500000000003p 6.5343730000000006e-08 72.775000000000006p 6.4602699999999997e-08 72.787500000000009p 6.3778169999999998e-08 72.799999999999997p 6.2871419999999996e-08 72.8125p 6.1883819999999996e-08 72.825000000000003p 6.0816869999999999e-08 72.837499999999991p 5.9672160000000005e-08 72.849999999999994p 5.8451369999999997e-08 72.862499999999997p 5.7156289999999999e-08 72.875p 5.5788789999999997e-08 72.887500000000003p 5.4350839999999997e-08 72.900000000000006p 5.2844489999999997e-08
+ 72.912500000000009p 5.1271879999999999e-08 72.924999999999997p 4.9635239999999998e-08 72.9375p 4.7936860000000003e-08 72.950000000000003p 4.6179110000000001e-08 72.962499999999991p 4.436446e-08 72.974999999999994p 4.2495410000000003e-08 72.987499999999997p 4.057455e-08 73p 3.860452e-08 73.012500000000003p 3.6588020000000003e-08 73.025000000000006p 3.4527830000000002e-08 73.037500000000009p 3.242674e-08 73.049999999999997p 3.0287610000000001e-08 73.0625p 2.8113340000000001e-08 73.075000000000003p 2.590688e-08 73.087499999999991p 2.3671200000000002e-08 73.099999999999994p 2.140931e-08 73.112499999999997p 1.912424e-08 73.125p 1.6819059999999999e-08
+ 73.137500000000003p 1.4496829999999999e-08 73.150000000000006p 1.216067e-08 73.162500000000009p 9.8136710000000004e-09 73.174999999999997p 7.4589499999999998e-09 73.1875p 5.0996240000000003e-09 73.200000000000003p 2.7388109999999999e-09 73.212499999999991p 3.7962290000000002e-10 73.224999999999994p -1.974838e-09 73.237499999999997p -4.3214800000000003e-09 73.25p -6.6572309999999997e-09 73.262500000000003p -8.9790379999999994e-09 73.275000000000006p -1.128387e-08 73.287500000000009p -1.356874e-08 73.299999999999997p -1.5830659999999999e-08 73.3125p -1.8066719999999999e-08 73.325000000000003p -2.027402e-08 73.337499999999991p -2.2449709999999999e-08 73.349999999999994p -2.4591010000000002e-08
+ 73.362499999999997p -2.669515e-08 73.375p -2.8759450000000001e-08 73.387500000000003p -3.0781270000000003e-08 73.400000000000006p -3.2758040000000001e-08 73.412500000000009p -3.4687249999999998e-08 73.424999999999997p -3.6566459999999999e-08 73.4375p -3.8393300000000001e-08 73.450000000000003p -4.0165459999999997e-08 73.462500000000006p -4.1880739999999999e-08 73.474999999999994p -4.3536989999999998e-08 73.487499999999997p -4.5132160000000001e-08 73.5p -4.6664259999999997e-08 73.512499999999989p -4.8131410000000001e-08 73.525000000000006p -4.9531819999999999e-08 73.537500000000009p -5.0863780000000001e-08 73.549999999999997p -5.212567e-08 73.5625p -5.3315979999999999e-08 73.575000000000003p -5.4433299999999998e-08
+ 73.587500000000006p -5.5476300000000003e-08 73.599999999999994p -5.6443749999999999e-08 73.612499999999997p -5.7334560000000002e-08 73.625p -5.8147689999999999e-08 73.637499999999989p -5.8882240000000001e-08 73.650000000000006p -5.9537400000000001e-08 73.662500000000009p -6.0112479999999997e-08 73.674999999999997p -6.0606890000000006e-08 73.6875p -6.1020140000000005e-08 73.700000000000003p -6.1351850000000004e-08 73.712500000000006p -6.1601760000000001e-08 73.724999999999994p -6.1769709999999997e-08 73.737499999999997p -6.1855649999999996e-08 73.75p -6.1859629999999994e-08 73.762499999999989p -6.1781819999999999e-08 73.774999999999991p -6.1622489999999998e-08 73.787500000000009p -6.1382020000000006e-08 73.800000000000011p -6.1060909999999998e-08
+ 73.8125p -6.0659730000000002e-08 73.825000000000003p -6.0179180000000004e-08 73.837500000000006p -5.9620070000000003e-08 73.849999999999994p -5.8983289999999999e-08 73.862499999999997p -5.8269849999999997e-08 73.875p -5.7480839999999999e-08 73.887499999999989p -5.6617470000000001e-08 73.899999999999991p -5.5681020000000001e-08 73.912500000000009p -5.4672879999999997e-08 73.925000000000011p -5.359453e-08 73.9375p -5.2447550000000003e-08 73.950000000000003p -5.1233579999999999e-08 73.962500000000006p -4.9954360000000001e-08 73.974999999999994p -4.8611729999999999e-08 73.987499999999997p -4.7207569999999997e-08 74p -4.5743879999999997e-08 74.012499999999989p -4.4222700000000002e-08 74.024999999999991p -4.2646169999999998e-08
+ 74.037500000000009p -4.1016460000000003e-08 74.050000000000011p -3.9335859999999997e-08 74.0625p -3.7606670000000001e-08 74.075000000000003p -3.5831280000000002e-08 74.087500000000006p -3.4012130000000002e-08 74.099999999999994p -3.2151710000000002e-08 74.112499999999997p -3.0252550000000002e-08 74.125p -2.8317239999999998e-08 74.137500000000003p -2.634841e-08 74.149999999999991p -2.4348729999999998e-08 74.162499999999994p -2.232089e-08 74.175000000000011p -2.0267630000000001e-08 74.1875p -1.8191709999999999e-08 74.200000000000003p -1.6095909999999998e-08 74.212500000000006p -1.398304e-08 74.224999999999994p -1.185591e-08 74.237499999999997p -9.7173650000000008e-09 74.25p -7.5702449999999996e-09
+ 74.262500000000003p -5.4173960000000003e-09 74.274999999999991p -3.2616680000000002e-09 74.287499999999994p -1.10591e-09 74.300000000000011p 1.047039e-09 74.3125p 3.1943459999999998e-09 74.325000000000003p 5.3331949999999998e-09 74.337500000000006p 7.4607840000000004e-09 74.349999999999994p 9.5743330000000005e-09 74.362499999999997p 1.167109e-08 74.375p 1.374832e-08 74.387500000000003p 1.5803329999999999e-08 74.399999999999991p 1.7833469999999999e-08 74.412499999999994p 1.9836099999999999e-08 74.424999999999997p 2.1808650000000001e-08 74.4375p 2.3748590000000001e-08 74.450000000000003p 2.565342e-08 74.462500000000006p 2.7520719999999999e-08 74.474999999999994p 2.9348090000000001e-08
+ 74.487499999999997p 3.1133220000000002e-08 74.5p 3.2873849999999999e-08 74.512500000000003p 3.4567779999999998e-08 74.524999999999991p 3.621287e-08 74.537499999999994p 3.7807060000000002e-08 74.549999999999997p 3.9348359999999998e-08 74.5625p 4.0834840000000003e-08 74.575000000000003p 4.2264679999999999e-08 74.587500000000006p 4.3636089999999997e-08 74.600000000000009p 4.4947409999999997e-08 74.612499999999997p 4.6197030000000003e-08 74.625p 4.738343e-08 74.637500000000003p 4.8505180000000001e-08 74.649999999999991p 4.9560939999999997e-08 74.662499999999994p 5.0549470000000002e-08 74.674999999999997p 5.1469589999999999e-08 74.6875p 5.2320239999999998e-08 74.700000000000003p 5.3100449999999997e-08
+ 74.712500000000006p 5.3809330000000002e-08 74.725000000000009p 5.4446100000000002e-08 74.737499999999997p 5.5010069999999997e-08 74.75p 5.550064e-08 74.762500000000003p 5.5917330000000003e-08 74.774999999999991p 5.6259739999999999e-08 74.787499999999994p 5.6527569999999997e-08 74.799999999999997p 5.6720630000000003e-08 74.8125p 5.6838799999999999e-08 74.825000000000003p 5.6882090000000002e-08 74.837500000000006p 5.6850589999999999e-08 74.850000000000009p 5.6744500000000002e-08 74.862499999999997p 5.6564109999999998e-08 74.875p 5.6309809999999998e-08 74.887500000000003p 5.5982079999999997e-08 74.899999999999991p 5.55815e-08 74.912499999999994p 5.5108739999999997e-08 74.924999999999997p 5.4564570000000001e-08
+ 74.9375p 5.3949850000000002e-08 74.950000000000003p 5.3265529999999998e-08 74.962500000000006p 5.251264e-08 74.975000000000009p 5.169232e-08 74.987499999999997p 5.0805769999999998e-08 75p 4.9854289999999997e-08 75.012500000000003p 4.8839249999999998e-08 75.024999999999991p 4.776212e-08 75.037499999999994p 4.6624440000000002e-08 75.049999999999997p 4.5427810000000001e-08 75.0625p 4.4173919999999997e-08 75.075000000000003p 4.2864530000000003e-08 75.087500000000006p 4.150147e-08 75.100000000000009p 4.0086630000000001e-08 75.112499999999997p 3.862196e-08 75.125p 3.7109499999999999e-08 75.137500000000003p 3.5551300000000002e-08 75.149999999999991p 3.3949509999999999e-08
+ 75.162499999999994p 3.2306300000000001e-08 75.174999999999997p 3.0623919999999998e-08 75.1875p 2.8904640000000001e-08 75.200000000000003p 2.7150779999999999e-08 75.212500000000006p 2.5364719999999999e-08 75.225000000000009p 2.354885e-08 75.237499999999997p 2.1705620000000001e-08 75.25p 1.9837469999999998e-08 75.262500000000003p 1.7946919999999999e-08 75.275000000000006p 1.603648e-08 75.287499999999994p 1.410868e-08 75.299999999999997p 1.216609e-08 75.3125p 1.021127e-08 75.325000000000003p 8.2468010000000004e-09 75.337500000000006p 6.2752799999999999e-09 75.350000000000009p 4.2992949999999999e-09 75.362499999999997p 2.3214389999999999e-09 75.375p 3.4430250000000001e-10
+ 75.387500000000003p -1.629531e-09 75.400000000000006p -3.5974879999999999e-09 75.412499999999994p -5.5570070000000003e-09 75.424999999999997p -7.5055420000000008e-09 75.4375p -9.4405679999999996e-09 75.449999999999989p -1.1359580000000001e-08 75.462500000000006p -1.326011e-08 75.475000000000009p -1.5139699999999999e-08 75.487499999999997p -1.699594e-08 75.5p -1.882646e-08 75.512500000000003p -2.06289e-08 75.525000000000006p -2.240097e-08 75.537499999999994p -2.4140410000000001e-08 75.549999999999997p -2.5845020000000001e-08 75.5625p -2.7512630000000001e-08 75.574999999999989p -2.9141150000000001e-08 75.587500000000006p -3.0728520000000003e-08 75.600000000000009p -3.2272759999999997e-08
+ 75.612500000000011p -3.3771920000000001e-08 75.625p -3.5224140000000003e-08 75.637500000000003p -3.6627609999999997e-08 75.650000000000006p -3.7980610000000002e-08 75.662499999999994p -3.9281449999999997e-08 75.674999999999997p -4.0528559999999997e-08 75.6875p -4.1720400000000001e-08 75.699999999999989p -4.2855529999999999e-08 75.712499999999991p -4.3932579999999999e-08 75.725000000000009p -4.4950259999999999e-08 75.737500000000011p -4.5907359999999998e-08 75.75p -4.6802749999999999e-08 75.762500000000003p -4.7635379999999998e-08 75.775000000000006p -4.8404290000000001e-08 75.787499999999994p -4.9108610000000001e-08 75.799999999999997p -4.9747540000000002e-08 75.8125p -5.0320379999999999e-08 75.824999999999989p -5.0826520000000002e-08
+ 75.837499999999991p -5.1265430000000001e-08 75.850000000000009p -5.1636670000000002e-08 75.862500000000011p -5.1939889999999999e-08 75.875p -5.2174830000000001e-08 75.887500000000003p -5.2341329999999998e-08 75.900000000000006p -5.24393e-08 75.912499999999994p -5.2468749999999998e-08 75.924999999999997p -5.242979e-08 75.9375p -5.2322600000000003e-08 75.949999999999989p -5.2147459999999998e-08 75.962499999999991p -5.1904739999999997e-08 75.974999999999994p -5.1594880000000001e-08 75.987500000000011p -5.1218439999999997e-08 76p -5.077603e-08 76.012500000000003p -5.0268370000000003e-08 76.025000000000006p -4.9696249999999997e-08 76.037499999999994p -4.9060550000000001e-08 76.049999999999997p -4.836223e-08
+ 76.0625p -4.7602320000000001e-08 76.075000000000003p -4.6781960000000002e-08 76.087499999999991p -4.5902310000000003e-08 76.099999999999994p -4.496467e-08 76.112500000000011p -4.3970370000000001e-08 76.125p -4.2920810000000003e-08 76.137500000000003p -4.1817490000000001e-08 76.150000000000006p -4.0661959999999998e-08 76.162499999999994p -3.9455820000000002e-08 76.174999999999997p -3.8200760000000002e-08 76.1875p -3.6898510000000001e-08 76.200000000000003p -3.5550869999999997e-08 76.212499999999991p -3.4159690000000003e-08 76.224999999999994p -3.2726880000000001e-08 76.237500000000011p -3.1254379999999999e-08 76.25p -2.9744209999999999e-08 76.262500000000003p -2.8198400000000001e-08 76.275000000000006p -2.6619050000000001e-08
+ 76.287499999999994p -2.5008290000000001e-08 76.299999999999997p -2.3368280000000001e-08 76.3125p -2.1701220000000001e-08 76.325000000000003p -2.000934e-08 76.337499999999991p -1.8294900000000001e-08 76.349999999999994p -1.6560169999999999e-08 76.362499999999997p -1.4807470000000001e-08 76.375p -1.303912e-08 76.387500000000003p -1.1257450000000001e-08 76.400000000000006p -9.4648049999999998e-09 76.412500000000009p -7.6635560000000007e-09 76.424999999999997p -5.8560620000000004e-09 76.4375p -4.0446940000000001e-09 76.450000000000003p -2.231818e-09 76.462499999999991p -4.1979919999999999e-10 76.474999999999994p 1.389003e-09 76.487499999999997p 3.1922389999999998e-09 76.5p 4.9875719999999998e-09
+ 76.512500000000003p 6.7726809999999997e-09 76.525000000000006p 8.5452620000000006e-09 76.537500000000009p 1.0303029999999999e-08 76.549999999999997p 1.204374e-08 76.5625p 1.3765149999999999e-08 76.575000000000003p 1.5465049999999999e-08 76.587499999999991p 1.7141300000000001e-08 76.599999999999994p 1.879175e-08 76.612499999999997p 2.041431e-08 76.625p 2.2006920000000001e-08 76.637500000000003p 2.3567590000000001e-08 76.650000000000006p 2.5094339999999999e-08 76.662500000000009p 2.658526e-08 76.674999999999997p 2.803849e-08 76.6875p 2.9452219999999999e-08 76.700000000000003p 3.0824699999999997e-08 76.712499999999991p 3.2154220000000002e-08 76.724999999999994p 3.3439159999999997e-08
+ 76.737499999999997p 3.4677929999999999e-08 76.75p 3.5869029999999998e-08 76.762500000000003p 3.7011010000000003e-08 76.775000000000006p 3.8102489999999997e-08 76.787500000000009p 3.9142159999999999e-08 76.799999999999997p 4.0128779999999998e-08 76.8125p 4.1061190000000001e-08 76.825000000000003p 4.1938279999999998e-08 76.837499999999991p 4.2759050000000002e-08 76.849999999999994p 4.3522550000000001e-08 76.862499999999997p 4.4227910000000002e-08 76.875p 4.4874339999999998e-08 76.887500000000003p 4.5461139999999998e-08 76.900000000000006p 4.5987659999999999e-08 76.912500000000009p 4.6453360000000001e-08 76.924999999999997p 4.6857770000000001e-08 76.9375p 4.72005e-08 76.950000000000003p 4.7481230000000001e-08
+ 76.962499999999991p 4.7699749999999997e-08 76.974999999999994p 4.785591e-08 76.987499999999997p 4.794964e-08 77p 4.7980959999999998e-08 77.012500000000003p 4.794997e-08 77.025000000000006p 4.7856850000000001e-08 77.037500000000009p 4.7701860000000001e-08 77.049999999999997p 4.7485340000000001e-08 77.0625p 4.7207710000000002e-08 77.075000000000003p 4.6869460000000002e-08 77.087499999999991p 4.6471179999999998e-08 77.099999999999994p 4.6013519999999997e-08 77.112499999999997p 4.5497210000000001e-08 77.125p 4.4923050000000001e-08 77.137500000000003p 4.4291910000000002e-08 77.150000000000006p 4.3604760000000002e-08 77.162500000000009p 4.2862600000000003e-08 77.174999999999997p 4.2066529999999998e-08
+ 77.1875p 4.1217709999999999e-08 77.200000000000003p 4.0317359999999999e-08 77.212500000000006p 3.9366760000000001e-08 77.224999999999994p 3.8367279999999999e-08 77.237499999999997p 3.7320320000000002e-08 77.25p 3.6227350000000003e-08 77.262499999999989p 3.5089890000000003e-08 77.275000000000006p 3.3909540000000003e-08 77.287500000000009p 3.2687920000000002e-08 77.299999999999997p 3.1426710000000001e-08 77.3125p 3.0127649999999998e-08 77.325000000000003p 2.8792520000000001e-08 77.337500000000006p 2.7423129999999999e-08 77.349999999999994p 2.6021340000000001e-08 77.362499999999997p 2.4589059999999999e-08 77.375p 2.3128220000000001e-08 77.387499999999989p 2.1640780000000001e-08 77.400000000000006p 2.0128740000000001e-08
+ 77.412500000000009p 1.8594119999999999e-08 77.424999999999997p 1.7038980000000001e-08 77.4375p 1.5465389999999998e-08 77.450000000000003p 1.387543e-08 77.462500000000006p 1.227121e-08 77.474999999999994p 1.065486e-08 77.487499999999997p 9.0285110000000006e-09 77.5p 7.3942940000000001e-09 77.512499999999989p 5.7543609999999999e-09 77.524999999999991p 4.1108590000000001e-09 77.537500000000009p 2.4659359999999998e-09 77.550000000000011p 8.2173669999999998e-10 77.5625p -8.195989e-10 77.575000000000003p -2.455941e-09 77.587500000000006p -4.0851700000000003e-09 77.599999999999994p -5.7051799999999999e-09 77.612499999999997p -7.3138849999999999e-09 77.625p -8.9092149999999996e-09
+ 77.637499999999989p -1.0489120000000001e-08 77.649999999999991p -1.2051589999999999e-08 77.662500000000009p -1.359462e-08 77.675000000000011p -1.5116240000000002e-08 77.6875p -1.6614539999999999e-08 77.700000000000003p -1.8087600000000001e-08 77.712500000000006p -1.953357e-08 77.724999999999994p -2.0950640000000001e-08 77.737499999999997p -2.233701e-08 77.75p -2.3690960000000001e-08 77.762499999999989p -2.5010800000000001e-08 77.774999999999991p -2.6294899999999999e-08 77.787500000000009p -2.754165e-08 77.800000000000011p -2.8749540000000002e-08 77.8125p -2.9917060000000002e-08 77.825000000000003p -3.1042810000000001e-08 77.837500000000006p -3.21254e-08 77.849999999999994p -3.3163539999999997e-08
+ 77.862499999999997p -3.4155970000000002e-08 77.875p -3.5101519999999998e-08 77.887500000000003p -3.599905e-08 77.899999999999991p -3.6847519999999999e-08 77.912499999999994p -3.7645939999999999e-08 77.925000000000011p -3.839338e-08 77.9375p -3.9088989999999997e-08 77.950000000000003p -3.9732000000000001e-08 77.962500000000006p -4.0321690000000002e-08 77.974999999999994p -4.0857409999999998e-08 77.987499999999997p -4.1338609999999999e-08 78p -4.176478e-08 78.012500000000003p -4.2135509999999997e-08 78.024999999999991p -4.2450440000000001e-08 78.037499999999994p -4.2709299999999999e-08 78.050000000000011p -4.2911880000000002e-08 78.0625p -4.3058070000000003e-08 78.075000000000003p -4.3147810000000003e-08
+ 78.087500000000006p -4.3181110000000003e-08 78.099999999999994p -4.3158080000000001e-08 78.112499999999997p -4.307888e-08 78.125p -4.2943749999999997e-08 78.137500000000003p -4.2753010000000002e-08 78.149999999999991p -4.2507039999999998e-08 78.162499999999994p -4.220631e-08 78.174999999999997p -4.1851330000000001e-08 78.1875p -4.1442710000000003e-08 78.200000000000003p -4.0981109999999997e-08 78.212500000000006p -4.0467259999999998e-08 78.225000000000009p -3.9901969999999999e-08 78.237499999999997p -3.9286110000000001e-08 78.25p -3.8620599999999997e-08 78.262500000000003p -3.790643e-08 78.274999999999991p -3.714467e-08 78.287499999999994p -3.6336419999999997e-08 78.299999999999997p -3.5482860000000003e-08
+ 78.3125p -3.4585210000000002e-08 78.325000000000003p -3.3644759999999997e-08 78.337500000000006p -3.2662849999999998e-08 78.350000000000009p -3.164086e-08 78.362499999999997p -3.058023e-08 78.375p -2.948244e-08 78.387500000000003p -2.8349020000000001e-08 78.399999999999991p -2.718154e-08 78.412499999999994p -2.5981619999999999e-08 78.424999999999997p -2.4750909999999999e-08 78.4375p -2.3491080000000001e-08 78.450000000000003p -2.220387e-08 78.462500000000006p -2.0891030000000001e-08 78.475000000000009p -1.955433e-08 78.487499999999997p -1.8195590000000001e-08 78.5p -1.6816639999999999e-08 78.512500000000003p -1.541933e-08 78.524999999999991p -1.400555e-08
+ 78.537499999999994p -1.257717e-08 78.549999999999997p -1.113611e-08 78.5625p -9.6842859999999994e-09 78.575000000000003p -8.223622e-09 78.587500000000006p -6.7560529999999998e-09 78.600000000000009p -5.2835179999999997e-09 78.612499999999997p -3.8079560000000001e-09 78.625p -2.3313070000000002e-09 78.637500000000003p -8.555052e-10 78.649999999999991p 6.1751890000000001e-10 78.662499999999994p 2.0858439999999999e-09 78.674999999999997p 3.547561e-09 78.6875p 5.0007710000000002e-09 78.700000000000003p 6.4435949999999996e-09 78.712500000000006p 7.8741680000000005e-09 78.725000000000009p 9.2906509999999999e-09 78.737499999999997p 1.069122e-08 78.75p 1.207409e-08
+ 78.762500000000003p 1.3437490000000001e-08 78.774999999999991p 1.477968e-08 78.787499999999994p 1.6098960000000001e-08 78.799999999999997p 1.7393660000000001e-08 78.8125p 1.866215e-08 78.825000000000003p 1.9902829999999998e-08 78.837500000000006p 2.1114150000000001e-08 78.850000000000009p 2.229459e-08 78.862499999999997p 2.3442690000000001e-08 78.875p 2.4557019999999999e-08 78.887500000000003p 2.5636219999999999e-08 78.899999999999991p 2.6678950000000001e-08 78.912499999999994p 2.7683949999999999e-08 78.924999999999997p 2.8649989999999999e-08 78.9375p 2.9575900000000001e-08 78.950000000000003p 3.0460569999999999e-08 78.962500000000006p 3.130296e-08 78.975000000000009p 3.2102050000000001e-08
+ 78.987499999999997p 3.2856920000000002e-08 79p 3.3566689999999999e-08 79.012500000000003p 3.423053e-08 79.025000000000006p 3.4847699999999999e-08 79.037499999999994p 3.5417510000000003e-08 79.049999999999997p 3.5939330000000001e-08 79.0625p 3.6412589999999998e-08 79.075000000000003p 3.6836799999999997e-08 79.087500000000006p 3.7211520000000002e-08 79.100000000000009p 3.7536400000000001e-08 79.112499999999997p 3.7811119999999999e-08 79.125p 3.8035459999999997e-08 79.137500000000003p 3.8209239999999999e-08 79.150000000000006p 3.8332379999999997e-08 79.162499999999994p 3.8404820000000001e-08 79.174999999999997p 3.8426609999999999e-08 79.1875p 3.8397850000000003e-08 79.199999999999989p 3.8318699999999998e-08
+ 79.212500000000006p 3.8189380000000001e-08 79.225000000000009p 3.8010210000000002e-08 79.237499999999997p 3.778152e-08 79.25p 3.7503759999999999e-08 79.262500000000003p 3.7177410000000001e-08 79.275000000000006p 3.6803009999999999e-08 79.287499999999994p 3.6381190000000001e-08 79.299999999999997p 3.5912599999999997e-08 79.3125p 3.5397990000000001e-08 79.324999999999989p 3.4838140000000002e-08 79.337500000000006p 3.4233909999999998e-08 79.350000000000009p 3.3586190000000001e-08 79.362500000000011p 3.2895950000000003e-08 79.375p 3.21642e-08 79.387500000000003p 3.1391989999999998e-08 79.400000000000006p 3.0580460000000001e-08 79.412499999999994p 2.973076e-08 79.424999999999997p 2.8844099999999999e-08
+ 79.4375p 2.792173e-08 79.449999999999989p 2.6964970000000001e-08 79.462499999999991p 2.5975150000000001e-08 79.475000000000009p 2.495366e-08 79.487500000000011p 2.3901909999999999e-08 79.5p 2.2821359999999999e-08 79.512500000000003p 2.1713510000000001e-08 79.525000000000006p 2.0579880000000001e-08 79.537499999999994p 1.942202e-08 79.549999999999997p 1.8241520000000001e-08 79.5625p 1.7039989999999999e-08 79.574999999999989p 1.581905e-08 79.587499999999991p 1.4580359999999999e-08 79.600000000000009p 1.332559e-08 79.612500000000011p 1.205644e-08 79.625p 1.077461e-08 79.637500000000003p 9.481823e-09 79.650000000000006p 8.1797989999999999e-09
+ 79.662499999999994p 6.8702790000000001e-09 79.674999999999997p 5.5550060000000002e-09 79.6875p 4.2357249999999999e-09 79.699999999999989p 2.914184e-09 79.712499999999991p 1.5921290000000001e-09 79.724999999999994p 2.7130339999999998e-10 79.737500000000011p -1.0465559999999999e-09 79.75p -2.3597200000000002e-09 79.762500000000003p -3.6664700000000001e-09 79.775000000000006p -4.9650979999999999e-09 79.787499999999994p -6.2539120000000002e-09 79.799999999999997p -7.5312369999999992e-09 79.8125p -8.7954169999999993e-09 79.825000000000003p -1.004482e-08 79.837499999999991p -1.1277820000000001e-08 79.849999999999994p -1.249285e-08 79.862500000000011p -1.3688329999999999e-08 79.875p -1.486275e-08
+ 79.887500000000003p -1.60146e-08 79.900000000000006p -1.7142410000000001e-08 79.912499999999994p -1.8244759999999999e-08 79.924999999999997p -1.9320250000000001e-08 79.9375p -2.036752e-08 79.950000000000003p -2.1385259999999999e-08 79.962499999999991p -2.2372200000000001e-08 79.974999999999994p -2.33271e-08 79.987499999999997p -2.424878e-08 80p -2.51361e-08 80.012500000000003p -2.5987980000000001e-08 80.025000000000006p -2.6803360000000001e-08 80.037499999999994p -2.7581260000000001e-08 80.049999999999997p -2.8320749999999999e-08 80.0625p -2.902092e-08 80.075000000000003p -2.968095e-08 80.087499999999991p -3.0300070000000002e-08 80.099999999999994p -3.0877539999999999e-08
+ 80.112499999999997p -3.1412709999999998e-08 80.125p -3.1904969999999997e-08 80.137500000000003p -3.2353749999999999e-08 80.150000000000006p -3.2758589999999997e-08 80.162500000000009p -3.3119030000000003e-08 80.174999999999997p -3.3434710000000001e-08 80.1875p -3.3705310000000003e-08 80.200000000000003p -3.393058e-08 80.212499999999991p -3.4110329999999998e-08 80.224999999999994p -3.4244429999999997e-08 80.237499999999997p -3.4332800000000003e-08 80.25p -3.4375440000000003e-08 80.262500000000003p -3.4372389999999997e-08 80.275000000000006p -3.432376e-08 80.287500000000009p -3.422972e-08 80.299999999999997p -3.409051e-08 80.3125p -3.3906400000000001e-08 80.325000000000003p -3.3677749999999999e-08
+ 80.337499999999991p -3.3404960000000001e-08 80.349999999999994p -3.3088499999999999e-08 80.362499999999997p -3.272887e-08 80.375p -3.2326670000000003e-08 80.387500000000003p -3.1882509999999998e-08 80.400000000000006p -3.1397079999999999e-08 80.412500000000009p -3.0871130000000001e-08 80.424999999999997p -3.0305420000000001e-08 80.4375p -2.9700820000000001e-08 80.450000000000003p -2.9058199999999999e-08 80.462499999999991p -2.8378500000000002e-08 80.474999999999994p -2.7662710000000001e-08 80.487499999999997p -2.6911850000000002e-08 80.5p -2.6127e-08 80.512500000000003p -2.5309279999999998e-08 80.525000000000006p -2.4459840000000001e-08 80.537500000000009p -2.3579880000000002e-08 80.549999999999997p -2.2670639999999999e-08
+ 80.5625p -2.1733369999999999e-08 80.575000000000003p -2.0769400000000001e-08 80.587499999999991p -1.9780039999999999e-08 80.599999999999994p -1.8766679999999999e-08 80.612499999999997p -1.7730699999999999e-08 80.625p -1.667353e-08 80.637500000000003p -1.5596609999999999e-08 80.650000000000006p -1.450142e-08 80.662500000000009p -1.338945e-08 80.674999999999997p -1.22622e-08 80.6875p -1.11212e-08 80.700000000000003p -9.9679929999999997e-09 80.712499999999991p -8.8041350000000006e-09 80.724999999999994p -7.6311870000000007e-09 80.737499999999997p -6.4507220000000001e-09 80.75p -5.2643200000000003e-09 80.762500000000003p -4.0735650000000001e-09 80.775000000000006p -2.8800409999999998e-09
+ 80.787500000000009p -1.685335e-09 80.799999999999997p -4.9102970000000002e-10 80.8125p 7.0129459999999998e-10 80.825000000000003p 1.8900649999999999e-09 80.837499999999991p 3.0737150000000001e-09 80.849999999999994p 4.2506919999999997e-09 80.862499999999997p 5.4194519999999997e-09 80.875p 6.5784659999999999e-09 80.887500000000003p 7.7262239999999994e-09 80.900000000000006p 8.8612309999999999e-09 80.912500000000009p 9.9820140000000008e-09 80.924999999999997p 1.108712e-08 80.9375p 1.217513e-08 80.950000000000003p 1.324463e-08 80.962500000000006p 1.4294250000000001e-08 80.974999999999994p 1.5322649999999999e-08 80.987499999999997p 1.6328509999999999e-08 81p 1.7310550000000001e-08
+ 81.012499999999989p 1.8267530000000001e-08 81.025000000000006p 1.9198230000000001e-08 81.037500000000009p 2.010149e-08 81.049999999999997p 2.097616e-08 81.0625p 2.1821149999999999e-08 81.075000000000003p 2.2635409999999999e-08 81.087500000000006p 2.3417929999999999e-08 81.099999999999994p 2.4167750000000001e-08 81.112499999999997p 2.488394e-08 81.125p 2.556562e-08 81.137499999999989p 2.621198e-08 81.150000000000006p 2.6822240000000001e-08 81.162500000000009p 2.739566e-08 81.174999999999997p 2.793156e-08 81.1875p 2.8429329999999999e-08 81.200000000000003p 2.8888369999999999e-08 81.212500000000006p 2.9308180000000001e-08 81.224999999999994p 2.9688270000000001e-08
+ 81.237499999999997p 3.002824e-08 81.25p 3.0327709999999999e-08 81.262499999999989p 3.0586380000000002e-08 81.274999999999991p 3.0803989999999999e-08 81.287500000000009p 3.0980339999999999e-08 81.300000000000011p 3.1115280000000001e-08 81.3125p 3.1208729999999998e-08 81.325000000000003p 3.1260649999999999e-08 81.337500000000006p 3.1271060000000002e-08 81.349999999999994p 3.124002e-08 81.362499999999997p 3.1167680000000002e-08 81.375p 3.1054199999999999e-08 81.387499999999989p 3.0899829999999998e-08 81.399999999999991p 3.0704859999999998e-08 81.412500000000009p 3.0469619999999999e-08 81.425000000000011p 3.0194510000000003e-08 81.4375p 2.9879969999999997e-08 81.450000000000003p 2.952651e-08
+ 81.462500000000006p 2.913466e-08 81.474999999999994p 2.8705030000000001e-08 81.487499999999997p 2.8238260000000001e-08 81.5p 2.7735039999999999e-08 81.512499999999989p 2.7196109999999999e-08 81.524999999999991p 2.6622259999999999e-08 81.537500000000009p 2.60143e-08 81.550000000000011p 2.537311e-08 81.5625p 2.4699610000000001e-08 81.575000000000003p 2.3994750000000001e-08 81.587500000000006p 2.325952e-08 81.599999999999994p 2.2494950000000001e-08 81.612499999999997p 2.170211e-08 81.625p 2.08821e-08 81.637500000000003p 2.0036060000000001e-08 81.649999999999991p 1.9165150000000001e-08 81.662499999999994p 1.8270570000000001e-08 81.675000000000011p 1.735354e-08
+ 81.6875p 1.6415320000000001e-08 81.700000000000003p 1.5457189999999998e-08 81.712500000000006p 1.4480450000000001e-08 81.724999999999994p 1.3486430000000001e-08 81.737499999999997p 1.247645e-08 81.75p 1.14519e-08 81.762500000000003p 1.041414e-08 81.774999999999991p 9.3645620000000008e-09 81.787499999999994p 8.3045809999999994e-09 81.800000000000011p 7.2356080000000002e-09 81.8125p 6.1590689999999996e-09 81.825000000000003p 5.0763949999999996e-09 81.837500000000006p 3.9890230000000001e-09 81.849999999999994p 2.8983930000000001e-09 81.862499999999997p 1.8059479999999999e-09 81.875p 7.1312669999999998e-10 81.887500000000003p -3.7863069999999998e-10 81.899999999999991p -1.46789e-09
+ 81.912499999999994p -2.553224e-09 81.924999999999997p -3.633211e-09 81.9375p -4.7064420000000004e-09 81.950000000000003p -5.771519e-09 81.962500000000006p -6.8270549999999999e-09 81.975000000000009p -7.8716820000000005e-09 81.987499999999997p -8.9040459999999996e-09 82p -9.9228139999999992e-09 82.012500000000003p -1.092667e-08 82.024999999999991p -1.1914329999999999e-08 82.037499999999994p -1.288452e-08 82.049999999999997p -1.3836000000000001e-08 82.0625p -1.4767550000000001e-08 82.075000000000003p -1.5678e-08 82.087500000000006p -1.6566169999999999e-08 82.100000000000009p -1.743096e-08 82.112499999999997p -1.8271259999999999e-08 82.125p -1.908601e-08
+ 82.137500000000003p -1.9874210000000001e-08 82.149999999999991p -2.0634850000000001e-08 82.162499999999994p -2.1366999999999999e-08 82.174999999999997p -2.2069740000000002e-08 82.1875p -2.274222e-08 82.200000000000003p -2.3383590000000001e-08 82.212500000000006p -2.3993090000000001e-08 82.225000000000009p -2.4569970000000001e-08 82.237499999999997p -2.5113520000000002e-08 82.25p -2.5623109999999999e-08 82.262500000000003p -2.6098130000000002e-08 82.274999999999991p -2.6538019999999999e-08 82.287499999999994p -2.6942260000000001e-08 82.299999999999997p -2.7310399999999999e-08 82.3125p -2.764201e-08 82.325000000000003p -2.793674e-08 82.337500000000006p -2.8194260000000001e-08 82.350000000000009p -2.8414299999999999e-08
+ 82.362499999999997p -2.8596659999999999e-08 82.375p -2.8741150000000001e-08 82.387500000000003p -2.8847659999999999e-08 82.399999999999991p -2.8916130000000001e-08 82.412499999999994p -2.894652e-08 82.424999999999997p -2.893889e-08 82.4375p -2.8893289999999999e-08 82.450000000000003p -2.8809879999999999e-08 82.462500000000006p -2.8688819999999999e-08 82.475000000000009p -2.853035e-08 82.487499999999997p -2.8334739999999998e-08 82.5p -2.8102329999999998e-08 82.512500000000003p -2.7833469999999999e-08 82.524999999999991p -2.7528599999999999e-08 82.537499999999994p -2.7188179999999999e-08 82.549999999999997p -2.681273e-08 82.5625p -2.6402790000000001e-08 82.575000000000003p -2.5958980000000001e-08
+ 82.587500000000006p -2.548194e-08 82.600000000000009p -2.4972349999999999e-08 82.612499999999997p -2.4430949999999999e-08 82.625p -2.3858500000000002e-08 82.637500000000003p -2.3255809999999999e-08 82.649999999999991p -2.2623730000000001e-08 82.662499999999994p -2.1963130000000001e-08 82.674999999999997p -2.1274950000000001e-08 82.6875p -2.0560119999999999e-08 82.700000000000003p -1.9819649999999999e-08 82.712500000000006p -1.905454e-08 82.725000000000009p -1.8265840000000002e-08 82.737499999999997p -1.7454630000000001e-08 82.75p -1.6622010000000001e-08 82.762500000000003p -1.5769119999999999e-08 82.775000000000006p -1.48971e-08 82.787499999999994p -1.4007139999999999e-08 82.799999999999997p -1.310043e-08
+ 82.8125p -1.2178189999999999e-08 82.825000000000003p -1.124166e-08 82.837500000000006p -1.0292089999999999e-08 82.850000000000009p -9.3307400000000008e-09 82.862499999999997p -8.3588960000000005e-09 82.875p -7.3778459999999997e-09 82.887500000000003p -6.3888919999999997e-09 82.900000000000006p -5.3933399999999999e-09 82.912499999999994p -4.3925050000000002e-09 82.924999999999997p -3.3877050000000001e-09 82.9375p -2.3802610000000001e-09 82.949999999999989p -1.371494e-09 82.962500000000006p -3.6272570000000002e-10 82.975000000000009p 6.4472669999999999e-10 82.987499999999997p 1.649549e-09 83p 2.6504339999999999e-09 83.012500000000003p 3.6460820000000001e-09 83.025000000000006p 4.6352019999999997e-09
+ 83.037499999999994p 5.616515e-09 83.049999999999997p 6.5887539999999996e-09 83.0625p 7.5506679999999993e-09 83.074999999999989p 8.5010199999999992e-09 83.087500000000006p 9.438592e-09 83.100000000000009p 1.036219e-08 83.112500000000011p 1.127062e-08 83.125p 1.2162739999999999e-08 83.137500000000003p 1.3037419999999999e-08 83.150000000000006p 1.3893540000000001e-08 83.162499999999994p 1.473002e-08 83.174999999999997p 1.5545810000000001e-08 83.1875p 1.6339900000000001e-08 83.199999999999989p 1.711127e-08 83.212499999999991p 1.7858980000000002e-08 83.225000000000009p 1.8582089999999999e-08 83.237500000000011p 1.9279710000000001e-08 83.25p 1.9950970000000001e-08
+ 83.262500000000003p 2.0595059999999999e-08 83.275000000000006p 2.1211190000000001e-08 83.287499999999994p 2.17986e-08 83.299999999999997p 2.2356600000000001e-08 83.3125p 2.2884499999999999e-08 83.324999999999989p 2.3381690000000001e-08 83.337499999999991p 2.3847570000000001e-08 83.350000000000009p 2.428159e-08 83.362500000000011p 2.468327e-08 83.375p 2.505212e-08 83.387500000000003p 2.5387749999999998e-08 83.400000000000006p 2.568978e-08 83.412499999999994p 2.5957880000000001e-08 83.424999999999997p 2.619177e-08 83.4375p 2.6391209999999999e-08 83.449999999999989p 2.6556019999999999e-08 83.462499999999991p 2.6686040000000001e-08 83.474999999999994p 2.6781180000000001e-08
+ 83.487500000000011p 2.6841380000000001e-08 83.5p 2.6866629999999999e-08 83.512500000000003p 2.685698e-08 83.525000000000006p 2.681249e-08 83.537499999999994p 2.6733310000000001e-08 83.549999999999997p 2.6619600000000001e-08 83.5625p 2.6471579999999999e-08 83.575000000000003p 2.6289519999999998e-08 83.587499999999991p 2.6073709999999999e-08 83.599999999999994p 2.5824500000000001e-08 83.612500000000011p 2.5542290000000001e-08 83.625p 2.5227519999999999e-08 83.637500000000003p 2.4880650000000001e-08 83.650000000000006p 2.4502200000000001e-08 83.662499999999994p 2.4092739999999999e-08 83.674999999999997p 2.3652839999999999e-08 83.6875p 2.3183160000000001e-08 83.700000000000003p 2.2684349999999999e-08
+ 83.712499999999991p 2.215713e-08 83.724999999999994p 2.1602240000000001e-08 83.737499999999997p 2.102046e-08 83.75p 2.04126e-08 83.762500000000003p 1.9779499999999999e-08 83.775000000000006p 1.912204e-08 83.787499999999994p 1.8441120000000001e-08 83.799999999999997p 1.773768e-08 83.8125p 1.7012669999999999e-08 83.825000000000003p 1.6267079999999998e-08 83.837499999999991p 1.550192e-08 83.849999999999994p 1.471824e-08 83.862499999999997p 1.3917070000000001e-08 83.875p 1.3099510000000001e-08 83.887500000000003p 1.2266649999999999e-08 83.900000000000006p 1.1419590000000001e-08 83.912500000000009p 1.055948e-08 83.924999999999997p 9.6874529999999998e-09
+ 83.9375p 8.8046669999999998e-09 83.950000000000003p 7.9122920000000004e-09 83.962499999999991p 7.0115070000000002e-09 83.974999999999994p 6.1034999999999999e-09 83.987499999999997p 5.189464e-09 84p 4.2705999999999997e-09 84.012500000000003p 3.3481099999999999e-09 84.025000000000006p 2.423201e-09 84.037500000000009p 1.4970759999999999e-09 84.049999999999997p 5.7094319999999998e-10 84.0625p -3.5399710000000002e-10 84.075000000000003p -1.2765460000000001e-09 84.087499999999991p -2.1955109999999999e-09 84.099999999999994p -3.1097069999999999e-09 84.112499999999997p -4.0179579999999998e-09 84.125p -4.9190970000000004e-09 84.137500000000003p -5.8119699999999997e-09 84.150000000000006p -6.6954350000000003e-09
+ 84.162500000000009p -7.5683669999999999e-09 84.174999999999997p -8.4296540000000006e-09 84.1875p -9.2782049999999996e-09 84.200000000000003p -1.011294e-08 84.212499999999991p -1.093282e-08 84.224999999999994p -1.17368e-08 84.237499999999997p -1.252388e-08 84.25p -1.329306e-08 84.262500000000003p -1.4043400000000001e-08 84.275000000000006p -1.4773949999999999e-08 84.287500000000009p -1.548382e-08 84.299999999999997p -1.6172129999999999e-08 84.3125p -1.6838030000000001e-08 84.325000000000003p -1.748071e-08 84.337499999999991p -1.8099380000000001e-08 84.349999999999994p -1.869329e-08 84.362499999999997p -1.9261740000000001e-08 84.375p -1.9804029999999999e-08
+ 84.387500000000003p -2.0319519999999999e-08 84.400000000000006p -2.0807610000000002e-08 84.412500000000009p -2.1267709999999999e-08 84.424999999999997p -2.1699300000000001e-08 84.4375p -2.210188e-08 84.450000000000003p -2.2474980000000001e-08 84.462499999999991p -2.281821e-08 84.474999999999994p -2.3131159999999999e-08 84.487499999999997p -2.341351e-08 84.5p -2.3664970000000001e-08 84.512500000000003p -2.3885259999999999e-08 84.525000000000006p -2.4074179999999999e-08 84.537500000000009p -2.423155e-08 84.549999999999997p -2.4357250000000001e-08 84.5625p -2.445117e-08 84.575000000000003p -2.4513269999999999e-08 84.587500000000006p -2.454355e-08 84.599999999999994p -2.4542029999999999e-08
+ 84.612499999999997p -2.4508780000000001e-08 84.625p -2.4443940000000001e-08 84.637500000000003p -2.4347650000000002e-08 84.650000000000006p -2.42201e-08 84.662500000000009p -2.4061549999999999e-08 84.674999999999997p -2.3872250000000001e-08 84.6875p -2.3652539999999999e-08 84.700000000000003p -2.3402770000000001e-08 84.712500000000006p -2.3123330000000001e-08 84.724999999999994p -2.281465e-08 84.737499999999997p -2.2477200000000001e-08 84.75p -2.2111489999999999e-08 84.762499999999989p -2.1718059999999999e-08 84.775000000000006p -2.129748e-08 84.787500000000009p -2.085036e-08 84.799999999999997p -2.037735e-08 84.8125p -1.9879120000000001e-08 84.825000000000003p -1.935638e-08
+ 84.837500000000006p -1.8809859999999999e-08 84.849999999999994p -1.8240329999999999e-08 84.862499999999997p -1.764858e-08 84.875p -1.7035440000000001e-08 84.887499999999989p -1.640175e-08 84.900000000000006p -1.5748379999999999e-08 84.912500000000009p -1.5076229999999999e-08 84.924999999999997p -1.438622e-08 84.9375p -1.367928e-08 84.950000000000003p -1.2956380000000001e-08 84.962500000000006p -1.221849e-08 84.974999999999994p -1.1466599999999999e-08 84.987499999999997p -1.070173e-08 85p -9.9249040000000004e-09 85.012499999999989p -9.1371540000000005e-09 85.024999999999991p -8.3395320000000003e-09 85.037500000000009p -7.5330980000000002e-09 85.050000000000011p -6.7189219999999996e-09
+ 85.0625p -5.89808e-09 85.075000000000003p -5.0716549999999999e-09 85.087500000000006p -4.2407340000000001e-09 85.099999999999994p -3.4064079999999998e-09 85.112499999999997p -2.5697699999999999e-09 85.125p -1.731911e-09 85.137499999999989p -8.9392480000000003e-10 85.149999999999991p -5.68998e-11 85.162500000000009p 7.7807830000000004e-10 85.175000000000011p 1.6099289999999999e-09 85.1875p 2.4375789999999999e-09 85.200000000000003p 3.2599630000000001e-09 85.212500000000006p 4.0760250000000001e-09 85.224999999999994p 4.8847179999999998e-09 85.237499999999997p 5.6850110000000003e-09 85.25p 6.4758839999999998e-09 85.262499999999989p 7.2563310000000002e-09 85.274999999999991p 8.0253639999999993e-09
+ 85.287500000000009p 8.7820100000000004e-09 85.300000000000011p 9.5253169999999994e-09 85.3125p 1.0254349999999999e-08 85.325000000000003p 1.09682e-08 85.337500000000006p 1.166597e-08 85.349999999999994p 1.23468e-08 85.362499999999997p 1.3009840000000001e-08 85.375p 1.3654279999999999e-08 85.387500000000003p 1.4279319999999999e-08 85.399999999999991p 1.48842e-08 85.412499999999994p 1.5468180000000001e-08 85.425000000000011p 1.6030559999999998e-08 85.4375p 1.6570650000000001e-08 85.450000000000003p 1.708781e-08 85.462500000000006p 1.7581429999999999e-08 85.474999999999994p 1.8050920000000002e-08 85.487499999999997p 1.8495729999999999e-08 85.5p 1.891535e-08
+ 85.512500000000003p 1.9309290000000001e-08 85.524999999999991p 1.967711e-08 85.537499999999994p 2.001838e-08 85.550000000000011p 2.0332740000000001e-08 85.5625p 2.0619850000000001e-08 85.575000000000003p 2.087939e-08 85.587500000000006p 2.1111099999999998e-08 85.599999999999994p 2.1314749999999999e-08 85.612499999999997p 2.1490150000000001e-08 85.625p 2.1637139999999999e-08 85.637500000000003p 2.1755600000000001e-08 85.649999999999991p 2.1845449999999999e-08 85.662499999999994p 2.190664e-08 85.674999999999997p 2.193917e-08 85.6875p 2.1943069999999999e-08 85.700000000000003p 2.191841e-08 85.712500000000006p 2.1865290000000001e-08 85.725000000000009p 2.178385e-08
+ 85.737499999999997p 2.1674279999999999e-08 85.75p 2.1536779999999999e-08 85.762500000000003p 2.1371619999999999e-08 85.774999999999991p 2.117907e-08 85.787499999999994p 2.095946e-08 85.799999999999997p 2.071314e-08 85.8125p 2.044051e-08 85.825000000000003p 2.0141989999999999e-08 85.837500000000006p 1.9818019999999999e-08 85.850000000000009p 1.9469119999999999e-08 85.862499999999997p 1.909578e-08 85.875p 1.8698569999999999e-08 85.887500000000003p 1.8278049999999999e-08 85.899999999999991p 1.7834859999999999e-08 85.912499999999994p 1.7369610000000001e-08 85.924999999999997p 1.688297e-08 85.9375p 1.6375640000000002e-08 85.950000000000003p 1.584833e-08
+ 85.962500000000006p 1.530179e-08 85.975000000000009p 1.4736769999999999e-08 85.987499999999997p 1.415406e-08 86p 1.3554479999999999e-08 86.012500000000003p 1.293884e-08 86.024999999999991p 1.2308e-08 86.037499999999994p 1.1662810000000001e-08 86.049999999999997p 1.100417e-08 86.0625p 1.0332959999999999e-08 86.075000000000003p 9.6500969999999999e-09 86.087500000000006p 8.9565049999999998e-09 86.100000000000009p 8.2531199999999997e-09 86.112499999999997p 7.5408859999999996e-09 86.125p 6.8207580000000001e-09 86.137500000000003p 6.0937009999999997e-09 86.149999999999991p 5.3606840000000002e-09 86.162499999999994p 4.6226819999999998e-09 86.174999999999997p 3.8806739999999996e-09
+ 86.1875p 3.1356429999999999e-09 86.200000000000003p 2.388572e-09 86.212500000000006p 1.640446e-09 86.225000000000009p 8.9224720000000003e-10 86.237499999999997p 1.4495610000000001e-10 86.25p -6.0045009999999996e-10 86.262500000000003p -1.3429989999999999e-09 86.274999999999991p -2.081726e-09 86.287499999999994p -2.815671e-09 86.299999999999997p -3.543884e-09 86.3125p -4.2654259999999998e-09 86.325000000000003p -4.9793680000000001e-09 86.337500000000006p -5.6847930000000003e-09 86.350000000000009p -6.3807980000000003e-09 86.362499999999997p -7.0664930000000002e-09 86.375p -7.7410070000000002e-09 86.387500000000003p -8.4034829999999993e-09 86.399999999999991p -9.0530819999999997e-09
+ 86.412499999999994p -9.6889860000000004e-09 86.424999999999997p -1.0310399999999999e-08 86.4375p -1.091653e-08 86.450000000000003p -1.1506639999999999e-08 86.462500000000006p -1.207999e-08 86.475000000000009p -1.263586e-08 86.487499999999997p -1.317358e-08 86.5p -1.369248e-08 86.512500000000003p -1.419193e-08 86.525000000000006p -1.467133e-08 86.537499999999994p -1.5130099999999999e-08 86.549999999999997p -1.5567680000000001e-08 86.5625p -1.5983560000000001e-08 86.574999999999989p -1.6377259999999999e-08 86.587500000000006p -1.6748299999999999e-08 86.600000000000009p -1.709626e-08 86.612499999999997p -1.7420740000000001e-08 86.625p -1.7721369999999999e-08
+ 86.637500000000003p -1.7997829999999999e-08 86.650000000000006p -1.824981e-08 86.662499999999994p -1.847705e-08 86.674999999999997p -1.8679300000000001e-08 86.6875p -1.8856379999999999e-08 86.699999999999989p -1.9008099999999999e-08 86.712500000000006p -1.913434e-08 86.725000000000009p -1.9235e-08 86.737499999999997p -1.9310009999999999e-08 86.75p -1.9359340000000001e-08 86.762500000000003p -1.9382989999999999e-08 86.775000000000006p -1.938099e-08 86.787499999999994p -1.935342e-08 86.799999999999997p -1.9300379999999999e-08 86.8125p -1.9222010000000002e-08 86.824999999999989p -1.911847e-08 86.837500000000006p -1.898997e-08 86.850000000000009p -1.8836729999999998e-08
+ 86.862500000000011p -1.8659040000000001e-08 86.875p -1.8457179999999999e-08 86.887500000000003p -1.823148e-08 86.900000000000006p -1.7982300000000001e-08 86.912499999999994p -1.7710040000000001e-08 86.924999999999997p -1.7415109999999999e-08 86.9375p -1.7097969999999999e-08 86.949999999999989p -1.6759070000000001e-08 86.962499999999991p -1.6398940000000001e-08 86.975000000000009p -1.60181e-08 86.987500000000011p -1.5617099999999999e-08 87p -1.5196529999999999e-08 87.012500000000003p -1.475699e-08 87.025000000000006p -1.429912e-08 87.037499999999994p -1.382357e-08 87.049999999999997p -1.3331e-08 87.0625p -1.2822109999999999e-08 87.074999999999989p -1.229763e-08
+ 87.087499999999991p -1.175827e-08 87.100000000000009p -1.1204789999999999e-08 87.112500000000011p -1.0637969999999999e-08 87.125p -1.005857e-08 87.137500000000003p -9.467411e-09 87.150000000000006p -8.8652900000000001e-09 87.162499999999994p -8.2530350000000008e-09 87.174999999999997p -7.6314810000000001e-09 87.1875p -7.0014730000000004e-09 87.199999999999989p -6.3638669999999997e-09 87.212499999999991p -5.7195239999999997e-09 87.224999999999994p -5.0693150000000001e-09 87.237500000000011p -4.414112e-09 87.25p -3.7547970000000002e-09 87.262500000000003p -3.0922509999999999e-09 87.275000000000006p -2.4273589999999999e-09 87.287499999999994p -1.7610060000000001e-09 87.299999999999997p -1.094078e-09
+ 87.3125p -4.2745819999999998e-10 87.325000000000003p 2.379721e-10 87.337499999999991p 9.0133539999999999e-10 87.349999999999994p 1.5617590000000001e-09 87.362500000000011p 2.2183769999999998e-09 87.375p 2.870329e-09 87.387500000000003p 3.5167640000000002e-09 87.400000000000006p 4.1568410000000002e-09 87.412499999999994p 4.7897289999999998e-09 87.424999999999997p 5.4146069999999996e-09 87.4375p 6.0306689999999999e-09 87.450000000000003p 6.6371200000000003e-09 87.462499999999991p 7.2331820000000003e-09 87.474999999999994p 7.8180930000000008e-09 87.487499999999997p 8.3911040000000006e-09 87.5p 8.9514859999999996e-09 87.512500000000003p 9.4985300000000003e-09 87.525000000000006p 1.0031540000000001e-08
+ 87.537499999999994p 1.054985e-08 87.549999999999997p 1.105281e-08 87.5625p 1.153979e-08 87.575000000000003p 1.2010190000000001e-08 87.587499999999991p 1.246341e-08 87.599999999999994p 1.289891e-08 87.612499999999997p 1.331615e-08 87.625p 1.371462e-08 87.637500000000003p 1.4093840000000001e-08 87.650000000000006p 1.4453359999999999e-08 87.662500000000009p 1.479274e-08 87.674999999999997p 1.5111579999999998e-08 87.6875p 1.540952e-08 87.700000000000003p 1.56862e-08 87.712499999999991p 1.594132e-08 87.724999999999994p 1.6174579999999999e-08 87.737499999999997p 1.6385739999999998e-08 87.75p 1.657455e-08
+ 87.762500000000003p 1.674083e-08 87.775000000000006p 1.6884409999999999e-08 87.787500000000009p 1.7005150000000001e-08 87.799999999999997p 1.7102950000000002e-08 87.8125p 1.717774e-08 87.825000000000003p 1.7229449999999999e-08 87.837499999999991p 1.72581e-08 87.849999999999994p 1.7263679999999999e-08 87.862499999999997p 1.7246240000000001e-08 87.875p 1.720587e-08 87.887500000000003p 1.7142670000000001e-08 87.900000000000006p 1.7056780000000001e-08 87.912500000000009p 1.694836e-08 87.924999999999997p 1.681761e-08 87.9375p 1.666476e-08 87.950000000000003p 1.649005e-08 87.962499999999991p 1.629378e-08 87.974999999999994p 1.6076240000000002e-08
+ 87.987499999999997p 1.5837779999999999e-08 88p 1.557877e-08 88.012500000000003p 1.529958e-08 88.025000000000006p 1.5000650000000001e-08 88.037500000000009p 1.4682400000000001e-08 88.049999999999997p 1.43453e-08 88.0625p 1.398985e-08 88.075000000000003p 1.3616560000000001e-08 88.087499999999991p 1.3225959999999999e-08 88.099999999999994p 1.28186e-08 88.112499999999997p 1.239508e-08 88.125p 1.195597e-08 88.137500000000003p 1.150191e-08 88.150000000000006p 1.1033520000000001e-08 88.162500000000009p 1.0551450000000001e-08 88.174999999999997p 1.0056389999999999e-08 88.1875p 9.5490039999999996e-09 88.200000000000003p 9.0300019999999994e-09
+ 88.212499999999991p 8.5000950000000005e-09 88.224999999999994p 7.9600099999999997e-09 88.237499999999997p 7.4104840000000003e-09 88.25p 6.8522669999999998e-09 88.262500000000003p 6.2861180000000004e-09 88.275000000000006p 5.7128029999999997e-09 88.287500000000009p 5.1330989999999997e-09 88.299999999999997p 4.5477879999999998e-09 88.3125p 3.9576579999999999e-09 88.325000000000003p 3.3635010000000001e-09 88.337500000000006p 2.7661130000000002e-09 88.349999999999994p 2.1662930000000001e-09 88.362499999999997p 1.5648430000000001e-09 88.375p 9.6256070000000005e-10 88.387500000000003p 3.6024820000000002e-10 88.400000000000006p -2.4129670000000002e-10 88.412500000000009p -8.4127829999999999e-10 88.424999999999997p -1.438905e-09
+ 88.4375p -2.0333879999999999e-09 88.450000000000003p -2.623948e-09 88.462500000000006p -3.2098100000000001e-09 88.474999999999994p -3.7902059999999998e-09 88.487499999999997p -4.3643799999999998e-09 88.5p -4.9315830000000002e-09 88.512499999999989p -5.4910769999999999e-09 88.525000000000006p -6.0421370000000003e-09 88.537500000000009p -6.5840510000000001e-09 88.549999999999997p -7.1161180000000002e-09 88.5625p -7.6376539999999992e-09 88.575000000000003p -8.1479889999999994e-09 88.587500000000006p -8.6464699999999994e-09 88.599999999999994p -9.1324589999999994e-09 88.612499999999997p -9.6053399999999998e-09 88.625p -1.006451e-08 88.637499999999989p -1.050939e-08 88.650000000000006p -1.0939419999999999e-08
+ 88.662500000000009p -1.135406e-08 88.674999999999997p -1.175279e-08 88.6875p -1.2135109999999999e-08 88.700000000000003p -1.2500559999999999e-08 88.712500000000006p -1.284867e-08 88.724999999999994p -1.317902e-08 88.737499999999997p -1.349122e-08 88.75p -1.378488e-08 88.762499999999989p -1.4059650000000001e-08 88.774999999999991p -1.43152e-08 88.787500000000009p -1.4551239999999999e-08 88.800000000000011p -1.476748e-08 88.8125p -1.4963680000000001e-08 88.825000000000003p -1.513963e-08 88.837500000000006p -1.5295120000000001e-08 88.849999999999994p -1.542998e-08 88.862499999999997p -1.5544089999999999e-08 88.875p -1.5637339999999999e-08
+ 88.887499999999989p -1.5709620000000001e-08 88.899999999999991p -1.5760899999999999e-08 88.912500000000009p -1.5791140000000001e-08 88.925000000000011p -1.5800350000000002e-08 88.9375p -1.5788549999999999e-08 88.950000000000003p -1.5755790000000001e-08 88.962500000000006p -1.5702169999999999e-08 88.974999999999994p -1.5627789999999999e-08 88.987499999999997p -1.553279e-08 89p -1.5417330000000001e-08 89.012499999999989p -1.5281609999999999e-08 89.024999999999991p -1.5125840000000001e-08 89.037500000000009p -1.4950259999999998e-08 89.050000000000011p -1.475515e-08 89.0625p -1.454081e-08 89.075000000000003p -1.430754e-08 89.087500000000006p -1.4055700000000001e-08 89.099999999999994p -1.3785649999999999e-08
+ 89.112499999999997p -1.3497780000000001e-08 89.125p -1.319251e-08 89.137500000000003p -1.287027e-08 89.149999999999991p -1.253152e-08 89.162499999999994p -1.217674e-08 89.175000000000011p -1.180642e-08 89.1875p -1.1421090000000001e-08 89.200000000000003p -1.102127e-08 89.212500000000006p -1.060754e-08 89.224999999999994p -1.018045e-08 89.237499999999997p -9.740592e-09 89.25p -9.2885789999999995e-09 89.262500000000003p -8.8250249999999993e-09 89.274999999999991p -8.3505639999999998e-09 89.287499999999994p -7.8658409999999997e-09 89.300000000000011p -7.3715160000000002e-09 89.3125p -6.8682580000000002e-09 89.325000000000003p -6.3567480000000002e-09
+ 89.337500000000006p -5.8376749999999997e-09 89.349999999999994p -5.3117379999999999e-09 89.362499999999997p -4.7796449999999998e-09 89.375p -4.2421059999999999e-09 89.387500000000003p -3.699843e-09 89.399999999999991p -3.1535770000000001e-09 89.412499999999994p -2.6040369999999999e-09 89.424999999999997p -2.0519529999999999e-09 89.4375p -1.498057e-09 89.450000000000003p -9.430835000000001e-10 89.462500000000006p -3.8776520000000002e-10 89.475000000000009p 1.6716549999999999e-10 89.487499999999997p 7.2097789999999998e-10 89.5p 1.272944e-09 89.512500000000003p 1.822341e-09 89.524999999999991p 2.36845e-09 89.537499999999994p 2.9105559999999999e-09 89.549999999999997p 3.4479539999999999e-09
+ 89.5625p 3.9799440000000003e-09 89.575000000000003p 4.5058350000000003e-09 89.587500000000006p 5.0249459999999997e-09 89.600000000000009p 5.5366069999999998e-09 89.612499999999997p 6.0401570000000002e-09 89.625p 6.5349480000000003e-09 89.637500000000003p 7.0203439999999998e-09 89.649999999999991p 7.4957239999999995e-09 89.662499999999994p 7.9604809999999993e-09 89.674999999999997p 8.4140230000000008e-09 89.6875p 8.8557720000000001e-09 89.700000000000003p 9.2851689999999994e-09 89.712500000000006p 9.7016719999999995e-09 89.725000000000009p 1.010476e-08 89.737499999999997p 1.0493920000000001e-08 89.75p 1.086866e-08 89.762500000000003p 1.122853e-08 89.774999999999991p 1.1573079999999999e-08
+ 89.787499999999994p 1.1901879999999999e-08 89.799999999999997p 1.221452e-08 89.8125p 1.251062e-08 89.825000000000003p 1.2789839999999999e-08 89.837500000000006p 1.3051820000000001e-08 89.850000000000009p 1.3296250000000001e-08 89.862499999999997p 1.352286e-08 89.875p 1.373136e-08 89.887500000000003p 1.392152e-08 89.899999999999991p 1.4093119999999999e-08 89.912499999999994p 1.4245969999999999e-08 89.924999999999997p 1.437991e-08 89.9375p 1.4494779999999999e-08 89.950000000000003p 1.459047e-08 89.962500000000006p 1.4666899999999999e-08 89.975000000000009p 1.4724e-08 89.987499999999997p 1.476172e-08 90p 1.478004e-08
+ 90.012500000000003p 1.477899e-08 90.024999999999991p 1.47586e-08 90.037499999999994p 1.471892e-08 90.049999999999997p 1.466004e-08 90.0625p 1.458208e-08 90.075000000000003p 1.448517e-08 90.087500000000006p 1.436947e-08 90.100000000000009p 1.4235159999999999e-08 90.112499999999997p 1.4082459999999999e-08 90.125p 1.3911600000000001e-08 90.137500000000003p 1.372282e-08 90.149999999999991p 1.351642e-08 90.162499999999994p 1.3292690000000001e-08 90.174999999999997p 1.3051950000000001e-08 90.1875p 1.279455e-08 90.200000000000003p 1.252086e-08 90.212500000000006p 1.2231260000000001e-08 90.225000000000009p 1.192616e-08
+ 90.237499999999997p 1.160599e-08 90.25p 1.127118e-08 90.262500000000003p 1.0922209999999999e-08 90.275000000000006p 1.055956e-08 90.287499999999994p 1.0183710000000001e-08 90.299999999999997p 9.7951989999999999e-09 90.3125p 9.394541e-09 90.324999999999989p 8.9822840000000002e-09 90.337500000000006p 8.5589869999999999e-09 90.350000000000009p 8.1252219999999996e-09 90.362499999999997p 7.6815740000000004e-09 90.375p 7.2286389999999997e-09 90.387500000000003p 6.767025e-09 90.400000000000006p 6.29735e-09 90.412499999999994p 5.8202390000000003e-09 90.424999999999997p 5.3363299999999999e-09 90.4375p 4.8462630000000003e-09 90.449999999999989p 4.3506910000000003e-09
+ 90.462500000000006p 3.850268e-09 90.475000000000009p 3.345654e-09 90.487499999999997p 2.8375159999999999e-09 90.5p 2.3265220000000002e-09 90.512500000000003p 1.8133420000000001e-09 90.525000000000006p 1.298648e-09 90.537499999999994p 7.8311449999999998e-10 90.549999999999997p 2.6741310000000002e-10 90.5625p -2.4778430000000002e-10 90.574999999999989p -7.6180769999999997e-10 90.587500000000006p -1.2739900000000001e-09 90.600000000000009p -1.783669e-09 90.612500000000011p -2.290185e-09 90.625p -2.7928849999999999e-09 90.637500000000003p -3.2911219999999999e-09 90.650000000000006p -3.7842570000000002e-09 90.662499999999994p -4.2716559999999997e-09 90.674999999999997p -4.7526969999999998e-09
+ 90.6875p -5.2267660000000001e-09 90.699999999999989p -5.6932600000000003e-09 90.712499999999991p -6.1515850000000003e-09 90.725000000000009p -6.6011620000000002e-09 90.737500000000011p -7.0414219999999997e-09 90.75p -7.4718099999999997e-09 90.762500000000003p -7.8917849999999998e-09 90.775000000000006p -8.3008220000000005e-09 90.787499999999994p -8.6984080000000006e-09 90.799999999999997p -9.0840489999999996e-09 90.8125p -9.4572660000000003e-09 90.824999999999989p -9.8175969999999996e-09 90.837499999999991p -1.01646e-08 90.850000000000009p -1.0497849999999999e-08 90.862500000000011p -1.0816929999999999e-08 90.875p -1.112147e-08 90.887500000000003p -1.1411089999999999e-08 90.900000000000006p -1.168545e-08
+ 90.912499999999994p -1.194421e-08 90.924999999999997p -1.2187079999999999e-08 90.9375p -1.2413760000000001e-08 90.950000000000003p -1.262399e-08 90.962499999999991p -1.281754e-08 90.974999999999994p -1.299418e-08 90.987500000000011p -1.315372e-08 91p -1.3295980000000001e-08 91.012500000000003p -1.3420810000000001e-08 91.025000000000006p -1.3528089999999999e-08 91.037499999999994p -1.36177e-08 91.049999999999997p -1.3689559999999999e-08 91.0625p -1.374363e-08 91.075000000000003p -1.377985e-08 91.087499999999991p -1.379822e-08 91.099999999999994p -1.379876e-08 91.112500000000011p -1.378148e-08 91.125p -1.3746460000000001e-08
+ 91.137500000000003p -1.369377e-08 91.150000000000006p -1.3623509999999999e-08 91.162499999999994p -1.353582e-08 91.174999999999997p -1.343083e-08 91.1875p -1.330872e-08 91.200000000000003p -1.316968e-08 91.212499999999991p -1.3013919999999999e-08 91.224999999999994p -1.2841680000000001e-08 91.237499999999997p -1.265322e-08 91.25p -1.244881e-08 91.262500000000003p -1.222875e-08 91.275000000000006p -1.1993349999999999e-08 91.287499999999994p -1.174296e-08 91.299999999999997p -1.147791e-08 91.3125p -1.11986e-08 91.325000000000003p -1.0905400000000001e-08 91.337499999999991p -1.0598729999999999e-08 91.349999999999994p -1.027901e-08
+ 91.362499999999997p -9.9466750000000003e-09 91.375p -9.6021889999999996e-09 91.387500000000003p -9.2460210000000006e-09 91.400000000000006p -8.8786550000000005e-09 91.412500000000009p -8.5005890000000008e-09 91.424999999999997p -8.1123349999999994e-09 91.4375p -7.7144150000000004e-09 91.450000000000003p -7.3073659999999997e-09 91.462499999999991p -6.8917320000000004e-09 91.474999999999994p -6.4680690000000001e-09 91.487499999999997p -6.0369429999999998e-09 91.5p -5.5989250000000003e-09 91.512500000000003p -5.1545979999999997e-09 91.525000000000006p -4.7045489999999999e-09 91.537500000000009p -4.249372e-09 91.549999999999997p -3.7896670000000001e-09 91.5625p -3.3260389999999999e-09 91.575000000000003p -2.8590939999999999e-09
+ 91.587499999999991p -2.389444e-09 91.599999999999994p -1.9177029999999998e-09 91.612499999999997p -1.4444830000000001e-09 91.625p -9.7040180000000004e-10 91.637500000000003p -4.9607269999999996e-10 91.650000000000006p -2.2109849999999999e-11 91.662500000000009p 4.5087459999999998e-10 91.674999999999997p 9.2227129999999996e-10 91.6875p 1.391474e-09 91.700000000000003p 1.8578809999999999e-09 91.712499999999991p 2.3208960000000001e-09 91.724999999999994p 2.7799269999999998e-09 91.737499999999997p 3.2343890000000001e-09 91.75p 3.6837049999999999e-09 91.762500000000003p 4.1273060000000003e-09 91.775000000000006p 4.5646300000000002e-09 91.787500000000009p 4.9951259999999999e-09 91.799999999999997p 5.4182529999999997e-09
+ 91.8125p 5.83348e-09 91.825000000000003p 6.2402879999999999e-09 91.837499999999991p 6.63817e-09 91.849999999999994p 7.0266309999999997e-09 91.862499999999997p 7.4051900000000002e-09 91.875p 7.7733799999999999e-09 91.887500000000003p 8.1307489999999995e-09 91.900000000000006p 8.4768590000000001e-09 91.912500000000009p 8.8112870000000008e-09 91.924999999999997p 9.1336290000000001e-09 91.9375p 9.4434949999999996e-09 91.950000000000003p 9.7405119999999993e-09 91.962499999999991p 1.002433e-08 91.974999999999994p 1.02946e-08 91.987499999999997p 1.0551019999999999e-08 92p 1.0793279999999999e-08 92.012500000000003p 1.10211e-08 92.025000000000006p 1.1234220000000001e-08
+ 92.037500000000009p 1.14324e-08 92.049999999999997p 1.161541e-08 92.0625p 1.178307e-08 92.075000000000003p 1.193517e-08 92.087500000000006p 1.2071580000000001e-08 92.099999999999994p 1.2192129999999999e-08 92.112499999999997p 1.2296719999999999e-08 92.125p 1.238526e-08 92.137500000000003p 1.2457650000000001e-08 92.150000000000006p 1.2513840000000001e-08 92.162500000000009p 1.255381e-08 92.174999999999997p 1.2577540000000001e-08 92.1875p 1.258503e-08 92.200000000000003p 1.2576320000000001e-08 92.212500000000006p 1.2551450000000001e-08 92.224999999999994p 1.25105e-08 92.237499999999997p 1.2453550000000001e-08 92.25p 1.238072e-08
+ 92.262499999999989p 1.229215e-08 92.275000000000006p 1.218797e-08 92.287500000000009p 1.206838e-08 92.299999999999997p 1.193355e-08 92.3125p 1.17837e-08 92.325000000000003p 1.1619060000000001e-08 92.337500000000006p 1.143987e-08 92.349999999999994p 1.124642e-08 92.362499999999997p 1.1038970000000001e-08 92.375p 1.081784e-08 92.387499999999989p 1.058334e-08 92.400000000000006p 1.033581e-08 92.412500000000009p 1.00756e-08 92.424999999999997p 9.8030799999999992e-09 92.4375p 9.5186350000000002e-09 92.450000000000003p 9.2226600000000001e-09 92.462500000000006p 8.9155679999999998e-09 92.474999999999994p 8.5977839999999993e-09
+ 92.487499999999997p 8.2697460000000007e-09 92.5p 7.9319040000000003e-09 92.512499999999989p 7.5847199999999998e-09 92.524999999999991p 7.2286679999999998e-09 92.537500000000009p 6.86423e-09 92.550000000000011p 6.4919010000000002e-09 92.5625p 6.1121810000000002e-09 92.575000000000003p 5.7255820000000002e-09 92.587500000000006p 5.332622e-09 92.599999999999994p 4.9338259999999997e-09 92.612499999999997p 4.5297249999999999e-09 92.625p 4.1208580000000004e-09 92.637499999999989p 3.7077659999999999e-09 92.649999999999991p 3.290995e-09 92.662500000000009p 2.8710950000000002e-09 92.675000000000011p 2.4486179999999999e-09 92.6875p 2.0241189999999999e-09 92.700000000000003p 1.598153e-09
+ 92.712500000000006p 1.171277e-09 92.724999999999994p 7.4404629999999999e-10 92.737499999999997p 3.1701619999999999e-10 92.75p -1.0925979999999999e-10 92.762499999999989p -5.3423079999999997e-10 92.774999999999991p -9.5734859999999998e-10 92.787499999999994p -1.3780690000000001e-09 92.800000000000011p -1.795852e-09 92.8125p -2.2101640000000002e-09 92.825000000000003p -2.6204750000000001e-09 92.837500000000006p -3.026263e-09 92.849999999999994p -3.4270140000000002e-09 92.862499999999997p -3.8222200000000001e-09 92.875p -4.2113819999999998e-09 92.887500000000003p -4.5940109999999998e-09 92.899999999999991p -4.9696279999999997e-09 92.912499999999994p -5.3377619999999998e-09 92.925000000000011p -5.6979549999999997e-09
+ 92.9375p -6.04976e-09 92.950000000000003p -6.3927429999999997e-09 92.962500000000006p -6.7264800000000001e-09 92.974999999999994p -7.0505630000000002e-09 92.987499999999997p -7.3645960000000004e-09 93p -7.6681979999999998e-09 93.012500000000003p -7.9610009999999996e-09 93.024999999999991p -8.242653e-09 93.037499999999994p -8.5128190000000001e-09 93.050000000000011p -8.7711769999999998e-09 93.0625p -9.0174229999999998e-09 93.075000000000003p -9.2512699999999996e-09 93.087500000000006p -9.472445e-09 93.099999999999994p -9.6806959999999998e-09 93.112499999999997p -9.8757870000000002e-09 93.125p -1.0057499999999999e-08 93.137500000000003p -1.022563e-08 93.149999999999991p -1.0379999999999999e-08
+ 93.162499999999994p -1.0520440000000001e-08 93.174999999999997p -1.064682e-08 93.1875p -1.0759000000000001e-08 93.200000000000003p -1.0856870000000001e-08 93.212500000000006p -1.094035e-08 93.225000000000009p -1.100936e-08 93.237499999999997p -1.1063870000000001e-08 93.25p -1.110383e-08 93.262500000000003p -1.112923e-08 93.274999999999991p -1.114008e-08 93.287499999999994p -1.113641e-08 93.299999999999997p -1.1118259999999999e-08 93.3125p -1.108569e-08 93.325000000000003p -1.103879e-08 93.337500000000006p -1.097766e-08 93.350000000000009p -1.0902410000000001e-08 93.362499999999997p -1.081318e-08 93.375p -1.071013e-08
+ 93.387500000000003p -1.0593430000000001e-08 93.399999999999991p -1.0463270000000001e-08 93.412499999999994p -1.0319860000000001e-08 93.424999999999997p -1.016342e-08 93.4375p -9.9941949999999993e-09 93.450000000000003p -9.8124370000000008e-09 93.462500000000006p -9.6184200000000004e-09 93.475000000000009p -9.4124310000000003e-09 93.487499999999997p -9.1947739999999997e-09 93.5p -8.9657650000000002e-09 93.512500000000003p -8.7257360000000001e-09 93.524999999999991p -8.4750299999999994e-09 93.537499999999994p -8.2140049999999999e-09 93.549999999999997p -7.9430320000000007e-09 93.5625p -7.6624929999999994e-09 93.575000000000003p -7.3727809999999998e-09 93.587500000000006p -7.0743019999999997e-09 93.600000000000009p -6.7674700000000004e-09
+ 93.612499999999997p -6.4527109999999996e-09 93.625p -6.130459e-09 93.637500000000003p -5.8011569999999997e-09 93.649999999999991p -5.4652549999999999e-09 93.662499999999994p -5.1232129999999999e-09 93.674999999999997p -4.7754950000000004e-09 93.6875p -4.4225729999999997e-09 93.700000000000003p -4.0649240000000001e-09 93.712500000000006p -3.7030310000000001e-09 93.725000000000009p -3.3373780000000001e-09 93.737499999999997p -2.9684580000000001e-09 93.75p -2.5967609999999999e-09 93.762500000000003p -2.2227840000000001e-09 93.774999999999991p -1.847023e-09 93.787499999999994p -1.469977e-09 93.799999999999997p -1.0921439999999999e-09 93.8125p -7.1402170000000001e-10 93.825000000000003p -3.3610719999999998e-10
+ 93.837500000000006p 4.1103890000000002e-11 93.850000000000009p 4.171182e-10 93.862499999999997p 7.9144539999999997e-10 93.875p 1.1635990000000001e-09 93.887500000000003p 1.5330950000000001e-09 93.899999999999991p 1.8994559999999999e-09 93.912499999999994p 2.2622110000000001e-09 93.924999999999997p 2.6208909999999999e-09 93.9375p 2.975037e-09 93.950000000000003p 3.3241960000000001e-09 93.962500000000006p 3.6679239999999999e-09 93.975000000000009p 4.0057819999999996e-09 93.987499999999997p 4.3373439999999999e-09 94p 4.66219e-09 94.012500000000003p 4.9799130000000002e-09 94.025000000000006p 5.2901130000000002e-09 94.037499999999994p 5.5924049999999998e-09 94.049999999999997p 5.8864110000000001e-09
+ 94.0625p 6.171767e-09 94.074999999999989p 6.4481239999999999e-09 94.087500000000006p 6.71514e-09 94.100000000000009p 6.9724909999999997e-09 94.112499999999997p 7.2198650000000003e-09 94.125p 7.4569640000000003e-09 94.137500000000003p 7.6835019999999996e-09 94.150000000000006p 7.8992130000000002e-09 94.162499999999994p 8.1038399999999996e-09 94.174999999999997p 8.2971439999999994e-09 94.1875p 8.4789040000000002e-09 94.199999999999989p 8.6489099999999997e-09 94.212500000000006p 8.8069699999999994e-09 94.225000000000009p 8.9529100000000003e-09 94.237499999999997p 9.0865700000000008e-09 94.25p 9.2078080000000005e-09 94.262500000000003p 9.3164970000000001e-09 94.275000000000006p 9.4125290000000001e-09
+ 94.287499999999994p 9.4958120000000008e-09 94.299999999999997p 9.5662709999999998e-09 94.3125p 9.6238469999999999e-09 94.324999999999989p 9.6685010000000002e-09 94.337500000000006p 9.7002079999999993e-09 94.350000000000009p 9.718961e-09 94.362500000000011p 9.7247719999999995e-09 94.375p 9.7176679999999998e-09 94.387500000000003p 9.697693e-09 94.400000000000006p 9.664909e-09 94.412499999999994p 9.6193939999999998e-09 94.424999999999997p 9.5612419999999998e-09 94.4375p 9.4905650000000007e-09 94.449999999999989p 9.4074889999999998e-09 94.462499999999991p 9.3121590000000003e-09 94.475000000000009p 9.2047329999999996e-09 94.487500000000011p 9.0853860000000006e-09 94.5p 8.9543070000000006e-09
+ 94.512500000000003p 8.8117029999999994e-09 94.525000000000006p 8.6577910000000001e-09 94.537499999999994p 8.492807e-09 94.549999999999997p 8.3169990000000006e-09 94.5625p 8.1306270000000004e-09 94.574999999999989p 7.9339679999999998e-09 94.587499999999991p 7.7273079999999992e-09 94.600000000000009p 7.5109490000000005e-09 94.612500000000011p 7.2852020000000003e-09 94.625p 7.050391e-09 94.637500000000003p 6.8068520000000001e-09 94.650000000000006p 6.5549299999999998e-09 94.662499999999994p 6.2949820000000003e-09 94.674999999999997p 6.0273720000000003e-09 94.6875p 5.7524769999999998e-09 94.700000000000003p 5.4706790000000001e-09 94.712499999999991p 5.1823709999999997e-09 94.724999999999994p 4.8879520000000001e-09
+ 94.737500000000011p 4.5878290000000004e-09 94.75p 4.2824140000000003e-09 94.762500000000003p 3.9721260000000004e-09 94.775000000000006p 3.6573909999999998e-09 94.787499999999994p 3.3386359999999999e-09 94.799999999999997p 3.0162969999999999e-09 94.8125p 2.6908100000000001e-09 94.825000000000003p 2.3626149999999999e-09 94.837499999999991p 2.0321560000000001e-09 94.849999999999994p 1.699877e-09 94.862500000000011p 1.3662240000000001e-09 94.875p 1.0316430000000001e-09 94.887500000000003p 6.9658310000000004e-10 94.900000000000006p 3.6148920000000001e-10 94.912499999999994p 2.6807260000000001e-11 94.924999999999997p -3.070189e-10 94.9375p -6.3954770000000002e-10 94.950000000000003p -9.7034010000000001e-10
+ 94.962499999999991p -1.2989609999999999e-09 94.974999999999994p -1.6249780000000001e-09 94.987499999999997p -1.947964e-09 95p -2.2674980000000001e-09 95.012500000000003p 1.944777e-07 95.025000000000006p 3.76622e-07 95.037499999999994p 5.4358289999999999e-07 95.049999999999997p 6.9570919999999998e-07 95.0625p 8.3367410000000002e-07 95.075000000000003p 9.5826629999999994e-07 95.087499999999991p 1.070316e-06 95.099999999999994p 1.170668e-06 95.112499999999997p 1.260167e-06 95.125p 1.339651e-06 95.137500000000003p 1.4099489999999999e-06 95.150000000000006p 1.4718700000000001e-06 95.162500000000009p 1.5262089999999999e-06 95.174999999999997p 1.573735e-06
+ 95.1875p 1.615193e-06 95.200000000000003p 1.6513e-06 95.212499999999991p 1.6827420000000001e-06 95.224999999999994p 1.7101759999999999e-06 95.237499999999997p 1.734221e-06 95.25p 1.7554660000000001e-06 95.262500000000003p 1.7744610000000001e-06 95.275000000000006p 1.7917200000000001e-06 95.287500000000009p 1.807722e-06 95.299999999999997p 1.822908e-06 95.3125p 1.8376800000000001e-06 95.325000000000003p 1.852406e-06 95.337499999999991p 1.8674169999999999e-06 95.349999999999994p 1.883006e-06 95.362499999999997p 1.8994340000000001e-06 95.375p 1.9169269999999999e-06 95.387500000000003p 1.9356760000000001e-06 95.400000000000006p 1.9558439999999999e-06
+ 95.412500000000009p 1.9775600000000001e-06 95.424999999999997p 2.0009260000000001e-06 95.4375p 2.0260160000000002e-06 95.450000000000003p 2.0528789999999999e-06 95.462499999999991p 2.081536e-06 95.474999999999994p 2.1119890000000002e-06 95.487499999999997p 2.144217e-06 95.5p 2.17818e-06 95.512500000000003p 2.21382e-06 95.525000000000006p 2.251063e-06 95.537500000000009p 2.2898200000000002e-06 95.549999999999997p 2.3299899999999999e-06 95.5625p 2.3714599999999998e-06 95.575000000000003p 2.4141060000000001e-06 95.587499999999991p 2.4577990000000002e-06 95.599999999999994p 2.5024010000000002e-06 95.612499999999997p 2.5477690000000002e-06 95.625p 2.5937560000000001e-06
+ 95.637500000000003p 2.6402129999999999e-06 95.650000000000006p 2.6869890000000002e-06 95.662500000000009p 2.7339330000000001e-06 95.674999999999997p 2.7808940000000002e-06 95.6875p 2.8277239999999999e-06 95.700000000000003p 2.8742759999999999e-06 95.712499999999991p 2.9204090000000001e-06 95.724999999999994p 2.965984e-06 95.737499999999997p 3.0108699999999999e-06 95.75p 3.054938e-06 95.762500000000003p 3.0980689999999998e-06 95.775000000000006p 3.1401479999999999e-06 95.787500000000009p 3.1810690000000001e-06 95.799999999999997p 3.2207330000000002e-06 95.8125p 3.2590489999999999e-06 95.825000000000003p 3.295935e-06 95.837500000000006p 3.3313160000000002e-06 95.849999999999994p 3.3651249999999998e-06
+ 95.862499999999997p 3.397307e-06 95.875p 3.4278110000000001e-06 95.887500000000003p 3.4565989999999998e-06 95.900000000000006p 3.4836369999999999e-06 95.912500000000009p 3.5089029999999999e-06 95.924999999999997p 3.532383e-06 95.9375p 3.5540670000000001e-06 95.950000000000003p 3.5739589999999999e-06 95.962500000000006p 3.592065e-06 95.974999999999994p 3.6084020000000001e-06 95.987499999999997p 3.6229920000000001e-06 96p 3.6358649999999999e-06 96.012499999999989p 3.4499950000000001e-06 96.025000000000006p 3.2770900000000001e-06 96.037500000000009p 3.1177810000000001e-06 96.049999999999997p 2.9717720000000001e-06 96.0625p 2.8384479999999998e-06 96.075000000000003p 2.7170820000000001e-06
+ 96.087500000000006p 2.6069119999999999e-06 96.099999999999994p 2.5071620000000001e-06 96.112499999999997p 2.4170630000000002e-06 96.125p 2.3358530000000001e-06 96.137499999999989p 2.2627829999999999e-06 96.150000000000006p 2.1971250000000002e-06 96.162500000000009p 2.1381689999999999e-06 96.174999999999997p 2.085232e-06 96.1875p 2.037654e-06 96.200000000000003p 1.9948069999999999e-06 96.212500000000006p 1.956092e-06 96.224999999999994p 1.9209429999999998e-06 96.237499999999997p 1.8888269999999999e-06 96.25p 1.8592450000000001e-06 96.262499999999989p 1.8317350000000001e-06 96.274999999999991p 1.8058679999999999e-06 96.287500000000009p 1.7812519999999999e-06 96.300000000000011p 1.7575319999999999e-06
+ 96.3125p 1.734388e-06 96.325000000000003p 1.7115329999999999e-06 96.337500000000006p 1.6887170000000001e-06 96.349999999999994p 1.665724e-06 96.362499999999997p 1.6423689999999999e-06 96.375p 1.618499e-06 96.387499999999989p 1.5939920000000001e-06 96.399999999999991p 1.568756e-06 96.412500000000009p 1.5427259999999999e-06 96.425000000000011p 1.5158609999999999e-06 96.4375p 1.4881500000000001e-06 96.450000000000003p 1.4595989999999999e-06 96.462500000000006p 1.4302399999999999e-06 96.474999999999994p 1.4001229999999999e-06 96.487499999999997p 1.369317e-06 96.5p 1.3379050000000001e-06 96.512499999999989p 1.305988e-06 96.524999999999991p 1.273678e-06
+ 96.537499999999994p 1.241099e-06 96.550000000000011p 1.2083829999999999e-06 96.5625p 1.1756739999999999e-06 96.575000000000003p 1.143119e-06 96.587500000000006p 1.1108710000000001e-06 96.599999999999994p 1.0790880000000001e-06 96.612499999999997p 1.0479289999999999e-06 96.625p 1.017555e-06 96.637500000000003p 9.881243999999999e-07 96.649999999999991p 9.5979730000000006e-07 96.662499999999994p 9.3272940000000001e-07 96.675000000000011p 9.0707329999999999e-07 96.6875p 8.8297699999999995e-07 96.700000000000003p 8.6058309999999996e-07 96.712500000000006p 8.4002800000000004e-07 96.724999999999994p 8.2144140000000003e-07 96.737499999999997p 8.0494510000000003e-07 96.75p 7.9065299999999998e-07
+ 96.762500000000003p 7.786703e-07 96.774999999999991p 7.6909319999999997e-07 96.787499999999994p 7.6200819999999996e-07 96.800000000000011p 7.5749249999999995e-07 96.8125p 7.5561299999999995e-07 96.825000000000003p 7.5642670000000005e-07 96.837500000000006p 7.5998039999999998e-07 96.849999999999994p 7.6631050000000005e-07 96.862499999999997p 7.7544320000000003e-07 96.875p 7.8739459999999997e-07 96.887500000000003p 8.0217049999999995e-07 96.899999999999991p 8.1976689999999997e-07 96.912499999999994p 8.4017000000000004e-07 96.924999999999997p 8.6335650000000003e-07 96.9375p 8.8929370000000002e-07 96.950000000000003p 9.1793999999999997e-07 96.962500000000006p 9.4924520000000001e-07 96.975000000000009p 9.8315059999999991e-07
+ 96.987499999999997p 1.0195900000000001e-06 97p 1.058488e-06 97.012500000000003p 1.0997649999999999e-06 97.024999999999991p 1.143332e-06 97.037499999999994p 1.189095e-06 97.049999999999997p 1.2369529999999999e-06 97.0625p 1.2868009999999999e-06 97.075000000000003p 1.3385279999999999e-06 97.087500000000006p 1.392018e-06 97.100000000000009p 1.4471530000000001e-06 97.112499999999997p 1.5038079999999999e-06 97.125p 1.5618579999999999e-06 97.137500000000003p 1.621174e-06 97.149999999999991p 1.6816239999999999e-06 97.162499999999994p 1.743074e-06 97.174999999999997p 1.80539e-06 97.1875p 1.8684350000000001e-06 97.200000000000003p 1.932073e-06
+ 97.212500000000006p 1.9961650000000001e-06 97.225000000000009p 2.060576e-06 97.237499999999997p 2.125168e-06 97.25p 2.1898050000000001e-06 97.262500000000003p 2.2543499999999999e-06 97.274999999999991p 2.318672e-06 97.287499999999994p 2.382636e-06 97.299999999999997p 2.4461129999999999e-06 97.3125p 2.508975e-06 97.325000000000003p 2.5710940000000001e-06 97.337500000000006p 2.6323490000000001e-06 97.350000000000009p 2.6926170000000001e-06 97.362499999999997p 2.751782e-06 97.375p 2.8097290000000001e-06 97.387500000000003p 2.866348e-06 97.399999999999991p 2.9215290000000001e-06 97.412499999999994p 2.9751710000000002e-06 97.424999999999997p 3.0271720000000001e-06
+ 97.4375p 3.0774360000000001e-06 97.450000000000003p 3.1258720000000001e-06 97.462500000000006p 3.17239e-06 97.475000000000009p 3.2169079999999999e-06 97.487499999999997p 3.2593439999999998e-06 97.5p 3.299624e-06 97.512500000000003p 3.3376769999999998e-06 97.524999999999991p 3.3734350000000001e-06 97.537499999999994p 3.4068359999999999e-06 97.549999999999997p 3.4378209999999999e-06 97.5625p 3.4663379999999999e-06 97.575000000000003p 3.492337e-06 97.587500000000006p 3.5157719999999999e-06 97.600000000000009p 3.5366039999999998e-06 97.612499999999997p 3.5547949999999999e-06 97.625p 3.5703139999999999e-06 97.637500000000003p 3.5831329999999999e-06 97.649999999999991p 3.5932289999999999e-06
+ 97.662499999999994p 3.6005819999999998e-06 97.674999999999997p 3.6051769999999998e-06 97.6875p 3.6070029999999998e-06 97.700000000000003p 3.6060540000000001e-06 97.712500000000006p 3.6023249999999999e-06 97.725000000000009p 3.5958189999999998e-06 97.737499999999997p 3.5865389999999999e-06 97.75p 3.5744949999999999e-06 97.762500000000003p 3.5596979999999999e-06 97.775000000000006p 3.542164e-06 97.787499999999994p 3.5219140000000001e-06 97.799999999999997p 3.4989699999999999e-06 97.8125p 3.4733580000000002e-06 97.824999999999989p 3.4451080000000001e-06 97.837500000000006p 3.4142540000000001e-06 97.850000000000009p 3.3808319999999999e-06 97.862499999999997p 3.3448819999999999e-06 97.875p 3.306445e-06
+ 97.887500000000003p 3.2655669999999998e-06 97.900000000000006p 3.222298e-06 97.912499999999994p 3.1766880000000001e-06 97.924999999999997p 3.128791e-06 97.9375p 3.0786629999999999e-06 97.949999999999989p 3.026365e-06 97.962500000000006p 2.9719580000000002e-06 97.975000000000009p 2.915506e-06 97.987499999999997p 2.8570750000000001e-06 98p 2.7967350000000002e-06 98.012500000000003p 2.7345560000000001e-06 98.025000000000006p 2.670611e-06 98.037499999999994p 2.6049759999999998e-06 98.049999999999997p 2.5377260000000002e-06 98.0625p 2.4689409999999998e-06 98.074999999999989p 2.3987020000000001e-06 98.087500000000006p 2.327089e-06 98.100000000000009p 2.254188e-06
+ 98.112500000000011p 2.180082e-06 98.125p 2.1048580000000001e-06 98.137500000000003p 2.0286029999999998e-06 98.150000000000006p 1.9514070000000001e-06 98.162499999999994p 1.8733590000000001e-06 98.174999999999997p 1.794549e-06 98.1875p 1.7150699999999999e-06 98.199999999999989p 1.635013e-06 98.212499999999991p 1.5544709999999999e-06 98.225000000000009p 1.4735379999999999e-06 98.237500000000011p 1.392307e-06 98.25p 1.3108720000000001e-06 98.262500000000003p 1.2293269999999999e-06 98.275000000000006p 1.147768e-06 98.287499999999994p 1.0662869999999999e-06 98.299999999999997p 9.8497850000000003e-07 98.3125p 9.03937e-07 98.324999999999989p 8.2325540000000002e-07
+ 98.337499999999991p 7.4302650000000001e-07 98.350000000000009p 6.6334249999999997e-07 98.362500000000011p 5.8429480000000005e-07 98.375p 5.0597400000000003e-07 98.387500000000003p 4.284696e-07 98.400000000000006p 3.5187009999999998e-07 98.412499999999994p 2.7626270000000001e-07 98.424999999999997p 2.0173339999999999e-07 98.4375p 1.2836660000000001e-07 98.450000000000003p 5.6245300000000001e-08 98.462499999999991p -1.4549329999999999e-08 98.474999999999994p -8.3937770000000006e-08 98.487500000000011p -1.5184240000000001e-07 98.5p -2.181876e-07 98.512500000000003p -2.8289979999999999e-07 98.525000000000006p -3.4590770000000003e-07 98.537499999999994p -4.0714210000000003e-07 98.549999999999997p -4.6653640000000001e-07
+ 98.5625p -5.2402620000000005e-07 98.575000000000003p -5.7954989999999998e-07 98.587499999999991p -6.3304829999999999e-07 98.599999999999994p -6.8446499999999996e-07 98.612500000000011p -7.3374640000000003e-07 98.625p -7.8084180000000001e-07 98.637500000000003p -8.257033e-07 98.650000000000006p -8.682859e-07 98.662499999999994p -9.0854789999999997e-07 98.674999999999997p -9.4645060000000001e-07 98.6875p -9.8195820000000007e-07 98.700000000000003p -1.015038e-06 98.712499999999991p -1.045662e-06 98.724999999999994p -1.0738030000000001e-06 98.737499999999997p -1.099438e-06 98.75p -1.1225489999999999e-06 98.762500000000003p -1.14312e-06 98.775000000000006p -1.161137e-06
+ 98.787499999999994p -1.1765910000000001e-06 98.799999999999997p -1.189477e-06 98.8125p -1.1997910000000001e-06 98.825000000000003p -1.207535e-06 98.837499999999991p -1.212713e-06 98.849999999999994p -1.2153330000000001e-06 98.862499999999997p -1.2154039999999999e-06 98.875p -1.212942e-06 98.887500000000003p -1.207964e-06 98.900000000000006p -1.2004899999999999e-06 98.912500000000009p -1.190544e-06 98.924999999999997p -1.178154e-06 98.9375p -1.1633500000000001e-06 98.950000000000003p -1.146164e-06 98.962499999999991p -1.1266350000000001e-06 98.974999999999994p -1.104799e-06 98.987499999999997p -1.0807009999999999e-06 99p -1.054385e-06
+ 99.012500000000003p -1.0259e-06 99.025000000000006p -9.9529529999999992e-07 99.037500000000009p -9.6262490000000001e-07 99.049999999999997p -9.2794480000000003e-07 99.0625p -8.913135e-07 99.075000000000003p -8.5279169999999997e-07 99.087499999999991p -8.1244270000000004e-07 99.099999999999994p -7.7033199999999999e-07 99.112499999999997p -7.2652729999999998e-07 99.125p -6.8109810000000002e-07 99.137500000000003p -6.341162e-07 99.150000000000006p -5.8565519999999997e-07 99.162500000000009p -5.3579020000000005e-07 99.174999999999997p -4.8459829999999996e-07 99.1875p -4.3215800000000002e-07 99.200000000000003p -3.7854920000000002e-07 99.212499999999991p -3.2385329999999998e-07 99.224999999999994p -2.6815269999999998e-07
+ 99.237499999999997p -2.1153129999999999e-07 99.25p -1.5407349999999999e-07 99.262500000000003p -9.5864979999999999e-08 99.275000000000006p -3.6991999999999998e-08 99.287500000000009p 2.2458489999999999e-08 99.299999999999997p 8.2398989999999999e-08 99.3125p 1.427416e-07 99.325000000000003p 2.0339819999999999e-07 99.337499999999991p 2.642804e-07 99.349999999999994p 3.252997e-07 99.362499999999997p 3.8636789999999999e-07 99.375p 4.4739679999999998e-07 99.387500000000003p 5.0829859999999997e-07 99.400000000000006p 5.6898589999999997e-07 99.412500000000009p 6.2937180000000005e-07 99.424999999999997p 6.8937020000000002e-07 99.4375p 7.4889570000000001e-07 99.450000000000003p 8.078638e-07
+ 99.462499999999991p 8.6619100000000003e-07 99.474999999999994p 9.2379500000000002e-07 99.487499999999997p 9.8059460000000008e-07 99.5p 1.03651e-06 99.512500000000003p 1.0914630000000001e-06 99.525000000000006p 1.1453770000000001e-06 99.537500000000009p 1.198177e-06 99.549999999999997p 1.249789e-06 99.5625p 1.3001419999999999e-06 99.575000000000003p 1.3491660000000001e-06 99.587500000000006p 1.396794e-06 99.599999999999994p 1.4429599999999999e-06 99.612499999999997p 1.487602e-06 99.625p 1.5306570000000001e-06 99.637500000000003p 1.5720689999999999e-06 99.650000000000006p 1.6117800000000001e-06 99.662500000000009p 1.649737e-06 99.674999999999997p 1.6858879999999999e-06
+ 99.6875p 1.7201860000000001e-06 99.700000000000003p 1.752585e-06 99.712500000000006p 1.783041e-06 99.724999999999994p 1.8115139999999999e-06 99.737499999999997p 1.8379659999999999e-06 99.75p 1.862364e-06 99.762499999999989p 1.8846740000000001e-06 99.775000000000006p 1.90487e-06 99.787500000000009p 1.9229229999999998e-06 99.799999999999997p 1.9388119999999999e-06 99.8125p 1.9525170000000002e-06 99.825000000000003p 1.9640199999999999e-06 99.837500000000006p 1.973308e-06 99.849999999999994p 1.9803689999999999e-06 99.862499999999997p 1.9851970000000002e-06 99.875p 1.9877850000000001e-06 99.887499999999989p 1.9881320000000001e-06 99.900000000000006p 1.98624e-06
+ 99.912500000000009p 1.9821110000000001e-06 99.924999999999997p 1.9757540000000002e-06 99.9375p 1.9671779999999998e-06 99.950000000000003p 1.9563959999999999e-06 99.962500000000006p 1.9434229999999999e-06 99.974999999999994p 1.9282800000000001e-06 99.987499999999997p 1.910986e-06 100p 1.8915659999999999e-06 100.01249999999999p 1.8700469999999999e-06 100.02499999999999p 1.846459e-06 100.03750000000001p 1.8208340000000001e-06 100.05000000000001p 1.793207e-06 100.0625p 1.7636149999999999e-06 100.075p 1.7320990000000001e-06 100.08750000000001p 1.698701e-06 100.09999999999999p 1.6634649999999999e-06 100.1125p 1.626439e-06 100.125p 1.5876709999999999e-06
+ 100.13749999999999p 1.5472139999999999e-06 100.14999999999999p 1.5051209999999999e-06 100.16250000000001p 1.4614479999999999e-06 100.17500000000001p 1.416251e-06 100.1875p 1.369592e-06 100.2p 1.3215299999999999e-06 100.21250000000001p 1.272129e-06 100.22499999999999p 1.2214530000000001e-06 100.2375p 1.169569e-06 100.25p 1.116544e-06 100.26249999999999p 1.062448e-06 100.27499999999999p 1.00735e-06 100.28749999999999p 9.5132149999999996e-07 100.30000000000001p 8.9443589999999996e-07 100.3125p 8.3676660000000005e-07 100.325p 7.7838809999999996e-07 100.33750000000001p 7.1937569999999999e-07 100.34999999999999p 6.5980549999999996e-07
+ 100.3625p 5.9975420000000005e-07 100.375p 5.3929900000000004e-07 100.3875p 4.7851769999999999e-07 100.39999999999999p 4.1748829999999999e-07 100.41249999999999p 3.562889e-07 100.42500000000001p 2.9499789999999999e-07 100.4375p 2.336937e-07 100.45p 1.724546e-07 100.46250000000001p 1.113588e-07 100.47499999999999p 5.0484060000000003e-08 100.4875p -1.009216e-08 100.5p -7.0292860000000001e-08 100.5125p -1.300416e-07 100.52499999999999p -1.8926280000000001e-07 100.53749999999999p -2.4788150000000001e-07 100.55000000000001p -3.0582350000000001e-07 100.5625p -3.6301600000000003e-07 100.575p -4.1938689999999998e-07
+ 100.58750000000001p -4.7486540000000001e-07 100.59999999999999p -5.29382e-07 100.6125p -5.8286850000000004e-07 100.625p -6.3525830000000001e-07 100.6375p -6.8648609999999999e-07 100.64999999999999p -7.3648840000000002e-07 100.66249999999999p -7.8520339999999996e-07 100.675p -8.3257100000000002e-07 100.6875p -8.7853310000000004e-07 100.7p -9.2303360000000001e-07 100.71250000000001p -9.6601809999999995e-07 100.72500000000001p -1.007435e-06 100.7375p -1.047233e-06 100.75p -1.0853659999999999e-06 100.7625p -1.1217880000000001e-06 100.77499999999999p -1.1564559999999999e-06 100.78749999999999p -1.1893289999999999e-06 100.8p -1.22037e-06
+ 100.8125p -1.2495409999999999e-06 100.825p -1.2768110000000001e-06 100.83750000000001p -1.3021490000000001e-06 100.85000000000001p -1.325527e-06 100.8625p -1.3469190000000001e-06 100.875p -1.3663040000000001e-06 100.8875p -1.3836599999999999e-06 100.89999999999999p -1.3989719999999999e-06 100.91249999999999p -1.4122250000000001e-06 100.925p -1.423407e-06 100.9375p -1.4325090000000001e-06 100.95p -1.439526e-06 100.96250000000001p -1.4444540000000001e-06 100.97500000000001p -1.4472929999999999e-06 100.9875p -1.4480459999999999e-06 101p -1.4467170000000001e-06 101.0125p -1.443314e-06 101.02499999999999p -1.4378480000000001e-06
+ 101.03749999999999p -1.4303329999999999e-06 101.05p -1.420784e-06 101.0625p -1.4092199999999999e-06 101.075p -1.3956630000000001e-06 101.08750000000001p -1.3801370000000001e-06 101.10000000000001p -1.3626680000000001e-06 101.1125p -1.3432849999999999e-06 101.125p -1.3220199999999999e-06 101.1375p -1.298908e-06 101.14999999999999p -1.273983e-06 101.16249999999999p -1.2472859999999999e-06 101.175p -1.218857e-06 101.1875p -1.188739e-06 101.2p -1.1569770000000001e-06 101.21250000000001p -1.1236200000000001e-06 101.22500000000001p -1.0887170000000001e-06 101.2375p -1.0523179999999999e-06 101.25p -1.014478e-06
+ 101.2625p -9.7525110000000007e-07 101.27499999999999p -9.3469440000000004e-07 101.28749999999999p -8.9286619999999995e-07 101.3p -8.4982660000000003e-07 101.3125p -8.0563709999999997e-07 101.325p -7.6036039999999998e-07 101.33750000000001p -7.1406070000000003e-07 101.35000000000001p -6.6680350000000001e-07 101.3625p -6.1865509999999997e-07 101.375p -5.6968310000000003e-07 101.3875p -5.1995599999999995e-07 101.39999999999999p -4.6954309999999998e-07 101.41249999999999p -4.1851429999999999e-07 101.425p -3.669404e-07 101.4375p -3.1489269999999998e-07 101.45p -2.624429e-07 101.46250000000001p -2.0966299999999999e-07 101.47500000000001p -1.5662540000000001e-07
+ 101.4875p -1.034027e-07 101.5p -5.0067360000000003e-08 101.5125p 3.3080130000000002e-09 101.52500000000001p 5.6651000000000002e-08 101.53749999999999p 1.0988939999999999e-07 101.55p 1.6295129999999999e-07 101.5625p 2.157653e-07 101.57499999999999p 2.6826040000000002e-07 101.58750000000001p 3.2036629999999997e-07 101.60000000000001p 3.7201330000000001e-07 101.6125p 4.2313260000000001e-07 101.625p 4.7365629999999999e-07 101.6375p 5.2351730000000002e-07 101.65000000000001p 5.7264980000000005e-07 101.66249999999999p 6.2098890000000004e-07 101.675p 6.6847119999999996e-07 101.6875p 7.1503450000000004e-07 101.69999999999999p 7.606179e-07
+ 101.71250000000001p 8.0516220000000003e-07 101.72500000000001p 8.4860949999999996e-07 101.7375p 8.9090380000000004e-07 101.75p 9.3199049999999998e-07 101.7625p 9.7181709999999994e-07 101.77500000000001p 1.0103329999999999e-06 101.78749999999999p 1.047488e-06 101.8p 1.083237e-06 101.8125p 1.117534e-06 101.82499999999999p 1.150336e-06 101.83750000000001p 1.1816029999999999e-06 101.85000000000001p 1.211296e-06 101.86250000000001p 1.239378e-06 101.875p 1.265816e-06 101.8875p 1.290577e-06 101.90000000000001p 1.3136330000000001e-06 101.91249999999999p 1.334956e-06 101.925p 1.3545220000000001e-06
+ 101.9375p 1.372307e-06 101.94999999999999p 1.3882929999999999e-06 101.96249999999999p 1.4024619999999999e-06 101.97500000000001p 1.414799e-06 101.98750000000001p 1.4252909999999999e-06 102p 1.4339289999999999e-06 102.0125p 1.440705e-06 102.02500000000001p 1.445615e-06 102.03749999999999p 1.4486560000000001e-06 102.05p 1.449827e-06 102.0625p 1.4491320000000001e-06 102.07499999999999p 1.446575e-06 102.08749999999999p 1.442165e-06 102.10000000000001p 1.4359099999999999e-06 102.11250000000001p 1.4278239999999999e-06 102.125p 1.4179199999999999e-06 102.1375p 1.406216e-06 102.15000000000001p 1.3927320000000001e-06
+ 102.16249999999999p 1.3774890000000001e-06 102.175p 1.360511e-06 102.1875p 1.3418250000000001e-06 102.2p 1.3214589999999999e-06 102.21249999999999p 1.2994420000000001e-06 102.22499999999999p 1.275809e-06 102.23750000000001p 1.250594e-06 102.25p 1.2238330000000001e-06 102.2625p 1.1955659999999999e-06 102.27500000000001p 1.165832e-06 102.28749999999999p 1.134674e-06 102.3p 1.1021359999999999e-06 102.3125p 1.0682650000000001e-06 102.325p 1.0331070000000001e-06 102.33749999999999p 9.9671230000000007e-07 102.34999999999999p 9.5913079999999998e-07 102.36250000000001p 9.2041480000000002e-07 102.375p 8.8061779999999997e-07
+ 102.3875p 8.3979459999999999e-07 102.40000000000001p 7.9800100000000005e-07 102.41249999999999p 7.5529429999999996e-07 102.425p 7.1173259999999999e-07 102.4375p 6.6737530000000003e-07 102.45p 6.222825e-07 102.46249999999999p 5.7651510000000004e-07 102.47499999999999p 5.3013500000000003e-07 102.4875p 4.832045e-07 102.5p 4.357868e-07 102.5125p 3.8794529999999997e-07 102.52500000000001p 3.3974419999999999e-07 102.53749999999999p 2.9124769999999999e-07 102.55p 2.425204e-07 102.5625p 1.936272e-07 102.575p 1.4463280000000001e-07 102.58749999999999p 9.5602349999999997e-08 102.59999999999999p 4.6600500000000001e-08
+ 102.6125p -2.3080490000000002e-09 102.625p -5.1058880000000002e-08 102.6375p -9.9587890000000003e-08 102.65000000000001p -1.4783139999999999e-07 102.66250000000001p -1.9572629999999999e-07 102.675p -2.4320990000000003e-07 102.6875p -2.9022029999999999e-07 102.7p -3.3669630000000002e-07 102.71249999999999p -3.8257750000000001e-07 102.72499999999999p -4.2780439999999998e-07 102.7375p -4.7231859999999999e-07 102.75p -5.1606270000000003e-07 102.7625p -5.5898020000000003e-07 102.77500000000001p -6.0101610000000001e-07 102.78750000000001p -6.4211660000000004e-07 102.8p -6.8222920000000005e-07 102.8125p -7.2130279999999997e-07 102.825p -7.5928790000000002e-07
+ 102.83749999999999p -7.9613629999999995e-07 102.84999999999999p -8.3180170000000005e-07 102.8625p -8.6623930000000001e-07 102.875p -8.9940599999999997e-07 102.8875p -9.312606e-07 102.90000000000001p -9.6176359999999993e-07 102.91250000000001p -9.9087750000000003e-07 102.925p -1.018567e-06 102.9375p -1.0447970000000001e-06 102.95p -1.0695380000000001e-06 102.96249999999999p -1.0927590000000001e-06 102.97499999999999p -1.1144329999999999e-06 102.9875p -1.134535e-06 103p -1.1530410000000001e-06 103.0125p -1.16993e-06 103.02500000000001p -1.1851840000000001e-06 103.03750000000001p -1.1987860000000001e-06 103.05p -1.2107210000000001e-06
+ 103.0625p -1.2209780000000001e-06 103.075p -1.2295470000000001e-06 103.08749999999999p -1.2364200000000001e-06 103.09999999999999p -1.2415910000000001e-06 103.1125p -1.2450590000000001e-06 103.125p -1.246822e-06 103.1375p -1.246882e-06 103.15000000000001p -1.2452430000000001e-06 103.16250000000001p -1.241911e-06 103.175p -1.236895e-06 103.1875p -1.230204e-06 103.2p -1.2218530000000001e-06 103.21249999999999p -1.211856e-06 103.22499999999999p -1.200231e-06 103.2375p -1.1869959999999999e-06 103.25p -1.1721740000000001e-06 103.2625p -1.1557870000000001e-06 103.27500000000001p -1.137863e-06
+ 103.28750000000001p -1.1184270000000001e-06 103.3p -1.097511e-06 103.3125p -1.0751450000000001e-06 103.325p -1.0513640000000001e-06 103.33750000000001p -1.026201e-06 103.34999999999999p -9.996945000000001e-07 103.3625p -9.7188310000000007e-07 103.375p -9.4280710000000002e-07 103.3875p -9.1250840000000003e-07 103.40000000000001p -8.8103080000000004e-07 103.41250000000001p -8.4841919999999998e-07 103.425p -8.1472000000000003e-07 103.4375p -7.7998120000000004e-07 103.45p -7.4425179999999998e-07 103.46250000000001p -7.0758220000000003e-07 103.47499999999999p -6.7002379999999998e-07 103.4875p -6.316293e-07 103.5p -5.9245199999999999e-07
+ 103.51249999999999p -5.525467e-07 103.52500000000001p -5.1196839999999996e-07 103.53750000000001p -4.7077350000000002e-07 103.55p -4.290188e-07 103.5625p -3.8676149999999999e-07 103.575p -3.4405979999999999e-07 103.58750000000001p -3.0097210000000002e-07 103.59999999999999p -2.575571e-07 103.6125p -2.1387409999999999e-07 103.625p -1.6998239999999999e-07 103.63749999999999p -1.259414e-07 103.65000000000001p -8.1810719999999994e-08 103.66250000000001p -3.7649899999999998e-08 103.67500000000001p 6.481653e-09 103.6875p 5.0524680000000001e-08 103.7p 9.4420200000000005e-08 103.71250000000001p 1.381095e-07 103.72499999999999p 1.815345e-07
+ 103.7375p 2.246373e-07 103.75p 2.6736090000000002e-07 103.76249999999999p 3.0964859999999997e-07 103.77499999999999p 3.5144469999999998e-07 103.78750000000001p 3.926941e-07 103.80000000000001p 4.3334290000000003e-07 103.8125p 4.733377e-07 103.825p 5.1262640000000002e-07 103.83750000000001p 5.5115780000000003e-07 103.84999999999999p 5.8888209999999996e-07 103.8625p 6.2575039999999997e-07 103.875p 6.6171529999999997e-07 103.88749999999999p 6.9673050000000003e-07 103.89999999999999p 7.3075140000000005e-07 103.91250000000001p 7.6373449999999999e-07 103.92500000000001p 7.9563809999999999e-07 103.9375p 8.2642189999999997e-07 103.95p 8.5604720000000005e-07
+ 103.96250000000001p 8.8447690000000002e-07 103.97499999999999p 9.1167570000000004e-07 103.9875p 9.3760999999999999e-07 104p 9.6224799999999992e-07 104.01249999999999p 9.8555959999999992e-07 104.02499999999999p 1.0075169999999999e-06 104.03749999999999p 1.028093e-06 104.05000000000001p 1.047264e-06 104.0625p 1.0650069999999999e-06 104.075p 1.081302e-06 104.08750000000001p 1.096131e-06 104.09999999999999p 1.1094759999999999e-06 104.1125p 1.121323e-06 104.125p 1.1316600000000001e-06 104.1375p 1.1404769999999999e-06 104.14999999999999p 1.1477649999999999e-06 104.16249999999999p 1.1535170000000001e-06 104.17500000000001p 1.1577289999999999e-06
+ 104.1875p 1.1603999999999999e-06 104.2p 1.161529e-06 104.21250000000001p 1.161117e-06 104.22499999999999p 1.1591700000000001e-06 104.2375p 1.155692e-06 104.25p 1.150691e-06 104.2625p 1.144179e-06 104.27499999999999p 1.1361659999999999e-06 104.28749999999999p 1.1266660000000001e-06 104.30000000000001p 1.115695e-06 104.3125p 1.103272e-06 104.325p 1.0894150000000001e-06 104.33750000000001p 1.074146e-06 104.34999999999999p 1.0574889999999999e-06 104.3625p 1.0394679999999999e-06 104.375p 1.02011e-06 104.3875p 9.9944470000000006e-07 104.39999999999999p 9.7750090000000005e-07
+ 104.41249999999999p 9.54311e-07 104.425p 9.2990839999999996e-07 104.4375p 9.0432789999999995e-07 104.45p 8.7760600000000003e-07 104.46250000000001p 8.4978060000000004e-07 104.47500000000001p 8.2089089999999997e-07 104.4875p 7.909774e-07 104.5p 7.6008199999999996e-07 104.5125p 7.2824769999999999e-07 104.52499999999999p 6.9551879999999996e-07 104.53749999999999p 6.6194039999999998e-07 104.55p 6.2755899999999996e-07 104.5625p 5.9242180000000002e-07 104.575p 5.5657710000000004e-07 104.58750000000001p 5.2007389999999998e-07 104.60000000000001p 4.8296199999999998e-07 104.6125p 4.4529199999999999e-07 104.625p 4.0711499999999998e-07
+ 104.6375p 3.6848280000000002e-07 104.64999999999999p 3.294477e-07 104.66249999999999p 2.9006240000000002e-07 104.675p 2.5037980000000001e-07 104.6875p 2.104535e-07 104.7p 1.70337e-07 104.71250000000001p 1.300839e-07 104.72500000000001p 8.9748240000000001e-08 104.7375p 4.9383710000000001e-08 104.75p 9.0441089999999998e-09 104.7625p -3.1216909999999999e-08 104.77499999999999p -7.1345930000000007e-08 104.78749999999999p -1.112898e-07 104.8p -1.5099559999999999e-07 104.8125p -1.9041109999999999e-07 104.825p -2.294842e-07 104.83750000000001p -2.6816370000000002e-07 104.85000000000001p -3.0639869999999999e-07
+ 104.8625p -3.4413920000000002e-07 104.875p -3.813359e-07 104.8875p -4.1794030000000003e-07 104.89999999999999p -4.539048e-07 104.91249999999999p -4.891826e-07 104.925p -5.2372819999999997e-07 104.9375p -5.5749699999999998e-07 104.95p -5.9044540000000004e-07 104.96250000000001p -6.2253110000000002e-07 104.97500000000001p -6.5371309999999996e-07 104.9875p -6.8395149999999997e-07 105p -7.1320800000000002e-07 105.0125p -7.4144539999999995e-07 105.02499999999999p -7.6862819999999995e-07 105.03749999999999p -7.9472220000000005e-07 105.05p -8.1969470000000001e-07 105.0625p -8.4351459999999997e-07 105.075p -8.6615270000000001e-07
+ 105.08750000000001p -8.8758090000000005e-07 105.10000000000001p -9.0777309999999995e-07 105.1125p -9.2670499999999999e-07 105.125p -9.4435380000000003e-07 105.1375p -9.6069850000000003e-07 105.14999999999999p -9.757201000000001e-07 105.16249999999999p -9.8940109999999997e-07 105.175p -1.001726e-06 105.1875p -1.012681e-06 105.2p -1.022255e-06 105.21250000000001p -1.0304370000000001e-06 105.22500000000001p -1.0372199999999999e-06 105.2375p -1.0425960000000001e-06 105.25p -1.0465630000000001e-06 105.2625p -1.0491179999999999e-06 105.27500000000001p -1.0502600000000001e-06 105.28749999999999p -1.04999e-06 105.3p -1.0483120000000001e-06
+ 105.3125p -1.045231e-06 105.32499999999999p -1.0407550000000001e-06 105.33750000000001p -1.034891e-06 105.35000000000001p -1.027651e-06 105.3625p -1.019048e-06 105.375p -1.0090950000000001e-06 105.3875p -9.9780909999999998e-07 105.40000000000001p -9.8520780000000003e-07 105.41249999999999p -9.7131079999999992e-07 105.425p -9.5613940000000003e-07 105.4375p -9.3971650000000001e-07 105.44999999999999p -9.2206679999999998e-07 105.46250000000001p -9.0321650000000002e-07 105.47500000000001p -8.8319319999999997e-07 105.4875p -8.6202629999999997e-07 105.5p -8.3974639999999995e-07 105.5125p -8.1638559999999999e-07 105.52500000000001p -7.9197759999999995e-07
+ 105.53749999999999p -7.6655710000000002e-07 105.55p -7.4016030000000001e-07 105.5625p -7.1282450000000002e-07 105.57499999999999p -6.8458829999999999e-07 105.58749999999999p -6.5549130000000001e-07 105.60000000000001p -6.255742e-07 105.61250000000001p -5.9487890000000002e-07 105.625p -5.6344800000000003e-07 105.6375p -5.3132499999999995e-07 105.65000000000001p -4.9855449999999999e-07 105.66249999999999p -4.6518149999999998e-07 105.675p -4.3125209999999999e-07 105.6875p -3.9681260000000003e-07 105.69999999999999p -3.6191040000000001e-07 105.71249999999999p -3.265929e-07 105.72500000000001p -2.9090829999999998e-07 105.73750000000001p -2.5490500000000002e-07 105.75p -2.18632e-07
+ 105.7625p -1.821381e-07 105.77500000000001p -1.4547269999999999e-07 105.78749999999999p -1.086851e-07 105.8p -7.182472e-08 105.8125p -3.4940940000000002e-08 105.82499999999999p 1.9169190000000001e-09 105.83749999999999p 3.8699690000000003e-08 105.85000000000001p 7.5358430000000004e-08 105.86250000000001p 1.118444e-07 105.875p 1.4810939999999999e-07 105.8875p 1.8410539999999999e-07 105.90000000000001p 2.1978500000000001e-07 105.91249999999999p 2.5510120000000001e-07 105.925p 2.900078e-07 105.9375p 3.244591e-07 105.95p 3.5840999999999999e-07 105.96249999999999p 3.9181660000000003e-07 105.97499999999999p 4.2463530000000002e-07
+ 105.98750000000001p 4.568238e-07 106p 4.883405e-07 106.0125p 5.1914500000000001e-07 106.02500000000001p 5.4919769999999999e-07 106.03749999999999p 5.7846039999999997e-07 106.05p 6.0689570000000003e-07 106.0625p 6.344678e-07 106.075p 6.6114169999999998e-07 106.08749999999999p 6.8688389999999998e-07 106.09999999999999p 7.1166239999999998e-07 106.11250000000001p 7.3544630000000001e-07 106.125p 7.582061e-07 106.1375p 7.7991389999999996e-07 106.15000000000001p 8.0054309999999996e-07 106.16249999999999p 8.200688e-07 106.175p 8.3846740000000001e-07 106.1875p 8.5571699999999996e-07 106.2p 8.7179730000000001e-07
+ 106.21249999999999p 8.866894e-07 106.22499999999999p 9.0037629999999999e-07 106.2375p 9.1284240000000004e-07 106.25p 9.2407399999999999e-07 106.2625p 9.3405880000000003e-07 106.27500000000001p 9.4278629999999996e-07 106.28749999999999p 9.5024770000000005e-07 106.3p 9.5643590000000006e-07 106.3125p 9.6134560000000004e-07 106.325p 9.6497290000000003e-07 106.33749999999999p 9.6731589999999991e-07 106.34999999999999p 9.6837430000000007e-07 106.3625p 9.6814950000000009e-07 106.375p 9.6664450000000005e-07 106.3875p 9.6386400000000006e-07 106.40000000000001p 9.5981459999999992e-07 106.41250000000001p 9.5450430000000006e-07 106.425p 9.479428e-07
+ 106.4375p 9.4014149999999999e-07 106.45p 9.3111330000000004e-07 106.46249999999999p 9.2087270000000001e-07 106.47499999999999p 9.0943590000000003e-07 106.4875p 8.9682060000000001e-07 106.5p 8.8304579999999997e-07 106.5125p 8.6813209999999997e-07 106.52500000000001p 8.5210180000000003e-07 106.53750000000001p 8.3497819999999996e-07 106.55p 8.1678630000000002e-07 106.5625p 7.9755229999999997e-07 106.575p 7.7730370000000003e-07 106.58749999999999p 7.5606949999999995e-07 106.59999999999999p 7.3387970000000003e-07 106.6125p 7.1076550000000004e-07 106.625p 6.8675929999999999e-07 106.6375p 6.6189470000000001e-07 106.65000000000001p 6.3620630000000003e-07
+ 106.66250000000001p 6.0972970000000002e-07 106.675p 5.8250129999999999e-07 106.6875p 5.545588e-07 106.7p 5.2594040000000003e-07 106.71249999999999p 4.9668540000000003e-07 106.72499999999999p 4.6683359999999999e-07 106.7375p 4.3642570000000002e-07 106.75p 4.0550290000000001e-07 106.7625p 3.7410730000000001e-07 106.77500000000001p 3.4228119999999998e-07 106.78750000000001p 3.1006750000000001e-07 106.8p 2.7750959999999998e-07 106.8125p 2.4465130000000001e-07 106.825p 2.115366e-07 106.83749999999999p 1.782097e-07 106.84999999999999p 1.447154e-07 106.8625p 1.1109800000000001e-07 106.875p 7.7402529999999997e-08
+ 106.8875p 4.3673600000000003e-08 106.90000000000001p 9.9559560000000008e-09 106.91250000000001p -2.370577e-08 106.925p -5.7267099999999998e-08 106.9375p -9.0683770000000006e-08 106.95p -1.2391179999999999e-07 106.96249999999999p -1.569075e-07 106.97499999999999p -1.8962770000000001e-07 106.9875p -2.220294e-07 107p -2.5407040000000002e-07 107.0125p -2.8570880000000002e-07 107.02500000000001p -3.1690360000000002e-07 107.03750000000001p -3.4761410000000002e-07 107.05p -3.7780070000000001e-07 107.0625p -4.0742430000000001e-07 107.075p -4.3644660000000002e-07 107.08750000000001p -4.6483039999999998e-07 107.09999999999999p -4.9253929999999999e-07
+ 107.1125p -5.1953770000000003e-07 107.125p -5.4579130000000002e-07 107.1375p -5.7126670000000005e-07 107.15000000000001p -5.9593169999999999e-07 107.16250000000001p -6.1975489999999996e-07 107.175p -6.4270660000000002e-07 107.1875p -6.6475799999999998e-07 107.2p -6.8588149999999999e-07 107.21250000000001p -7.0605109999999997e-07 107.22499999999999p -7.2524170000000003e-07 107.2375p -7.4343000000000003e-07 107.25p -7.6059369999999999e-07 107.26249999999999p -7.7671209999999997e-07 107.27500000000001p -7.91766e-07 107.28750000000001p -8.0573740000000001e-07 107.3p -8.1861020000000003e-07 107.3125p -8.3036930000000005e-07 107.325p -8.4100150000000001e-07
+ 107.33750000000001p -8.5049500000000002e-07 107.34999999999999p -8.5883949999999997e-07 107.3625p -8.6602620000000001e-07 107.375p -8.7204820000000001e-07 107.38749999999999p -8.7689959999999995e-07 107.40000000000001p -8.8057669999999996e-07 107.41250000000001p -8.8307690000000002e-07 107.42500000000001p -8.843994e-07 107.4375p -8.8454489999999999e-07 107.45p -8.8351569999999998e-07 107.46250000000001p -8.8131570000000003e-07 107.47499999999999p -8.7795019999999998e-07 107.4875p -8.7342640000000002e-07 107.5p -8.6775250000000004e-07 107.51249999999999p -8.6093869999999997e-07 107.52499999999999p -8.5299639999999999e-07 107.53750000000001p -8.4393860000000003e-07 107.55000000000001p -8.3377979999999996e-07
+ 107.5625p -8.2253580000000002e-07 107.575p -8.1022409999999996e-07 107.58750000000001p -7.9686310000000003e-07 107.59999999999999p -7.8247300000000002e-07 107.6125p -7.6707519999999996e-07 107.625p -7.5069240000000003e-07 107.63749999999999p -7.3334839999999995e-07 107.64999999999999p -7.1506850000000002e-07 107.66250000000001p -6.9587900000000003e-07 107.67500000000001p -6.7580750000000005e-07 107.6875p -6.5488250000000001e-07 107.7p -6.3313389999999996e-07 107.71250000000001p -6.1059230000000005e-07 107.72499999999999p -5.872895e-07 107.7375p -5.6325810000000002e-07 107.75p -5.3853179999999996e-07 107.76249999999999p -5.1314510000000003e-07 107.77499999999999p -4.8713300000000003e-07
+ 107.78749999999999p -4.6053180000000003e-07 107.80000000000001p -4.3337789999999999e-07 107.8125p -4.0570889999999998e-07 107.825p -3.775627e-07 107.83750000000001p -3.4897780000000001e-07 107.84999999999999p -3.1999320000000001e-07 107.8625p -2.9064849999999998e-07 107.875p -2.609833e-07 107.8875p -2.3103800000000001e-07 107.89999999999999p -2.0085300000000001e-07 107.91249999999999p -1.7046910000000001e-07 107.92500000000001p -1.3992700000000001e-07 107.9375p -1.092678e-07 107.95p -7.8532569999999994e-08 107.96250000000001p -4.7762339999999997e-08 107.97499999999999p -1.6998129999999999e-08 107.9875p 1.371915e-08 108p 4.4348750000000002e-08
+ 108.0125p -1.2221070000000001e-07 108.02499999999999p -2.7433349999999999e-07 108.03749999999999p -4.1147670000000002e-07 108.05000000000001p -5.3402830000000005e-07 108.0625p -6.4270010000000005e-07 108.075p -7.3831930000000001e-07 108.08750000000001p -8.217542e-07 108.09999999999999p -8.9388599999999996e-07 108.1125p -9.5559640000000008e-07 108.125p -1.0077600000000001e-06 108.1375p -1.051239e-06 108.14999999999999p -1.086881e-06 108.16249999999999p -1.11551e-06 108.175p -1.1379299999999999e-06 108.1875p -1.154918e-06 108.2p -1.167222e-06 108.21250000000001p -1.1755579999999999e-06 108.22500000000001p -1.1806110000000001e-06
+ 108.2375p -1.1830299999999999e-06 108.25p -1.1834289999999999e-06 108.2625p -1.1823840000000001e-06 108.27499999999999p -1.1804350000000001e-06 108.28749999999999p -1.1780829999999999e-06 108.3p -1.175791e-06 108.3125p -1.1739840000000001e-06 108.325p -1.1730489999999999e-06 108.33750000000001p -1.1733329999999999e-06 108.35000000000001p -1.1751500000000001e-06 108.3625p -1.178775e-06 108.375p -1.1844470000000001e-06 108.3875p -1.192375e-06 108.39999999999999p -1.2027290000000001e-06 108.41249999999999p -1.215651e-06 108.425p -1.2312529999999999e-06 108.4375p -1.2496150000000001e-06 108.45p -1.270792e-06
+ 108.46250000000001p -1.294814e-06 108.47500000000001p -1.3216829999999999e-06 108.4875p -1.3513830000000001e-06 108.5p -1.3838739999999999e-06 108.5125p -1.419098e-06 108.52499999999999p -1.456979e-06 108.53749999999999p -1.497427e-06 108.55p -1.540334e-06 108.5625p -1.5855840000000001e-06 108.575p -1.6330460000000001e-06 108.58750000000001p -1.6825829999999999e-06 108.60000000000001p -1.7340480000000001e-06 108.6125p -1.7872870000000001e-06 108.625p -1.842141e-06 108.6375p -1.89845e-06 108.64999999999999p -1.956048e-06 108.66249999999999p -2.014769e-06 108.675p -2.0744450000000002e-06
+ 108.6875p -2.134912e-06 108.7p -2.1960050000000002e-06 108.71250000000001p -2.2575629999999998e-06 108.72500000000001p -2.3194269999999999e-06 108.7375p -2.3814429999999999e-06 108.75p -2.443461e-06 108.7625p -2.5053380000000002e-06 108.77499999999999p -2.5669360000000001e-06 108.78749999999999p -2.6281229999999999e-06 108.8p -2.6887740000000001e-06 108.8125p -2.7487719999999999e-06 108.825p -2.808005e-06 108.83750000000001p -2.8663719999999999e-06 108.85000000000001p -2.9237769999999999e-06 108.8625p -2.9801329999999999e-06 108.875p -3.0353599999999999e-06 108.8875p -3.0893889999999999e-06 108.89999999999999p -3.1421540000000002e-06
+ 108.91249999999999p -3.1935999999999998e-06 108.925p -3.243679e-06 108.9375p -3.292352e-06 108.95p -3.3395840000000002e-06 108.96250000000001p -3.3853489999999999e-06 108.97500000000001p -3.4296289999999999e-06 108.9875p -3.4724110000000001e-06 109p -3.5136889999999998e-06 109.0125p -3.356403e-06 109.02500000000001p -3.2122229999999999e-06 109.03749999999999p -3.081744e-06 109.05p -2.9646329999999998e-06 109.0625p -2.86024e-06 109.07499999999999p -2.7678009999999998e-06 109.08750000000001p -2.686516e-06 109.10000000000001p -2.6155740000000001e-06 109.1125p -2.554168e-06 109.125p -2.5014989999999999e-06
+ 109.1375p -2.4567830000000001e-06 109.15000000000001p -2.419253e-06 109.16249999999999p -2.3881649999999999e-06 109.175p -2.362798e-06 109.1875p -2.3424569999999999e-06 109.19999999999999p -2.3264790000000001e-06 109.21250000000001p -2.314229e-06 109.22500000000001p -2.3051059999999999e-06 109.2375p -2.2985429999999998e-06 109.25p -2.2940060000000001e-06 109.2625p -2.2910000000000002e-06 109.27500000000001p -2.2890640000000001e-06 109.28749999999999p -2.2877740000000001e-06 109.3p -2.2867410000000001e-06 109.3125p -2.285615e-06 109.32499999999999p -2.284081e-06 109.33749999999999p -2.281857e-06 109.35000000000001p -2.2786990000000001e-06
+ 109.36250000000001p -2.274394e-06 109.375p -2.2687640000000001e-06 109.3875p -2.2616589999999998e-06 109.40000000000001p -2.2529629999999999e-06 109.41249999999999p -2.242586e-06 109.425p -2.230468e-06 109.4375p -2.2165709999999999e-06 109.44999999999999p -2.200886e-06 109.46249999999999p -2.1834219999999999e-06 109.47500000000001p -2.1642130000000001e-06 109.48750000000001p -2.1433089999999999e-06 109.5p -2.1207810000000002e-06 109.5125p -2.0967140000000001e-06 109.52500000000001p -2.0712070000000002e-06 109.53749999999999p -2.044374e-06 109.55p -2.016337e-06 109.5625p -1.9872300000000002e-06 109.57499999999999p -1.9571950000000002e-06
+ 109.58749999999999p -1.9263800000000002e-06 109.60000000000001p -1.8949380000000001e-06 109.61250000000001p -1.8630260000000001e-06 109.625p -1.830804e-06 109.6375p -1.7984330000000001e-06 109.65000000000001p -1.766074e-06 109.66249999999999p -1.7338860000000001e-06 109.675p -1.7020289999999999e-06 109.6875p -1.670657e-06 109.7p -1.6399219999999999e-06 109.71249999999999p -1.6099710000000001e-06 109.72499999999999p -1.5809449999999999e-06 109.73750000000001p -1.5529790000000001e-06 109.75p -1.526203e-06 109.7625p -1.5007380000000001e-06 109.77500000000001p -1.4766979999999999e-06 109.78749999999999p -1.4541899999999999e-06 109.8p -1.433312e-06
+ 109.8125p -1.4141520000000001e-06 109.825p -1.3967929999999999e-06 109.83749999999999p -1.381306e-06 109.84999999999999p -1.3677540000000001e-06 109.86250000000001p -1.35619e-06 109.875p -1.3466609999999999e-06 109.8875p -1.3392020000000001e-06 109.90000000000001p -1.3338419999999999e-06 109.91249999999999p -1.3305969999999999e-06 109.925p -1.32948e-06 109.9375p -1.330492e-06 109.95p -1.3336269999999999e-06 109.96249999999999p -1.3388710000000001e-06 109.97499999999999p -1.346203e-06 109.9875p -1.3555950000000001e-06 110p -1.3670110000000001e-06 110.0125p -1.38041e-06 110.02500000000001p -1.395743e-06
+ 110.03749999999999p -1.412958e-06 110.05p -1.431993e-06 110.0625p -1.4527869999999999e-06 110.075p -1.4752680000000001e-06 110.08749999999999p -1.4993650000000001e-06 110.09999999999999p -1.524999e-06 110.1125p -1.5520900000000001e-06 110.125p -1.580554e-06 110.1375p -1.610305e-06 110.15000000000001p -1.641252e-06 110.16250000000001p -1.673304e-06 110.175p -1.7063690000000001e-06 110.1875p -1.740351e-06 110.2p -1.775154e-06 110.21249999999999p -1.810683e-06 110.22499999999999p -1.8468390000000001e-06 110.2375p -1.8835259999999999e-06 110.25p -1.9206450000000001e-06
+ 110.2625p -1.9580999999999999e-06 110.27500000000001p -1.9957950000000001e-06 110.28750000000001p -2.0336330000000002e-06 110.3p -2.0715189999999999e-06 110.3125p -2.1093599999999998e-06 110.325p -2.147064e-06 110.33749999999999p -2.1845399999999998e-06 110.34999999999999p -2.221699e-06 110.3625p -2.2584540000000001e-06 110.375p -2.2947190000000001e-06 110.3875p -2.3304129999999999e-06 110.40000000000001p -2.3654529999999998e-06 110.41250000000001p -2.3997620000000001e-06 110.425p -2.4332650000000002e-06 110.4375p -2.4658869999999998e-06 110.45p -2.4975580000000001e-06 110.46249999999999p -2.5282100000000001e-06 110.47499999999999p -2.5577780000000001e-06
+ 110.4875p -2.5861990000000001e-06 110.5p -2.6134139999999998e-06 110.5125p -2.639366e-06 110.52500000000001p -2.6640019999999999e-06 110.53750000000001p -2.6872700000000001e-06 110.55p -2.7091219999999998e-06 110.5625p -2.7295139999999998e-06 110.575p -2.7484030000000001e-06 110.58749999999999p -2.765751e-06 110.59999999999999p -2.7815200000000001e-06 110.6125p -2.7956770000000002e-06 110.625p -2.8081930000000001e-06 110.6375p -2.819039e-06 110.65000000000001p -2.82819e-06 110.66250000000001p -2.8356259999999999e-06 110.675p -2.8413260000000001e-06 110.6875p -2.845275e-06 110.7p -2.8474590000000002e-06
+ 110.71249999999999p -2.847867e-06 110.72499999999999p -2.8464910000000002e-06 110.7375p -2.8433259999999998e-06 110.75p -2.8383680000000002e-06 110.7625p -2.831617e-06 110.77500000000001p -2.8230750000000001e-06 110.78750000000001p -2.812747e-06 110.8p -2.8006400000000002e-06 110.8125p -2.7867630000000002e-06 110.825p -2.771128e-06 110.83750000000001p -2.7537500000000001e-06 110.84999999999999p -2.734644e-06 110.8625p -2.7138300000000002e-06 110.875p -2.6913270000000001e-06 110.8875p -2.667159e-06 110.90000000000001p -2.6413500000000001e-06 110.91250000000001p -2.613928e-06 110.925p -2.584921e-06
+ 110.9375p -2.5543599999999998e-06 110.95p -2.522279e-06 110.96250000000001p -2.4887099999999998e-06 110.97499999999999p -2.4536909999999999e-06 110.9875p -2.4172599999999999e-06 111p -2.3794550000000001e-06 111.01249999999999p -2.3403190000000002e-06 111.02500000000001p -2.299894e-06 111.03750000000001p -2.2582240000000001e-06 111.05p -2.215354e-06 111.0625p -2.1713319999999999e-06 111.075p -2.1262059999999998e-06 111.08750000000001p -2.0800259999999999e-06 111.09999999999999p -2.0328420000000001e-06 111.1125p -1.9847050000000002e-06 111.125p -1.9356690000000002e-06 111.13749999999999p -1.8857880000000001e-06 111.15000000000001p -1.835116e-06
+ 111.16250000000001p -1.783708e-06 111.17500000000001p -1.731622e-06 111.1875p -1.6789130000000001e-06 111.2p -1.62564e-06 111.21250000000001p -1.5718609999999999e-06 111.22499999999999p -1.517634e-06 111.2375p -1.4630180000000001e-06 111.25p -1.408074e-06 111.26249999999999p -1.35286e-06 111.27499999999999p -1.297436e-06 111.28750000000001p -1.2418619999999999e-06 111.30000000000001p -1.1861989999999999e-06 111.3125p -1.130506e-06 111.325p -1.074843e-06 111.33750000000001p -1.0192699999999999e-06 111.34999999999999p -9.6384569999999996e-07 111.3625p -9.0862959999999998e-07 111.375p -8.5368020000000004e-07
+ 111.38749999999999p -7.9905570000000003e-07 111.39999999999999p -7.4481360000000005e-07 111.41250000000001p -6.9101080000000003e-07 111.42500000000001p -6.3770359999999998e-07 111.4375p -5.849474e-07 111.45p -5.3279689999999998e-07 111.46250000000001p -4.8130569999999998e-07 111.47499999999999p -4.3052659999999998e-07 111.4875p -3.8051130000000001e-07 111.5p -3.3131039999999999e-07 111.51249999999999p -2.8297320000000001e-07 111.52499999999999p -2.355481e-07 111.53749999999999p -1.8908190000000001e-07 111.55000000000001p -1.436202e-07 111.5625p -9.9207309999999996e-08 111.575p -5.5885880000000003e-08 111.58750000000001p -1.369725e-08 111.59999999999999p 2.731884e-08
+ 111.6125p 6.7124199999999997e-08 111.625p 1.056823e-07 111.6375p 1.4295820000000001e-07 111.64999999999999p 1.7891859999999999e-07 111.66249999999999p 2.1353219999999999e-07 111.67500000000001p 2.467691e-07 111.6875p 2.7860150000000001e-07 111.7p 3.090031e-07 111.71250000000001p 3.3794979999999999e-07 111.72499999999999p 3.6541889999999998e-07 111.7375p 3.9139000000000001e-07 111.75p 4.1584440000000002e-07 111.7625p 4.387653e-07 111.77499999999999p 4.601378e-07 111.78749999999999p 4.7994900000000003e-07 111.8p 4.9818779999999995e-07 111.8125p 5.1484519999999999e-07 111.825p 5.2991399999999996e-07
+ 111.83750000000001p 5.4338899999999997e-07 111.84999999999999p 5.552669e-07 111.8625p 5.6554620000000001e-07 111.875p 5.7422770000000005e-07 111.8875p 5.8131360000000004e-07 111.89999999999999p 5.8680829999999997e-07 111.91249999999999p 5.9071799999999998e-07 111.925p 5.9305080000000002e-07 111.9375p 5.9381649999999996e-07 111.95p 5.9302699999999998e-07 111.96250000000001p 5.9069569999999998e-07 111.97500000000001p 5.8683800000000003e-07 111.9875p 5.8147089999999996e-07 112p 5.7461330000000004e-07 112.0125p 5.6628550000000001e-07 112.02499999999999p 5.5650979999999996e-07 112.03749999999999p 5.4530990000000001e-07 112.05p 5.3271130000000001e-07
+ 112.0625p 5.1874090000000003e-07 112.075p 5.0342729999999995e-07 112.08750000000001p 4.8680029999999997e-07 112.10000000000001p 4.6889159999999999e-07 112.1125p 4.49734e-07 112.125p 4.293617e-07 112.1375p 4.0781040000000002e-07 112.14999999999999p 3.8511689999999997e-07 112.16249999999999p 3.613194e-07 112.175p 3.3645729999999998e-07 112.1875p 3.1057109999999997e-07 112.2p 2.837025e-07 112.21250000000001p 2.55894e-07 112.22500000000001p 2.271895e-07 112.2375p 1.9763370000000001e-07 112.25p 1.6727199999999999e-07 112.2625p 1.3615100000000001e-07 112.27499999999999p 1.043179e-07
+ 112.28749999999999p 7.1820799999999994e-08 112.3p 3.8708329999999998e-08 112.3125p 5.0298600000000002e-09 112.325p -2.9164660000000001e-08 112.33750000000001p -6.382478e-08 112.35000000000001p -9.8899550000000001e-08 112.3625p -1.343376e-07 112.375p -1.7008730000000001e-07 112.3875p -2.0609669999999999e-07 112.39999999999999p -2.4231349999999999e-07 112.41249999999999p -2.7868540000000001e-07 112.425p -3.1515979999999999e-07 112.4375p -3.5168440000000001e-07 112.45p -3.8820660000000001e-07 112.46250000000001p -4.2467390000000002e-07 112.47500000000001p -4.6103419999999998e-07 112.4875p -4.9723550000000001e-07 112.5p -5.3322589999999997e-07
+ 112.5125p -5.6895410000000002e-07 112.52499999999999p -6.0436910000000002e-07 112.53749999999999p -6.3942030000000002e-07 112.55p -6.7405779999999995e-07 112.5625p -7.0823219999999997e-07 112.575p -7.4189469999999998e-07 112.58750000000001p -7.7499750000000003e-07 112.60000000000001p -8.074932e-07 112.6125p -8.3933560000000002e-07 112.625p -8.7047920000000001e-07 112.6375p -9.0087960000000004e-07 112.64999999999999p -9.3049329999999997e-07 112.66249999999999p -9.592780000000001e-07 112.675p -9.8719249999999995e-07 112.6875p -1.0141970000000001e-06 112.7p -1.040252e-06 112.71250000000001p -1.065322e-06 112.72500000000001p -1.0893680000000001e-06
+ 112.7375p -1.112358e-06 112.75p -1.134258e-06 112.7625p -1.1550360000000001e-06 112.77500000000001p -1.174662e-06 112.78749999999999p -1.1931080000000001e-06 112.8p -1.2103460000000001e-06 112.8125p -1.226352e-06 112.82499999999999p -1.2411019999999999e-06 112.83750000000001p -1.2545739999999999e-06 112.85000000000001p -1.2667479999999999e-06 112.8625p -1.277606e-06 112.875p -1.287132e-06 112.8875p -1.29531e-06 112.90000000000001p -1.3021289999999999e-06 112.91249999999999p -1.307578e-06 112.925p -1.3116479999999999e-06 112.9375p -1.3143310000000001e-06 112.94999999999999p -1.3156229999999999e-06
+ 112.96250000000001p -1.3155210000000001e-06 112.97500000000001p -1.314023e-06 112.9875p -1.31113e-06 113p -1.3068449999999999e-06 113.0125p -1.301172e-06 113.02500000000001p -1.2941189999999999e-06 113.03749999999999p -1.2856930000000001e-06 113.05p -1.2759050000000001e-06 113.0625p -1.2647670000000001e-06 113.07499999999999p -1.2522930000000001e-06 113.08749999999999p -1.2384990000000001e-06 113.10000000000001p -1.2234020000000001e-06 113.11250000000001p -1.207023e-06 113.125p -1.189383e-06 113.1375p -1.170504e-06 113.15000000000001p -1.1504109999999999e-06 113.16249999999999p -1.1291309999999999e-06 113.175p -1.1066910000000001e-06
+ 113.1875p -1.083121e-06 113.19999999999999p -1.0584530000000001e-06 113.21249999999999p -1.0327179999999999e-06 113.22500000000001p -1.0059509999999999e-06 113.23750000000001p -9.7818630000000008e-07 113.25p -9.4946160000000001e-07 113.2625p -9.1981459999999999e-07 113.27500000000001p -8.8928430000000001e-07 113.28749999999999p -8.579111e-07 113.3p -8.257364e-07 113.3125p -7.9280270000000001e-07 113.32499999999999p -7.5915329999999997e-07 113.33749999999999p -7.2483269999999996e-07 113.35000000000001p -6.8988599999999999e-07 113.36250000000001p -6.5435929999999999e-07 113.375p -6.1829900000000005e-07 113.3875p -5.8175270000000003e-07 113.40000000000001p -5.4476820000000001e-07
+ 113.41249999999999p -5.0739379999999996e-07 113.425p -4.6967839999999997e-07 113.4375p -4.316713e-07 113.45p -3.934218e-07 113.46249999999999p -3.5497969999999999e-07 113.47499999999999p -3.1639489999999998e-07 113.48750000000001p -2.7771729999999997e-07 113.5p -2.389968e-07 113.5125p -2.002833e-07 113.52500000000001p -1.6162669999999999e-07 113.53749999999999p -1.2307630000000001e-07 113.55p -8.4681580000000002e-08 113.5625p -4.6491399999999998e-08 113.575p -8.5543070000000003e-09 113.58749999999999p 2.908165e-08 113.59999999999999p 6.6368949999999994e-08 113.61250000000001p 1.032607e-07 113.625p 1.397106e-07
+ 113.6375p 1.756732e-07 113.65000000000001p 2.1110370000000001e-07 113.66249999999999p 2.4595829999999999e-07 113.675p 2.8019399999999997e-07 113.6875p 3.1376880000000002e-07 113.7p 3.4664170000000001e-07 113.71249999999999p 3.787727e-07 113.72499999999999p 4.1012319999999998e-07 113.7375p 4.4065529999999997e-07 113.75p 4.703328e-07 113.7625p 4.9912050000000005e-07 113.77500000000001p 5.2698449999999999e-07 113.78750000000001p 5.5389219999999998e-07 113.8p 5.7981260000000001e-07 113.8125p 6.0471589999999998e-07 113.825p 6.2857389999999998e-07 113.83749999999999p 6.5135969999999995e-07 113.84999999999999p 6.7304810000000005e-07
+ 113.8625p 6.9361519999999999e-07 113.875p 7.1303900000000001e-07 113.8875p 7.3129879999999998e-07 113.90000000000001p 7.4837549999999996e-07 113.91250000000001p 7.642518e-07 113.925p 7.7891190000000004e-07 113.9375p 7.9234180000000003e-07 113.95p 8.0452879999999995e-07 113.96249999999999p 8.154623e-07 113.97499999999999p 8.2513300000000001e-07 113.9875p 8.3353359999999996e-07 114p 8.4065829999999999e-07 114.0125p 8.465029e-07 114.02500000000001p 8.5106490000000004e-07 114.03750000000001p 8.543436e-07 114.05p 8.5634e-07 114.0625p 8.5705640000000004e-07 114.075p 8.56497e-07
+ 114.08749999999999p 8.5466760000000004e-07 114.09999999999999p 8.5157569999999997e-07 114.1125p 8.4723019999999998e-07 114.125p 8.416415e-07 114.1375p 8.3482189999999996e-07 114.15000000000001p 8.2678490000000004e-07 114.16250000000001p 8.1754569999999998e-07 114.175p 8.0712080000000003e-07 114.1875p 7.9552840000000005e-07 114.2p 7.8278789999999999e-07 114.21249999999999p 7.6892010000000002e-07 114.22499999999999p 7.5394739999999999e-07 114.2375p 7.3789319999999996e-07 114.25p 7.2078240000000005e-07 114.2625p 7.0264109999999996e-07 114.27500000000001p 6.8349669999999999e-07 114.28750000000001p 6.6337760000000003e-07 114.3p 6.4231350000000003e-07
+ 114.3125p 6.2033520000000001e-07 114.325p 5.9747439999999999e-07 114.33749999999999p 5.7376410000000002e-07 114.34999999999999p 5.4923790000000002e-07 114.3625p 5.239308e-07 114.375p 4.9787829999999998e-07 114.3875p 4.7111689999999998e-07 114.40000000000001p 4.4368379999999998e-07 114.41250000000001p 4.1561709999999997e-07 114.425p 3.869555e-07 114.4375p 3.5773839999999999e-07 114.45p 3.2800579999999999e-07 114.46249999999999p 2.9779820000000001e-07 114.47499999999999p 2.6715649999999997e-07 114.4875p 2.361224e-07 114.5p 2.0473769999999999e-07 114.5125p 1.730446e-07 114.52500000000001p 1.410856e-07
+ 114.53750000000001p 1.089036e-07 114.55p 7.654153e-08 114.5625p 4.4042430000000003e-08 114.575p 1.1449530000000001e-08 114.58750000000001p -2.1193919999999999e-08 114.59999999999999p -5.3844729999999997e-08 114.6125p -8.6459759999999998e-08 114.625p -1.18996e-07 114.6375p -1.5141060000000001e-07 114.65000000000001p -1.836609e-07 114.66250000000001p -2.1570470000000001e-07 114.675p -2.4750000000000001e-07 114.6875p -2.7900510000000002e-07 114.7p -3.1017900000000001e-07 114.71250000000001p -3.4098080000000002e-07 114.72499999999999p -3.7137070000000002e-07 114.7375p -4.0130890000000002e-07 114.75p -4.3075659999999998e-07
+ 114.76249999999999p -4.5967560000000002e-07 114.77500000000001p -4.8802840000000003e-07 114.78750000000001p -5.1577850000000004e-07 114.8p -5.4288979999999998e-07 114.8125p -5.6932759999999995e-07 114.825p -5.950577e-07 114.83750000000001p -6.2004700000000002e-07 114.84999999999999p -6.4426360000000001e-07 114.8625p -6.6767629999999998e-07 114.875p -6.9025530000000004e-07 114.88749999999999p -7.1197180000000001e-07 114.90000000000001p -7.3279809999999999e-07 114.91250000000001p -7.5270780000000003e-07 114.92500000000001p -7.716757e-07 114.9375p -7.8967790000000002e-07 114.95p -8.0669180000000005e-07 114.96250000000001p -8.2269610000000002e-07 114.97499999999999p -8.376708e-07
+ 114.9875p -8.5159740000000002e-07 115p -8.6445870000000005e-07 115.01249999999999p -8.7623899999999999e-07 115.02499999999999p -8.869241e-07 115.03750000000001p -8.9650109999999998e-07 115.05000000000001p -9.0495870000000002e-07 115.0625p -9.12287e-07 115.075p -9.1847789999999996e-07 115.08750000000001p -9.2352449999999997e-07 115.09999999999999p -9.2742140000000003e-07 115.1125p -9.3016510000000004e-07 115.125p -9.3175330000000002e-07 115.13749999999999p -9.3218540000000003e-07 115.14999999999999p -9.3146219999999999e-07 115.16250000000001p -9.2958619999999998e-07 115.17500000000001p -9.265614e-07 115.1875p -9.223933e-07 115.2p -9.170888e-07
+ 115.21250000000001p -9.1065649999999999e-07 115.22499999999999p -9.0310649999999995e-07 115.2375p -8.9445010000000001e-07 115.25p -8.8470040000000005e-07 115.26249999999999p -8.7387179999999999e-07 115.27499999999999p -8.6198000000000005e-07 115.28749999999999p -8.4904229999999996e-07 115.30000000000001p -8.3507729999999998e-07 115.3125p -8.2010489999999998e-07 115.325p -8.0414629999999998e-07 115.33750000000001p -7.8722410000000003e-07 115.34999999999999p -7.6936210000000005e-07 115.3625p -7.5058510000000001e-07 115.375p -7.3091949999999997e-07 115.3875p -7.1039259999999995e-07 115.39999999999999p -6.8903270000000002e-07 115.41249999999999p -6.6686930000000004e-07 115.42500000000001p -6.4393290000000001e-07
+ 115.4375p -6.2025509999999998e-07 115.45p -5.9586820000000004e-07 115.46250000000001p -5.708054e-07 115.47499999999999p -5.4510110000000005e-07 115.4875p -5.1878990000000001e-07 115.5p -4.9190769999999998e-07 115.5125p -4.644907e-07 115.52499999999999p -4.3657590000000001e-07 115.53749999999999p -4.0820099999999999e-07 115.55p -3.7940379999999999e-07 115.5625p -3.5022319999999998e-07 115.575p -3.20698e-07 115.58750000000001p -2.9086759999999999e-07 115.59999999999999p -2.607717e-07 115.6125p -2.3045030000000001e-07 115.625p -1.999434e-07 115.6375p -1.692914e-07 115.64999999999999p -1.3853470000000001e-07
+ 115.66249999999999p -1.077137e-07 115.675p -7.6868819999999994e-08 115.6875p -4.6040420000000002e-08 115.7p -1.52687e-08 115.71250000000001p 1.5406289999999999e-08 115.72500000000001p 4.5944729999999999e-08 115.7375p 7.6307119999999995e-08 115.75p 1.064543e-07 115.7625p 1.3634739999999999e-07 115.77499999999999p 1.6594809999999999e-07 115.78749999999999p 1.9521850000000001e-07 115.8p 2.2412139999999999e-07 115.8125p 2.5261999999999999e-07 115.825p 2.8067819999999998e-07 115.83750000000001p 3.082605e-07 115.85000000000001p 3.353324e-07 115.8625p 3.618598e-07 115.875p 3.878097e-07
+ 115.8875p 4.1314990000000002e-07 115.89999999999999p 4.378489e-07 115.91249999999999p 4.6187640000000002e-07 115.925p 4.8520300000000001e-07 115.9375p 5.0780009999999997e-07 115.95p 5.2964030000000005e-07 115.96250000000001p 5.5069739999999997e-07 115.97500000000001p 5.7094609999999995e-07 115.9875p 5.9036230000000003e-07 116p 6.0892310000000005e-07 116.0125p 6.2660670000000002e-07 116.02499999999999p 6.4339249999999996e-07 116.03749999999999p 6.5926140000000004e-07 116.05p 6.7419509999999995e-07 116.0625p 6.8817689999999999e-07 116.075p 7.0119130000000005e-07 116.08750000000001p 7.1322409999999997e-07 116.10000000000001p 7.2426239999999997e-07
+ 116.1125p 7.3429470000000005e-07 116.125p 7.4331080000000005e-07 116.1375p 7.5130170000000004e-07 116.14999999999999p 7.5825999999999996e-07 116.16249999999999p 7.6417960000000004e-07 116.175p 7.6905550000000001e-07 116.1875p 7.7288450000000004e-07 116.2p 7.7566439999999997e-07 116.21250000000001p 7.7739450000000002e-07 116.22500000000001p 7.7807549999999997e-07 116.2375p 7.7770939999999999e-07 116.25p 7.7629960000000001e-07 116.2625p 7.7385070000000001e-07 116.27499999999999p 7.7036870000000003e-07 116.28749999999999p 7.6586100000000003e-07 116.3p 7.6033619999999997e-07 116.3125p 7.5380419999999998e-07 116.325p 7.4627620000000002e-07
+ 116.33750000000001p 7.3776470000000001e-07 116.35000000000001p 7.2828320000000002e-07 116.3625p 7.1784670000000003e-07 116.375p 7.064713e-07 116.3875p 6.9417419999999996e-07 116.39999999999999p 6.8097370000000002e-07 116.41249999999999p 6.6688940000000001e-07 116.42499999999998p 6.5194179999999996e-07 116.43749999999999p 6.3615260000000005e-07 116.45p 6.1954439999999997e-07 116.46250000000001p 6.0214099999999999e-07 116.47500000000001p 5.8396679999999999e-07 116.48750000000001p 5.6504759999999997e-07 116.50000000000001p 5.4540970000000003e-07 116.51249999999999p 5.2508049999999995e-07 116.52499999999999p 5.040881e-07 116.53749999999999p 4.8246150000000004e-07 116.55p 4.6023040000000001e-07
+ 116.5625p 4.3742520000000003e-07 116.575p 4.1407699999999998e-07 116.58750000000001p 3.902174e-07 116.59999999999999p 3.6587890000000002e-07 116.6125p 3.4109419999999998e-07 116.625p 3.158968e-07 116.6375p 2.9032039999999999e-07 116.65000000000001p 2.6439940000000001e-07 116.66250000000001p 2.381683e-07 116.67499999999998p 2.1166219999999999e-07 116.68749999999999p 1.849162e-07 116.69999999999999p 1.5796590000000001e-07 116.71250000000001p 1.3084700000000001e-07 116.72500000000001p 1.035954e-07 116.73750000000001p 7.6246900000000002e-08 116.75000000000001p 4.8837640000000001e-08 116.76249999999999p 2.1403619999999999e-08 116.77499999999999p -6.0191649999999997e-09
+ 116.78749999999999p -3.3394790000000001e-08 116.8p -6.0687470000000004e-08 116.8125p -8.7861569999999998e-08 116.825p -1.1488170000000001e-07 116.83750000000001p -1.417126e-07 116.84999999999999p -1.6831959999999999e-07 116.8625p -1.946681e-07 116.875p -2.207241e-07 116.8875p -2.4645380000000001e-07 116.90000000000001p -2.718241e-07 116.91250000000001p -2.9680229999999999e-07 116.92500000000001p -3.2135639999999998e-07 116.93749999999999p -3.454549e-07 116.94999999999999p -3.6906699999999998e-07 116.96249999999999p -3.921625e-07 116.97500000000001p -4.1471199999999999e-07 116.98750000000001p -4.3668680000000001e-07 117.00000000000001p -4.5805920000000002e-07
+ 117.01249999999999p -4.7880209999999997e-07 117.02499999999999p -4.9888939999999998e-07 117.03749999999999p -5.1829590000000003e-07 117.05p -5.3699729999999995e-07 117.0625p -5.5497019999999998e-07 117.075p -5.7219239999999996e-07 117.08750000000001p -5.8864260000000002e-07 117.09999999999999p -6.0430040000000005e-07 117.1125p -6.1914690000000001e-07 117.125p -6.3316390000000005e-07 117.1375p -6.463346e-07 117.15000000000001p -6.5864299999999995e-07 117.16250000000001p -6.7007480000000001e-07 117.17500000000001p -6.8061639999999998e-07 117.18749999999999p -6.9025559999999996e-07 117.19999999999999p -6.9898150000000002e-07 117.21249999999999p -7.0678429999999996e-07 117.22499999999999p -7.1365540000000004e-07
+ 117.23750000000001p -7.1958770000000002e-07 117.25000000000001p -7.2457510000000001e-07 117.26250000000002p -7.286129e-07 117.27499999999999p -7.3169749999999995e-07 117.28749999999999p -7.3382699999999997e-07 117.3p -7.3500020000000004e-07 117.3125p -7.3521759999999996e-07 117.325p -7.3448080000000004e-07 117.33750000000001p -7.3279280000000003e-07 117.34999999999999p -7.3015760000000005e-07 117.3625p -7.2658070000000004e-07 117.375p -7.220687e-07 117.3875p -7.1662950000000002e-07 117.40000000000001p -7.102723e-07 117.41250000000001p -7.0300729999999999e-07 117.42500000000001p -6.9484610000000005e-07 117.43749999999999p -6.8580119999999997e-07 117.44999999999999p -6.7588669999999999e-07
+ 117.46249999999999p -6.6511729999999996e-07 117.47499999999999p -6.5350910000000005e-07 117.4875p -6.4107940000000001e-07 117.50000000000001p -6.2784620000000003e-07 117.51250000000002p -6.1382880000000003e-07 117.52499999999999p -5.9904750000000004e-07 117.53749999999999p -5.8352350000000002e-07 117.55p -5.6727880000000002e-07 117.5625p -5.503365e-07 117.575p -5.3272059999999997e-07 117.58750000000001p -5.1445579999999997e-07 117.60000000000001p -4.9556759999999996e-07 117.6125p -4.7608249999999998e-07 117.625p -4.5602739999999998e-07 117.6375p -4.3543020000000001e-07 117.65000000000001p -4.1431919999999998e-07 117.66250000000001p -3.9272349999999998e-07 117.67500000000001p -3.7067249999999999e-07
+ 117.68749999999999p -3.4819660000000001e-07 117.69999999999999p -3.253261e-07 117.71249999999999p -3.0209220000000001e-07 117.72499999999999p -2.7852640000000001e-07 117.7375p -2.546604e-07 117.75p -2.3052630000000001e-07 117.76250000000002p -2.061565e-07 117.77499999999999p -1.815836e-07 117.78749999999999p -1.5684050000000001e-07 117.8p -1.3195990000000001e-07 117.8125p -1.069749e-07 117.825p -8.1918580000000006e-08 117.83750000000001p -5.6823969999999997e-08 117.85000000000001p -3.1724059999999999e-08 117.86249999999998p -6.6517780000000001e-09 117.875p 1.8360089999999999e-08 117.8875p 4.3278940000000001e-08 117.90000000000001p 6.8072369999999995e-08
+ 117.91250000000001p 9.2708250000000006e-08 117.92500000000001p 1.171548e-07 117.93750000000001p 1.4138040000000001e-07 117.94999999999999p 1.6535400000000001e-07 117.96249999999999p 1.8904500000000001e-07 117.97499999999999p 2.1242309999999999e-07 117.9875p 2.354586e-07 118p 2.5812230000000002e-07 118.0125p 2.8038560000000001e-07 118.02499999999999p 3.0222049999999998e-07 118.03749999999999p 3.2359969999999998e-07 118.05p 3.4449640000000001e-07 118.0625p 3.6488470000000002e-07 118.075p 3.8473929999999999e-07 118.08750000000001p 4.0403580000000002e-07 118.10000000000001p 4.2275050000000001e-07 118.11249999999998p 4.408606e-07 118.12499999999999p 4.5834410000000001e-07
+ 118.1375p 4.7517990000000001e-07 118.15000000000001p 4.9134769999999998e-07 118.16250000000001p 5.0682830000000002e-07 118.17500000000001p 5.2160339999999996e-07 118.18750000000001p 5.3565559999999999e-07 118.19999999999999p 5.4896850000000004e-07 118.21249999999999p 5.6152659999999997e-07 118.22499999999999p 5.7331569999999997e-07 118.2375p 5.843224e-07 118.25p 5.9453440000000004e-07 118.2625p 6.0394050000000001e-07 118.27500000000002p 6.1253040000000001e-07 118.28749999999999p 6.2029519999999997e-07 118.3p 6.2722680000000002e-07 118.3125p 6.3331819999999999e-07 118.325p 6.3856370000000005e-07 118.33750000000001p 6.4295850000000005e-07 118.35000000000001p 6.4649900000000005e-07
+ 118.36249999999998p 6.4918269999999999e-07 118.37499999999999p 6.5100810000000005e-07 118.38749999999999p 6.5197500000000001e-07 118.40000000000001p 6.520841e-07 118.41250000000001p 6.5133730000000001e-07 118.42500000000001p 6.4973760000000002e-07 118.43750000000001p 6.4728900000000005e-07 118.44999999999999p 6.4399660000000005e-07 118.46249999999999p 6.3986659999999997e-07 118.47499999999999p 6.3490630000000004e-07 118.4875p 6.2912379999999998e-07 118.5p 6.2252859999999995e-07 118.5125p 6.1513090000000001e-07 118.52500000000001p 6.0694199999999996e-07 118.53749999999999p 5.9797429999999998e-07 118.55p 5.8824110000000005e-07 118.5625p 5.7775649999999996e-07 118.575p 5.6653570000000001e-07
+ 118.58750000000001p 5.5459469999999999e-07 118.60000000000001p 5.4195060000000001e-07 118.61249999999998p 5.286211e-07 118.62499999999999p 5.1462479999999998e-07 118.63749999999999p 4.9998130000000001e-07 118.65000000000001p 4.8471069999999995e-07 118.66250000000001p 4.6883419999999999e-07 118.67500000000001p 4.5237350000000001e-07 118.68750000000001p 4.3535100000000002e-07 118.69999999999999p 4.1778989999999999e-07 118.71249999999999p 3.9971410000000002e-07 118.72499999999999p 3.8114780000000001e-07 118.7375p 3.6211629999999999e-07 118.75p 3.4264489999999999e-07 118.7625p 3.2275990000000002e-07 118.77500000000001p 3.0248790000000001e-07 118.78749999999999p 2.8185580000000002e-07 118.8p 2.6089120000000001e-07
+ 118.8125p 2.3962189999999998e-07 118.825p 2.1807620000000001e-07 118.83750000000001p 1.9628259999999999e-07 118.85000000000001p 1.7426989999999999e-07 118.86250000000001p 1.5206719999999999e-07 118.87499999999999p 1.297038e-07 118.88749999999999p 1.072092e-07 118.89999999999999p 8.4612899999999999e-08 118.91250000000001p 6.1944599999999995e-08 118.92500000000001p 3.9234059999999998e-08 118.93750000000001p 1.6511040000000001e-08 118.94999999999999p -6.1947330000000003e-09 118.96249999999999p -2.885356e-08 118.97499999999999p -5.143584e-08 118.9875p -7.3912130000000002e-08 119p -9.6253149999999997e-08 119.0125p -1.184298e-07 119.02500000000001p -1.404133e-07
+ 119.03749999999999p -1.6217500000000001e-07 119.05p -1.8368680000000001e-07 119.0625p -2.0492070000000001e-07 119.075p -2.2584939999999999e-07 119.08750000000001p -2.464458e-07 119.10000000000001p -2.6668320000000002e-07 119.11250000000001p -2.8653579999999998e-07 119.12499999999999p -3.059778e-07 119.13749999999999p -3.2498440000000002e-07 119.14999999999999p -3.4353120000000002e-07 119.16249999999999p -3.6159450000000002e-07 119.17500000000001p -3.7915120000000002e-07 119.18750000000001p -3.9617900000000002e-07 119.20000000000002p -4.1265630000000002e-07 119.21249999999999p -4.2856220000000001e-07 119.22499999999999p -4.4387659999999998e-07 119.2375p -4.5858020000000001e-07 119.25p -4.726546e-07
+ 119.2625p -4.8608229999999995e-07 119.27500000000001p -4.9884650000000001e-07 119.28749999999999p -5.1093140000000003e-07 119.3p -5.2232220000000002e-07 119.3125p -5.3300509999999999e-07 119.325p -5.4296690000000003e-07 119.33750000000001p -5.5219590000000004e-07 119.35000000000001p -5.6068099999999999e-07 119.36250000000001p -5.6841220000000003e-07 119.37499999999999p -5.7538070000000001e-07 119.38749999999999p -5.8157859999999995e-07 119.39999999999999p -5.8699889999999998e-07 119.41249999999999p -5.9163600000000002e-07 119.425p -5.9548510000000001e-07 119.43750000000001p -5.9854249999999997e-07 119.45000000000002p -6.0080569999999996e-07 119.46249999999999p -6.0227300000000004e-07 119.47499999999999p -6.0294420000000001e-07
+ 119.4875p -6.0281980000000001e-07 119.5p -6.0190140000000001e-07 119.5125p -6.0019199999999998e-07 119.52500000000001p -5.9769519999999996e-07 119.53750000000001p -5.9441610000000004e-07 119.55p -5.9036040000000002e-07 119.5625p -5.8553520000000005e-07 119.575p -5.7994859999999995e-07 119.58750000000001p -5.7360940000000001e-07 119.60000000000001p -5.6652759999999995e-07 119.61250000000001p -5.5871439999999998e-07 119.62499999999999p -5.501816e-07 119.63749999999999p -5.4094210000000002e-07 119.64999999999999p -5.3100970000000001e-07 119.66249999999999p -5.2039930000000003e-07 119.675p -5.0912639999999997e-07 119.6875p -4.9720740000000003e-07 119.70000000000002p -4.8465979999999996e-07
+ 119.71249999999999p -4.7150159999999999e-07 119.72499999999999p -4.577518e-07 119.7375p -4.4342999999999999e-07 119.75p -4.2855670000000001e-07 119.7625p -4.131529e-07 119.77500000000001p -3.9724030000000001e-07 119.78750000000001p -3.8084140000000001e-07 119.79999999999998p -3.6397920000000002e-07 119.8125p -3.4667729999999998e-07 119.825p -3.2895970000000003e-07 119.83750000000001p -3.1085099999999998e-07 119.85000000000001p -2.923763e-07 119.86250000000001p -2.7356109999999999e-07 119.87500000000001p -2.5443129999999999e-07 119.88749999999999p -2.3501310000000001e-07 119.89999999999999p -2.1533310000000001e-07 119.91249999999999p -1.9541800000000001e-07 119.925p -1.752951e-07
+ 119.9375p -1.549915e-07 119.95p -1.345347e-07 119.96249999999999p -1.139522e-07 119.97499999999999p -9.3271850000000001e-08 119.9875p -7.2521209999999999e-08 120p -5.1728039999999998e-08 120.0125p -3.0920040000000001e-08 120.02500000000001p -1.012486e-08 120.03750000000001p 1.062998e-08 120.04999999999998p 3.1317089999999997e-08 120.06249999999999p 5.1909229999999999e-08 120.075p 7.2379409999999994e-08 120.08750000000001p 9.2700859999999999e-08 120.10000000000001p 1.128471e-07 120.11250000000001p 1.3279199999999999e-07 120.12500000000001p 1.525097e-07 120.13749999999999p 1.7197479999999999e-07 120.14999999999999p 1.911624e-07
+ 120.16249999999999p 2.1004779999999999e-07 120.175p 2.28607e-07 120.1875p 2.468164e-07 120.2p 2.646531e-07 120.21250000000001p 2.8209450000000003e-07 120.22499999999999p 2.9911889999999997e-07 120.2375p 3.1570510000000003e-07 120.25p 3.318324e-07 120.2625p 3.4748100000000001e-07 120.27500000000001p 3.6263179999999998e-07 120.28750000000001p 3.7726609999999998e-07 120.29999999999998p 3.9136640000000001e-07 120.31249999999999p 4.0491570000000002e-07 120.32499999999999p 4.1789770000000002e-07 120.33750000000001p 4.3029719999999999e-07 120.35000000000001p 4.4209950000000001e-07 120.36250000000001p 4.5329089999999999e-07 120.37500000000001p 4.6385859999999998e-07
+ 120.38749999999999p 4.7379060000000002e-07 120.39999999999999p 4.8307559999999998e-07 120.41249999999999p 4.9170349999999998e-07 120.425p 4.996649e-07 120.4375p 5.0695119999999998e-07 120.45p 5.1355499999999997e-07 120.46250000000001p 5.1946960000000001e-07 120.47499999999999p 5.2468920000000003e-07 120.4875p 5.2920910000000003e-07 120.5p 5.3302540000000004e-07 120.5125p 5.3613499999999995e-07 120.52500000000001p 5.3853600000000005e-07 120.53750000000001p 5.4022720000000002e-07 120.55000000000001p 5.4120839999999998e-07 120.56249999999999p 5.4148039999999997e-07 120.57499999999999p 5.4104470000000004e-07 120.58749999999999p 5.3990400000000001e-07 120.60000000000001p 5.3806160000000002e-07
+ 120.61250000000001p 5.3552179999999999e-07 120.62500000000001p 5.3228980000000003e-07 120.63749999999999p 5.2837179999999998e-07 120.64999999999999p 5.2377469999999999e-07 120.66249999999999p 5.1850609999999999e-07 120.675p 5.1257480000000004e-07 120.6875p 5.0599020000000003e-07 120.7p 4.9876250000000002e-07 120.71250000000001p 4.9090269999999998e-07 120.72499999999999p 4.824227e-07 120.7375p 4.73335e-07 120.75p 4.6365279999999999e-07 120.7625p 4.5339029999999999e-07 120.77500000000001p 4.4256210000000001e-07 120.78750000000001p 4.3118360000000001e-07 120.80000000000001p 4.192709e-07 120.81249999999999p 4.0684070000000001e-07 120.82499999999999p 3.939102e-07
+ 120.83749999999999p 3.8049739999999999e-07 120.85000000000001p 3.6662059999999999e-07 120.86250000000001p 3.5229900000000002e-07 120.87500000000001p 3.37552e-07 120.88749999999999p 3.2239960000000001e-07 120.89999999999999p 3.0686240000000001e-07 120.91249999999999p 2.9096110000000003e-07 120.925p 2.7471720000000002e-07 120.9375p 2.5815239999999999e-07 120.95p 2.4128860000000002e-07 120.96250000000001p 2.241484e-07 120.97499999999999p 2.0675449999999999e-07 120.9875p 1.891297e-07 121p 1.712974e-07 121.0125p 1.5328100000000001e-07 121.02500000000001p 1.3510399999999999e-07 121.03750000000001p 1.167904e-07 121.05000000000001p 9.8363879999999995e-08
+ 121.06249999999999p 7.9848580000000001e-08 121.07499999999999p 6.1268540000000003e-08 121.08749999999999p 4.2647869999999997e-08 121.09999999999999p 2.4010699999999999e-08 121.11250000000001p 5.3811099999999998e-09 121.12500000000001p -1.321684e-08 121.13750000000002p -3.1759199999999998e-08 121.14999999999999p -5.0222120000000003e-08 121.16249999999999p -6.858188e-08 121.175p -8.6814950000000004e-08 121.1875p -1.04898e-07 121.2p -1.228079e-07 121.21250000000001p -1.4052180000000001e-07 121.22499999999999p -1.5801719999999999e-07 121.2375p -1.752718e-07 121.25p -1.9226360000000001e-07 121.2625p -2.089713e-07 121.27500000000001p -2.253735e-07
+ 121.28750000000001p -2.4144970000000001e-07 121.30000000000001p -2.5717950000000002e-07 121.31249999999999p -2.7254319999999999e-07 121.32499999999999p -2.8752140000000002e-07 121.33749999999999p -3.0209550000000002e-07 121.34999999999999p -3.162472e-07 121.3625p -3.2995880000000001e-07 121.37500000000001p -3.4321330000000002e-07 121.38750000000002p -3.5599429999999998e-07 121.39999999999999p -3.6828600000000002e-07 121.41249999999999p -3.800732e-07 121.425p -3.9134159999999999e-07 121.4375p -4.0207720000000002e-07 121.45p -4.1226709999999999e-07 121.46250000000001p -4.2189890000000002e-07 121.47500000000001p -4.3096110000000001e-07 121.4875p -4.3944270000000002e-07 121.5p -4.4733389999999998e-07
+ 121.5125p -4.5462529999999999e-07 121.52500000000001p -4.6130840000000001e-07 121.53750000000001p -4.6737549999999998e-07 121.55000000000001p -4.7281989999999998e-07 121.56249999999999p -4.7763550000000002e-07 121.57499999999999p -4.8181709999999997e-07 121.58749999999999p -4.8536050000000001e-07 121.59999999999999p -4.8826190000000002e-07 121.6125p -4.9051889999999995e-07 121.625p -4.9212969999999997e-07 121.63750000000002p -4.9309319999999999e-07 121.64999999999999p -4.9340940000000002e-07 121.66249999999999p -4.9307900000000004e-07 121.675p -4.9210369999999999e-07 121.6875p -4.904859e-07 121.7p -4.8822889999999995e-07 121.71250000000001p -4.8533689999999996e-07 121.72500000000001p -4.8181479999999999e-07
+ 121.73749999999998p -4.7766849999999997e-07 121.75p -4.7290450000000002e-07 121.7625p -4.6753039999999997e-07 121.77500000000001p -4.6155419999999999e-07 121.78750000000001p -4.5498509999999999e-07 121.80000000000001p -4.478328e-07 121.81250000000001p -4.401078e-07 121.82499999999999p -4.3182140000000001e-07 121.83749999999999p -4.2298570000000002e-07 121.84999999999999p -4.1361330000000002e-07 121.8625p -4.0371759999999999e-07 121.875p -3.9331270000000002e-07 121.8875p -3.8241339999999999e-07 121.89999999999999p -3.7103499999999999e-07 121.91249999999999p -3.5919350000000002e-07 121.925p -3.4690530000000002e-07 121.9375p -3.3418770000000002e-07 121.95p -3.2105830000000002e-07
+ 121.96250000000001p -3.0753520000000002e-07 121.97500000000001p -2.9363719999999998e-07 121.98749999999998p -2.7938330000000001e-07 121.99999999999999p -2.6479300000000001e-07 122.0125p -2.4988649999999998e-07 122.02500000000001p -2.3468389999999999e-07 122.03750000000001p -2.1920600000000001e-07 122.05000000000001p -2.0347389999999999e-07 122.06250000000001p -1.8750870000000001e-07 122.07499999999999p -1.713322e-07 122.08749999999999p -1.549661e-07 122.09999999999999p -1.3843249999999999e-07 122.1125p -1.2175350000000001e-07 122.125p -1.049516e-07 122.1375p -8.8049020000000003e-08 122.15000000000001p -7.1068480000000006e-08 122.16249999999999p -5.4032510000000001e-08 122.175p -3.6963740000000002e-08
+ 122.1875p -1.9884769999999999e-08 122.2p -2.8181690000000001e-09 122.21250000000001p 1.4213569999999999e-08 122.22500000000001p 3.1188040000000001e-08 122.23749999999998p 4.8082980000000001e-08 122.24999999999999p 6.4876270000000005e-08 122.26249999999999p 8.1546010000000004e-08 122.27500000000001p 9.8070470000000002e-08 122.28750000000001p 1.1442819999999999e-07 122.30000000000001p 1.3059799999999999e-07 122.31250000000001p 1.465591e-07 122.32499999999999p 1.622908e-07 122.33749999999999p 1.7777289999999999e-07 122.34999999999999p 1.929857e-07 122.3625p 2.0790970000000001e-07 122.375p 2.2252599999999999e-07 122.3875p 2.3681610000000001e-07 122.40000000000001p 2.5076180000000002e-07
+ 122.41249999999999p 2.6434569999999997e-07 122.425p 2.7755079999999998e-07 122.4375p 2.9036060000000002e-07 122.45p 3.0275910000000001e-07 122.46250000000001p 3.1473109999999998e-07 122.47500000000001p 3.2626190000000002e-07 122.48750000000001p 3.3733740000000002e-07 122.49999999999999p 3.4794399999999998e-07 122.51249999999999p 3.5806909999999999e-07 122.52499999999999p 3.677005e-07 122.53750000000001p 3.7682670000000001e-07 122.55000000000001p 3.8543700000000001e-07 122.56250000000001p 3.935213e-07 122.57499999999999p 4.010704e-07 122.58749999999999p 4.0807560000000001e-07 122.59999999999999p 4.1452910000000001e-07 122.6125p 4.2042369999999998e-07 122.625p 4.2575309999999998e-07
+ 122.6375p 4.3051169999999998e-07 122.65000000000001p 4.3469459999999999e-07 122.66249999999999p 4.3829790000000001e-07 122.675p 4.4131809999999997e-07 122.6875p 4.4375279999999998e-07 122.7p 4.456002e-07 122.71250000000001p 4.4685940000000001e-07 122.72500000000001p 4.4752999999999998e-07 122.73750000000001p 4.4761270000000002e-07 122.74999999999999p 4.4710890000000002e-07 122.76249999999999p 4.4602049999999998e-07 122.77499999999999p 4.4435049999999999e-07 122.78749999999999p 4.4210239999999999e-07 122.80000000000001p 4.3928060000000001e-07 122.81250000000001p 4.3589020000000001e-07 122.82500000000002p 4.3193690000000002e-07 122.83749999999999p 4.2742730000000001e-07 122.84999999999999p 4.2236869999999999e-07
+ 122.8625p 4.1676890000000003e-07 122.875p 4.1063649999999999e-07 122.8875p 4.0398089999999998e-07 122.90000000000001p 3.9681200000000002e-07 122.91249999999999p 3.8914040000000002e-07 122.925p 3.8097720000000002e-07 122.9375p 3.7233429999999998e-07 122.95p 3.6322419999999998e-07 122.96250000000001p 3.5365969999999998e-07 122.97500000000001p 3.4365440000000001e-07 122.98750000000001p 3.3322249999999998e-07 122.99999999999999p 3.2237850000000002e-07 123.01249999999999p 3.111375e-07 123.02499999999999p 2.9951509999999998e-07 123.03749999999999p 2.8752740000000003e-07 123.05p 2.7519080000000001e-07 123.06250000000001p 2.6252219999999998e-07 123.07500000000002p 2.4953889999999998e-07
+ 123.08749999999999p 2.362586e-07 123.09999999999999p 2.2269909999999999e-07 123.1125p 2.08879e-07 123.125p 1.9481659999999999e-07 123.1375p 1.8053110000000001e-07 123.15000000000001p 1.6604139999999999e-07 123.16250000000001p 1.5136689999999999e-07 123.175p 1.365272e-07 123.1875p 1.215419e-07 123.2p 1.064311e-07 123.21250000000001p 9.1214579999999998e-08 123.22500000000001p 7.5912499999999999e-08 123.23750000000001p 6.0545000000000004e-08 123.24999999999999p 4.5132269999999997e-08 123.26249999999999p 2.9694530000000001e-08 123.27499999999999p 1.425196e-08 123.28749999999999p -1.175257e-09 123.3p -1.6567029999999998e-08
+ 123.31250000000001p -3.1903329999999997e-08 123.32500000000002p -4.7164269999999998e-08 123.33749999999999p -6.2330070000000005e-08 123.34999999999999p -7.7381130000000005e-08 123.3625p -9.2298050000000006e-08 123.375p -1.070616e-07 123.3875p -1.2165289999999999e-07 123.40000000000001p -1.360531e-07 123.41250000000001p -1.5024390000000001e-07 123.42499999999998p -1.642071e-07 123.4375p -1.77925e-07 123.45p -1.9138019999999999e-07 123.46250000000001p -2.045556e-07 123.47500000000001p -2.1743459999999999e-07 123.48750000000001p -2.3000080000000001e-07 123.49999999999999p -2.4223870000000003e-07 123.51249999999999p -2.5413270000000001e-07 123.52499999999999p -2.6566800000000002e-07
+ 123.53749999999999p -2.7683039999999999e-07 123.55p -2.8760590000000002e-07 123.5625p -2.9798119999999998e-07 123.57500000000002p -3.0794360000000003e-07 123.58749999999999p -3.1748089999999999e-07 123.59999999999999p -3.2658149999999999e-07 123.6125p -3.3523420000000001e-07 123.625p -3.4342889999999998e-07 123.6375p -3.5115550000000001e-07 123.65000000000001p -3.5840500000000001e-07 123.66250000000001p -3.6516880000000002e-07 123.67499999999998p -3.7143910000000001e-07 123.6875p -3.7720870000000002e-07 123.7p -3.8247099999999998e-07 123.71250000000001p -3.8722019999999998e-07 123.72500000000001p -3.9145109999999999e-07 123.73750000000001p -3.951593e-07 123.75000000000001p -3.9834089999999999e-07
+ 123.76249999999999p -4.0099300000000002e-07 123.77499999999999p -4.0311299999999999e-07 123.78749999999999p -4.0469940000000001e-07 123.8p -4.057512e-07 123.8125p -4.0626809999999999e-07 123.825p -4.0625059999999998e-07 123.83749999999999p -4.056998e-07 123.84999999999999p -4.0461750000000002e-07 123.8625p -4.0300640000000002e-07 123.875p -4.0086969999999999e-07 123.8875p -3.9821130000000002e-07 123.90000000000001p -3.9503590000000003e-07 123.91250000000001p -3.9134860000000002e-07 123.92499999999998p -3.8715550000000002e-07 123.93749999999999p -3.8246310000000002e-07 123.95p -3.7727879999999999e-07 123.96250000000001p -3.716104e-07 123.97500000000001p -3.6546640000000002e-07
+ 123.98750000000001p -3.5885589999999998e-07 124.00000000000001p -3.5178879999999999e-07 124.01249999999999p -3.4427520000000001e-07 124.02499999999999p -3.3632599999999999e-07 124.03749999999999p -3.2795270000000002e-07 124.05p -3.1916730000000002e-07 124.0625p -3.0998210000000002e-07 124.075p -3.004103e-07 124.08750000000001p -2.9046529999999998e-07 124.09999999999999p -2.8016090000000002e-07 124.1125p -2.6951160000000002e-07 124.125p -2.5853220000000001e-07 124.1375p -2.4723789999999999e-07 124.15000000000001p -2.356442e-07 124.16250000000001p -2.2376720000000001e-07 124.17499999999998p -2.1162299999999999e-07 124.18749999999999p -1.9922840000000001e-07 124.19999999999999p -1.8660010000000001e-07
+ 124.21250000000001p -1.737554e-07 124.22500000000001p -1.6071159999999999e-07 124.23750000000001p -1.474864e-07 124.25000000000001p -1.3409770000000001e-07 124.26249999999999p -1.2056339999999999e-07 124.27499999999999p -1.069017e-07 124.28749999999999p -9.3130810000000001e-08 124.3p -7.9269189999999994e-08 124.3125p -6.5335269999999996e-08 124.325p -5.134755e-08 124.33750000000001p -3.7324559999999997e-08 124.34999999999999p -2.3284839999999998e-08 124.3625p -9.2468899999999997e-09 124.375p 4.7708199999999999e-09 124.3875p 1.87499e-08 124.40000000000001p 3.2672069999999999e-08 124.41250000000001p 4.6519139999999999e-08 124.42500000000001p 6.0273089999999995e-08
+ 124.43749999999999p 7.3916060000000004e-08 124.44999999999999p 8.7430370000000002e-08 124.46249999999999p 1.0079860000000001e-07 124.47500000000001p 1.1400350000000001e-07 124.48750000000001p 1.2702810000000001e-07 124.50000000000001p 1.398557e-07 124.51249999999999p 1.5246999999999999e-07 124.52499999999999p 1.6485479999999999e-07 124.53749999999999p 1.7699460000000001e-07 124.55p 1.8887379999999999e-07 124.5625p 2.0047760000000001e-07 124.575p 2.1179139999999999e-07 124.58750000000001p 2.2280100000000001e-07 124.59999999999999p 2.3349270000000001e-07 124.6125p 2.4385320000000002e-07 124.625p 2.5386970000000001e-07 124.6375p 2.6352999999999998e-07 124.65000000000001p 2.7282210000000002e-07
+ 124.66250000000001p 2.8173480000000002e-07 124.67500000000001p 2.9025730000000001e-07 124.68749999999999p 2.983793e-07 124.69999999999999p 3.0609120000000002e-07 124.71249999999999p 3.1338379999999998e-07 124.72499999999999p 3.2024859999999998e-07 124.73750000000001p 3.2667749999999999e-07 124.75000000000001p 3.3266319999999998e-07 124.76250000000002p 3.3819879999999999e-07 124.77499999999999p 3.4327830000000001e-07 124.78749999999999p 3.4789589999999999e-07 124.8p 3.5204680000000002e-07 124.8125p 3.5572649999999998e-07 124.825p 3.5893149999999999e-07 124.83750000000001p 3.6165849999999998e-07 124.84999999999999p 3.6390509999999999e-07 124.8625p 3.656696e-07 124.875p 3.6695059999999999e-07
+ 124.8875p 3.6774770000000002e-07 124.90000000000001p 3.6806080000000002e-07 124.91250000000001p 3.6789079999999998e-07 124.92500000000001p 3.6723889999999998e-07 124.93749999999999p 3.661071e-07 124.94999999999999p 3.6449790000000002e-07 124.96249999999999p 3.6241459999999998e-07 124.97499999999999p 3.5986089999999998e-07 124.9875p 3.5684120000000002e-07 125.00000000000001p 3.5336059999999999e-07 125.01250000000002p 3.4942449999999998e-07 125.02499999999999p 3.4503930000000003e-07 125.03749999999999p 3.4021149999999999e-07 125.05p 3.3494860000000002e-07 125.0625p 3.292583e-07 125.075p 3.23149e-07 125.08750000000001p 3.1662970000000002e-07 125.10000000000001p 3.0970970000000001e-07
+ 125.1125p 3.0239899999999998e-07 125.125p 2.9470810000000001e-07 125.1375p 2.8664770000000001e-07 125.15000000000001p 2.7822919999999998e-07 125.16250000000001p 2.694645e-07 125.17500000000001p 2.6036570000000001e-07 125.18749999999999p 2.509454e-07 125.19999999999999p 2.4121669999999998e-07 125.21249999999999p 2.3119290000000001e-07 125.22499999999999p 2.208878e-07 125.2375p 2.103155e-07 125.25p 1.9949039999999999e-07 125.26250000000002p 1.8842709999999999e-07 125.27499999999999p 1.7714070000000001e-07 125.28749999999999p 1.6564639999999999e-07 125.3p 1.5395970000000001e-07 125.3125p 1.4209630000000001e-07 125.325p 1.3007220000000001e-07
+ 125.33750000000001p 1.179032e-07 125.35000000000001p 1.0560589999999999e-07 125.36249999999998p 9.3196400000000005e-08 125.375p 8.0691339999999994e-08 125.3875p 6.8107260000000006e-08 125.40000000000001p 5.5460830000000002e-08 125.41250000000001p 4.2768749999999997e-08 125.42500000000001p 3.0047769999999998e-08 125.43750000000001p 1.7314610000000001e-08 125.44999999999999p 4.5859990000000002e-09 125.46249999999999p -8.1213680000000002e-09 125.47499999999999p -2.0790869999999999e-08 125.4875p -3.3405949999999999e-08 125.5p -4.5950180000000002e-08 125.5125p -5.8407239999999999e-08 125.52499999999999p -7.0760940000000002e-08 125.53749999999999p -8.2995290000000003e-08 125.55p -9.5094460000000005e-08
+ 125.5625p -1.070428e-07 125.575p -1.1882499999999999e-07 125.58750000000001p -1.3042589999999999e-07 125.60000000000001p -1.4183069999999999e-07 125.61249999999998p -1.5302459999999999e-07 125.62499999999999p -1.6399349999999999e-07 125.6375p -1.7472339999999999e-07 125.65000000000001p -1.8520069999999999e-07 125.66250000000001p -1.9541219999999999e-07 125.67500000000001p -2.053449e-07 125.68750000000001p -2.1498640000000001e-07 125.69999999999999p -2.243245e-07 125.71249999999999p -2.333478e-07 125.72499999999999p -2.4204480000000001e-07 125.7375p -2.50405e-07 125.75p -2.5841790000000001e-07 125.7625p -2.6607380000000002e-07 125.77500000000002p -2.7336330000000001e-07
+ 125.78749999999999p -2.8027769999999999e-07 125.8p -2.8680850000000002e-07 125.8125p -2.9294809999999998e-07 125.825p -2.9868919999999999e-07 125.83750000000001p -3.0402500000000002e-07 125.85000000000001p -3.0894950000000001e-07 125.86249999999998p -3.1345700000000003e-07 125.87499999999999p -3.1754239999999999e-07 125.88749999999999p -3.2120139999999999e-07 125.90000000000001p -3.2443009999999999e-07 125.91250000000001p -3.2722500000000002e-07 125.92500000000001p -3.2958350000000001e-07 125.93750000000001p -3.3150350000000001e-07 125.94999999999999p -3.3298340000000001e-07 125.96249999999999p -3.3402220000000001e-07 125.97499999999999p -3.346195e-07 125.9875p -3.3477550000000002e-07 126p -3.3449109999999999e-07
+ 126.0125p -3.3376749999999999e-07 126.02500000000001p -3.326068e-07 126.03749999999999p -3.3101149999999999e-07 126.05p -3.2898459999999998e-07 126.0625p -3.2652990000000001e-07 126.075p -3.236515e-07 126.08750000000001p -3.2035420000000002e-07 126.10000000000001p -3.1664330000000001e-07 126.11249999999998p -3.1252479999999999e-07 126.12499999999999p -3.0800499999999998e-07 126.13749999999999p -3.0309069999999999e-07 126.15000000000001p -2.9778940000000002e-07 126.16250000000001p -2.9210900000000001e-07 126.17500000000001p -2.8605790000000001e-07 126.18750000000001p -2.7964490000000002e-07 126.19999999999999p -2.7287939999999999e-07 126.21249999999999p -2.657711e-07 126.22499999999999p -2.583302e-07
+ 126.2375p -2.505673e-07 126.25p -2.4249349999999999e-07 126.2625p -2.3412000000000001e-07 126.27500000000001p -2.254587e-07 126.28749999999999p -2.1652170000000001e-07 126.3p -2.0732149999999999e-07 126.3125p -1.9787070000000001e-07 126.325p -1.8818240000000001e-07 126.33750000000001p -1.7827010000000001e-07 126.35000000000001p -1.6814719999999999e-07 126.36250000000001p -1.5782760000000001e-07 126.37499999999999p -1.4732549999999999e-07 126.38749999999999p -1.36655e-07 126.39999999999999p -1.2583059999999999e-07 126.41250000000001p -1.148669e-07 126.42500000000001p -1.037787e-07 126.43750000000001p -9.2580899999999995e-08 126.44999999999999p -8.1288449999999998e-08
+ 126.46249999999999p -6.9916439999999997e-08 126.47499999999999p -5.8479999999999998e-08 126.4875p -4.6994309999999997e-08 126.5p -3.5474559999999997e-08 126.5125p -2.393597e-08 126.52500000000001p -1.239372e-08 126.53749999999999p -8.6295490000000001e-10 126.55p 1.064123e-08 126.5625p 2.2103829999999999e-08 126.575p 3.3509929999999998e-08 126.58750000000001p 4.4844719999999999e-08 126.60000000000001p 5.6093539999999998e-08 126.61250000000001p 6.7241889999999999e-08 126.62499999999999p 7.8275420000000006e-08 126.63749999999999p 8.9179989999999999e-08 126.64999999999999p 9.9941670000000003e-08 126.66249999999999p 1.105467e-07 126.67500000000001p 1.2098180000000001e-07
+ 126.68750000000001p 1.3123350000000001e-07 126.70000000000002p 1.4128899999999999e-07 126.71249999999999p 1.5113570000000001e-07 126.72499999999999p 1.607612e-07 126.7375p 1.7015360000000001e-07 126.75p 1.7930109999999999e-07 126.7625p 1.8819250000000001e-07 126.77500000000001p 1.968168e-07 126.78749999999999p 2.0516339999999999e-07 126.8p 2.1322220000000001e-07 126.8125p 2.2098340000000001e-07 126.825p 2.284376e-07 126.83750000000001p 2.3557580000000001e-07 126.85000000000001p 2.4238970000000001e-07 126.86250000000001p 2.4887100000000001e-07 126.87499999999999p 2.5501229999999998e-07 126.88749999999999p 2.6080629999999999e-07 126.89999999999999p 2.6624640000000001e-07
+ 126.91249999999999p 2.713264e-07 126.925p 2.7604059999999998e-07 126.93750000000001p 2.8038360000000001e-07 126.95000000000002p 2.8435090000000001e-07 126.96249999999999p 2.879382e-07 126.97499999999999p 2.9114159999999998e-07 126.9875p 2.9395810000000001e-07 127p 2.9638480000000001e-07 127.0125p 2.9841949999999998e-07 127.02500000000001p 3.0006060000000001e-07 127.03750000000001p 3.0130679999999998e-07 127.05p 3.0215739999999999e-07 127.0625p 3.0261230000000001e-07 127.075p 3.0267190000000001e-07 127.08750000000001p 3.0233679999999998e-07 127.10000000000001p 3.0160860000000002e-07 127.11250000000001p 3.0048899999999999e-07 127.12499999999999p 2.9898040000000002e-07
+ 127.13749999999999p 2.970856e-07 127.14999999999999p 2.9480799999999998e-07 127.16249999999999p 2.9215129999999998e-07 127.175p 2.8911989999999999e-07 127.1875p 2.857186e-07 127.20000000000002p 2.8195239999999998e-07 127.21249999999999p 2.778272e-07 127.22499999999999p 2.7334900000000002e-07 127.2375p 2.6852449999999999e-07 127.25p 2.6336050000000001e-07 127.2625p 2.5786460000000002e-07 127.27500000000001p 2.5204449999999999e-07 127.28750000000001p 2.4590850000000002e-07 127.29999999999998p 2.3946520000000002e-07 127.3125p 2.3272359999999999e-07 127.325p 2.2569300000000001e-07 127.33750000000001p 2.1838319999999999e-07 127.35000000000001p 2.108041e-07
+ 127.36250000000001p 2.029663e-07 127.37500000000001p 1.9488019999999999e-07 127.38749999999999p 1.8655699999999999e-07 127.39999999999999p 1.780079e-07 127.41249999999999p 1.692444e-07 127.425p 1.602783e-07 127.4375p 1.5112169999999999e-07 127.45p 1.4178679999999999e-07 127.46249999999999p 1.32286e-07 127.47499999999999p 1.2263200000000001e-07 127.4875p 1.128376e-07 127.5p 1.029159e-07 127.5125p 9.2879919999999996e-08 127.52500000000001p 8.2742910000000006e-08 127.53750000000001p 7.2518260000000005e-08 127.54999999999998p 6.2219410000000001e-08 127.56249999999999p 5.1859879999999997e-08 127.575p 4.1453270000000001e-08
+ 127.58750000000001p 3.1013179999999999e-08 127.60000000000001p 2.0553259999999999e-08 127.61250000000001p 1.0087159999999999e-08 127.62500000000001p -3.7149279999999999e-10 127.63749999999999p -1.080909e-08 127.64999999999999p -2.1212090000000001e-08 127.66249999999999p -3.1566989999999998e-08 127.675p -4.1860380000000001e-08 127.6875p -5.2078970000000003e-08 127.7p -6.2209570000000001e-08 127.71250000000001p -7.2239110000000004e-08 127.72499999999999p -8.2154699999999994e-08 127.7375p -9.1943599999999998e-08 127.75p -1.015932e-07 127.7625p -1.110913e-07 127.77500000000001p -1.204256e-07 127.78750000000001p -1.2958430000000001e-07 127.79999999999998p -1.3855559999999999e-07
+ 127.81249999999999p -1.4732830000000001e-07 127.82499999999999p -1.5589109999999999e-07 127.83750000000001p -1.6423329999999999e-07 127.85000000000001p -1.723443e-07 127.86250000000001p -1.8021390000000001e-07 127.87500000000001p -1.8783219999999999e-07 127.88749999999999p -1.9518980000000001e-07 127.89999999999999p -2.0227730000000001e-07 127.91249999999999p -2.09086e-07 127.925p -2.1560749999999999e-07 127.9375p -2.2183379999999999e-07 127.95p -2.2775710000000001e-07 127.96250000000001p -2.3337030000000001e-07 127.97499999999999p -2.3866650000000001e-07 127.9875p -2.4363940000000002e-07 128p -2.4828299999999997e-07 128.01249999999999p -2.5259179999999998e-07 128.02500000000001p -2.5656070000000001e-07
+ 128.03750000000002p -2.6018520000000001e-07 128.05000000000001p -2.6346110000000002e-07 128.0625p -2.6638479999999998e-07 128.07499999999999p -2.6895290000000002e-07 128.08750000000001p -2.7116289999999999e-07 128.09999999999999p -2.730125e-07 128.11250000000001p -2.7449989999999998e-07 128.125p -2.756238e-07 128.13749999999999p -2.7638349999999998e-07 128.15000000000001p -2.7677849999999998e-07 128.16249999999999p -2.7680910000000002e-07 128.17500000000001p -2.7647599999999999e-07 128.1875p -2.7578019999999998e-07 128.20000000000002p -2.747235e-07 128.21250000000001p -2.7330780000000002e-07 128.22499999999999p -2.7153569999999997e-07 128.23749999999998p -2.694103e-07 128.25p -2.6693509999999999e-07
+ 128.26249999999999p -2.6411390000000001e-07 128.27500000000001p -2.6095140000000001e-07 128.28749999999999p -2.5745220000000001e-07 128.30000000000001p -2.5362169999999999e-07 128.3125p -2.494656e-07 128.32499999999999p -2.4499000000000003e-07 128.33750000000001p -2.4020159999999997e-07 128.34999999999999p -2.351072e-07 128.36250000000001p -2.2971429999999999e-07 128.375p -2.2403060000000001e-07 128.38750000000002p -2.180642e-07 128.39999999999998p -2.1182349999999999e-07 128.41249999999999p -2.0531740000000001e-07 128.42500000000001p -1.9855510000000001e-07 128.4375p -1.9154610000000001e-07 128.45000000000002p -1.843e-07 128.46250000000001p -1.7682709999999999e-07 128.47499999999999p -1.6913770000000001e-07
+ 128.48749999999998p -1.612424e-07 128.5p -1.5315210000000001e-07 128.51249999999999p -1.4487800000000001e-07 128.52500000000001p -1.3643129999999999e-07 128.53749999999999p -1.2782369999999999e-07 128.55000000000001p -1.1906680000000001e-07 128.5625p -1.1017259999999999e-07 128.57499999999999p -1.011532e-07 128.58750000000001p -9.2020709999999994e-08 128.59999999999999p -8.2787520000000006e-08 128.61250000000001p -7.346605e-08 128.625p -6.4068829999999995e-08 128.63750000000002p -5.4608460000000003e-08 128.64999999999998p -4.5097580000000003e-08 128.66249999999999p -3.5548879999999998e-08 128.67500000000001p -2.5975069999999998e-08 128.6875p -1.638887e-08 128.70000000000002p -6.8029600000000003e-09
+ 128.71250000000001p 2.76998e-09 128.72499999999999p 1.231734e-08 128.73749999999998p 2.182656e-08 128.75p 3.1285180000000003e-08 128.76249999999999p 4.0680829999999998e-08 128.77500000000001p 5.0001240000000003e-08 128.78749999999999p 5.9234289999999999e-08 128.80000000000001p 6.8367999999999994e-08 128.8125p 7.7390550000000003e-08 128.82499999999999p 8.629031e-08 128.83750000000001p 9.5055830000000006e-08 128.84999999999999p 1.036759e-07 128.86250000000001p 1.121394e-07 128.875p 1.204357e-07 128.88750000000002p 1.2855409999999999e-07 128.89999999999998p 1.3648450000000001e-07 128.91249999999999p 1.4421679999999999e-07 128.92499999999998p 1.517414e-07
+ 128.9375p 1.5904870000000001e-07 128.95000000000002p 1.6612980000000001e-07 128.96250000000001p 1.7297590000000001e-07 128.97500000000002p 1.795786e-07 128.98749999999998p 1.859296e-07 129p 1.9202139999999999e-07 129.01249999999999p 1.9784659999999999e-07 129.02500000000001p 2.033981e-07 129.03749999999999p 2.086693e-07 129.05000000000001p 2.1365410000000001e-07 129.0625p 2.183465e-07 129.07499999999999p 2.2274109999999999e-07 129.08750000000001p 2.2683290000000001e-07 129.09999999999999p 2.3061730000000001e-07 129.11250000000001p 2.3409009999999999e-07 129.125p 2.3724749999999999e-07 129.13750000000002p 2.4008610000000002e-07 129.14999999999998p 2.4260299999999999e-07
+ 129.16249999999999p 2.4479579999999998e-07 129.17499999999998p 2.4666229999999999e-07 129.1875p 2.4820089999999999e-07 129.20000000000002p 2.4941039999999998e-07 129.21250000000001p 2.5029019999999998e-07 129.22500000000002p 2.5083970000000001e-07 129.23749999999998p 2.5105919999999998e-07 129.25p 2.5094920000000002e-07 129.26249999999999p 2.5051059999999999e-07 129.27500000000001p 2.497449e-07 129.28749999999999p 2.4865380000000001e-07 129.30000000000001p 2.4723970000000001e-07 129.3125p 2.45505e-07 129.32499999999999p 2.43453e-07 129.33750000000001p 2.4108710000000001e-07 129.34999999999999p 2.384111e-07 129.36250000000001p 2.3542940000000001e-07 129.375p 2.321466e-07
+ 129.38750000000002p 2.2856759999999999e-07 129.39999999999998p 2.2469799999999999e-07 129.41249999999999p 2.2054350000000001e-07 129.42499999999998p 2.1611020000000001e-07 129.4375p 2.1140449999999999e-07 129.44999999999999p 2.064334e-07 129.46250000000001p 2.0120400000000001e-07 129.47500000000002p 1.9572359999999999e-07 129.48749999999998p 1.900001e-07 129.5p 1.8404149999999999e-07 129.51249999999999p 1.7785620000000001e-07 129.52500000000001p 1.7145280000000001e-07 129.53749999999999p 1.648402e-07 129.55000000000001p 1.580275e-07 129.5625p 1.5102410000000001e-07 129.57499999999999p 1.4383950000000001e-07 129.58750000000001p 1.364836e-07 129.59999999999999p 1.2896639999999999e-07
+ 129.61250000000001p 1.212981e-07 129.625p 1.13489e-07 129.63750000000002p 1.055497e-07 129.65000000000001p 9.7490740000000006e-08 129.66249999999999p 8.9323020000000005e-08 129.67499999999998p 8.1057400000000004e-08 129.6875p 7.2704910000000006e-08 129.69999999999999p 6.4276629999999995e-08 129.71250000000001p 5.5783740000000002e-08 129.72500000000002p 4.7237469999999999e-08 129.73749999999998p 3.8649080000000003e-08 129.75p 3.002986e-08 129.76249999999999p 2.1391150000000001e-08 129.77500000000001p 1.274424e-08 129.78749999999999p 4.1004360000000003e-09 129.80000000000001p -4.5289940000000001e-09 129.8125p -1.313283e-08 129.82499999999999p -2.16999e-08
+ 129.83750000000001p -3.0219110000000003e-08 129.84999999999999p -3.867946e-08 129.86250000000001p -4.7070039999999997e-08 129.875p -5.5380060000000003e-08 129.88750000000002p -6.3598859999999994e-08 129.90000000000001p -7.17159e-08 129.91249999999999p -7.9720840000000005e-08 129.92499999999998p -8.7603470000000005e-08 129.9375p -9.5353769999999994e-08 129.94999999999999p -1.029619e-07 129.96250000000001p -1.1041830000000001e-07 129.97500000000002p -1.177135e-07 129.98750000000001p -1.2483839999999999e-07 130p -1.3178400000000001e-07 130.01249999999999p -1.385416e-07 130.02500000000001p -1.4510290000000001e-07 130.03749999999999p -1.514597e-07 130.05000000000001p -1.576042e-07
+ 130.0625p -1.6352870000000001e-07 130.07499999999999p -1.692261e-07 130.08750000000001p -1.7468930000000001e-07 130.09999999999999p -1.799117e-07 130.11250000000001p -1.848871e-07 130.125p -1.896095e-07 130.13750000000002p -1.940732e-07 130.15000000000001p -1.9827299999999999e-07 130.16249999999999p -2.02204e-07 130.17499999999998p -2.0586150000000001e-07 130.1875p -2.092415e-07 130.19999999999999p -2.123401e-07 130.21250000000001p -2.1515380000000001e-07 130.22499999999999p -2.1767960000000001e-07 130.23750000000001p -2.1991480000000001e-07 130.25p -2.2185709999999999e-07 130.26249999999999p -2.2350459999999999e-07 130.27500000000001p -2.248558e-07
+ 130.28749999999999p -2.2590959999999999e-07 130.30000000000001p -2.2666520000000001e-07 130.3125p -2.2712229999999999e-07 130.32500000000002p -2.2728089999999999e-07 130.33749999999998p -2.271415e-07 130.34999999999999p -2.267049e-07 130.36250000000001p -2.259724e-07 130.375p -2.2494549999999999e-07 130.38750000000002p -2.236262e-07 130.40000000000001p -2.22017e-07 130.41249999999999p -2.2012040000000001e-07 130.42499999999998p -2.1793979999999999e-07 130.4375p -2.1547839999999999e-07 130.44999999999999p -2.1274029999999999e-07 130.46250000000001p -2.097295e-07 130.47499999999999p -2.0645060000000001e-07 130.48750000000001p -2.0290860000000001e-07 130.5p -1.9910859999999999e-07
+ 130.51249999999999p -1.9505620000000001e-07 130.52500000000001p -1.907573e-07 130.53749999999999p -1.8621800000000001e-07 130.55000000000001p -1.8144480000000001e-07 130.5625p -1.7644459999999999e-07 130.57500000000002p -1.712243e-07 130.58749999999998p -1.657914e-07 130.59999999999999p -1.6015340000000001e-07 130.61250000000001p -1.543182e-07 130.625p -1.482939e-07 130.63750000000002p -1.4208869999999999e-07 130.65000000000001p -1.3571140000000001e-07 130.66250000000002p -1.291705e-07 130.67499999999998p -1.2247510000000001e-07 130.6875p -1.156343e-07 130.69999999999999p -1.0865750000000001e-07 130.71250000000001p -1.0155390000000001e-07 130.72499999999999p -9.4333409999999993e-08
+ 130.73750000000001p -8.7005610000000006e-08 130.75p -7.958039e-08 130.76249999999999p -7.2067719999999997e-08 130.77500000000001p -6.4477669999999997e-08 130.78749999999999p -5.6820370000000001e-08 130.80000000000001p -4.9106029999999999e-08 130.8125p -4.1344899999999999e-08 130.82500000000002p -3.3547290000000002e-08 130.83749999999998p -2.5723499999999999e-08 130.84999999999999p -1.7883870000000001e-08 130.86249999999998p -1.003873e-08 130.875p -2.1983769999999999e-09 130.88750000000002p 5.6268989999999998e-09 130.90000000000001p 1.342686e-08 130.91250000000002p 2.119134e-08 130.92499999999998p 2.891021e-08 130.9375p 3.657346e-08 130.94999999999999p 4.417115e-08
+ 130.96250000000001p 5.1693479999999999e-08 130.97499999999999p 5.9130730000000002e-08 130.98750000000001p 6.6473350000000001e-08 131p 7.3711920000000006e-08 131.01249999999999p 8.0837180000000002e-08 131.02500000000001p 8.7840060000000004e-08 131.03749999999999p 9.4711630000000002e-08 131.05000000000001p 1.014432e-07 131.0625p 1.0802629999999999e-07 131.07500000000002p 1.144525e-07 131.08749999999998p 1.2071390000000001e-07 131.09999999999999p 1.2680260000000001e-07 131.11249999999998p 1.32711e-07 131.125p 1.3843179999999999e-07 131.13750000000002p 1.4395790000000001e-07 131.15000000000001p 1.4928260000000001e-07 131.16250000000002p 1.5439919999999999e-07 131.17499999999998p 1.593017e-07
+ 131.1875p 1.6398399999999999e-07 131.19999999999999p 1.6844050000000001e-07 131.21250000000001p 1.7266599999999999e-07 131.22499999999999p 1.7665540000000001e-07 131.23750000000001p 1.8040400000000001e-07 131.25p 1.8390749999999999e-07 131.26249999999999p 1.871619e-07 131.27500000000001p 1.901634e-07 131.28749999999999p 1.9290880000000001e-07 131.30000000000001p 1.9539489999999999e-07 131.3125p 1.9761929999999999e-07 131.32500000000002p 1.995795e-07 131.33749999999998p 2.0127360000000001e-07 131.34999999999999p 2.027001e-07 131.36249999999998p 2.0385750000000001e-07 131.375p 2.0474520000000001e-07 131.38749999999999p 2.053625e-07 131.40000000000001p 2.0570919999999999e-07
+ 131.41250000000002p 2.057855e-07 131.42499999999998p 2.0559189999999999e-07 131.4375p 2.0512940000000001e-07 131.44999999999999p 2.04399e-07 131.46250000000001p 2.034025e-07 131.47499999999999p 2.0214170000000001e-07 131.48750000000001p 2.0061890000000001e-07 131.5p 1.9883669999999999e-07 131.51249999999999p 1.9679789999999999e-07 131.52500000000001p 1.9450589999999999e-07 131.53749999999999p 1.9196429999999999e-07 131.55000000000001p 1.8917690000000001e-07 131.5625p 1.8614789999999999e-07 131.57500000000002p 1.828818e-07 131.58750000000001p 1.7938359999999999e-07 131.59999999999999p 1.7565820000000001e-07 131.61249999999998p 1.7171109999999999e-07 131.625p 1.6754800000000001e-07
+ 131.63749999999999p 1.631747e-07 131.65000000000001p 1.5859749999999999e-07 131.66250000000002p 1.538228e-07 131.67499999999998p 1.488573e-07 131.6875p 1.4370800000000001e-07 131.69999999999999p 1.38382e-07 131.71250000000001p 1.328866e-07 131.72499999999999p 1.2722949999999999e-07 131.73750000000001p 1.214184e-07 131.75p 1.1546129999999999e-07 131.76249999999999p 1.093663e-07 131.77500000000001p 1.031416e-07 131.78749999999999p 9.6795690000000002e-08 131.80000000000001p 9.0337189999999998e-08 131.8125p 8.3774769999999994e-08 131.82500000000002p 7.7117260000000005e-08 131.83750000000001p 7.0373569999999994e-08 131.84999999999999p 6.3552720000000003e-08
+ 131.86249999999998p 5.6663830000000002e-08 131.875p 4.9716039999999999e-08 131.88749999999999p 4.2718590000000002e-08 131.90000000000001p 3.5680760000000003e-08 131.91249999999999p 2.861183e-08 131.92500000000001p 2.152113e-08 131.9375p 1.4418e-08 131.94999999999999p 7.3117560000000004e-09 131.96250000000001p 2.1171609999999999e-10 131.97499999999999p -6.87284e-09 131.98750000000001p -1.393267e-08 132p -2.0958580000000001e-08 132.01249999999999p -2.794145e-08 132.02499999999998p -3.4872229999999997e-08 132.03749999999999p -4.1741950000000001e-08 132.05000000000001p -4.8541749999999999e-08 132.0625p -5.5262879999999998e-08 132.07500000000002p -6.1896709999999995e-08
+ 132.08750000000001p -6.8434730000000004e-08 132.09999999999999p -7.4868599999999998e-08 132.11249999999998p -8.1190110000000003e-08 132.125p -8.7391219999999996e-08 132.13749999999999p -9.3464079999999995e-08 132.15000000000001p -9.9401010000000001e-08 132.16249999999999p -1.051945e-07 132.17500000000001p -1.108373e-07 132.1875p -1.163224e-07 132.19999999999999p -1.2164279999999999e-07 132.21250000000001p -1.2679210000000001e-07 132.22499999999999p -1.3176370000000001e-07 132.23750000000001p -1.365516e-07 132.25p -1.4114999999999999e-07 132.26250000000002p -1.455531e-07 132.27499999999998p -1.4975560000000001e-07 132.28749999999999p -1.5375259999999999e-07 132.30000000000001p -1.5753910000000001e-07
+ 132.3125p -1.6111069999999999e-07 132.32500000000002p -1.644631e-07 132.33750000000001p -1.675925e-07 132.34999999999999p -1.704952e-07 132.36249999999998p -1.7316789999999999e-07 132.375p -1.7560769999999999e-07 132.38749999999999p -1.7781179999999999e-07 132.40000000000001p -1.797778e-07 132.41249999999999p -1.8150370000000001e-07 132.42500000000001p -1.8298780000000001e-07 132.4375p -1.8422860000000001e-07 132.44999999999999p -1.8522510000000001e-07 132.46250000000001p -1.8597639999999999e-07 132.47499999999999p -1.864822e-07 132.48750000000001p -1.867423e-07 132.5p -1.8675689999999999e-07 132.51250000000002p -1.865265e-07 132.52499999999998p -1.86052e-07
+ 132.53749999999999p -1.853345e-07 132.55000000000001p -1.843755e-07 132.5625p -1.8317690000000001e-07 132.57500000000002p -1.8174059999999999e-07 132.58750000000001p -1.8006909999999999e-07 132.60000000000002p -1.7816519999999999e-07 132.61249999999998p -1.7603179999999999e-07 132.625p -1.736723e-07 132.63749999999999p -1.7109019999999999e-07 132.65000000000001p -1.682894e-07 132.66249999999999p -1.6527409999999999e-07 132.67500000000001p -1.6204880000000001e-07 132.6875p -1.58618e-07 132.69999999999999p -1.5498689999999999e-07 132.71250000000001p -1.511605e-07 132.72499999999999p -1.4714440000000001e-07 132.73750000000001p -1.429442e-07 132.75p -1.3856590000000001e-07
+ 132.76250000000002p -1.3401560000000001e-07 132.77499999999998p -1.292996e-07 132.78749999999999p -1.2442460000000001e-07 132.79999999999998p -1.193972e-07 132.8125p -1.142244e-07 132.82500000000002p -1.089134e-07 132.83750000000001p -1.034713e-07 132.85000000000002p -9.7905660000000001e-08 132.86249999999998p -9.2224029999999995e-08 132.875p -8.6434120000000003e-08 132.88749999999999p -8.0543759999999999e-08 132.90000000000001p -7.4560899999999996e-08 132.91249999999999p -6.8493599999999996e-08 132.92500000000001p -6.2350009999999996e-08 132.9375p -5.6138359999999998e-08 132.94999999999999p -4.9866930000000003e-08 132.96250000000001p -4.3544100000000001e-08 132.97499999999999p -3.7178260000000001e-08
+ 132.98750000000001p -3.0777869999999998e-08 133p -2.435138e-08 133.01250000000002p -1.7907279999999999e-08 133.02499999999998p -1.145406e-08 133.03749999999999p -5.0002030000000003e-09 133.04999999999998p 1.4458369999999999e-09 133.0625p 7.8756260000000004e-09 133.07500000000002p 1.428077e-08 133.08750000000001p 2.065294e-08 133.10000000000002p 2.698386e-08 133.11249999999998p 3.3265320000000003e-08 133.125p 3.9489189999999998e-08 133.13749999999999p 4.5647470000000003e-08 133.15000000000001p 5.173222e-08 133.16249999999999p 5.7735650000000003e-08 133.17500000000001p 6.3650059999999997e-08 133.1875p 6.9467910000000001e-08 133.19999999999999p 7.5181799999999994e-08
+ 133.21250000000001p 8.0784470000000002e-08 133.22499999999999p 8.6268840000000005e-08 133.23750000000001p 9.1627989999999995e-08 133.25p 9.6855179999999994e-08 133.26250000000002p 1.019439e-07 133.27500000000001p 1.0688769999999999e-07 133.28749999999999p 1.1168050000000001e-07 133.29999999999998p 1.163163e-07 133.3125p 1.207895e-07 133.32499999999999p 1.2509450000000001e-07 133.33750000000001p 1.29226e-07 133.35000000000002p 1.331791e-07 133.36249999999998p 1.3694899999999999e-07 133.375p 1.405311e-07 133.38749999999999p 1.439211e-07 133.40000000000001p 1.471151e-07 133.41249999999999p 1.501092e-07 133.42500000000001p 1.5290009999999999e-07
+ 133.4375p 1.5548450000000001e-07 133.44999999999999p 1.5785940000000001e-07 133.46250000000001p 1.6002220000000001e-07 133.47499999999999p 1.6197059999999999e-07 133.48750000000001p 1.6370250000000001e-07 133.5p 1.6521599999999999e-07 133.51250000000002p 1.665097e-07 133.52500000000001p 1.675823e-07 133.53749999999999p 1.6843289999999999e-07 133.54999999999998p 1.6906089999999999e-07 133.5625p 1.6946599999999999e-07 133.57499999999999p 1.6964800000000001e-07 133.58750000000001p 1.696072e-07 133.60000000000002p 1.693442e-07 133.61249999999998p 1.6885969999999999e-07 133.625p 1.6815489999999999e-07 133.63749999999999p 1.6723109999999999e-07 133.65000000000001p 1.6609009999999999e-07
+ 133.66249999999999p 1.6473379999999999e-07 133.67500000000001p 1.6316429999999999e-07 133.6875p 1.6138429999999999e-07 133.69999999999999p 1.593964e-07 133.71250000000001p 1.572038e-07 133.72499999999999p 1.5480969999999999e-07 133.73750000000001p 1.522176e-07 133.75p 1.494315e-07 133.76250000000002p 1.4645520000000001e-07 133.77500000000001p 1.432932e-07 133.78749999999999p 1.3994989999999999e-07 133.79999999999998p 1.364301e-07 133.8125p 1.3273870000000001e-07 133.82499999999999p 1.28881e-07 133.83750000000001p 1.2486239999999999e-07 133.84999999999999p 1.206884e-07 133.86250000000001p 1.163648e-07 133.875p 1.1189760000000001e-07
+ 133.88749999999999p 1.0729300000000001e-07 133.90000000000001p 1.0255719999999999e-07 133.91249999999999p 9.7696740000000001e-08 133.92500000000001p 9.2718239999999994e-08 133.9375p 8.762845e-08 133.94999999999999p 8.2434280000000005e-08 133.96249999999998p 7.7142740000000001e-08 133.97499999999999p 7.1760979999999997e-08 133.98750000000001p 6.6296220000000004e-08 134p 6.0755799999999994e-08 134.01250000000002p 5.5147149999999999e-08 134.02500000000001p 4.9477750000000001e-08 134.03749999999999p 4.3755169999999998e-08 134.04999999999998p 3.7987020000000001e-08 134.0625p 3.2180960000000003e-08 134.07499999999999p 2.6344689999999999e-08 134.08750000000001p 2.048593e-08 134.09999999999999p 1.461241e-08
+ 134.11250000000001p 8.7318770000000005e-09 134.125p 2.8520639999999998e-09 134.13749999999999p -3.0193090000000001e-09 134.15000000000001p -8.8745479999999999e-09 134.16249999999999p -1.4705999999999999e-08 134.17500000000001p -2.0506040000000001e-08 134.1875p -2.6267120000000001e-08 134.20000000000002p -3.1981750000000001e-08 134.21249999999998p -3.7642509999999998e-08 134.22499999999999p -4.324207e-08 134.23750000000001p -4.8773189999999997e-08 134.25p -5.4228739999999999e-08 134.26250000000002p -5.9601699999999997e-08 134.27500000000001p -6.4885169999999996e-08 134.28749999999999p -7.0072379999999996e-08 134.29999999999998p -7.5156709999999996e-08 134.3125p -8.013167e-08 134.32499999999999p -8.4990959999999997e-08
+ 134.33750000000001p -8.9728390000000006e-08 134.34999999999999p -9.4337999999999994e-08 134.36250000000001p -9.8813979999999994e-08 134.375p -1.0315070000000001e-07 134.38749999999999p -1.073428e-07 134.40000000000001p -1.113849e-07 134.41249999999999p -1.1527209999999999e-07 134.42500000000001p -1.189997e-07 134.4375p -1.2256289999999999e-07 134.45000000000002p -1.259576e-07 134.46249999999998p -1.2917939999999999e-07 134.47499999999999p -1.3222460000000001e-07 134.48749999999998p -1.3508960000000001e-07 134.5p -1.3777080000000001e-07 134.51250000000002p -1.402652e-07 134.52500000000001p -1.4256989999999999e-07 134.53750000000002p -1.446823e-07 134.54999999999998p -1.4659990000000001e-07
+ 134.5625p -1.483206e-07 134.57499999999999p -1.498427e-07 134.58750000000001p -1.5116440000000001e-07 134.59999999999999p -1.522846e-07 134.61250000000001p -1.5320209999999999e-07 134.625p -1.5391629999999999e-07 134.63749999999999p -1.544265e-07 134.65000000000001p -1.5473259999999999e-07 134.66249999999999p -1.5483450000000001e-07 134.67500000000001p -1.5473270000000001e-07 134.6875p -1.5442770000000001e-07 134.70000000000002p -1.5392029999999999e-07 134.71249999999998p -1.5321159999999999e-07 134.72499999999999p -1.523031e-07 134.73749999999998p -1.5119639999999999e-07 134.75p -1.4989330000000001e-07 134.76250000000002p -1.48396e-07 134.77500000000001p -1.4670699999999999e-07
+ 134.78750000000002p -1.4482889999999999e-07 134.79999999999998p -1.427646e-07 134.8125p -1.405172e-07 134.82499999999999p -1.380902e-07 134.83750000000001p -1.35487e-07 134.84999999999999p -1.327117e-07 134.86250000000001p -1.2976809999999999e-07 134.875p -1.266606e-07 134.88749999999999p -1.233937e-07 134.90000000000001p -1.199721e-07 134.91249999999999p -1.164005e-07 134.92500000000001p -1.126841e-07 134.9375p -1.08828e-07 134.95000000000002p -1.048378e-07 134.96249999999998p -1.00719e-07 134.97499999999999p -9.6477239999999995e-08 134.98749999999998p -9.2118489999999995e-08 135p -8.7648749999999999e-08
+ 135.01250000000002p -8.3074170000000001e-08 135.02500000000001p -7.8401030000000005e-08 135.03750000000002p -7.3635710000000005e-08 135.04999999999998p -6.8784719999999994e-08 135.0625p -6.3854640000000003e-08 135.07499999999999p -5.8852169999999998e-08 135.08750000000001p -5.3784050000000003e-08 135.09999999999999p -4.8657120000000002e-08 135.11250000000001p -4.3478279999999997e-08 135.125p -3.8254460000000001e-08 135.13749999999999p -3.2992649999999997e-08 135.15000000000001p -2.7699860000000002e-08 135.16249999999999p -2.2383140000000001e-08 135.17500000000001p -1.704953e-08 135.1875p -1.17061e-08 135.20000000000002p -6.3598850000000001e-09 135.21250000000001p -1.017932e-09 135.22499999999999p 4.3127480000000002e-09
+ 135.23749999999998p 9.6251780000000007e-09 135.25p 1.491242e-08 135.26249999999999p 2.0167590000000001e-08 135.27500000000001p 2.5383869999999999e-08 135.28750000000002p 3.0554490000000001e-08 135.29999999999998p 3.5672780000000001e-08 135.3125p 4.0732160000000002e-08 135.32499999999999p 4.572612e-08 135.33750000000001p 5.0648269999999998e-08 135.34999999999999p 5.5492340000000001e-08 135.36250000000001p 6.0252160000000001e-08 135.375p 6.4921700000000001e-08 135.38749999999999p 6.9495059999999994e-08 135.40000000000001p 7.3966490000000006e-08 135.41249999999999p 7.8330370000000006e-08 135.42500000000001p 8.2581249999999997e-08 135.4375p 8.6713850000000003e-08 135.45000000000002p 9.0723049999999994e-08
+ 135.46250000000001p 9.4603909999999996e-08 135.47499999999999p 9.8351660000000004e-08 135.48749999999998p 1.0196169999999999e-07 135.5p 1.054297e-07 135.51249999999999p 1.0875150000000001e-07 135.52500000000001p 1.11923e-07 135.53750000000002p 1.149405e-07 135.55000000000001p 1.178005e-07 135.5625p 1.2049960000000001e-07 135.57499999999999p 1.2303459999999999e-07 135.58750000000001p 1.2540260000000001e-07 135.59999999999999p 1.276011e-07 135.61250000000001p 1.296274e-07 135.625p 1.314795e-07 135.63749999999999p 1.3315519999999999e-07 135.65000000000001p 1.3465300000000001e-07 135.66249999999999p 1.3597110000000001e-07 135.67500000000001p 1.371085e-07
+ 135.6875p 1.3806400000000001e-07 135.70000000000002p 1.388368e-07 135.71250000000001p 1.394263e-07 135.72499999999999p 1.398324e-07 135.73749999999998p 1.4005469999999999e-07 135.75p 1.4009370000000001e-07 135.76249999999999p 1.3994949999999999e-07 135.77500000000001p 1.3962289999999999e-07 135.78749999999999p 1.3911470000000001e-07 135.80000000000001p 1.3842609999999999e-07 135.8125p 1.375583e-07 135.82499999999999p 1.36513e-07 135.83750000000001p 1.3529180000000001e-07 135.84999999999999p 1.3389690000000001e-07 135.86250000000001p 1.3233039999999999e-07 135.875p 1.3059489999999999e-07 135.88750000000002p 1.2869290000000001e-07 135.89999999999998p 1.2662729999999999e-07
+ 135.91249999999999p 1.2440130000000001e-07 135.92500000000001p 1.22018e-07 135.9375p 1.1948100000000001e-07 135.95000000000002p 1.1679399999999999e-07 135.96250000000001p 1.1396069999999999e-07 135.97499999999999p 1.109852e-07 135.98749999999998p 1.078717e-07 136p 1.046246e-07 136.01249999999999p 1.012484e-07 136.02500000000001p 9.774772e-08 136.03749999999999p 9.412752e-08 136.05000000000001p 9.0392729999999994e-08 136.0625p 8.6548469999999999e-08 136.07499999999999p 8.2599990000000002e-08 136.08750000000001p 7.855266e-08 136.09999999999999p 7.4411970000000002e-08 136.11250000000001p 7.0183509999999998e-08 136.125p 6.5872969999999994e-08
+ 136.13750000000002p 6.148615e-08 136.14999999999998p 5.7028920000000002e-08 136.16249999999999p 5.2507230000000002e-08 136.17500000000001p 4.7927100000000002e-08 136.1875p 4.3294629999999999e-08 136.20000000000002p 3.8615940000000001e-08 136.21250000000001p 3.3897230000000003e-08 136.22499999999999p 2.9144720000000001e-08 136.23749999999998p 2.4364660000000001e-08 136.25p 1.9563320000000001e-08 136.26249999999999p 1.474701e-08 136.27500000000001p 9.9220199999999992e-09 136.28749999999999p 5.0946379999999999e-09 136.30000000000001p 2.7115209999999999e-10 136.3125p -4.5421710000000002e-09 136.32499999999999p -9.3390900000000007e-09 136.33750000000001p -1.4113400000000001e-08 136.34999999999999p -1.8858940000000001e-08
+ 136.36250000000001p -2.356958e-08 136.375p -2.8239289999999999e-08 136.38750000000002p -3.2862050000000003e-08 136.39999999999998p -3.7431969999999998e-08 136.41249999999999p -4.1943190000000001e-08 136.42499999999998p -4.6389960000000001e-08 136.4375p -5.0766650000000001e-08 136.45000000000002p -5.5067679999999998e-08 136.46250000000001p -5.9287610000000003e-08 136.47500000000002p -6.3421130000000004e-08 136.48749999999998p -6.7463009999999997e-08 136.5p -7.1408199999999997e-08 136.51249999999999p -7.5251740000000001e-08 136.52500000000001p -7.8988839999999995e-08 136.53749999999999p -8.2614850000000001e-08 136.55000000000001p -8.6125269999999999e-08 136.5625p -8.9515759999999995e-08 136.57499999999999p -9.2782150000000005e-08
+ 136.58750000000001p -9.5920429999999999e-08 136.59999999999999p -9.8926780000000006e-08 136.61250000000001p -1.017975e-07 136.625p -1.0452919999999999e-07 136.63750000000002p -1.071186e-07 136.64999999999998p -1.095626e-07 136.66249999999999p -1.1185820000000001e-07 136.67499999999998p -1.1400279999999999e-07 136.6875p -1.15994e-07 136.70000000000002p -1.1782930000000001e-07 136.71250000000001p -1.195068e-07 136.72500000000002p -1.210245e-07 136.73749999999998p -1.223809e-07 136.75p -1.2357439999999999e-07 136.76249999999999p -1.246039e-07 136.77500000000001p -1.254683e-07 136.78749999999999p -1.261669e-07 136.80000000000001p -1.2669899999999999e-07
+ 136.8125p -1.270644e-07 136.82499999999999p -1.2726280000000001e-07 136.83750000000001p -1.272944e-07 136.84999999999999p -1.271594e-07 136.86250000000001p -1.2685840000000001e-07 136.875p -1.263922e-07 136.88750000000002p -1.2576159999999999e-07 136.89999999999998p -1.249678e-07 136.91249999999999p -1.2401229999999999e-07 136.92499999999998p -1.228965e-07 136.9375p -1.2162230000000001e-07 136.94999999999999p -1.2019180000000001e-07 136.96250000000001p -1.1860690000000001e-07 136.97500000000002p -1.168703e-07 136.98749999999998p -1.149844e-07 137p -1.129521e-07 137.01249999999999p -1.107763e-07 137.02500000000001p -1.084602e-07
+ 137.03749999999999p -1.06007e-07 137.05000000000001p -1.034204e-07 137.0625p -1.00704e-07 137.07499999999999p -9.7861500000000006e-08 137.08750000000001p -9.4897040000000005e-08 137.09999999999999p -9.1814740000000002e-08 137.11250000000001p -8.8618860000000003e-08 137.125p -8.5313860000000001e-08 137.13750000000002p -8.1904300000000006e-08 137.15000000000001p -7.8394860000000003e-08 137.16249999999999p -7.4790379999999999e-08 137.17499999999998p -7.1095770000000003e-08 137.1875p -6.7316090000000001e-08 137.19999999999999p -6.3456480000000003e-08 137.21250000000001p -5.9522170000000003e-08 137.22500000000002p -5.5518480000000002e-08 137.23749999999998p -5.1450819999999997e-08 137.25p -4.7324679999999999e-08
+ 137.26249999999999p -4.3145590000000003e-08 137.27500000000001p -3.8919150000000001e-08 137.28749999999999p -3.465101e-08 137.30000000000001p -3.0346880000000002e-08 137.3125p -2.6012479999999999e-08 137.32499999999999p -2.1653559999999999e-08 137.33750000000001p -1.727591e-08 137.34999999999999p -1.288532e-08 137.36250000000001p -8.4875739999999995e-09 137.375p -4.0884710000000004e-09 137.38750000000002p 3.0620909999999999e-10 137.40000000000001p 4.6907049999999999e-09 137.41249999999999p 9.0592810000000005e-09 137.42499999999998p 1.340623e-08 137.4375p 1.7725900000000001e-08 137.44999999999999p 2.2012670000000001e-08 137.46250000000001p 2.6260989999999999e-08 137.47500000000002p 3.0465359999999997e-08
+ 137.48750000000001p 3.4620350000000001e-08 137.5p 3.8720619999999998e-08 137.51249999999999p 4.2760900000000003e-08 137.52500000000001p 4.6736029999999999e-08 137.53749999999999p 5.0640930000000001e-08 137.55000000000001p 5.4470620000000003e-08 137.5625p 5.8220250000000001e-08 137.57499999999999p 6.1885070000000004e-08 137.58749999999998p 6.5460460000000006e-08 137.59999999999999p 6.8941919999999997e-08 137.61250000000001p 7.23251e-08 137.625p 7.5605769999999995e-08 137.63750000000002p 7.8779860000000003e-08 137.65000000000001p 8.1843439999999995e-08 137.66249999999999p 8.4792739999999994e-08 137.67499999999998p 8.7624139999999996e-08 137.6875p 9.0334200000000004e-08 137.69999999999999p 9.2919629999999995e-08
+ 137.71250000000001p 9.5377320000000004e-08 137.72499999999999p 9.7704340000000002e-08 137.73750000000001p 9.989792e-08 137.75p 1.019555e-07 137.76249999999999p 1.0387470000000001e-07 137.77500000000001p 1.056533e-07 137.78749999999999p 1.072892e-07 137.80000000000001p 1.087808e-07 137.8125p 1.101262e-07 137.82500000000002p 1.113242e-07 137.83749999999998p 1.123734e-07 137.84999999999999p 1.1327290000000001e-07 137.86250000000001p 1.140218e-07 137.875p 1.146194e-07 137.88750000000002p 1.150654e-07 137.90000000000001p 1.153594e-07 137.91249999999999p 1.155015e-07 137.92499999999998p 1.154918e-07
+ 137.9375p 1.1533059999999999e-07 137.94999999999999p 1.150186e-07 137.96250000000001p 1.145565e-07 137.97499999999999p 1.139451e-07 137.98750000000001p 1.1318579999999999e-07 138p 1.122798e-07 138.01249999999999p 1.112286e-07 138.02500000000001p 1.100339e-07 138.03749999999999p 1.086977e-07 138.05000000000001p 1.0722200000000001e-07 138.0625p 1.056091e-07 138.07500000000002p 1.038614e-07 138.08749999999998p 1.0198150000000001e-07 138.09999999999999p 9.9972080000000002e-08 138.11250000000001p 9.7836209999999998e-08 138.125p 9.5576910000000001e-08 138.13750000000002p 9.3197450000000002e-08 138.15000000000001p 9.0701199999999997e-08
+ 138.16250000000002p 8.8091709999999999e-08 138.17499999999998p 8.5372649999999994e-08 138.1875p 8.2547850000000004e-08 138.19999999999999p 7.9621229999999996e-08 138.21250000000001p 7.6596879999999996e-08 138.22499999999999p 7.3478970000000003e-08 138.23750000000001p 7.0271809999999995e-08 138.25p 6.6979790000000001e-08 138.26249999999999p 6.3607430000000006e-08 138.27500000000001p 6.0159329999999996e-08 138.28749999999999p 5.6640180000000001e-08 138.30000000000001p 5.3054750000000001e-08 138.3125p 4.9407889999999999e-08 138.32500000000002p 4.5704519999999997e-08 138.33749999999998p 4.194962e-08 138.34999999999999p 3.8148220000000003e-08 138.36249999999998p 3.430541e-08 138.375p 3.0426330000000003e-08
+ 138.38750000000002p 2.6516129999999999e-08 138.40000000000001p 2.2580020000000001e-08 138.41250000000002p 1.8623200000000002e-08 138.42499999999998p 1.46509e-08 138.4375p 1.066838e-08 138.44999999999999p 6.6808709999999998e-09 138.46250000000001p 2.6936079999999999e-09 138.47499999999999p -1.288182e-09 138.48750000000001p -5.2592940000000004e-09 138.5p -9.2145459999999993e-09 138.51249999999999p -1.314879e-08 138.52500000000001p -1.7056919999999999e-08 138.53749999999999p -2.0933869999999999e-08 138.55000000000001p -2.477462e-08 138.5625p -2.8574229999999999e-08 138.57500000000002p -3.2327799999999999e-08 138.58749999999998p -3.6030530000000003e-08 138.59999999999999p -3.9677659999999997e-08
+ 138.61249999999998p -4.3264540000000003e-08 138.625p -4.6786610000000002e-08 138.63750000000002p -5.0239390000000003e-08 138.65000000000001p -5.3618499999999998e-08 138.66250000000002p -5.6919690000000003e-08 138.67499999999998p -6.0138799999999996e-08 138.6875p -6.3271779999999995e-08 138.69999999999999p -6.6314729999999995e-08 138.71250000000001p -6.9263850000000003e-08 138.72499999999999p -7.2115480000000002e-08 138.73750000000001p -7.4866110000000005e-08 138.75p -7.7512349999999999e-08 138.76249999999999p -8.0050949999999997e-08 138.77500000000001p -8.2478839999999996e-08 138.78749999999999p -8.4793069999999999e-08 138.80000000000001p -8.699085e-08 138.8125p -8.9069570000000005e-08 138.82500000000002p -9.1026769999999998e-08
+ 138.83749999999998p -9.2860140000000004e-08 138.84999999999999p -9.4567549999999999e-08 138.86249999999998p -9.6147050000000003e-08 138.875p -9.7596849999999996e-08 138.88749999999999p -9.8915330000000002e-08 138.90000000000001p -1.001011e-07 138.91250000000002p -1.011528e-07 138.92499999999998p -1.0206939999999999e-07 138.9375p -1.0285e-07 138.94999999999999p -1.0349389999999999e-07 138.96250000000001p -1.0400050000000001e-07 138.97499999999999p -1.043695e-07 138.98750000000001p -1.046007e-07 139p -1.046941e-07 139.01249999999999p -1.046499e-07 139.02500000000001p -1.0446849999999999e-07 139.03749999999999p -1.0415030000000001e-07 139.05000000000001p -1.036962e-07
+ 139.0625p -1.03107e-07 139.07500000000002p -1.023838e-07 139.08750000000001p -1.015278e-07 139.09999999999999p -1.005405e-07 139.11249999999998p -9.9423439999999998e-08 139.125p -9.8178409999999999e-08 139.13749999999999p -9.6807310000000001e-08 139.15000000000001p -9.5312230000000001e-08 139.16250000000002p -9.3695409999999998e-08 139.17499999999998p -9.1959239999999994e-08 139.1875p -9.010627e-08 139.19999999999999p -8.813921e-08 139.21250000000001p -8.6060879999999994e-08 139.22499999999999p -8.3874279999999997e-08 139.23750000000001p -8.1582499999999996e-08 139.25p -7.9188809999999994e-08 139.26249999999999p -7.6696570000000004e-08 139.27500000000001p -7.4109289999999999e-08
+ 139.28749999999999p -7.1430560000000005e-08 139.30000000000001p -6.8664129999999994e-08 139.3125p -6.5813809999999995e-08 139.32500000000002p -6.2883539999999995e-08 139.33750000000001p -5.9877359999999996e-08 139.34999999999999p -5.6799390000000003e-08 139.36249999999998p -5.3653820000000001e-08 139.375p -5.044494e-08 139.38749999999999p -4.7177119999999998e-08 139.40000000000001p -4.3854780000000001e-08 139.41249999999999p -4.04824e-08 139.42500000000001p -3.706454e-08 139.4375p -3.3605770000000003e-08 139.44999999999999p -3.0110749999999997e-08 139.46250000000001p -2.658414e-08 139.47499999999999p -2.3030640000000001e-08 139.48750000000001p -1.9455000000000001e-08 139.5p -1.5861940000000001e-08
+ 139.51249999999999p -1.2256239999999999e-08 139.52499999999998p -8.6426519999999999e-09 139.53749999999999p -5.0259479999999998e-09 139.55000000000001p -1.410884e-09 139.5625p 2.1977950000000001e-09 139.57500000000002p 5.795366e-09 139.58750000000001p 9.3771260000000006e-09 139.59999999999999p 1.293841e-08 139.61249999999998p 1.6474579999999999e-08 139.625p 1.9981060000000001e-08 139.63749999999999p 2.3453310000000001e-08 139.65000000000001p 2.688684e-08 139.66249999999999p 3.0277239999999997e-08 139.67500000000001p 3.3620139999999998e-08 139.6875p 3.6911269999999999e-08 139.69999999999999p 4.0146429999999999e-08 139.71250000000001p 4.3321489999999999e-08 139.72499999999999p 4.643243e-08
+ 139.73750000000001p 4.9475300000000001e-08 139.75p 5.2446260000000002e-08 139.76250000000002p 5.5341570000000002e-08 139.77499999999998p 5.8157620000000002e-08 139.78749999999999p 6.0890870000000004e-08 139.80000000000001p 6.3537940000000004e-08 139.8125p 6.6095539999999997e-08 139.82500000000002p 6.8560519999999994e-08 139.83750000000001p 7.0929849999999999e-08 139.84999999999999p 7.3200639999999999e-08 139.86249999999998p 7.5370139999999998e-08 139.875p 7.7435730000000006e-08 139.88749999999999p 7.9394930000000001e-08 139.90000000000001p 8.1245419999999999e-08 139.91249999999999p 8.2985009999999995e-08 139.92500000000001p 8.4611669999999998e-08 139.9375p 8.612353e-08 139.94999999999999p 8.7518850000000003e-08
+ 139.96250000000001p 8.8796090000000005e-08 139.97499999999999p 8.9953809999999998e-08 139.98750000000001p 9.0990790000000003e-08 140p 9.190593e-08 140.01250000000002p 9.269831e-08 140.02499999999998p 9.3367169999999999e-08 140.03749999999999p 9.3911899999999995e-08 140.05000000000001p 9.433208e-08 140.0625p 9.4627439999999999e-08 140.07500000000002p 9.4797870000000004e-08 140.08750000000001p 9.4843440000000006e-08 140.10000000000002p 9.4764359999999996e-08 140.11249999999998p 9.4561010000000005e-08 140.125p 9.4233959999999996e-08 140.13749999999999p 9.3783910000000006e-08 140.15000000000001p 9.3211720000000005e-08 140.16249999999999p 9.2518419999999997e-08 140.17500000000001p 9.1705199999999997e-08
+ 140.1875p 9.077339e-08 140.19999999999999p 8.9724479999999997e-08 140.21250000000001p 8.8560120000000005e-08 140.22499999999999p 8.7282089999999996e-08 140.23750000000001p 8.5892319999999995e-08 140.25p 8.4392890000000005e-08 140.26250000000002p 8.2786009999999994e-08 140.27499999999998p 8.1074030000000005e-08 140.28749999999999p 7.9259440000000003e-08 140.29999999999998p 7.7344849999999994e-08 140.3125p 7.5332989999999994e-08 140.32500000000002p 7.3226720000000001e-08 140.33750000000001p 7.1029010000000003e-08 140.35000000000002p 6.8742959999999996e-08 140.36249999999998p 6.6371759999999997e-08 140.375p 6.3918709999999998e-08 140.38749999999999p 6.1387219999999996e-08 140.40000000000001p 5.8780779999999998e-08
+ 140.41249999999999p 5.6102980000000003e-08 140.42500000000001p 5.3357490000000003e-08 140.4375p 5.0548080000000003e-08 140.44999999999999p 4.7678550000000002e-08 140.46250000000001p 4.4752819999999999e-08 140.47499999999999p 4.177485e-08 140.48750000000001p 3.8748669999999999e-08 140.5p 3.5678350000000003e-08 140.51250000000002p 3.2568019999999997e-08 140.52499999999998p 2.9421839999999999e-08 140.53749999999999p 2.6244039999999999e-08 140.54999999999998p 2.3038850000000001e-08 140.5625p 1.981053e-08 140.57500000000002p 1.656338e-08 140.58750000000001p 1.3301699999999999e-08 140.60000000000002p 1.00298e-08 140.61249999999998p 6.7519919999999998e-09 140.625p 3.4725989999999999e-09
+ 140.63749999999999p 1.959246e-10 140.65000000000001p -3.0737360000000001e-09 140.66249999999999p -6.3321079999999997e-09 140.67500000000001p -9.5749390000000001e-09 140.6875p -1.279801e-08 140.69999999999999p -1.5997129999999999e-08 140.71250000000001p -1.9168160000000001e-08 140.72499999999999p -2.2306999999999999e-08 140.73750000000001p -2.5409599999999999e-08 140.75p -2.8471969999999999e-08 140.76250000000002p -3.1490179999999997e-08 140.77500000000001p -3.4460360000000001e-08 140.78749999999999p -3.737873e-08 140.79999999999998p -4.0241569999999999e-08 140.8125p -4.304525e-08 140.82499999999999p -4.5786220000000001e-08 140.83750000000001p -4.8461019999999999e-08 140.85000000000002p -5.1066290000000002e-08
+ 140.86249999999998p -5.3598770000000002e-08 140.875p -5.6055290000000001e-08 140.88749999999999p -5.8432809999999997e-08 140.90000000000001p -6.0728359999999995e-08 140.91249999999999p -6.2939139999999997e-08 140.92500000000001p -6.5062430000000002e-08 140.9375p -6.7095630000000002e-08 140.94999999999999p -6.9036279999999994e-08 140.96250000000001p -7.0882039999999999e-08 140.97499999999999p -7.2630699999999994e-08 140.98750000000001p -7.4280180000000005e-08 141p -7.5828560000000002e-08 141.01250000000002p -7.7273999999999994e-08 141.02500000000001p -7.8614869999999998e-08 141.03749999999999p -7.9849620000000002e-08 141.04999999999998p -8.0976889999999996e-08 141.0625p -8.1995420000000002e-08 141.07499999999999p -8.2904140000000004e-08
+ 141.08750000000001p -8.3702099999999996e-08 141.10000000000002p -8.4388490000000005e-08 141.11250000000001p -8.4962690000000005e-08 141.125p -8.5424170000000006e-08 141.13749999999999p -8.5772600000000001e-08 141.15000000000001p -8.6007779999999994e-08 141.16249999999999p -8.6129639999999995e-08 141.17500000000001p -8.6138300000000003e-08 141.1875p -8.6034000000000001e-08 141.19999999999999p -8.5817120000000005e-08 141.21250000000001p -8.5488219999999995e-08 141.22499999999999p -8.5047980000000002e-08 141.23750000000001p -8.4497219999999996e-08 141.25p -8.3836929999999996e-08 141.26250000000002p -8.306823e-08 141.27500000000001p -8.2192349999999998e-08 141.28749999999999p -8.1210710000000005e-08 141.29999999999998p -8.0124830000000003e-08
+ 141.3125p -7.8936370000000005e-08 141.32499999999999p -7.7647130000000002e-08 141.33750000000001p -7.6259020000000001e-08 141.34999999999999p -7.4774099999999997e-08 141.36250000000001p -7.319454e-08 141.375p -7.1522609999999999e-08 141.38749999999999p -6.9760729999999998e-08 141.40000000000001p -6.79114e-08 141.41249999999999p -6.5977269999999996e-08 141.42500000000001p -6.3961049999999996e-08 141.4375p -6.1865569999999995e-08 141.44999999999999p -5.9693770000000004e-08 141.46249999999998p -5.7448670000000001e-08 141.47499999999999p -5.513337e-08 141.48750000000001p -5.2751079999999999e-08 141.5p -5.0305059999999999e-08 141.51250000000002p -4.7798669999999997e-08 141.52500000000001p -4.523533e-08
+ 141.53749999999999p -4.2618530000000002e-08 141.54999999999998p -3.9951809999999998e-08 141.5625p -3.7238789999999999e-08 141.57499999999999p -3.448313e-08 141.58750000000001p -3.1688519999999999e-08 141.59999999999999p -2.885873e-08 141.61250000000001p -2.5997520000000001e-08 141.625p -2.3108729999999999e-08 141.63749999999999p -2.0196189999999999e-08 141.65000000000001p -1.7263780000000001e-08 141.66249999999999p -1.431537e-08 141.67500000000001p -1.135486e-08 141.6875p -8.386146e-09 141.70000000000002p -5.4131389999999999e-09 141.71249999999998p -2.4397339999999998e-09 141.72499999999999p 5.3017879999999995e-10 141.73750000000001p 3.492723e-09 141.75p 6.4440419999999998e-09
+ 141.76250000000002p 9.3803010000000003e-09 141.77500000000001p 1.2297700000000001e-08 141.78749999999999p 1.5192459999999999e-08 141.79999999999998p 1.8060850000000001e-08 141.8125p 2.0899189999999998e-08 141.82499999999999p 2.3703820000000001e-08 141.83750000000001p 2.6471170000000001e-08 141.84999999999999p 2.9197710000000001e-08 141.86250000000001p 3.1879950000000002e-08 141.875p 3.4514500000000001e-08 141.88749999999999p 3.7098030000000002e-08 141.90000000000001p 3.9627270000000001e-08 141.91249999999999p 4.2099039999999998e-08 141.92500000000001p 4.451025e-08 141.9375p 4.6857880000000003e-08 141.95000000000002p 4.9139009999999997e-08 141.96249999999998p 5.135081e-08 141.97499999999999p 5.3490550000000001e-08
+ 141.98749999999998p 5.5555600000000003e-08 142p 5.7543420000000003e-08 142.01250000000002p 5.94516e-08 142.02500000000001p 6.1277819999999997e-08 142.03750000000002p 6.3019880000000006e-08 142.04999999999998p 6.46757e-08 142.0625p 6.6243299999999996e-08 142.07499999999999p 6.7720840000000003e-08 142.08750000000001p 6.9106579999999996e-08 142.09999999999999p 7.0398930000000005e-08 142.11250000000001p 7.1596399999999996e-08 142.125p 7.2697630000000001e-08 142.13749999999999p 7.3701409999999998e-08 142.15000000000001p 7.4606640000000005e-08 142.16249999999999p 7.541235e-08 142.17500000000001p 7.6117710000000001e-08 142.1875p 7.672201e-08 142.20000000000002p 7.7224690000000005e-08
+ 142.21249999999998p 7.7625320000000005e-08 142.22499999999999p 7.7923589999999999e-08 142.23749999999998p 7.8119340000000002e-08 142.25p 7.8212530000000003e-08 142.26250000000002p 7.8203260000000006e-08 142.27500000000001p 7.8091769999999995e-08 142.28750000000002p 7.7878420000000006e-08 142.29999999999998p 7.7563700000000003e-08 142.3125p 7.7148239999999994e-08 142.32499999999999p 7.6632809999999994e-08 142.33750000000001p 7.6018279999999996e-08 142.34999999999999p 7.5305669999999994e-08 142.36250000000001p 7.4496120000000006e-08 142.375p 7.3590880000000002e-08 142.38749999999999p 7.2591350000000004e-08 142.40000000000001p 7.1499020000000004e-08 142.41249999999999p 7.0315510000000002e-08 142.42500000000001p 6.9042559999999997e-08
+ 142.4375p 6.768203e-08 142.45000000000002p 6.6235849999999997e-08 142.46249999999998p 6.4706109999999999e-08 142.47499999999999p 6.3094980000000004e-08 142.48749999999998p 6.1404710000000006e-08 142.5p 5.9637700000000005e-08 142.51250000000002p 5.7796390000000002e-08 142.52500000000001p 5.5883349999999997e-08 142.53750000000002p 5.3901219999999998e-08 142.54999999999998p 5.1852739999999998e-08 142.5625p 4.9740710000000002e-08 142.57499999999999p 4.7568019999999999e-08 142.58750000000001p 4.533763e-08 142.59999999999999p 4.305258e-08 142.61250000000001p 4.0715959999999999e-08 142.625p 3.8330920000000002e-08 142.63749999999999p 3.5900680000000002e-08 142.65000000000001p 3.3428509999999997e-08
+ 142.66249999999999p 3.0917729999999999e-08 142.67500000000001p 2.8371680000000001e-08 142.6875p 2.5793769999999999e-08 142.70000000000002p 2.3187439999999999e-08 142.71250000000001p 2.0556140000000001e-08 142.72499999999999p 1.790337e-08 142.73749999999998p 1.5232629999999999e-08 142.75p 1.2547459999999999e-08 142.76249999999999p 9.8513979999999995e-09 142.77500000000001p 7.1479849999999999e-09 142.78750000000002p 4.4407759999999996e-09 142.79999999999998p 1.733317e-09 142.8125p -9.7084709999999992e-10 142.82499999999999p -3.6681869999999998e-09 142.83750000000001p -6.3551860000000002e-09 142.84999999999999p -9.0283500000000006e-09 142.86250000000001p -1.168421e-08 142.875p -1.431931e-08
+ 142.88749999999999p -1.693027e-08 142.90000000000001p -1.9513689999999999e-08 142.91249999999999p -2.2066260000000001e-08 142.92500000000001p -2.4584699999999998e-08 142.9375p -2.7065769999999998e-08 142.95000000000002p -2.9506299999999999e-08 142.96250000000001p -3.1903180000000002e-08 142.97499999999999p -3.4253350000000001e-08 142.98749999999998p -3.655382e-08 143p -3.880167e-08 143.01249999999999p -4.0994080000000002e-08 143.02500000000001p -4.3128270000000001e-08 143.03750000000002p -4.5201569999999999e-08 143.05000000000001p -4.721138e-08 143.0625p -4.9155179999999997e-08 143.07499999999999p -5.1030569999999997e-08 143.08750000000001p -5.283522e-08 143.09999999999999p -5.4566900000000003e-08
+ 143.11250000000001p -5.62235e-08 143.125p -5.7802979999999998e-08 143.13749999999999p -5.930344e-08 143.15000000000001p -6.0723050000000003e-08 143.16249999999999p -6.2060129999999996e-08 143.17500000000001p -6.3313090000000001e-08 143.1875p -6.448044e-08 143.20000000000002p -6.5560840000000002e-08 143.21250000000001p -6.6553030000000003e-08 143.22499999999999p -6.74559e-08 143.23749999999998p -6.8268439999999994e-08 143.25p -6.8989779999999994e-08 143.26249999999999p -6.9619140000000001e-08 143.27500000000001p -7.0155889999999994e-08 143.28749999999999p -7.0599510000000006e-08 143.30000000000001p -7.0949619999999995e-08 143.3125p -7.120595e-08 143.32499999999999p -7.1368339999999997e-08
+ 143.33750000000001p -7.1436789999999999e-08 143.34999999999999p -7.1411399999999998e-08 143.36250000000001p -7.1292399999999996e-08 143.375p -7.1080129999999994e-08 143.38750000000002p -7.0775079999999996e-08 143.39999999999998p -7.0377830000000002e-08 143.41249999999999p -6.9889100000000003e-08 143.42500000000001p -6.9309730000000003e-08 143.4375p -6.8640659999999997e-08 143.45000000000002p -6.7882979999999993e-08 143.46250000000001p -6.7037850000000006e-08 143.47499999999999p -6.6106579999999996e-08 143.48749999999998p -6.5090569999999999e-08 143.5p -6.3991350000000006e-08 143.51249999999999p -6.2810529999999995e-08 143.52500000000001p -6.1549839999999994e-08 143.53749999999999p -6.0211109999999998e-08 143.55000000000001p -5.8796269999999999e-08
+ 143.5625p -5.7307349999999997e-08 143.57499999999999p -5.5746460000000003e-08 143.58750000000001p -5.4115820000000002e-08 143.59999999999999p -5.241771e-08 143.61250000000001p -5.0654519999999998e-08 143.625p -4.882871e-08 143.63750000000002p -4.6942829999999998e-08 143.64999999999998p -4.4999470000000002e-08 143.66249999999999p -4.3001339999999998e-08 143.67500000000001p -4.0951159999999999e-08 143.6875p -3.8851770000000002e-08 143.70000000000002p -3.6706030000000001e-08 143.71250000000001p -3.4516859999999999e-08 143.72500000000002p -3.228724e-08 143.73749999999998p -3.0020190000000001e-08 143.75p -2.7718790000000001e-08 143.76249999999999p -2.5386130000000002e-08 143.77500000000001p -2.3025360000000002e-08
+ 143.78749999999999p -2.0639649999999999e-08 143.80000000000001p -1.8232179999999999e-08 143.8125p -1.5806180000000001e-08 143.82499999999999p -1.3364890000000001e-08 143.83750000000001p -1.0911529999999999e-08 143.84999999999999p -8.4493800000000004e-09 143.86250000000001p -5.9816890000000004e-09 143.875p -3.5117169999999998e-09 143.88750000000002p -1.0427180000000001e-09 143.89999999999998p 1.4220610000000001e-09 143.91249999999999p 3.8793890000000003e-09 143.92499999999998p 6.3260500000000001e-09 143.9375p 8.7588509999999997e-09 143.95000000000002p 1.117462e-08 143.96250000000001p 1.3570230000000001e-08 143.97500000000002p 1.5942570000000001e-08 143.98749999999998p 1.8288570000000001e-08 144p 2.0605219999999999e-08
+ 144.01249999999999p 2.2889520000000001e-08 144.02500000000001p 2.513856e-08 144.03749999999999p 2.734947e-08 144.05000000000001p 2.9519409999999999e-08 144.0625p 3.1645640000000002e-08 144.07499999999999p 3.372546e-08 144.08750000000001p 3.575625e-08 144.09999999999999p 3.7735449999999998e-08 144.11250000000001p 3.9660590000000002e-08 144.125p 4.1529259999999998e-08 144.13750000000002p 4.3339129999999997e-08 144.14999999999998p 4.508798e-08 144.16249999999999p 4.6773639999999997e-08 144.17499999999998p 4.8394040000000003e-08 144.1875p 4.9947220000000001e-08 144.20000000000002p 5.1431300000000002e-08 144.21250000000001p 5.2844480000000001e-08 144.22500000000002p 5.4185079999999998e-08
+ 144.23749999999998p 5.5451510000000002e-08 144.25p 5.6642280000000002e-08 144.26249999999999p 5.7756019999999998e-08 144.27500000000001p 5.8791429999999998e-08 144.28749999999999p 5.9747340000000001e-08 144.30000000000001p 6.0622699999999997e-08 144.3125p 6.1416539999999999e-08 144.32499999999999p 6.2128009999999995e-08 144.33750000000001p 6.2756379999999998e-08 144.34999999999999p 6.3301019999999999e-08 144.36250000000001p 6.3761410000000003e-08 144.375p 6.4137159999999999e-08 144.38750000000002p 6.4427950000000004e-08 144.39999999999998p 6.4633630000000003e-08 144.41249999999999p 6.4754119999999997e-08 144.42499999999998p 6.4789469999999996e-08 144.4375p 6.4739820000000005e-08 144.44999999999999p 6.4605460000000003e-08
+ 144.46250000000001p 6.4386749999999999e-08 144.47500000000002p 6.4084179999999998e-08 144.48749999999998p 6.3698360000000001e-08 144.5p 6.3229979999999998e-08 144.51249999999999p 6.2679850000000001e-08 144.52500000000001p 6.204889e-08 144.53749999999999p 6.1338110000000005e-08 144.55000000000001p 6.0548649999999996e-08 144.5625p 5.9681709999999998e-08 144.57499999999999p 5.8738619999999999e-08 144.58750000000001p 5.7720789999999997e-08 144.59999999999999p 5.6629740000000001e-08 144.61250000000001p 5.5467060000000002e-08 144.625p 5.4234460000000002e-08 144.63750000000002p 5.29337e-08 144.65000000000001p 5.1566650000000002e-08 144.66249999999999p 5.0135260000000002e-08 144.67499999999998p 4.8641550000000002e-08
+ 144.6875p 4.7087640000000002e-08 144.69999999999999p 4.547568e-08 144.71250000000001p 4.3807939999999998e-08 144.72500000000002p 4.2086720000000002e-08 144.73749999999998p 4.0314400000000001e-08 144.75p 3.8493420000000001e-08 144.76249999999999p 3.662629e-08 144.77500000000001p 3.4715539999999997e-08 144.78749999999999p 3.2763790000000001e-08 144.80000000000001p 3.0773670000000002e-08 144.8125p 2.8747900000000002e-08 144.82499999999999p 2.6689189999999999e-08 144.83750000000001p 2.4600330000000001e-08 144.84999999999999p 2.248411e-08 144.86250000000001p 2.0343360000000001e-08 144.875p 1.818094e-08 144.88750000000002p 1.5999730000000001e-08 144.90000000000001p 1.3802630000000001e-08
+ 144.91249999999999p 1.159255e-08 144.92499999999998p 9.3724030000000006e-09 144.9375p 7.1451210000000001e-09 144.94999999999999p 4.913631e-09 144.96250000000001p 2.6808610000000001e-09 144.97500000000002p 4.4973470000000001e-10 144.98750000000001p -1.776836e-09 145p -3.9959499999999996e-09 145.01249999999999p -6.2047230000000002e-09 145.02500000000001p -8.4002909999999992e-09 145.03749999999999p -1.057982e-08 145.05000000000001p -1.2740479999999999e-08 145.0625p -1.4879509999999999e-08 145.07499999999999p -1.6994150000000001e-08 145.08749999999998p -1.9081699999999999e-08 145.09999999999999p -2.1139499999999999e-08 145.11250000000001p -2.3164900000000001e-08 145.125p -2.5155360000000002e-08
+ 145.13750000000002p -2.7108339999999999e-08 145.15000000000001p -2.9021370000000001e-08 145.16249999999999p -3.0892049999999999e-08 145.17499999999998p -3.2718029999999999e-08 145.1875p -3.4497020000000001e-08 145.19999999999999p -3.6226810000000003e-08 145.21250000000001p -3.7905250000000001e-08 145.22499999999999p -3.9530249999999998e-08 145.23750000000001p -4.109982e-08 145.25p -4.2612039999999998e-08 145.26249999999999p -4.4065050000000001e-08 145.27500000000001p -4.5457089999999997e-08 145.28749999999999p -4.678648e-08 145.30000000000001p -4.805163e-08 145.3125p -4.9251029999999998e-08 145.32500000000002p -5.0383250000000002e-08 145.33749999999998p -5.1446970000000001e-08 145.34999999999999p -5.2440970000000003e-08
+ 145.36250000000001p -5.336408e-08 145.375p -5.4215269999999999e-08 145.38750000000002p -5.4993600000000001e-08 145.40000000000001p -5.5698199999999998e-08 145.41249999999999p -5.6328320000000003e-08 145.42499999999998p -5.688331e-08 145.4375p -5.7362609999999997e-08 145.44999999999999p -5.7765770000000002e-08 145.46250000000001p -5.809243e-08 145.47499999999999p -5.8342340000000003e-08 145.48750000000001p -5.8515349999999997e-08 145.5p -5.8611400000000003e-08 145.51249999999999p -5.8630540000000003e-08 145.52500000000001p -5.8572919999999999e-08 145.53749999999999p -5.8438789999999997e-08 145.55000000000001p -5.8228499999999998e-08 145.5625p -5.7942499999999998e-08 145.57500000000002p -5.7581329999999997e-08
+ 145.58749999999998p -5.7145630000000002e-08 145.59999999999999p -5.663615e-08 145.61250000000001p -5.605371e-08 145.625p -5.5399249999999999e-08 145.63750000000002p -5.467378e-08 145.65000000000001p -5.3878409999999999e-08 145.66250000000002p -5.3014340000000003e-08 145.67499999999998p -5.2082870000000002e-08 145.6875p -5.1085350000000003e-08 145.69999999999999p -5.0023249999999998e-08 145.71250000000001p -4.8898090000000001e-08 145.72499999999999p -4.771151e-08 145.73750000000001p -4.6465179999999997e-08 145.75p -4.5160870000000001e-08 145.76249999999999p -4.380043e-08 145.77500000000001p -4.2385760000000003e-08 145.78749999999999p -4.0918830000000003e-08 145.80000000000001p -3.9401689999999998e-08
+ 145.8125p -3.783643e-08 145.82500000000002p -3.6225210000000003e-08 145.83749999999998p -3.4570240000000002e-08 145.84999999999999p -3.2873800000000003e-08 145.86249999999998p -3.1138189999999998e-08 145.875p -2.9365779999999999e-08 145.88750000000002p -2.7558979999999999e-08 145.90000000000001p -2.5720209999999999e-08 145.91250000000002p -2.3851970000000001e-08 145.92499999999998p -2.1956769999999999e-08 145.9375p -2.0037150000000001e-08 145.94999999999999p -1.8095679999999999e-08 145.96250000000001p -1.6134949999999999e-08 145.97499999999999p -1.415758e-08 145.98750000000001p -1.2166190000000001e-08 146p -1.016342e-08 146.01249999999999p -8.1519150000000002e-09 146.02500000000001p -6.1343379999999999e-09
+ 146.03749999999999p -4.113342e-09 146.05000000000001p -2.0915820000000002e-09 146.0625p -7.1706980000000005e-11 146.07500000000002p 1.943641e-09 146.08749999999998p 3.9518310000000003e-09 146.09999999999999p 5.9502510000000001e-09 146.11249999999998p 7.936304e-09 146.125p 9.9074159999999992e-09 146.13750000000002p 1.1861040000000001e-08 146.15000000000001p 1.379466e-08 146.16250000000002p 1.5705780000000001e-08 146.17499999999998p 1.759195e-08 146.1875p 1.945076e-08 146.19999999999999p 2.1279830000000001e-08 146.21250000000001p 2.3076840000000001e-08 146.22499999999999p 2.4839499999999999e-08 146.23750000000001p 2.656558e-08 146.25p 2.8252909999999999e-08
+ 146.26249999999999p 2.9899359999999998e-08 146.27500000000001p 3.1502869999999999e-08 146.28749999999999p 3.3061429999999999e-08 146.30000000000001p 3.45731e-08 146.3125p 3.6036019999999999e-08 146.32500000000002p 3.7448360000000001e-08 146.33749999999998p 3.8808409999999998e-08 146.34999999999999p 4.0114490000000002e-08 146.36249999999998p 4.1365009999999997e-08 146.375p 4.2558470000000001e-08 146.38749999999999p 4.3693420000000001e-08 146.40000000000001p 4.4768529999999998e-08 146.41250000000002p 4.57825e-08 146.42499999999998p 4.6734150000000002e-08 146.4375p 4.7622380000000003e-08 146.44999999999999p 4.8446169999999997e-08 146.46250000000001p 4.9204580000000001e-08 146.47499999999999p 4.989677e-08
+ 146.48750000000001p 5.0521969999999998e-08 146.5p 5.1079530000000001e-08 146.51249999999999p 5.1568870000000002e-08 146.52500000000001p 5.1989490000000001e-08 146.53749999999999p 5.2341010000000002e-08 146.55000000000001p 5.2623119999999999e-08 146.5625p 5.2835600000000002e-08 146.57500000000002p 5.2978340000000002e-08 146.58750000000001p 5.3051310000000003e-08 146.59999999999999p 5.305456e-08 146.61249999999998p 5.2988260000000001e-08 146.625p 5.2852640000000001e-08 146.63749999999999p 5.2648049999999999e-08 146.65000000000001p 5.2374890000000002e-08 146.66250000000002p 5.2033699999999998e-08 146.67499999999998p 5.162506e-08 146.6875p 5.1149660000000002e-08 146.69999999999999p 5.0608289999999999e-08
+ 146.71250000000001p 5.0001789999999999e-08 146.72499999999999p 4.9331110000000002e-08 146.73750000000001p 4.8597270000000002e-08 146.75p 4.7801380000000001e-08 146.76249999999999p 4.6944610000000003e-08 146.77500000000001p 4.6028239999999997e-08 146.78749999999999p 4.5053579999999999e-08 146.80000000000001p 4.4022060000000001e-08 146.8125p 4.2935139999999999e-08 146.82500000000002p 4.1794379999999999e-08 146.83750000000001p 4.0601400000000003e-08 146.84999999999999p 3.9357869999999999e-08 146.86249999999998p 3.8065539999999997e-08 146.875p 3.6726210000000002e-08 146.88749999999999p 3.534173e-08 146.90000000000001p 3.3914040000000001e-08 146.91249999999999p 3.2445080000000003e-08 146.92500000000001p 3.0936889999999999e-08
+ 146.9375p 2.9391519999999999e-08 146.94999999999999p 2.7811079999999999e-08 146.96250000000001p 2.6197730000000001e-08 146.97499999999999p 2.455364e-08 146.98750000000001p 2.2881050000000001e-08 147p 2.1182200000000002e-08 147.01249999999999p 1.9459390000000001e-08 147.02499999999998p 1.7714920000000001e-08 147.03749999999999p 1.595112e-08 147.05000000000001p 1.4170359999999999e-08 147.0625p 1.2375e-08 147.07500000000002p 1.0567429999999999e-08 147.08750000000001p 8.7500379999999995e-09 147.09999999999999p 6.9252359999999999e-09 147.11249999999998p 5.0954289999999997e-09 147.125p 3.263026e-09 147.13749999999999p 1.430434e-09 147.15000000000001p -3.9994600000000002e-10
+ 147.16249999999999p -2.2257190000000001e-09 147.17500000000001p -4.0445039999999999e-09 147.1875p -5.8539319999999997e-09 147.19999999999999p -7.6516529999999999e-09 147.21250000000001p -9.4353369999999997e-09 147.22499999999999p -1.120268e-08 147.23750000000001p -1.295139e-08 147.25p -1.4679240000000001e-08 147.26250000000002p -1.638399e-08 147.27499999999998p -1.8063459999999999e-08 147.28749999999999p -1.9715519999999999e-08 147.30000000000001p -2.1338039999999998e-08 147.3125p -2.292899e-08 147.32500000000002p -2.4486330000000001e-08 147.33750000000001p -2.6008099999999999e-08 147.34999999999999p -2.7492390000000001e-08 147.36249999999998p -2.8937329999999999e-08 147.375p -3.0341119999999999e-08
+ 147.38749999999999p -3.1702000000000002e-08 147.40000000000001p -3.3018289999999998e-08 147.41249999999999p -3.4288359999999998e-08 147.42500000000001p -3.551065e-08 147.4375p -3.6683659999999997e-08 147.44999999999999p -3.7805969999999998e-08 147.46250000000001p -3.8876200000000001e-08 147.47499999999999p -3.9893079999999998e-08 147.48750000000001p -4.0855390000000003e-08 147.5p -4.1761980000000001e-08 147.51250000000002p -4.26118e-08 147.52499999999998p -4.3403850000000001e-08 147.53749999999999p -4.4137219999999997e-08 147.54999999999998p -4.4811089999999999e-08 147.5625p -4.5424680000000002e-08 147.57500000000002p -4.5977350000000001e-08 147.58750000000001p -4.646849e-08 147.60000000000002p -4.6897590000000002e-08
+ 147.61249999999998p -4.7264229999999999e-08 147.625p -4.7568070000000002e-08 147.63749999999999p -4.780885e-08 147.65000000000001p -4.7986390000000002e-08 147.66249999999999p -4.8100589999999997e-08 147.67500000000001p -4.815144e-08 147.6875p -4.8139030000000001e-08 147.69999999999999p -4.8063490000000002e-08 147.71250000000001p -4.792508e-08 147.72499999999999p -4.772411e-08 147.73750000000001p -4.7460970000000001e-08 147.75p -4.7136159999999997e-08 147.76250000000002p -4.6750240000000002e-08 147.77499999999998p -4.6303839999999998e-08 147.78749999999999p -4.5797680000000001e-08 147.79999999999998p -4.5232559999999997e-08 147.8125p -4.4609349999999998e-08 147.82500000000002p -4.3928989999999999e-08
+ 147.83750000000001p -4.3192500000000001e-08 147.85000000000002p -4.2400970000000001e-08 147.86249999999998p -4.1555559999999997e-08 147.875p -4.0657499999999999e-08 147.88749999999999p -3.970808e-08 147.90000000000001p -3.870865e-08 147.91249999999999p -3.766064e-08 147.92500000000001p -3.656553e-08 147.9375p -3.5424860000000003e-08 147.94999999999999p -3.4240230000000001e-08 147.96250000000001p -3.3013269999999999e-08 147.97499999999999p -3.1745709999999999e-08 147.98750000000001p -3.0439289999999999e-08 148p -2.90958e-08 148.01250000000002p -2.7717100000000001e-08 148.02499999999998p -2.6305059999999999e-08 148.03749999999999p -2.4861619999999999e-08 148.04999999999998p -2.3388729999999998e-08
+ 148.0625p -2.1888399999999999e-08 148.07500000000002p -2.0362639999999999e-08 148.08750000000001p -1.8813530000000001e-08 148.10000000000002p -1.7243129999999999e-08 148.11249999999998p -1.5653560000000001e-08 148.125p -1.4046950000000001e-08 148.13749999999999p -1.242543e-08 148.15000000000001p -1.079118e-08 148.16249999999999p -9.1463610000000006e-09 148.17500000000001p -7.4931540000000008e-09 148.1875p -5.8337480000000002e-09 148.19999999999999p -4.170334e-09 148.21250000000001p -2.5051020000000002e-09 148.22499999999999p -8.4024280000000005e-10 148.23750000000001p 8.2206160000000005e-10 148.25p 2.479635e-09 148.26250000000002p 4.1303130000000001e-09 148.27500000000001p 5.7719450000000002e-09
+ 148.28749999999999p 7.4023960000000004e-09 148.29999999999998p 9.0195509999999998e-09 148.3125p 1.0621320000000001e-08 148.32499999999999p 1.220563e-08 148.33750000000001p 1.377044e-08 148.35000000000002p 1.5313740000000001e-08 148.36249999999998p 1.6833559999999999e-08 148.375p 1.8327950000000001e-08 148.38749999999999p 1.9795e-08 148.40000000000001p 2.1232840000000001e-08 148.41249999999999p 2.263967e-08 148.42500000000001p 2.401369e-08 148.4375p 2.535317e-08 148.44999999999999p 2.6656439999999999e-08 148.46250000000001p 2.7921849999999999e-08 148.47499999999999p 2.9147839999999999e-08 148.48750000000001p 3.0332879999999999e-08 148.5p 3.147549e-08
+ 148.51250000000002p 3.2574280000000001e-08 148.52500000000001p 3.3627900000000003e-08 148.53749999999999p 3.4635059999999998e-08 148.54999999999998p 3.5594540000000001e-08 148.5625p 3.6505190000000003e-08 148.57499999999999p 3.7365910000000003e-08 148.58750000000001p 3.8175689999999998e-08 148.60000000000002p 3.8933560000000002e-08 148.61250000000001p 3.9638659999999999e-08 148.625p 4.0290159999999997e-08 148.63749999999999p 4.088733e-08 148.65000000000001p 4.1429500000000001e-08 148.66249999999999p 4.1916080000000002e-08 148.67500000000001p 4.2346549999999997e-08 148.6875p 4.2720469999999999e-08 148.69999999999999p 4.3037459999999998e-08 148.71250000000001p 4.3297239999999998e-08 148.72499999999999p 4.3499579999999998e-08
+ 148.73750000000001p 4.3644350000000003e-08 148.75p 4.3731479999999997e-08 148.76250000000002p 4.3760970000000001e-08 148.77500000000001p 4.373292e-08 148.78749999999999p 4.3647480000000001e-08 148.79999999999998p 4.3504890000000003e-08 148.8125p 4.3305459999999997e-08 148.82499999999999p 4.3049579999999997e-08 148.83750000000001p 4.2737690000000002e-08 148.84999999999999p 4.2370339999999997e-08 148.86250000000001p 4.1948130000000001e-08 148.875p 4.1471710000000003e-08 148.88749999999999p 4.0941850000000002e-08 148.90000000000001p 4.035934e-08 148.91249999999999p 3.9725070000000002e-08 148.92500000000001p 3.9039979999999998e-08 148.9375p 3.8305079999999997e-08 148.94999999999999p 3.7521439999999997e-08
+ 148.96249999999998p 3.6690199999999997e-08 148.97499999999999p 3.581255e-08 148.98750000000001p 3.4889729999999997e-08 149p 3.3923070000000001e-08 149.01250000000002p 3.291392e-08 149.02500000000001p 3.186371e-08 149.03749999999999p 3.0773889999999999e-08 149.04999999999998p 2.964599e-08 149.0625p 2.8481559999999999e-08 149.07499999999999p 2.728223e-08 149.08750000000001p 2.604963e-08 149.09999999999999p 2.4785460000000001e-08 149.11250000000001p 2.349144e-08 149.125p 2.2169350000000001e-08 149.13749999999999p 2.0820969999999999e-08 149.15000000000001p 1.9448140000000001e-08 149.16249999999999p 1.805272e-08 149.17500000000001p 1.663658e-08
+ 149.1875p 1.5201630000000001e-08 149.20000000000002p 1.374979e-08 149.21249999999998p 1.228302e-08 149.22499999999999p 1.0803259999999999e-08 149.23750000000001p 9.3124979999999992e-09 149.25p 7.8127110000000007e-09 149.26250000000002p 6.3058889999999997e-09 149.27500000000001p 4.7940279999999996e-09 149.28749999999999p 3.279126e-09 149.29999999999998p 1.763181e-09 149.3125p 2.4818719999999998e-10 149.32499999999999p -1.263867e-09 149.33750000000001p -2.7709990000000001e-09 149.34999999999999p -4.2712400000000002e-09 149.36250000000001p -5.7626309999999999e-09 149.375p -7.2432329999999997e-09 149.38749999999999p -8.7111230000000005e-09 149.40000000000001p -1.0164399999999999e-08
+ 149.41249999999999p -1.160118e-08 149.42500000000001p -1.301961e-08 149.4375p -1.441788e-08 149.45000000000002p -1.579418e-08 149.46249999999998p -1.7146750000000001e-08 149.47499999999999p -1.8473869999999999e-08 149.48749999999998p -1.9773840000000001e-08 149.5p -2.104503e-08 149.51250000000002p -2.2285810000000001e-08 149.52500000000001p -2.3494630000000001e-08 149.53750000000002p -2.4669959999999999e-08 149.54999999999998p -2.581034e-08 149.5625p -2.6914340000000001e-08 149.57499999999999p -2.7980579999999999e-08 149.58750000000001p -2.900776e-08 149.59999999999999p -2.999461e-08 149.61250000000001p -3.0939910000000002e-08 149.625p -3.1842509999999999e-08
+ 149.63749999999999p -3.2701339999999999e-08 149.65000000000001p -3.3515340000000002e-08 149.66249999999999p -3.428355e-08 149.67500000000001p -3.5005069999999997e-08 149.6875p -3.5679039999999998e-08 149.70000000000002p -3.6304679999999997e-08 149.71249999999998p -3.6881289999999998e-08 149.72499999999999p -3.7408210000000001e-08 149.73749999999998p -3.788486e-08 149.75p -3.8310720000000001e-08 149.76250000000002p -3.8685349999999998e-08 149.77500000000001p -3.9008380000000003e-08 149.78750000000002p -3.9279479999999998e-08 149.79999999999998p -3.9498420000000002e-08 149.8125p -3.9665039999999998e-08 149.82499999999999p -3.9779219999999999e-08 149.83750000000001p -3.9840950000000003e-08 149.84999999999999p -3.985024e-08
+ 149.86250000000001p -3.9807210000000001e-08 149.875p -3.9712039999999998e-08 149.88749999999999p -3.9564970000000001e-08 149.90000000000001p -3.93663e-08 149.91249999999999p -3.9116419999999999e-08 149.92500000000001p -3.8815770000000001e-08 149.9375p -3.8464849999999999e-08 149.95000000000002p -3.8064259999999999e-08 149.96249999999998p -3.7614609999999998e-08 149.97499999999999p -3.7116630000000002e-08 149.98749999999998p -3.6571060000000003e-08 150p -3.597875e-08 150.01249999999999p -3.5340559999999997e-08 150.02500000000001p -3.4657450000000002e-08 150.03750000000002p -3.3930420000000002e-08 150.04999999999998p -3.3160520000000001e-08 150.0625p -3.2348849999999999e-08 150.07499999999999p -3.1496590000000002e-08
+ 150.08750000000001p -3.0604949999999999e-08 150.09999999999999p -2.9675180000000001e-08 150.11250000000001p -2.8708600000000001e-08 150.125p -2.770655e-08 150.13749999999999p -2.6670440000000001e-08 150.15000000000001p -2.560171e-08 150.16249999999999p -2.4501829999999999e-08 150.17500000000001p -2.3372329999999998e-08 150.1875p -2.2214740000000001e-08 150.20000000000002p -2.1030659999999999e-08 150.21250000000001p -1.9821700000000001e-08 150.22499999999999p -1.8589499999999999e-08 150.23749999999998p -1.733574e-08 150.25p -1.606211e-08 150.26249999999999p -1.477033e-08 150.27500000000001p -1.346214e-08 150.28750000000002p -1.213928e-08 150.29999999999998p -1.0803539999999999e-08
+ 150.3125p -9.4566800000000005e-09 150.32499999999999p -8.1005060000000006e-09 150.33750000000001p -6.736815e-09 150.34999999999999p -5.3674130000000003e-09 150.36250000000001p -3.9941070000000003e-09 150.375p -2.6187069999999998e-09 150.38749999999999p -1.2430219999999999e-09 150.40000000000001p 1.3114539999999999e-10 150.41249999999999p 1.501998e-09 150.42500000000001p 2.8677460000000001e-09 150.4375p 4.2266130000000003e-09 150.45000000000002p 5.5768340000000001e-09 150.46250000000001p 6.9166610000000003e-09 150.47499999999999p 8.2443639999999995e-09 150.48749999999998p 9.5582300000000008e-09 150.5p 1.0856569999999999e-08 150.51249999999999p 1.2137729999999999e-08 150.52500000000001p 1.340006e-08
+ 150.53750000000002p 1.464196e-08 150.55000000000001p 1.5861839999999999e-08 150.5625p 1.7058170000000001e-08 150.57499999999999p 1.8229429999999999e-08 150.58750000000001p 1.937415e-08 150.59999999999999p 2.0490899999999999e-08 150.61250000000001p 2.157827e-08 150.625p 2.2634910000000002e-08 150.63749999999999p 2.3659510000000001e-08 150.65000000000001p 2.4650819999999999e-08 150.66249999999999p 2.5607600000000002e-08 150.67500000000001p 2.6528689999999999e-08 150.6875p 2.7412969999999999e-08 150.70000000000002p 2.8259360000000001e-08 150.71250000000001p 2.906685e-08 150.72499999999999p 2.9834480000000002e-08 150.73749999999998p 3.0561320000000001e-08 150.75p 3.1246540000000001e-08
+ 150.76249999999999p 3.1889319999999998e-08 150.77500000000001p 3.2488940000000001e-08 150.78749999999999p 3.3044690000000003e-08 150.80000000000001p 3.3555970000000003e-08 150.8125p 3.4022209999999999e-08 150.82499999999999p 3.4442889999999997e-08 150.83750000000001p 3.481758e-08 150.84999999999999p 3.5145899999999997e-08 150.86250000000001p 3.5427519999999997e-08 150.875p 3.5662180000000003e-08 150.88750000000002p 3.5849679999999997e-08 150.89999999999998p 3.5989900000000001e-08 150.91249999999999p 3.6082749999999999e-08 150.92500000000001p 3.6128220000000002e-08 150.9375p 3.6126359999999998e-08 150.95000000000002p 3.6077289999999999e-08 150.96250000000001p 3.5981169999999998e-08 150.97499999999999p 3.5838239999999997e-08
+ 150.98749999999998p 3.5648790000000003e-08 151p 3.5413179999999999e-08 151.01249999999999p 3.5131820000000002e-08 151.02500000000001p 3.4805170000000001e-08 151.03749999999999p 3.4433779999999999e-08 151.05000000000001p 3.4018219999999998e-08 151.0625p 3.3559140000000001e-08 151.07499999999999p 3.305724e-08 151.08750000000001p 3.2513270000000001e-08 151.09999999999999p 3.192802e-08 151.11250000000001p 3.1302369999999997e-08 151.125p 3.0637209999999999e-08 151.13750000000002p 2.9933509999999998e-08 151.14999999999998p 2.9192270000000001e-08 151.16249999999999p 2.8414529999999999e-08 151.17500000000001p 2.7601399999999999e-08 151.1875p 2.6754019999999999e-08 151.20000000000002p 2.5873559999999999e-08
+ 151.21250000000001p 2.4961250000000001e-08 151.22500000000002p 2.4018349999999999e-08 151.23749999999998p 2.3046170000000001e-08 151.25p 2.2046020000000001e-08 151.26249999999999p 2.1019280000000001e-08 151.27500000000001p 1.9967339999999999e-08 151.28749999999999p 1.8891639999999999e-08 151.30000000000001p 1.7793630000000002e-08 151.3125p 1.6674790000000001e-08 151.32499999999999p 1.553662e-08 151.33750000000001p 1.4380660000000001e-08 151.34999999999999p 1.320844e-08 151.36250000000001p 1.2021540000000001e-08 151.375p 1.082153e-08 151.38750000000002p 9.6100139999999992e-09 151.39999999999998p 8.3885860000000003e-09 151.41249999999999p 7.1588660000000001e-09 151.42499999999998p 5.9224750000000001e-09
+ 151.4375p 4.681042e-09 151.45000000000002p 3.4361949999999998e-09 151.46250000000001p 2.1895659999999999e-09 151.47500000000002p 9.4278589999999994e-10 151.48749999999998p -3.0251920000000001e-10 151.5p -1.5447280000000001e-09 151.51249999999999p -2.7822260000000002e-09 151.52500000000001p -4.0134089999999998e-09 151.53749999999999p -5.2366849999999997e-09 151.55000000000001p -6.4504749999999999e-09 151.5625p -7.6532139999999995e-09 151.57499999999999p -8.8433580000000001e-09 151.58750000000001p -1.0019380000000001e-08 151.59999999999999p -1.1179779999999999e-08 151.61250000000001p -1.232307e-08 151.625p -1.344779e-08 151.63750000000002p -1.455253e-08 151.64999999999998p -1.563587e-08
+ 151.66249999999999p -1.669646e-08 151.67499999999998p -1.7732950000000001e-08 151.6875p -1.8744049999999998e-08 151.70000000000002p -1.9728480000000001e-08 151.71250000000001p -2.0685019999999999e-08 151.72500000000002p -2.1612479999999999e-08 151.73749999999998p -2.2509710000000001e-08 151.75p -2.3375609999999998e-08 151.76249999999999p -2.4209100000000001e-08 151.77500000000001p -2.500917e-08 151.78749999999999p -2.5774839999999999e-08 151.80000000000001p -2.6505189999999999e-08 151.8125p -2.719933e-08 151.82499999999999p -2.7856449999999999e-08 151.83750000000001p -2.8475749999999999e-08 151.84999999999999p -2.9056499999999999e-08 151.86250000000001p -2.9598040000000001e-08 151.875p -3.0099729999999998e-08
+ 151.88750000000002p -3.0561010000000001e-08 151.89999999999998p -3.0981349999999997e-08 151.91249999999999p -3.1360289999999997e-08 151.92499999999998p -3.1697439999999997e-08 151.9375p -3.1992420000000001e-08 151.94999999999999p -3.2244949999999999e-08 151.96250000000001p -3.2454779999999998e-08 151.97500000000002p -3.2621740000000002e-08 151.98749999999998p -3.2745690000000001e-08 152p -3.2826570000000002e-08 152.01249999999999p -3.2864350000000001e-08 152.02500000000001p -3.2859080000000002e-08 152.03749999999999p -3.2810859999999997e-08 152.05000000000001p -3.271984e-08 152.0625p -3.2586229999999999e-08 152.07499999999999p -3.2410289999999997e-08 152.08750000000001p -3.219235e-08 152.09999999999999p -3.1932780000000001e-08
+ 152.11250000000001p -3.1632009999999998e-08 152.125p -3.1290519999999998e-08 152.13750000000002p -3.0908830000000001e-08 152.15000000000001p -3.0487549999999997e-08 152.16249999999999p -3.0027290000000001e-08 152.17499999999998p -2.9528759999999999e-08 152.1875p -2.8992670000000001e-08 152.19999999999999p -2.8419820000000001e-08 152.21250000000001p -2.781102e-08 152.22500000000002p -2.7167159999999999e-08 152.23749999999998p -2.6489160000000001e-08 152.25p -2.5777960000000001e-08 152.26249999999999p -2.5034590000000001e-08 152.27500000000001p -2.4260069999999999e-08 152.28749999999999p -2.3455480000000001e-08 152.30000000000001p -2.2621959999999999e-08 152.3125p -2.176064e-08 152.32499999999999p -2.0872730000000001e-08
+ 152.33750000000001p -1.9959429999999998e-08 152.34999999999999p -1.9022e-08 152.36250000000001p -1.806172e-08 152.375p -1.7079899999999999e-08 152.38750000000002p -1.6077869999999998e-08 152.40000000000001p -1.5056980000000001e-08 152.41249999999999p -1.4018619999999999e-08 152.42499999999998p -1.2964180000000001e-08 152.4375p -1.1895090000000001e-08 152.44999999999999p -1.081276e-08 152.46250000000001p -9.7186610000000003e-09 152.47500000000002p -8.6142390000000003e-09 152.48750000000001p -7.5009669999999999e-09 152.5p -6.3803239999999998e-09 152.51249999999999p -5.2537959999999998e-09 152.52500000000001p -4.1228710000000002e-09 152.53749999999999p -2.989043e-09 152.55000000000001p -1.853804e-09
+ 152.5625p -7.1864669999999998e-10 152.57499999999999p 4.1494149999999998e-10 152.58749999999998p 1.545477e-09 152.59999999999999p 2.6714849999999999e-09 152.61250000000001p 3.7914970000000003e-09 152.625p 4.9040579999999999e-09 152.63750000000002p 6.007725e-09 152.65000000000001p 7.1010709999999997e-09 152.66249999999999p 8.1826839999999997e-09 152.67499999999998p 9.2511699999999992e-09 152.6875p 1.030516e-08 152.69999999999999p 1.1343300000000001e-08 152.71250000000001p 1.2364259999999999e-08 152.72499999999999p 1.336674e-08 152.73750000000001p 1.4349469999999999e-08 152.75p 1.5311210000000001e-08 152.76249999999999p 1.6250730000000001e-08 152.77500000000001p 1.7166859999999999e-08
+ 152.78749999999999p 1.805844e-08 152.80000000000001p 1.892435e-08 152.8125p 1.976353e-08 152.82500000000002p 2.0574920000000002e-08 152.83749999999998p 2.1357530000000001e-08 152.84999999999999p 2.2110389999999999e-08 152.86250000000001p 2.2832579999999999e-08 152.875p 2.3523219999999999e-08 152.88750000000002p 2.4181480000000001e-08 152.90000000000001p 2.480656e-08 152.91249999999999p 2.539771e-08 152.92499999999998p 2.5954239999999999e-08 152.9375p 2.6475500000000001e-08 152.94999999999999p 2.6960870000000001e-08 152.96250000000001p 2.7409810000000001e-08 152.97499999999999p 2.7821799999999998e-08 152.98750000000001p 2.8196379999999999e-08 153p 2.853316e-08
+ 153.01249999999999p 2.8831759999999999e-08 153.02500000000001p 2.9091890000000001e-08 153.03749999999999p 2.9313289999999999e-08 153.05000000000001p 2.9495760000000001e-08 153.0625p 2.963914e-08 153.07500000000002p 2.974333e-08 153.08749999999998p 2.9808280000000001e-08 153.09999999999999p 2.9834009999999998e-08 153.11250000000001p 2.9820550000000002e-08 153.125p 2.9768029999999999e-08 153.13750000000002p 2.967658e-08 153.15000000000001p 2.954643e-08 153.16250000000002p 2.9377829999999999e-08 153.17499999999998p 2.9171079999999999e-08 153.1875p 2.892655e-08 153.19999999999999p 2.864464e-08 153.21250000000001p 2.8325800000000001e-08 153.22499999999999p 2.7970539999999998e-08
+ 153.23750000000001p 2.75794e-08 153.25p 2.7152979999999999e-08 153.26249999999999p 2.6691919999999999e-08 153.27500000000001p 2.6196890000000001e-08 153.28749999999999p 2.5668640000000001e-08 153.30000000000001p 2.510791e-08 153.3125p 2.4515529999999998e-08 153.32500000000002p 2.3892339999999999e-08 153.33749999999998p 2.3239230000000001e-08 153.34999999999999p 2.255712e-08 153.36249999999998p 2.1846970000000001e-08 153.375p 2.1109790000000001e-08 153.38750000000002p 2.0346589999999998e-08 153.40000000000001p 1.955843e-08 153.41250000000002p 1.874641e-08 153.42499999999998p 1.7911649999999999e-08 153.4375p 1.7055289999999999e-08 153.44999999999999p 1.6178510000000001e-08
+ 153.46250000000001p 1.5282490000000001e-08 153.47499999999999p 1.4368469999999999e-08 153.48750000000001p 1.343768e-08 153.5p 1.249137e-08 153.51249999999999p 1.153083e-08 153.52500000000001p 1.0557350000000001e-08 153.53749999999999p 9.5722289999999998e-09 153.55000000000001p 8.5767909999999992e-09 153.5625p 7.5723650000000005e-09 153.57500000000002p 6.5602879999999997e-09 153.58749999999998p 5.5419049999999996e-09 153.59999999999999p 4.5185669999999999e-09 153.61249999999998p 3.4916259999999998e-09 153.625p 2.4624379999999998e-09 153.63750000000002p 1.4323590000000001e-09 153.65000000000001p 4.0274040000000002e-10 153.66250000000002p -6.2506690000000004e-10 153.67499999999998p -1.6497190000000001e-09
+ 153.6875p -2.6698799999999999e-09 153.69999999999999p -3.6842209999999998e-09 153.71250000000001p -4.6914239999999999e-09 153.72499999999999p -5.6901850000000002e-09 153.73750000000001p -6.6792140000000002e-09 153.75p -7.6572330000000002e-09 153.76249999999999p -8.6229869999999997e-09 153.77500000000001p -9.5752350000000002e-09 153.78749999999999p -1.0512760000000001e-08 153.80000000000001p -1.1434360000000001e-08 153.8125p -1.233888e-08 153.82500000000002p -1.3225150000000001e-08 153.83750000000001p -1.4092060000000001e-08 153.84999999999999p -1.4938510000000002e-08 153.86249999999998p -1.5763440000000002e-08 153.875p -1.656583e-08 153.88749999999999p -1.7344660000000002e-08 153.90000000000001p -1.8098969999999999e-08
+ 153.91250000000002p -1.882782e-08 153.92499999999998p -1.953032e-08 153.9375p -2.0205600000000001e-08 153.94999999999999p -2.085285e-08 153.96250000000001p -2.1471270000000001e-08 153.97499999999999p -2.2060119999999999e-08 153.98750000000001p -2.2618689999999999e-08 154p -2.314633e-08 154.01249999999999p -2.3642399999999999e-08 154.02500000000001p -2.410634e-08 154.03749999999999p -2.4537599999999999e-08 154.05000000000001p -2.493569e-08 154.0625p -2.5300169999999999e-08 154.07500000000002p -2.5630630000000001e-08 154.08750000000001p -2.5926720000000001e-08 154.09999999999999p -2.6188130000000001e-08 154.11249999999998p -2.641459e-08 154.125p -2.6605890000000001e-08
+ 154.13749999999999p -2.676186e-08 154.15000000000001p -2.6882370000000001e-08 154.16250000000002p -2.6967339999999998e-08 154.17499999999998p -2.7016749999999999e-08 154.1875p -2.703061e-08 154.19999999999999p -2.7008980000000001e-08 154.21250000000001p -2.6951979999999999e-08 154.22499999999999p -2.685975e-08 154.23750000000001p -2.6732510000000001e-08 154.25p -2.657049e-08 154.26249999999999p -2.6373989999999999e-08 154.27500000000001p -2.614335e-08 154.28749999999999p -2.587894e-08 154.30000000000001p -2.558119e-08 154.3125p -2.5250570000000001e-08 154.32500000000002p -2.4887589999999999e-08 154.33750000000001p -2.4492789999999999e-08 154.34999999999999p -2.4066769999999999e-08
+ 154.36249999999998p -2.3610159999999999e-08 154.375p -2.312362e-08 154.38749999999999p -2.2607870000000001e-08 154.40000000000001p -2.2063639999999999e-08 154.41249999999999p -2.1491720000000002e-08 154.42500000000001p -2.0892930000000001e-08 154.4375p -2.0268099999999999e-08 154.44999999999999p -1.9618119999999999e-08 154.46250000000001p -1.8943889999999999e-08 154.47499999999999p -1.8246369999999999e-08 154.48750000000001p -1.7526510000000001e-08 154.5p -1.6785310000000001e-08 154.51249999999999p -1.6023800000000001e-08 154.52499999999998p -1.5243019999999999e-08 154.53749999999999p -1.444404e-08 154.55000000000001p -1.362795e-08 154.5625p -1.2795859999999999e-08 154.57500000000002p -1.194889e-08
+ 154.58750000000001p -1.1088200000000001e-08 154.59999999999999p -1.021495e-08 154.61249999999998p -9.3302999999999995e-09 154.625p -8.4354510000000006e-09 154.63749999999999p -7.5315969999999998e-09 154.65000000000001p -6.6199440000000002e-09 154.66249999999999p -5.7017060000000001e-09 154.67500000000001p -4.7781039999999999e-09 154.6875p -3.8503620000000002e-09 154.69999999999999p -2.919706e-09 154.71250000000001p -1.9873659999999999e-09 154.72499999999999p -1.054568e-09 154.73750000000001p -1.2253760000000001e-10 154.75p 8.0750410000000002e-10 154.76250000000002p 1.7343409999999999e-09 154.77499999999998p 2.6567650000000002e-09 154.78749999999999p 3.5735740000000001e-09 154.80000000000001p 4.4835799999999999e-09
+ 154.8125p 5.3856030000000002e-09 154.82500000000002p 6.2784780000000002e-09 154.83750000000001p 7.1610540000000002e-09 154.84999999999999p 8.0321970000000003e-09 154.86249999999998p 8.8907899999999992e-09 154.875p 9.7357360000000005e-09 154.88749999999999p 1.0565960000000001e-08 154.90000000000001p 1.13804e-08 154.91249999999999p 1.217802e-08 154.92500000000001p 1.295783e-08 154.9375p 1.3718830000000001e-08 154.94999999999999p 1.4460069999999999e-08 154.96250000000001p 1.518063e-08 154.97499999999999p 1.5879599999999999e-08 154.98750000000001p 1.6556120000000001e-08 155p 1.7209350000000001e-08 155.01250000000002p 1.7838500000000001e-08 155.02499999999998p 1.8442780000000001e-08
+ 155.03749999999999p 1.902146e-08 155.04999999999998p 1.9573849999999999e-08 155.0625p 2.009927e-08 155.07500000000002p 2.0597100000000001e-08 155.08750000000001p 2.1066759999999999e-08 155.10000000000002p 2.150768e-08 155.11249999999998p 2.1919360000000002e-08 155.125p 2.2301319999999998e-08 155.13749999999999p 2.2653139999999999e-08 155.15000000000001p 2.2974409999999999e-08 155.16249999999999p 2.3264789999999999e-08 155.17500000000001p 2.352396e-08 155.1875p 2.3751670000000001e-08 155.19999999999999p 2.3947670000000001e-08 155.21250000000001p 2.411179e-08 155.22499999999999p 2.424389e-08 155.23750000000001p 2.4343860000000001e-08 155.25p 2.4411660000000001e-08
+ 155.26250000000002p 2.4447250000000001e-08 155.27499999999998p 2.4450669999999999e-08 155.28749999999999p 2.4421989999999999e-08 155.29999999999998p 2.4361320000000002e-08 155.3125p 2.4268819999999999e-08 155.32500000000002p 2.414467e-08 155.33750000000001p 2.3989119999999999e-08 155.35000000000002p 2.3802429999999998e-08 155.36249999999998p 2.358493e-08 155.375p 2.333696e-08 155.38749999999999p 2.3058939999999999e-08 155.40000000000001p 2.275128e-08 155.41249999999999p 2.2414459999999999e-08 155.42500000000001p 2.2049000000000001e-08 155.4375p 2.1655419999999999e-08 155.44999999999999p 2.123432e-08 155.46250000000001p 2.0786310000000001e-08 155.47499999999999p 2.031204e-08
+ 155.48750000000001p 1.981219e-08 155.5p 1.928748e-08 155.51250000000002p 1.8738640000000001e-08 155.52499999999998p 1.816646e-08 155.53749999999999p 1.757174e-08 155.54999999999998p 1.6955310000000001e-08 155.5625p 1.6318030000000001e-08 155.57500000000002p 1.566078e-08 155.58750000000001p 1.4984470000000001e-08 155.60000000000002p 1.4290020000000001e-08 155.61249999999998p 1.3578409999999999e-08 155.625p 1.2850580000000001e-08 155.63749999999999p 1.2107540000000001e-08 155.65000000000001p 1.13503e-08 155.66249999999999p 1.0579879999999999e-08 155.67500000000001p 9.7973140000000008e-09 155.6875p 9.0036680000000008e-09 155.69999999999999p 8.2000029999999999e-09
+ 155.71250000000001p 7.3873949999999996e-09 155.72499999999999p 6.566932e-09 155.73750000000001p 5.7397060000000002e-09 155.75p 4.9068189999999999e-09 155.76250000000002p 4.069374e-09 155.77500000000001p 3.2284809999999999e-09 155.78749999999999p 2.3852499999999998e-09 155.79999999999998p 1.5407929999999999e-09 155.8125p 6.9621820000000005e-10 155.82499999999999p -1.4736509999999999e-10 155.83750000000001p -9.888534e-10 155.85000000000002p -1.827148e-09 155.86249999999998p -2.6611569999999998e-09 155.875p -3.489797e-09 155.88749999999999p -4.3119939999999997e-09 155.90000000000001p -5.126683e-09 155.91249999999999p -5.9328140000000004e-09 155.92500000000001p -6.7293500000000001e-09
+ 155.9375p -7.5152670000000005e-09 155.94999999999999p -8.2895600000000005e-09 155.96250000000001p -9.0512399999999999e-09 155.97499999999999p -9.7993370000000005e-09 155.98750000000001p -1.05329e-08 156p -1.1250999999999999e-08 156.01250000000002p -1.1952739999999999e-08 156.02500000000001p -1.263722e-08 156.03749999999999p -1.330359e-08 156.04999999999998p -1.395102e-08 156.0625p -1.457871e-08 156.07499999999999p -1.5185869999999999e-08 156.08750000000001p -1.577175e-08 156.10000000000002p -1.6335639999999999e-08 156.11250000000001p -1.6876840000000001e-08 156.125p -1.7394710000000001e-08 156.13749999999999p -1.78886e-08 156.15000000000001p -1.8357939999999999e-08
+ 156.16249999999999p -1.880215e-08 156.17500000000001p -1.9220720000000001e-08 156.1875p -1.961315e-08 156.19999999999999p -1.997899e-08 156.21250000000001p -2.0317819999999999e-08 156.22499999999999p -2.0629259999999999e-08 156.23750000000001p -2.0912950000000001e-08 156.25p -2.1168600000000001e-08 156.26250000000002p -2.1395919999999999e-08 156.27500000000001p -2.159469e-08 156.28749999999999p -2.176471e-08 156.29999999999998p -2.190582e-08 156.3125p -2.201791e-08 156.32499999999999p -2.2100879999999999e-08 156.33750000000001p -2.2154699999999999e-08 156.34999999999999p -2.2179359999999999e-08 156.36250000000001p -2.21749e-08 156.375p -2.2141390000000001e-08
+ 156.38749999999999p -2.207893e-08 156.40000000000001p -2.1987679999999999e-08 156.41249999999999p -2.186782e-08 156.42500000000001p -2.1719560000000001e-08 156.4375p -2.1543180000000001e-08 156.45000000000002p -2.1338950000000001e-08 156.46249999999998p -2.1107219999999999e-08 156.47499999999999p -2.0848350000000002e-08 156.48750000000001p -2.056273e-08 156.5p -2.0250809999999999e-08 156.51250000000002p -1.9913040000000001e-08 156.52500000000001p -1.954994e-08 156.53749999999999p -1.9162029999999999e-08 156.54999999999998p -1.8749880000000001e-08 156.5625p -1.831407e-08 156.57499999999999p -1.785524e-08 156.58750000000001p -1.737404e-08 156.59999999999999p -1.6871140000000001e-08
+ 156.61250000000001p -1.6347260000000001e-08 156.625p -1.5803120000000001e-08 156.63749999999999p -1.5239489999999999e-08 156.65000000000001p -1.465715e-08 156.66249999999999p -1.4056899999999999e-08 156.67500000000001p -1.343956e-08 156.6875p -1.2805990000000001e-08 156.70000000000002p -1.215704e-08 156.71249999999998p -1.149361e-08 156.72499999999999p -1.081659e-08 156.73750000000001p -1.01269e-08 156.75p -9.4254790000000005e-09 156.76250000000002p -8.7132579999999995e-09 156.77500000000001p -7.9911999999999995e-09 156.78749999999999p -7.2602709999999997e-09 156.79999999999998p -6.5214479999999998e-09 156.8125p -5.775715e-09 156.82499999999999p -5.0240639999999997e-09
+ 156.83750000000001p -4.2674919999999999e-09 156.84999999999999p -3.5070009999999999e-09 156.86250000000001p -2.7435940000000001e-09 156.875p -1.9782770000000002e-09 156.88749999999999p -1.2120549999999999e-09 156.90000000000001p -4.4593500000000002e-10 156.91249999999999p 3.1908189999999998e-10 156.92500000000001p 1.0819970000000001e-09 156.9375p 1.841815e-09 156.95000000000002p 2.59755e-09 156.96249999999998p 3.3482199999999998e-09 156.97499999999999p 4.0928560000000002e-09 156.98749999999998p 4.8304949999999999e-09 157p 5.5601869999999999e-09 157.01250000000002p 6.2809950000000002e-09 157.02500000000001p 6.9919949999999999e-09 157.03750000000002p 7.6922779999999996e-09 157.04999999999998p 8.3809499999999997e-09
+ 157.0625p 9.0571370000000003e-09 157.07499999999999p 9.7199800000000006e-09 157.08750000000001p 1.0368639999999999e-08 157.09999999999999p 1.10023e-08 157.11250000000001p 1.1620160000000001e-08 157.125p 1.222146e-08 157.13749999999999p 1.2805429999999999e-08 157.15000000000001p 1.337135e-08 157.16249999999999p 1.391852e-08 157.17500000000001p 1.4446270000000001e-08 157.1875p 1.495394e-08 157.20000000000002p 1.544091e-08 157.21249999999998p 1.59066e-08 157.22499999999999p 1.6350439999999999e-08 157.23749999999998p 1.6771890000000001e-08 157.25p 1.7170459999999999e-08 157.26250000000002p 1.7545660000000001e-08 157.27500000000001p 1.7897060000000001e-08
+ 157.28750000000002p 1.8224249999999999e-08 157.29999999999998p 1.852685e-08 157.3125p 1.8804530000000001e-08 157.32499999999999p 1.905696e-08 157.33750000000001p 1.9283870000000001e-08 157.34999999999999p 1.9485029999999998e-08 157.36250000000001p 1.9660219999999999e-08 157.375p 1.9809269999999999e-08 157.38749999999999p 1.9932039999999999e-08 157.40000000000001p 2.0028420000000001e-08 157.41249999999999p 2.0098340000000002e-08 157.42500000000001p 2.0141779999999999e-08 157.4375p 2.0158719999999999e-08 157.45000000000002p 2.0149210000000001e-08 157.46249999999998p 2.0113299999999999e-08 157.47499999999999p 2.0051110000000001e-08 157.48749999999998p 1.9962770000000001e-08 157.5p 1.9848460000000001e-08
+ 157.51249999999999p 1.9708369999999999e-08 157.52500000000001p 1.9542740000000002e-08 157.53750000000002p 1.9351849999999999e-08 157.54999999999998p 1.913599e-08 157.5625p 1.8895509999999999e-08 157.57499999999999p 1.8630769999999999e-08 157.58750000000001p 1.8342170000000001e-08 157.59999999999999p 1.8030129999999998e-08 157.61250000000001p 1.7695119999999999e-08 157.625p 1.7337610000000001e-08 157.63749999999999p 1.695814e-08 157.65000000000001p 1.6557230000000001e-08 157.66249999999999p 1.613546e-08 157.67500000000001p 1.5693419999999999e-08 157.6875p 1.523174e-08 157.70000000000002p 1.475107e-08 157.71250000000001p 1.425206e-08 157.72499999999999p 1.373542e-08
+ 157.73749999999998p 1.320186e-08 157.75p 1.265211e-08 157.76249999999999p 1.208692e-08 157.77500000000001p 1.1507080000000001e-08 157.78750000000002p 1.091336e-08 157.79999999999998p 1.0306579999999999e-08 157.8125p 9.6875580000000002e-09 157.82499999999999p 9.057131e-09 157.83750000000001p 8.4161490000000002e-09 157.84999999999999p 7.7654749999999996e-09 157.86250000000001p 7.1059820000000001e-09 157.875p 6.4385520000000001e-09 157.88749999999999p 5.7640759999999998e-09 157.90000000000001p 5.0834550000000002e-09 157.91249999999999p 4.3975919999999997e-09 157.92500000000001p 3.7073989999999999e-09 157.9375p 3.0137889999999999e-09 157.95000000000002p 2.3176789999999999e-09
+ 157.96250000000001p 1.6199860000000001e-09 157.97499999999999p 9.2162969999999996e-10 157.98749999999998p 2.2352670000000001e-10 158p -4.7340780000000005e-10 158.01249999999999p -1.1682620000000001e-09 158.02500000000001p -1.860129e-09 158.03750000000002p -2.5481070000000001e-09 158.05000000000001p -3.231302e-09 158.0625p -3.9088269999999999e-09 158.07499999999999p -4.5798059999999997e-09 158.08750000000001p -5.2433710000000002e-09 158.09999999999999p -5.8986679999999996e-09 158.11250000000001p -6.5448530000000003e-09 158.125p -7.1810979999999997e-09 158.13749999999999p -7.8065879999999994e-09 158.15000000000001p -8.4205259999999992e-09 158.16249999999999p -9.0221280000000008e-09 158.17500000000001p -9.6106319999999993e-09
+ 158.1875p -1.018529e-08 158.20000000000002p -1.074538e-08 158.21250000000001p -1.12902e-08 158.22499999999999p -1.1819060000000001e-08 158.23749999999998p -1.2331299999999999e-08 158.25p -1.282629e-08 158.26249999999999p -1.33034e-08 158.27500000000001p -1.376206e-08 158.28749999999999p -1.4201690000000001e-08 158.30000000000001p -1.462177e-08 158.3125p -1.502178e-08 158.32499999999999p -1.5401230000000001e-08 158.33750000000001p -1.5759670000000001e-08 158.34999999999999p -1.6096679999999999e-08 158.36250000000001p -1.641186e-08 158.375p -1.6704840000000002e-08 158.38750000000002p -1.6975280000000001e-08 158.39999999999998p -1.722287e-08
+ 158.41249999999999p -1.744734e-08 158.42500000000001p -1.7648440000000002e-08 158.4375p -1.7825960000000001e-08 158.45000000000002p -1.797972e-08 158.46250000000001p -1.810955e-08 158.47499999999999p -1.821535e-08 158.48749999999998p -1.8297020000000001e-08 158.5p -1.835452e-08 158.51249999999999p -1.8387800000000001e-08 158.52500000000001p -1.8396890000000001e-08 158.53749999999999p -1.8381830000000001e-08 158.55000000000001p -1.8342670000000002e-08 158.5625p -1.8279540000000001e-08 158.57499999999999p -1.8192549999999998e-08 158.58750000000001p -1.8081890000000001e-08 158.59999999999999p -1.794773e-08 158.61250000000001p -1.7790319999999999e-08 158.625p -1.7609900000000001e-08
+ 158.63750000000002p -1.7406770000000001e-08 158.64999999999998p -1.7181240000000001e-08 158.66249999999999p -1.6933659999999999e-08 158.67500000000001p -1.6664390000000001e-08 158.6875p -1.637384e-08 158.70000000000002p -1.606243e-08 158.71250000000001p -1.5730630000000002e-08 158.72500000000002p -1.5378909999999999e-08 158.73749999999998p -1.500778e-08 158.75p -1.461777e-08 158.76249999999999p -1.420943e-08 158.77500000000001p -1.3783329999999999e-08 158.78749999999999p -1.334009e-08 158.80000000000001p -1.288031e-08 158.8125p -1.240463e-08 158.82499999999999p -1.191373e-08 158.83750000000001p -1.140827e-08 158.84999999999999p -1.088895e-08
+ 158.86250000000001p -1.0356489999999999e-08 158.875p -9.8116139999999998e-09 158.88750000000002p -9.255065e-09 158.89999999999998p -8.687601e-09 158.91249999999999p -8.1099909999999999e-09 158.92499999999998p -7.5230169999999994e-09 158.9375p -6.9274710000000002e-09 158.95000000000002p -6.3241549999999999e-09 158.96250000000001p -5.7138779999999999e-09 158.97500000000002p -5.097459e-09 158.98749999999998p -4.4757199999999999e-09 159p -3.8494900000000001e-09 159.01249999999999p -3.2196020000000001e-09 159.02500000000001p -2.5868920000000002e-09 159.03749999999999p -1.9521969999999998e-09 159.05000000000001p -1.3163550000000001e-09 159.0625p -6.8020400000000002e-10 159.07499999999999p -4.4580590000000001e-11
+ 159.08750000000001p 5.8968180000000003e-10 159.09999999999999p 1.221753e-09 159.11250000000001p 1.8508079999999999e-09 159.125p 2.476028e-09 159.13750000000002p 3.0965989999999999e-09 159.14999999999998p 3.7117179999999999e-09 159.16249999999999p 4.3205900000000003e-09 159.17499999999998p 4.9224280000000001e-09 159.1875p 5.5164590000000003e-09 159.20000000000002p 6.10192e-09 159.21250000000001p 6.6780620000000002e-09 159.22500000000002p 7.2441500000000001e-09 159.23749999999998p 7.7994639999999999e-09 159.25p 8.343299e-09 159.26249999999999p 8.8749679999999998e-09 159.27500000000001p 9.3938000000000004e-09 159.28749999999999p 9.8991430000000008e-09 159.30000000000001p 1.039037e-08
+ 159.3125p 1.0866860000000001e-08 159.32499999999999p 1.132802e-08 159.33750000000001p 1.177329e-08 159.34999999999999p 1.2202119999999999e-08 159.36250000000001p 1.261398e-08 159.375p 1.300837e-08 159.38750000000002p 1.3384819999999999e-08 159.39999999999998p 1.3742859999999999e-08 159.41249999999999p 1.4082080000000001e-08 159.42499999999998p 1.440207e-08 159.4375p 1.4702459999999999e-08 159.44999999999999p 1.49829e-08 159.46250000000001p 1.5243059999999999e-08 159.47500000000002p 1.5482650000000001e-08 159.48749999999998p 1.5701410000000001e-08 159.5p 1.5899090000000001e-08 159.51249999999999p 1.6075480000000001e-08 159.52500000000001p 1.6230409999999999e-08
+ 159.53749999999999p 1.636372e-08 159.55000000000001p 1.647528e-08 159.5625p 1.656501e-08 159.57499999999999p 1.663282e-08 159.58750000000001p 1.6678680000000001e-08 159.59999999999999p 1.6702589999999999e-08 159.61250000000001p 1.6704559999999998e-08 159.625p 1.6684640000000001e-08 159.63750000000002p 1.664291e-08 159.65000000000001p 1.657947e-08 159.66249999999999p 1.649446e-08 159.67499999999998p 1.638804e-08 159.6875p 1.626039e-08 159.69999999999999p 1.6111729999999999e-08 159.71250000000001p 1.5942310000000001e-08 159.72500000000002p 1.5752399999999999e-08 159.73749999999998p 1.5542290000000001e-08 159.75p 1.5312300000000001e-08
+ 159.76249999999999p 1.506278e-08 159.77500000000001p 1.47941e-08 159.78749999999999p 1.4506669999999999e-08 159.80000000000001p 1.4200890000000001e-08 159.8125p 1.387721e-08 159.82499999999999p 1.35361e-08 159.83750000000001p 1.317805e-08 159.84999999999999p 1.2803550000000001e-08 159.86250000000001p 1.241315e-08 159.875p 1.200738e-08 159.88750000000002p 1.158682e-08 159.90000000000001p 1.1152040000000001e-08 159.91249999999999p 1.070366e-08 159.92499999999998p 1.024228e-08 159.9375p 9.7685479999999995e-09 159.94999999999999p 9.2831049999999999e-09 159.96250000000001p 8.7866159999999996e-09 159.97499999999999p 8.2797539999999997e-09
+ 159.98750000000001p 7.7632079999999999e-09 160p 7.2376749999999998e-09 160.01249999999999p 6.7038630000000002e-09 160.02500000000001p 6.1624910000000002e-09 160.03749999999999p 5.6142829999999999e-09 160.05000000000001p 5.0599719999999997e-09 160.0625p 4.5002979999999996e-09 160.07499999999999p 3.9360050000000004e-09 160.08749999999998p 3.3678410000000001e-09 160.09999999999999p 2.7965590000000002e-09 160.11250000000001p 2.2229129999999998e-09 160.125p 1.6476580000000001e-09 160.13750000000002p 1.071551e-09 160.15000000000001p 4.9534619999999998e-10 160.16249999999999p -8.0202049999999999e-11 160.17499999999998p -6.543428e-10 160.1875p -1.2263289999999999e-09 160.19999999999999p -1.795416e-09
+ 160.21250000000001p -2.360869e-09 160.22499999999999p -2.9219550000000002e-09 160.23750000000001p -3.4779509999999999e-09 160.25p -4.0281420000000003e-09 160.26249999999999p -4.5718230000000002e-09 160.27500000000001p -5.1082960000000002e-09 160.28749999999999p -5.636877e-09 160.30000000000001p -6.1568929999999999e-09 160.3125p -6.6676850000000002e-09 160.32500000000002p -7.1686050000000002e-09 160.33749999999998p -7.6590209999999994e-09 160.34999999999999p -8.1383159999999996e-09 160.36250000000001p -8.6058890000000005e-09 160.375p -9.0611559999999993e-09 160.38750000000002p -9.5035490000000004e-09 160.40000000000001p -9.9325199999999995e-09 160.41249999999999p -1.034754e-08 160.42499999999998p -1.074809e-08
+ 160.4375p -1.1133689999999999e-08 160.44999999999999p -1.150387e-08 160.46250000000001p -1.1858180000000001e-08 160.47499999999999p -1.219618e-08 160.48750000000001p -1.251748e-08 160.5p -1.2821689999999999e-08 160.51249999999999p -1.310846e-08 160.52500000000001p -1.3377450000000001e-08 160.53749999999999p -1.362835e-08 160.55000000000001p -1.3860870000000001e-08 160.5625p -1.407474e-08 160.57500000000002p -1.426974e-08 160.58749999999998p -1.444565e-08 160.59999999999999p -1.460229e-08 160.61250000000001p -1.473948e-08 160.625p -1.4857100000000001e-08 160.63750000000002p -1.495504e-08 160.65000000000001p -1.503321e-08
+ 160.66250000000002p -1.5091559999999999e-08 160.67499999999998p -1.513005e-08 160.6875p -1.5148679999999999e-08 160.69999999999999p -1.5147480000000001e-08 160.71250000000001p -1.512647e-08 160.72499999999999p -1.508575e-08 160.73750000000001p -1.5025399999999999e-08 160.75p -1.4945549999999999e-08 160.76249999999999p -1.484635e-08 160.77500000000001p -1.472797e-08 160.78749999999999p -1.45906e-08 160.80000000000001p -1.443448e-08 160.8125p -1.425985e-08 160.82500000000002p -1.406697e-08 160.83749999999998p -1.385614e-08 160.84999999999999p -1.362768e-08 160.86249999999998p -1.338192e-08 160.875p -1.3119220000000001e-08
+ 160.88750000000002p -1.283998e-08 160.90000000000001p -1.2544579999999999e-08 160.91250000000002p -1.2233450000000001e-08 160.92499999999998p -1.190703e-08 160.9375p -1.156579e-08 160.94999999999999p -1.12102e-08 160.96250000000001p -1.0840760000000001e-08 160.97499999999999p -1.045798e-08 160.98750000000001p -1.0062399999999999e-08 161p -9.6545560000000002e-09 161.01249999999999p -9.2350159999999998e-09 161.02500000000001p -8.804351e-09 161.03749999999999p -8.36315e-09 161.05000000000001p -7.9120139999999995e-09 161.0625p -7.4515529999999993e-09 161.07500000000002p -6.9823920000000001e-09 161.08749999999998p -6.5051640000000003e-09 161.09999999999999p -6.0205089999999996e-09
+ 161.11249999999998p -5.5290800000000001e-09 161.125p -5.0315319999999997e-09 161.13750000000002p -4.5285320000000001e-09 161.15000000000001p -4.020748e-09 161.16250000000002p -3.5088549999999999e-09 161.17499999999998p -2.9935319999999999e-09 161.1875p -2.475461e-09 161.19999999999999p -1.9553250000000002e-09 161.21250000000001p -1.4338089999999999e-09 161.22499999999999p -9.1159779999999996e-10 161.23750000000001p -3.8937639999999999e-10 161.25p 1.3217240000000001e-10 161.26249999999999p 6.5236810000000001e-10 161.27500000000001p 1.170533e-09 161.28749999999999p 1.685995e-09 161.30000000000001p 2.198084e-09 161.3125p 2.7061399999999999e-09 161.32500000000002p 3.209506e-09
+ 161.33750000000001p 3.7075349999999999e-09 161.34999999999999p 4.1995870000000003e-09 161.36249999999998p 4.6850319999999997e-09 161.375p 5.1632489999999996e-09 161.38749999999999p 5.6336299999999997e-09 161.40000000000001p 6.0955760000000001e-09 161.41250000000002p 6.5485019999999997e-09 161.42499999999998p 6.9918359999999997e-09 161.4375p 7.4250189999999998e-09 161.44999999999999p 7.8475080000000005e-09 161.46250000000001p 8.2587730000000001e-09 161.47499999999999p 8.6583010000000005e-09 161.48750000000001p 9.0455969999999993e-09 161.5p 9.4201800000000004e-09 161.51249999999999p 9.7815889999999992e-09 161.52500000000001p 1.012938e-08 161.53749999999999p 1.0463129999999999e-08 161.55000000000001p 1.078243e-08
+ 161.5625p 1.108691e-08 161.57500000000002p 1.137618e-08 161.58750000000001p 1.164991e-08 161.59999999999999p 1.1907769999999999e-08 161.61249999999998p 1.2149469999999999e-08 161.625p 1.237472e-08 161.63749999999999p 1.2583259999999999e-08 161.65000000000001p 1.277486e-08 161.66250000000002p 1.294931e-08 161.67499999999998p 1.310641e-08 161.6875p 1.324601e-08 161.69999999999999p 1.336795e-08 161.71250000000001p 1.347211e-08 161.72499999999999p 1.35584e-08 161.73750000000001p 1.362675e-08 161.75p 1.3677109999999999e-08 161.76249999999999p 1.370944e-08 161.77500000000001p 1.3723760000000001e-08
+ 161.78749999999999p 1.3720070000000001e-08 161.80000000000001p 1.3698429999999999e-08 161.8125p 1.365891e-08 161.82500000000002p 1.360159e-08 161.83750000000001p 1.3526589999999999e-08 161.84999999999999p 1.3434050000000001e-08 161.86249999999998p 1.3324130000000001e-08 161.875p 1.3197010000000001e-08 161.88749999999999p 1.3052890000000001e-08 161.90000000000001p 1.289201e-08 161.91249999999999p 1.271461e-08 161.92500000000001p 1.2520960000000001e-08 161.9375p 1.2311349999999999e-08 161.94999999999999p 1.208609e-08 161.96250000000001p 1.184551e-08 161.97499999999999p 1.158995e-08 161.98750000000001p 1.1319800000000001e-08 162p 1.1035430000000001e-08
+ 162.01249999999999p 1.0737250000000001e-08 162.02499999999998p 1.0425669999999999e-08 162.03749999999999p 1.0101140000000001e-08 162.05000000000001p 9.7641159999999995e-09 162.0625p 9.4150589999999992e-09 162.07500000000002p 9.0544550000000007e-09 162.08750000000001p 8.6828039999999995e-09 162.09999999999999p 8.3006150000000007e-09 162.11249999999998p 7.908414e-09 162.125p 7.5067359999999992e-09 162.13749999999999p 7.0961279999999998e-09 162.15000000000001p 6.6771490000000003e-09 162.16249999999999p 6.2503650000000003e-09 162.17500000000001p 5.8163520000000003e-09 162.1875p 5.3756960000000003e-09 162.19999999999999p 4.9289889999999996e-09 162.21250000000001p 4.4768279999999999e-09 162.22499999999999p 4.019819e-09
+ 162.23750000000001p 3.55857e-09 162.25p 3.0936960000000001e-09 162.26250000000002p 2.6258130000000002e-09 162.27499999999998p 2.1555410000000001e-09 162.28749999999999p 1.683502e-09 162.30000000000001p 1.2103170000000001e-09 162.3125p 7.3660950000000005e-10 162.32500000000002p 2.6300060000000001e-10 162.33750000000001p -2.0988919999999999e-10 162.34999999999999p -6.8144210000000002e-10 162.36249999999998p -1.1510429999999999e-09 162.375p -1.6180820000000001e-09 162.38749999999999p -2.0819510000000001e-09 162.40000000000001p -2.5420509999999998e-09 162.41249999999999p -2.9977870000000001e-09 162.42500000000001p -3.448572e-09 162.4375p -3.8938259999999999e-09 162.44999999999999p -4.3329769999999999e-09
+ 162.46250000000001p -4.7654650000000001e-09 162.47499999999999p -5.1907369999999997e-09 162.48750000000001p -5.6082510000000003e-09 162.5p -6.0174789999999999e-09 162.51250000000002p -6.4179020000000002e-09 162.52499999999998p -6.8090149999999998e-09 162.53749999999999p -7.1903259999999999e-09 162.54999999999998p -7.5613580000000006e-09 162.5625p -7.9216469999999997e-09 162.57500000000002p -8.2707439999999995e-09 162.58750000000001p -8.6082180000000001e-09 162.60000000000002p -8.9336510000000004e-09 162.61249999999998p -9.2466440000000007e-09 162.625p -9.5468139999999997e-09 162.63749999999999p -9.8337960000000001e-09 162.65000000000001p -1.010724e-08 162.66249999999999p -1.036683e-08 162.67500000000001p -1.061224e-08
+ 162.6875p -1.0843189999999999e-08 162.69999999999999p -1.105941e-08 162.71250000000001p -1.126065e-08 162.72499999999999p -1.1446660000000001e-08 162.73750000000001p -1.1617259999999999e-08 162.75p -1.177224e-08 162.76250000000002p -1.191144e-08 162.77499999999998p -1.203471e-08 162.78749999999999p -1.214193e-08 162.79999999999998p -1.223298e-08 162.8125p -1.2307789999999999e-08 162.82500000000002p -1.2366299999999999e-08 162.83750000000001p -1.240846e-08 162.85000000000002p -1.2434249999999999e-08 162.86249999999998p -1.2443679999999999e-08 162.875p -1.243678e-08 162.88749999999999p -1.241358e-08 162.90000000000001p -1.237415e-08
+ 162.91249999999999p -1.2318579999999999e-08 162.92500000000001p -1.2246990000000001e-08 162.9375p -1.2159490000000001e-08 162.94999999999999p -1.2056249999999999e-08 162.96250000000001p -1.193742e-08 162.97499999999999p -1.1803210000000001e-08 162.98750000000001p -1.165382e-08 163p -1.148947e-08 163.01250000000002p -1.131043e-08 163.02499999999998p -1.111696e-08 163.03749999999999p -1.0909339999999999e-08 163.04999999999998p -1.0687869999999999e-08 163.0625p -1.0452890000000001e-08 163.07500000000002p -1.0204719999999999e-08 163.08750000000001p -9.9437259999999999e-09 163.10000000000002p -9.6702739999999996e-09 163.11249999999998p -9.3847509999999994e-09 163.125p -9.0875600000000004e-09
+ 163.13749999999999p -8.7791159999999993e-09 163.15000000000001p -8.4598499999999995e-09 163.16249999999999p -8.1302029999999992e-09 163.17500000000001p -7.7906320000000002e-09 163.1875p -7.4416050000000004e-09 163.19999999999999p -7.0836010000000001e-09 163.21250000000001p -6.7171089999999999e-09 163.22499999999999p -6.3426299999999996e-09 163.23750000000001p -5.9606730000000004e-09 163.25p -5.5717560000000002e-09 163.26250000000002p -5.1764040000000001e-09 163.27500000000001p -4.7751520000000002e-09 163.28749999999999p -4.3685390000000004e-09 163.29999999999998p -3.9571110000000001e-09 163.3125p -3.5414180000000001e-09 163.32499999999999p -3.1220169999999998e-09 163.33750000000001p -2.699465e-09 163.35000000000002p -2.2743240000000001e-09
+ 163.36249999999998p -1.8471589999999999e-09 163.375p -1.418535e-09 163.38749999999999p -9.8901770000000006e-10 163.40000000000001p -5.5917320000000003e-10 163.41249999999999p -1.295666e-10 163.42500000000001p 2.992384e-10 163.4375p 7.2668070000000003e-10 163.44999999999999p 1.152202e-09 163.46250000000001p 1.575247e-09 163.47499999999999p 1.9952670000000002e-09 163.48750000000001p 2.4117169999999999e-09 163.5p 2.8240570000000001e-09 163.51250000000002p 3.2317550000000001e-09 163.52500000000001p 3.6342870000000001e-09 163.53749999999999p 4.0311340000000004e-09 163.54999999999998p 4.4217890000000004e-09 163.5625p 4.8057519999999997e-09 163.57499999999999p 5.1825340000000003e-09
+ 163.58750000000001p 5.5516549999999999e-09 163.60000000000002p 5.9126490000000004e-09 163.61250000000001p 6.2650579999999996e-09 163.625p 6.60844e-09 163.63749999999999p 6.9423639999999996e-09 163.65000000000001p 7.2664109999999998e-09 163.66249999999999p 7.5801779999999995e-09 163.67500000000001p 7.8832760000000005e-09 163.6875p 8.1753299999999997e-09 163.69999999999999p 8.4559820000000006e-09 163.71250000000001p 8.7248889999999997e-09 163.72499999999999p 8.9817219999999997e-09 163.73750000000001p 9.2261719999999996e-09 163.75p 9.4579450000000001e-09 163.76250000000002p 9.6767650000000008e-09 163.77500000000001p 9.8823740000000005e-09 163.78749999999999p 1.007453e-08 163.79999999999998p 1.0253010000000001e-08
+ 163.8125p 1.0417610000000001e-08 163.82499999999999p 1.0568150000000001e-08 163.83750000000001p 1.070446e-08 163.84999999999999p 1.0826390000000001e-08 163.86250000000001p 1.0933819999999999e-08 163.875p 1.102663e-08 163.88749999999999p 1.1104730000000001e-08 163.90000000000001p 1.116807e-08 163.91249999999999p 1.1216580000000001e-08 163.92500000000001p 1.125023e-08 163.9375p 1.126902e-08 163.95000000000002p 1.127295e-08 163.96249999999998p 1.1262059999999999e-08 163.97499999999999p 1.1236379999999999e-08 163.98750000000001p 1.119599e-08 164p 1.1140970000000001e-08 164.01250000000002p 1.107143e-08 164.02500000000001p 1.098749e-08
+ 164.03749999999999p 1.0889290000000001e-08 164.04999999999998p 1.077699e-08 164.0625p 1.065078e-08 164.07499999999999p 1.0510850000000001e-08 164.08750000000001p 1.035742e-08 164.09999999999999p 1.019071e-08 164.11250000000001p 1.001098e-08 164.125p 9.8184880000000007e-09 164.13749999999999p 9.6135210000000004e-09 164.15000000000001p 9.3963750000000007e-09 164.16249999999999p 9.1673619999999999e-09 164.17500000000001p 8.9268110000000004e-09 164.1875p 8.6750630000000002e-09 164.20000000000002p 8.412474e-09 164.21249999999998p 8.1394140000000006e-09 164.22499999999999p 7.8562649999999994e-09 164.23750000000001p 7.5634230000000005e-09 164.25p 7.2612939999999999e-09
+ 164.26250000000002p 6.9502960000000003e-09 164.27500000000001p 6.6308580000000002e-09 164.28749999999999p 6.3034180000000003e-09 164.29999999999998p 5.9684260000000002e-09 164.3125p 5.6263389999999999e-09 164.32499999999999p 5.2776219999999996e-09 164.33750000000001p 4.9227489999999999e-09 164.34999999999999p 4.5621999999999998e-09 164.36250000000001p 4.196462e-09 164.375p 3.8260279999999996e-09 164.38749999999999p 3.451394e-09 164.40000000000001p 3.0730640000000002e-09 164.41249999999999p 2.6915430000000001e-09 164.42500000000001p 2.3073390000000001e-09 164.4375p 1.920964e-09 164.45000000000002p 1.53293e-09 164.46249999999998p 1.1437519999999999e-09 164.47499999999999p 7.5394389999999999e-10
+ 164.48749999999998p 3.640192e-10 164.5p -2.550899e-11 164.51250000000002p -4.1412949999999999e-10 164.52500000000001p -8.0133340000000001e-10 164.53750000000002p -1.186615e-09 164.54999999999998p -1.569472e-09 164.5625p -1.9494070000000001e-09 164.57499999999999p -2.325926e-09 164.58750000000001p -2.6985430000000002e-09 164.59999999999999p -3.066776e-09 164.61250000000001p -3.430152e-09 164.625p -3.7882040000000002e-09 164.63749999999999p -4.1404720000000001e-09 164.65000000000001p -4.4865080000000002e-09 164.66249999999999p -4.8258699999999996e-09 164.67500000000001p -5.1581269999999997e-09 164.6875p -5.4828600000000002e-09 164.70000000000002p -5.7996569999999997e-09
+ 164.71249999999998p -6.1081209999999997e-09 164.72499999999999p -6.4078650000000002e-09 164.73749999999998p -6.6985150000000002e-09 164.75p -6.9797099999999997e-09 164.76250000000002p -7.2511009999999998e-09 164.77500000000001p -7.5123540000000001e-09 164.78750000000002p -7.7631489999999993e-09 164.79999999999998p -8.0031800000000001e-09 164.8125p -8.2321550000000003e-09 164.82499999999999p -8.4498010000000006e-09 164.83750000000001p -8.655855e-09 164.84999999999999p -8.8500729999999999e-09 164.86250000000001p -9.0322289999999996e-09 164.875p -9.202108e-09 164.88749999999999p -9.3595170000000007e-09 164.90000000000001p -9.5042769999999992e-09 164.91249999999999p -9.6362260000000003e-09 164.92500000000001p -9.7552199999999993e-09
+ 164.9375p -9.8611330000000008e-09 164.95000000000002p -9.9538549999999994e-09 164.96249999999998p -1.0033299999999999e-08 164.97499999999999p -1.009938e-08 164.98749999999998p -1.015205e-08 165p -1.019127e-08 165.01249999999999p -1.021702e-08 165.02500000000001p -1.022929e-08 165.03750000000002p -1.0228099999999999e-08 165.04999999999998p -1.0213479999999999e-08 165.0625p -1.0185490000000001e-08 165.07499999999999p -1.0144179999999999e-08 165.08750000000001p -1.0089650000000001e-08 165.09999999999999p -1.002199e-08 165.11250000000001p -9.9413290000000001e-09 165.125p -9.8477969999999997e-09 165.13749999999999p -9.741547e-09 165.15000000000001p -9.6227490000000006e-09
+ 165.16249999999999p -9.4915860000000003e-09 165.17500000000001p -9.3482600000000006e-09 165.1875p -9.1929860000000005e-09 165.20000000000002p -9.0259959999999996e-09 165.21250000000001p -8.8475349999999999e-09 165.22499999999999p -8.6578640000000002e-09 165.23749999999998p -8.4572580000000004e-09 165.25p -8.2460049999999998e-09 165.26249999999999p -8.0244070000000003e-09 165.27500000000001p -7.7927779999999994e-09 165.28750000000002p -7.5514450000000005e-09 165.29999999999998p -7.3007469999999999e-09 165.3125p -7.0410350000000004e-09 165.32499999999999p -6.7726700000000004e-09 165.33750000000001p -6.4960229999999998e-09 165.34999999999999p -6.2114780000000003e-09 165.36250000000001p -5.9194249999999997e-09 165.375p -5.6202639999999998e-09
+ 165.38749999999999p -5.3144040000000002e-09 165.40000000000001p -5.0022619999999999e-09 165.41249999999999p -4.6842619999999999e-09 165.42500000000001p -4.3608340000000002e-09 165.4375p -4.0324139999999998e-09 165.45000000000002p -3.699446e-09 165.46250000000001p -3.3623750000000002e-09 165.47499999999999p -3.0216529999999999e-09 165.48749999999998p -2.6777359999999999e-09 165.5p -2.3310810000000001e-09 165.51249999999999p -1.9821499999999998e-09 165.52500000000001p -1.631404e-09 165.53750000000002p -1.2793090000000001e-09 165.55000000000001p -9.2632779999999997e-10 165.5625p -5.729261e-10 165.57499999999999p -2.195679e-10 165.58750000000001p 1.3328390000000001e-10 165.59999999999999p 4.8516799999999997e-10
+ 165.61250000000001p 8.3562529999999999e-10 165.625p 1.1841999999999999e-09 165.63749999999999p 1.530439e-09 165.65000000000001p 1.873895e-09 165.66249999999999p 2.2141239999999998e-09 165.67500000000001p 2.5506869999999999e-09 165.6875p 2.8831509999999998e-09 165.70000000000002p 3.2110920000000001e-09 165.71250000000001p 3.5340879999999999e-09 165.72499999999999p 3.851729e-09 165.73749999999998p 4.1636099999999999e-09 165.75p 4.4693359999999998e-09 165.76249999999999p 4.7685209999999999e-09 165.77500000000001p 5.0607869999999997e-09 165.78749999999999p 5.3457669999999997e-09 165.80000000000001p 5.6231049999999997e-09 165.8125p 5.8924550000000002e-09 165.82499999999999p 6.1534820000000004e-09
+ 165.83750000000001p 6.4058640000000001e-09 165.84999999999999p 6.6492879999999997e-09 165.86250000000001p 6.8834569999999996e-09 165.875p 7.1080849999999997e-09 165.88750000000002p 7.3228989999999997e-09 165.89999999999998p 7.5276409999999994e-09 165.91249999999999p 7.7220640000000001e-09 165.92500000000001p 7.9059379999999999e-09 165.9375p 8.0790450000000002e-09 165.95000000000002p 8.2411829999999996e-09 165.96250000000001p 8.3921649999999996e-09 165.97499999999999p 8.5318169999999995e-09 165.98749999999998p 8.6599820000000003e-09 166p 8.776518e-09 166.01249999999999p 8.8812989999999996e-09 166.02500000000001p 8.9742140000000002e-09 166.03749999999999p 9.0551669999999993e-09 166.05000000000001p 9.1240789999999999e-09
+ 166.0625p 9.180887e-09 166.07499999999999p 9.2255429999999993e-09 166.08750000000001p 9.2580150000000007e-09 166.09999999999999p 9.2782889999999999e-09 166.11250000000001p 9.2863639999999998e-09 166.125p 9.2822579999999995e-09 166.13750000000002p 9.2660010000000004e-09 166.14999999999998p 9.2376430000000001e-09 166.16249999999999p 9.1972470000000006e-09 166.17500000000001p 9.1448920000000005e-09 166.1875p 9.0806730000000004e-09 166.20000000000002p 9.0047009999999992e-09 166.21250000000001p 8.9170989999999998e-09 166.22500000000002p 8.8180089999999995e-09 166.23749999999998p 8.7075849999999994e-09 166.25p 8.5859960000000003e-09 166.26249999999999p 8.4534249999999995e-09 166.27500000000001p 8.3100700000000004e-09
+ 166.28749999999999p 8.1561419999999993e-09 166.30000000000001p 7.991866e-09 166.3125p 7.8174769999999996e-09 166.32499999999999p 7.6332270000000008e-09 166.33750000000001p 7.4393780000000002e-09 166.34999999999999p 7.2362029999999996e-09 166.36250000000001p 7.0239890000000004e-09 166.375p 6.8030330000000004e-09 166.38750000000002p 6.5736430000000002e-09 166.39999999999998p 6.336136e-09 166.41249999999999p 6.0908419999999998e-09 166.42499999999998p 5.8380959999999999e-09 166.4375p 5.5782460000000002e-09 166.45000000000002p 5.3116469999999998e-09 166.46250000000001p 5.0386620000000003e-09 166.47500000000002p 4.7596610000000004e-09 166.48749999999998p 4.4750219999999999e-09 166.5p 4.18513e-09
+ 166.51249999999999p 3.8903739999999997e-09 166.52500000000001p 3.5911499999999999e-09 166.53749999999999p 3.2878599999999999e-09 166.55000000000001p 2.980908e-09 166.5625p 2.670703e-09 166.57499999999999p 2.3576580000000001e-09 166.58750000000001p 2.042189e-09 166.59999999999999p 1.7247130000000001e-09 166.61250000000001p 1.4056490000000001e-09 166.625p 1.0854179999999999e-09 166.63750000000002p 7.6444059999999998e-10 166.64999999999998p 4.4313889999999999e-10 166.66249999999999p 1.2193340000000001e-10 166.67499999999998p -1.9875600000000001e-10 166.6875p -5.185113e-10 166.70000000000002p -8.3691610000000004e-10 166.71250000000001p -1.153557e-09 166.72500000000002p -1.4680240000000001e-09
+ 166.73749999999998p -1.779909e-09 166.75p -2.0888109999999999e-09 166.76249999999999p -2.3943330000000001e-09 166.77500000000001p -2.6960800000000001e-09 166.78749999999999p -2.9936679999999998e-09 166.80000000000001p -3.2867140000000002e-09 166.8125p -3.5748459999999999e-09 166.82499999999999p -3.8576980000000002e-09 166.83750000000001p -4.1349090000000002e-09 166.84999999999999p -4.4061289999999996e-09 166.86250000000001p -4.6710169999999997e-09 166.875p -4.9292389999999999e-09 166.88750000000002p -5.18047e-09 166.89999999999998p -5.4243979999999998e-09 166.91249999999999p -5.6607170000000002e-09 166.92499999999998p -5.8891360000000002e-09 166.9375p -6.1093710000000003e-09 166.94999999999999p -6.3211519999999996e-09
+ 166.96250000000001p -6.5242189999999997e-09 166.97500000000002p -6.7183240000000001e-09 166.98749999999998p -6.9032320000000002e-09 167p -7.0787219999999999e-09 167.01249999999999p -7.2445810000000001e-09 167.02500000000001p -7.4006139999999998e-09 167.03749999999999p -7.5466369999999998e-09 167.05000000000001p -7.6824799999999997e-09 167.0625p -7.807986e-09 167.07499999999999p -7.9230119999999997e-09 167.08750000000001p -8.0274290000000008e-09 167.09999999999999p -8.1211240000000002e-09 167.11250000000001p -8.2039950000000003e-09 167.125p -8.2759580000000006e-09 167.13750000000002p -8.3369389999999992e-09 167.15000000000001p -8.386883e-09 167.16249999999999p -8.4257469999999992e-09 167.17499999999998p -8.4535029999999995e-09
+ 167.1875p -8.4701369999999997e-09 167.19999999999999p -8.4756519999999992e-09 167.21250000000001p -8.4700639999999996e-09 167.22500000000002p -8.4534020000000004e-09 167.23749999999998p -8.4257109999999993e-09 167.25p -8.3870519999999993e-09 167.26249999999999p -8.3374959999999998e-09 167.27500000000001p -8.2771329999999996e-09 167.28749999999999p -8.2060629999999994e-09 167.30000000000001p -8.1244009999999993e-09 167.3125p -8.0322779999999997e-09 167.32499999999999p -7.9298349999999992e-09 167.33750000000001p -7.8172269999999994e-09 167.34999999999999p -7.694625e-09 167.36250000000001p -7.5622080000000003e-09 167.375p -7.4201719999999998e-09 167.38750000000002p -7.2687220000000003e-09 167.40000000000001p -7.1080760000000001e-09
+ 167.41249999999999p -6.9384639999999997e-09 167.42499999999998p -6.7601260000000003e-09 167.4375p -6.5733149999999999e-09 167.44999999999999p -6.3782940000000003e-09 167.46250000000001p -6.1753339999999996e-09 167.47499999999999p -5.9647180000000002e-09 167.48750000000001p -5.7467389999999996e-09 167.5p -5.5216969999999999e-09 167.51249999999999p -5.2899019999999999e-09 167.52500000000001p -5.051672e-09 167.53749999999999p -4.8073319999999996e-09 167.55000000000001p -4.5572160000000001e-09 167.5625p -4.3016630000000003e-09 167.57499999999999p -4.0410200000000002e-09 167.58749999999998p -3.7756379999999998e-09 167.59999999999999p -3.5058759999999999e-09 167.61250000000001p -3.232096e-09 167.625p -2.9546660000000001e-09
+ 167.63750000000002p -2.6739560000000001e-09 167.65000000000001p -2.390343e-09 167.66249999999999p -2.1042020000000001e-09 167.67499999999998p -1.8159149999999999e-09 167.6875p -1.525864e-09 167.69999999999999p -1.2344340000000001e-09 167.71250000000001p -9.4200739999999993e-10 167.72499999999999p -6.4897140000000002e-10 167.73750000000001p -3.557108e-10 167.75p -6.2610560000000004e-11 167.76249999999999p 2.2994560000000001e-10 167.77500000000001p 5.2157530000000002e-10 167.78749999999999p 8.1189839999999996e-10 167.80000000000001p 1.1005370000000001e-09 167.8125p 1.3871169999999999e-09 167.82500000000002p 1.6712659999999999e-09 167.83749999999998p 1.9526170000000001e-09 167.84999999999999p 2.2308079999999999e-09
+ 167.86250000000001p 2.5054809999999998e-09 167.875p 2.776283e-09 167.88750000000002p 3.042868e-09 167.90000000000001p 3.3048940000000002e-09 167.91249999999999p 3.562029e-09 167.92499999999998p 3.8139459999999996e-09 167.9375p 4.0603260000000002e-09 167.94999999999999p 4.3008569999999998e-09 167.96250000000001p 4.5352380000000003e-09 167.97499999999999p 4.7631740000000002e-09 167.98750000000001p 4.9843790000000002e-09 168p 5.1985800000000001e-09 168.01249999999999p 5.4055090000000004e-09 168.02500000000001p 5.6049119999999996e-09 168.03749999999999p 5.796544e-09 168.05000000000001p 5.9801689999999997e-09 168.0625p 6.1555650000000001e-09 168.07500000000002p 6.3225190000000003e-09
+ 168.08749999999998p 6.4808310000000002e-09 168.09999999999999p 6.6303119999999998e-09 168.11250000000001p 6.7707860000000003e-09 168.125p 6.902087e-09 168.13750000000002p 7.0240640000000003e-09 168.15000000000001p 7.1365769999999996e-09 168.16250000000002p 7.2395000000000001e-09 168.17499999999998p 7.3327170000000002e-09 168.1875p 7.4161280000000003e-09 168.19999999999999p 7.4896459999999992e-09 168.21250000000001p 7.5531940000000005e-09 168.22499999999999p 7.6067129999999994e-09 168.23750000000001p 7.6501529999999998e-09 168.25p 7.6834799999999992e-09 168.26249999999999p 7.7066720000000005e-09 168.27500000000001p 7.7197209999999994e-09 168.28749999999999p 7.7226329999999995e-09 168.30000000000001p 7.7154239999999994e-09
+ 168.3125p 7.698128e-09 168.32500000000002p 7.6707900000000006e-09 168.33749999999998p 7.6334659999999992e-09 168.34999999999999p 7.5862280000000008e-09 168.36249999999998p 7.5291600000000005e-09 168.375p 7.4623570000000006e-09 168.38750000000002p 7.38593e-09 168.40000000000001p 7.3e-09 168.41250000000002p 7.2047000000000002e-09 168.42499999999998p 7.1001750000000002e-09 168.4375p 6.9865839999999997e-09 168.44999999999999p 6.8640939999999996e-09 168.46250000000001p 6.7328870000000002e-09 168.47499999999999p 6.5931540000000002e-09 168.48750000000001p 6.445096e-09 168.5p 6.2889259999999997e-09 168.51249999999999p 6.124867e-09 168.52500000000001p 5.9531509999999998e-09
+ 168.53749999999999p 5.7740210000000002e-09 168.55000000000001p 5.587727e-09 168.5625p 5.3945300000000004e-09 168.57500000000002p 5.194698e-09 168.58749999999998p 4.988507e-09 168.59999999999999p 4.7762429999999998e-09 168.61249999999998p 4.5581970000000001e-09 168.625p 4.3346679999999997e-09 168.63750000000002p 4.1059600000000002e-09 168.65000000000001p 3.8723850000000002e-09 168.66250000000002p 3.6342589999999999e-09 168.67499999999998p 3.3919060000000001e-09 168.6875p 3.145652e-09 168.69999999999999p 2.8958280000000001e-09 168.71250000000001p 2.64277e-09 168.72499999999999p 2.3868159999999998e-09 168.73750000000001p 2.1283090000000002e-09 168.75p 1.867592e-09
+ 168.76249999999999p 1.6050129999999999e-09 168.77500000000001p 1.34092e-09 168.78749999999999p 1.0756610000000001e-09 168.80000000000001p 8.0958699999999997e-10 168.8125p 5.430487e-10 168.82500000000002p 2.7639609999999999e-10 168.83750000000001p 9.9786159999999999e-12 168.84999999999999p -2.558552e-10 168.86249999999998p -5.2075830000000005e-10 168.875p -7.8438599999999998e-10 168.88749999999999p -1.046396e-09 168.90000000000001p -1.306448e-09 168.91250000000002p -1.5642060000000001e-09 168.92499999999998p -1.8193389999999999e-09 168.9375p -2.0715170000000002e-09 168.94999999999999p -2.320417e-09 168.96250000000001p -2.5657200000000001e-09 168.97499999999999p -2.8071139999999999e-09
+ 168.98750000000001p -3.0442909999999999e-09 169p -3.276949e-09 169.01249999999999p -3.5047950000000002e-09 169.02500000000001p -3.7275409999999996e-09 169.03749999999999p -3.9449070000000001e-09 169.05000000000001p -4.1566210000000004e-09 169.0625p -4.3624170000000002e-09 169.07500000000002p -4.5620400000000001e-09 169.08750000000001p -4.7552429999999999e-09 169.09999999999999p -4.9417869999999996e-09 169.11249999999998p -5.1214440000000001e-09 169.125p -5.2939920000000001e-09 169.13749999999999p -5.4592239999999997e-09 169.15000000000001p -5.6169390000000003e-09 169.16250000000002p -5.7669470000000001e-09 169.17500000000001p -5.9090709999999996e-09 169.1875p -6.0431410000000002e-09 169.19999999999999p -6.169001e-09
+ 169.21250000000001p -6.2865049999999997e-09 169.22499999999999p -6.395518e-09 169.23750000000001p -6.4959169999999999e-09 169.25p -6.58759e-09 169.26249999999999p -6.6704360000000004e-09 169.27500000000001p -6.744369e-09 169.28749999999999p -6.8093109999999998e-09 169.30000000000001p -6.865198e-09 169.3125p -6.9119779999999997e-09 169.32500000000002p -6.94961e-09 169.33750000000001p -6.978066e-09 169.34999999999999p -6.9973310000000002e-09 169.36249999999998p -7.0073990000000001e-09 169.375p -7.0082790000000002e-09 169.38749999999999p -6.9999910000000003e-09 169.40000000000001p -6.982568e-09 169.41249999999999p -6.9560519999999996e-09 169.42500000000001p -6.9204990000000003e-09
+ 169.4375p -6.8759769999999999e-09 169.44999999999999p -6.8225659999999999e-09 169.46250000000001p -6.7603549999999997e-09 169.47499999999999p -6.689445e-09 169.48750000000001p -6.6099510000000002e-09 169.5p -6.521996e-09 169.51249999999999p -6.4257150000000001e-09 169.52499999999998p -6.3212530000000004e-09 169.53749999999999p -6.2087660000000002e-09 169.55000000000001p -6.088419e-09 169.5625p -5.960389e-09 169.57500000000002p -5.8248600000000001e-09 169.58750000000001p -5.6820279999999999e-09 169.59999999999999p -5.5320969999999998e-09 169.61249999999998p -5.3752789999999998e-09 169.625p -5.2117949999999998e-09 169.63749999999999p -5.0418759999999999e-09 169.65000000000001p -4.8657580000000001e-09
+ 169.66249999999999p -4.6836870000000003e-09 169.67500000000001p -4.4959140000000001e-09 169.6875p -4.3026980000000002e-09 169.69999999999999p -4.1043070000000001e-09 169.71250000000001p -3.9010100000000004e-09 169.72499999999999p -3.6930850000000002e-09 169.73750000000001p -3.4808159999999999e-09 169.75p -3.2644910000000001e-09 169.76250000000002p -3.0444020000000002e-09 169.77499999999998p -2.8208459999999998e-09 169.78749999999999p -2.5941240000000002e-09 169.80000000000001p -2.3645389999999999e-09 169.8125p -2.1324000000000002e-09 169.82500000000002p -1.898016e-09 169.83750000000001p -1.6616979999999999e-09 169.84999999999999p -1.4237620000000001e-09 169.86249999999998p -1.184522e-09 169.875p -9.4429380000000003e-10
+ 169.88749999999999p -7.0339500000000003e-10 169.90000000000001p -4.6214229999999998e-10 169.91249999999999p -2.208523e-10 169.92500000000001p 2.0159139999999999e-11 169.9375p 2.605771e-10 169.94999999999999p 5.0008829999999995e-10 169.96250000000001p 7.3838129999999999e-10 169.97499999999999p 9.7514699999999996e-10 169.98750000000001p 1.2100789999999999e-09)
R_LOAD OUT 0 10
I_IBIAS 0 IBIAS pwl(0p 0 1p 35u 2p 35u 170p 35u)
.tran 0.0125p 170p
.print P(BJs|XBQ) V(BJs|XBQ) I(BJs|XBQ)
.print P(BJL1|XBQ) V(BJL1|XBQ) I(BJL1|XBQ)
.print P(BJL2|XBQ) V(BJL2|XBQ) I(BJL2|XBQ)
.print I(I_REPLAY) I(I_IBIAS) V(IN) V(OUT) I(R_LOAD)
.print I(Lin|XBQ) I(L0|XBQ) I(L1|XBQ) I(L2|XBQ) I(RB|XBQ) I(RJ1|XBQ) I(RJ2|XBQ)
.end
