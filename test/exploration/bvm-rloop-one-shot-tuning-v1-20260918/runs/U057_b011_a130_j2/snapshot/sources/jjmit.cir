* Unified JJ Model — area-scaled jjmit for all circuits
* ColdFlux SFQ5ee standard: Ic×RN=1.6mV, R0/RN=10, CAP∝IC
*
* Usage:
*   .include ../../circuits/models/jjmit.cir
*   B1 node1 node2 jjmit area=3.5    → IC=350μA  (T1 J1, J2)
*   B2 node1 node2 jjmit area=1.2    → IC=120μA  (BVM JM1)
*   B3 node1 node2 jjmit area=1.0    → IC=100μA  (SFQ logic)
*
* All junctions share: Ic×RN=1.6mV, CAP=0.07pF×area, R0/RN=10

.model jjmit jj(RTYPE=1, VG=2.8m, CAP=0.07p, r0=160, rn=16, icrit=0.1m)
