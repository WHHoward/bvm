* BVM 4x4 diagonal collection; canonical BVM/QB/sJTL/CB; T1_MODE=OFF.
* Cell WL/BL are physically shared buses; SE is cell-local.
.include ../../../../../circuits/models/jjmit.cir
.include ../../../../../circuits/bvm/bvm_cell_0923.cir
.include ../../../../../circuits/qb/BQ_0928.cir
.include ../../../../../circuits/sJTL_0923.cir
.include ../../../../../circuits/CB/CB_0928.cir
.include stimulus.inc

XBVM_R1C1 WL_R1 BL_C1 SE_R1C1 SL_R1C1 BVM
XBQ_R1C1 SL_R1C1 MERGE_D3_L1 BQ
XBVM_R1C2 WL_R1 BL_C2 SE_R1C2 SL_R1C2 BVM
XBQ_R1C2 SL_R1C2 MERGE_D2_L1 BQ
XBVM_R1C3 WL_R1 BL_C3 SE_R1C3 SL_R1C3 BVM
XBQ_R1C3 SL_R1C3 MERGE_D1_L1 BQ
XBVM_R1C4 WL_R1 BL_C4 SE_R1C4 SL_R1C4 BVM
XBQ_R1C4 SL_R1C4 MERGE_D0_L1 BQ
XBVM_R2C1 WL_R2 BL_C1 SE_R2C1 SL_R2C1 BVM
XBQ_R2C1 SL_R2C1 MERGE_D4_L1 BQ
XBVM_R2C2 WL_R2 BL_C2 SE_R2C2 SL_R2C2 BVM
XBQ_R2C2 SL_R2C2 MERGE_D3_L2 BQ
XBVM_R2C3 WL_R2 BL_C3 SE_R2C3 SL_R2C3 BVM
XBQ_R2C3 SL_R2C3 MERGE_D2_L2 BQ
XBVM_R2C4 WL_R2 BL_C4 SE_R2C4 SL_R2C4 BVM
XBQ_R2C4 SL_R2C4 MERGE_D1_L2 BQ
XBVM_R3C1 WL_R3 BL_C1 SE_R3C1 SL_R3C1 BVM
XBQ_R3C1 SL_R3C1 MERGE_D5_L1 BQ
XBVM_R3C2 WL_R3 BL_C2 SE_R3C2 SL_R3C2 BVM
XBQ_R3C2 SL_R3C2 MERGE_D4_L2 BQ
XBVM_R3C3 WL_R3 BL_C3 SE_R3C3 SL_R3C3 BVM
XBQ_R3C3 SL_R3C3 MERGE_D3_L3 BQ
XBVM_R3C4 WL_R3 BL_C4 SE_R3C4 SL_R3C4 BVM
XBQ_R3C4 SL_R3C4 MERGE_D2_L3 BQ
XBVM_R4C1 WL_R4 BL_C1 SE_R4C1 SL_R4C1 BVM
XBQ_R4C1 SL_R4C1 MERGE_D6_L1 BQ
XBVM_R4C2 WL_R4 BL_C2 SE_R4C2 SL_R4C2 BVM
XBQ_R4C2 SL_R4C2 MERGE_D5_L2 BQ
XBVM_R4C3 WL_R4 BL_C3 SE_R4C3 SL_R4C3 BVM
XBQ_R4C3 SL_R4C3 MERGE_D4_L3 BQ
XBVM_R4C4 WL_R4 BL_C4 SE_R4C4 SL_R4C4 BVM
XBQ_R4C4 SL_R4C4 MERGE_D3_L4 BQ
XSJTL_D0_L1 MERGE_D0_L1 SJTL_OUT_D0_L1 sJTL
XCB_D0_L1 SJTL_OUT_D0_L1 DOUT_D0 CB
R_TERM_D0 DOUT_D0 0 2
XSJTL_D1_L1 MERGE_D1_L1 SJTL_OUT_D1_L1 sJTL
XCB_D1_L1 SJTL_OUT_D1_L1 MERGE_D1_L2 CB
XSJTL_D1_L2 MERGE_D1_L2 SJTL_OUT_D1_L2 sJTL
XCB_D1_L2 SJTL_OUT_D1_L2 DOUT_D1 CB
R_TERM_D1 DOUT_D1 0 2
XSJTL_D2_L1 MERGE_D2_L1 SJTL_OUT_D2_L1 sJTL
XCB_D2_L1 SJTL_OUT_D2_L1 MERGE_D2_L2 CB
XSJTL_D2_L2 MERGE_D2_L2 SJTL_OUT_D2_L2 sJTL
XCB_D2_L2 SJTL_OUT_D2_L2 MERGE_D2_L3 CB
XSJTL_D2_L3 MERGE_D2_L3 SJTL_OUT_D2_L3 sJTL
XCB_D2_L3 SJTL_OUT_D2_L3 DOUT_D2 CB
R_TERM_D2 DOUT_D2 0 2
XSJTL_D3_L1 MERGE_D3_L1 SJTL_OUT_D3_L1 sJTL
XCB_D3_L1 SJTL_OUT_D3_L1 MERGE_D3_L2 CB
XSJTL_D3_L2 MERGE_D3_L2 SJTL_OUT_D3_L2 sJTL
XCB_D3_L2 SJTL_OUT_D3_L2 MERGE_D3_L3 CB
XSJTL_D3_L3 MERGE_D3_L3 SJTL_OUT_D3_L3 sJTL
XCB_D3_L3 SJTL_OUT_D3_L3 MERGE_D3_L4 CB
XSJTL_D3_L4 MERGE_D3_L4 SJTL_OUT_D3_L4 sJTL
XCB_D3_L4 SJTL_OUT_D3_L4 DOUT_D3 CB
R_TERM_D3 DOUT_D3 0 2
XSJTL_D4_L1 MERGE_D4_L1 SJTL_OUT_D4_L1 sJTL
XCB_D4_L1 SJTL_OUT_D4_L1 MERGE_D4_L2 CB
XSJTL_D4_L2 MERGE_D4_L2 SJTL_OUT_D4_L2 sJTL
XCB_D4_L2 SJTL_OUT_D4_L2 MERGE_D4_L3 CB
XSJTL_D4_L3 MERGE_D4_L3 SJTL_OUT_D4_L3 sJTL
XCB_D4_L3 SJTL_OUT_D4_L3 DOUT_D4 CB
R_TERM_D4 DOUT_D4 0 2
XSJTL_D5_L1 MERGE_D5_L1 SJTL_OUT_D5_L1 sJTL
XCB_D5_L1 SJTL_OUT_D5_L1 MERGE_D5_L2 CB
XSJTL_D5_L2 MERGE_D5_L2 SJTL_OUT_D5_L2 sJTL
XCB_D5_L2 SJTL_OUT_D5_L2 DOUT_D5 CB
R_TERM_D5 DOUT_D5 0 2
XSJTL_D6_L1 MERGE_D6_L1 SJTL_OUT_D6_L1 sJTL
XCB_D6_L1 SJTL_OUT_D6_L1 DOUT_D6 CB
R_TERM_D6 DOUT_D6 0 2

* Registered probes; P is raw radians.
.print I(R_WL|XBVM_R1C1)
.print I(R_BL|XBVM_R1C1)
.print I(R_SE|XBVM_R1C1)
.print V(SL_R1C1)
.print I(R_WL|XBVM_R1C2)
.print I(R_BL|XBVM_R1C2)
.print I(R_SE|XBVM_R1C2)
.print V(SL_R1C2)
.print I(R_WL|XBVM_R1C3)
.print I(R_BL|XBVM_R1C3)
.print I(R_SE|XBVM_R1C3)
.print V(SL_R1C3)
.print I(R_WL|XBVM_R1C4)
.print I(R_BL|XBVM_R1C4)
.print I(R_SE|XBVM_R1C4)
.print V(SL_R1C4)
.print I(R_WL|XBVM_R2C1)
.print I(R_BL|XBVM_R2C1)
.print I(R_SE|XBVM_R2C1)
.print V(SL_R2C1)
.print I(R_WL|XBVM_R2C2)
.print I(R_BL|XBVM_R2C2)
.print I(R_SE|XBVM_R2C2)
.print V(SL_R2C2)
.print I(R_WL|XBVM_R2C3)
.print I(R_BL|XBVM_R2C3)
.print I(R_SE|XBVM_R2C3)
.print V(SL_R2C3)
.print I(R_WL|XBVM_R2C4)
.print I(R_BL|XBVM_R2C4)
.print I(R_SE|XBVM_R2C4)
.print V(SL_R2C4)
.print I(R_WL|XBVM_R3C1)
.print I(R_BL|XBVM_R3C1)
.print I(R_SE|XBVM_R3C1)
.print V(SL_R3C1)
.print I(R_WL|XBVM_R3C2)
.print I(R_BL|XBVM_R3C2)
.print I(R_SE|XBVM_R3C2)
.print V(SL_R3C2)
.print I(R_WL|XBVM_R3C3)
.print I(R_BL|XBVM_R3C3)
.print I(R_SE|XBVM_R3C3)
.print V(SL_R3C3)
.print I(R_WL|XBVM_R3C4)
.print I(R_BL|XBVM_R3C4)
.print I(R_SE|XBVM_R3C4)
.print V(SL_R3C4)
.print I(R_WL|XBVM_R4C1)
.print I(R_BL|XBVM_R4C1)
.print I(R_SE|XBVM_R4C1)
.print V(SL_R4C1)
.print I(R_WL|XBVM_R4C2)
.print I(R_BL|XBVM_R4C2)
.print I(R_SE|XBVM_R4C2)
.print V(SL_R4C2)
.print I(R_WL|XBVM_R4C3)
.print I(R_BL|XBVM_R4C3)
.print I(R_SE|XBVM_R4C3)
.print V(SL_R4C3)
.print I(R_WL|XBVM_R4C4)
.print I(R_BL|XBVM_R4C4)
.print I(R_SE|XBVM_R4C4)
.print V(SL_R4C4)
.print V(MERGE_D0_L1)
.print V(DOUT_D0)
.print I(R_TERM_D0)
.print P(BJ1|XCB_D0_L1)
.print V(BJ1|XCB_D0_L1)
.print P(BJ2|XCB_D0_L1)
.print V(BJ2|XCB_D0_L1)
.print V(MERGE_D1_L1)
.print V(MERGE_D1_L2)
.print V(DOUT_D1)
.print I(R_TERM_D1)
.print P(BJ1|XCB_D1_L2)
.print V(BJ1|XCB_D1_L2)
.print P(BJ2|XCB_D1_L2)
.print V(BJ2|XCB_D1_L2)
.print V(MERGE_D2_L1)
.print V(MERGE_D2_L2)
.print V(MERGE_D2_L3)
.print V(DOUT_D2)
.print I(R_TERM_D2)
.print P(BJ1|XCB_D2_L3)
.print V(BJ1|XCB_D2_L3)
.print P(BJ2|XCB_D2_L3)
.print V(BJ2|XCB_D2_L3)
.print V(MERGE_D3_L1)
.print V(MERGE_D3_L2)
.print V(MERGE_D3_L3)
.print V(MERGE_D3_L4)
.print V(DOUT_D3)
.print I(R_TERM_D3)
.print P(BJ1|XCB_D3_L4)
.print V(BJ1|XCB_D3_L4)
.print P(BJ2|XCB_D3_L4)
.print V(BJ2|XCB_D3_L4)
.print V(MERGE_D4_L1)
.print V(MERGE_D4_L2)
.print V(MERGE_D4_L3)
.print V(DOUT_D4)
.print I(R_TERM_D4)
.print P(BJ1|XCB_D4_L3)
.print V(BJ1|XCB_D4_L3)
.print P(BJ2|XCB_D4_L3)
.print V(BJ2|XCB_D4_L3)
.print V(MERGE_D5_L1)
.print V(MERGE_D5_L2)
.print V(DOUT_D5)
.print I(R_TERM_D5)
.print P(BJ1|XCB_D5_L2)
.print V(BJ1|XCB_D5_L2)
.print P(BJ2|XCB_D5_L2)
.print V(BJ2|XCB_D5_L2)
.print V(MERGE_D6_L1)
.print V(DOUT_D6)
.print I(R_TERM_D6)
.print P(BJ1|XCB_D6_L1)
.print V(BJ1|XCB_D6_L1)
.print P(BJ2|XCB_D6_L1)
.print V(BJ2|XCB_D6_L1)
.print I(L_SL|XBVM_R1C1)
.print P(BJ1|XBQ_R1C1)
.print V(BJ1|XBQ_R1C1)
.print P(BJ2|XBQ_R1C1)
.print V(BJ2|XBQ_R1C1)
.print P(BJ3|XBQ_R1C1)
.print V(BJ3|XBQ_R1C1)
.print I(LIN|XBQ_R1C1)
.print I(L1|XBQ_R1C1)
.print I(L2|XBQ_R1C1)
.print I(L3|XBQ_R1C1)
.print I(RJ1|XBQ_R1C1)
.print I(RJ2|XBQ_R1C1)
.print I(IB2|XBQ_R1C1)
.print I(L_SL|XBVM_R2C2)
.print P(BJ1|XBQ_R2C2)
.print V(BJ1|XBQ_R2C2)
.print P(BJ2|XBQ_R2C2)
.print V(BJ2|XBQ_R2C2)
.print P(BJ3|XBQ_R2C2)
.print V(BJ3|XBQ_R2C2)
.print I(LIN|XBQ_R2C2)
.print I(L1|XBQ_R2C2)
.print I(L2|XBQ_R2C2)
.print I(L3|XBQ_R2C2)
.print I(RJ1|XBQ_R2C2)
.print I(RJ2|XBQ_R2C2)
.print I(IB2|XBQ_R2C2)
.print I(L_SL|XBVM_R3C3)
.print P(BJ1|XBQ_R3C3)
.print V(BJ1|XBQ_R3C3)
.print P(BJ2|XBQ_R3C3)
.print V(BJ2|XBQ_R3C3)
.print P(BJ3|XBQ_R3C3)
.print V(BJ3|XBQ_R3C3)
.print I(LIN|XBQ_R3C3)
.print I(L1|XBQ_R3C3)
.print I(L2|XBQ_R3C3)
.print I(L3|XBQ_R3C3)
.print I(RJ1|XBQ_R3C3)
.print I(RJ2|XBQ_R3C3)
.print I(IB2|XBQ_R3C3)
.print I(L_SL|XBVM_R4C4)
.print P(BJ1|XBQ_R4C4)
.print V(BJ1|XBQ_R4C4)
.print P(BJ2|XBQ_R4C4)
.print V(BJ2|XBQ_R4C4)
.print P(BJ3|XBQ_R4C4)
.print V(BJ3|XBQ_R4C4)
.print I(LIN|XBQ_R4C4)
.print I(L1|XBQ_R4C4)
.print I(L2|XBQ_R4C4)
.print I(L3|XBQ_R4C4)
.print I(RJ1|XBQ_R4C4)
.print I(RJ2|XBQ_R4C4)
.print I(IB2|XBQ_R4C4)
.print V(SJTL_OUT_D3_L1)
.print P(BJ1|XSJTL_D3_L1)
.print V(BJ1|XSJTL_D3_L1)
.print I(L1|XSJTL_D3_L1)
.print I(L2|XSJTL_D3_L1)
.print I(RJ1|XSJTL_D3_L1)
.print P(BJ1|XCB_D3_L1)
.print V(BJ1|XCB_D3_L1)
.print P(BJ2|XCB_D3_L1)
.print V(BJ2|XCB_D3_L1)
.print I(L1|XCB_D3_L1)
.print I(L2|XCB_D3_L1)
.print I(L3|XCB_D3_L1)
.print I(L4|XCB_D3_L1)
.print I(RJ1|XCB_D3_L1)
.print I(RJ2|XCB_D3_L1)
.print I(IB1|XCB_D3_L1)
.print V(SJTL_OUT_D3_L2)
.print P(BJ1|XSJTL_D3_L2)
.print V(BJ1|XSJTL_D3_L2)
.print I(L1|XSJTL_D3_L2)
.print I(L2|XSJTL_D3_L2)
.print I(RJ1|XSJTL_D3_L2)
.print P(BJ1|XCB_D3_L2)
.print V(BJ1|XCB_D3_L2)
.print P(BJ2|XCB_D3_L2)
.print V(BJ2|XCB_D3_L2)
.print I(L1|XCB_D3_L2)
.print I(L2|XCB_D3_L2)
.print I(L3|XCB_D3_L2)
.print I(L4|XCB_D3_L2)
.print I(RJ1|XCB_D3_L2)
.print I(RJ2|XCB_D3_L2)
.print I(IB1|XCB_D3_L2)
.print V(SJTL_OUT_D3_L3)
.print P(BJ1|XSJTL_D3_L3)
.print V(BJ1|XSJTL_D3_L3)
.print I(L1|XSJTL_D3_L3)
.print I(L2|XSJTL_D3_L3)
.print I(RJ1|XSJTL_D3_L3)
.print P(BJ1|XCB_D3_L3)
.print V(BJ1|XCB_D3_L3)
.print P(BJ2|XCB_D3_L3)
.print V(BJ2|XCB_D3_L3)
.print I(L1|XCB_D3_L3)
.print I(L2|XCB_D3_L3)
.print I(L3|XCB_D3_L3)
.print I(L4|XCB_D3_L3)
.print I(RJ1|XCB_D3_L3)
.print I(RJ2|XCB_D3_L3)
.print I(IB1|XCB_D3_L3)
.print V(SJTL_OUT_D3_L4)
.print P(BJ1|XSJTL_D3_L4)
.print V(BJ1|XSJTL_D3_L4)
.print I(L1|XSJTL_D3_L4)
.print I(L2|XSJTL_D3_L4)
.print I(RJ1|XSJTL_D3_L4)
.print I(L1|XCB_D3_L4)
.print I(L2|XCB_D3_L4)
.print I(L3|XCB_D3_L4)
.print I(L4|XCB_D3_L4)
.print I(RJ1|XCB_D3_L4)
.print I(RJ2|XCB_D3_L4)
.print I(IB1|XCB_D3_L4)
.tran 0.01p 250p
.end
