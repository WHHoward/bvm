* PAPER-SL-Q2 paper-j1-logical1-read: exact current replay; source=paper-j1-logical1-read.csv
.include jjmit.cir
.include bq_cell.cir
XBQ IN OUT IBIAS BQ
I_REPLAY 0 IN pwl(0p 0 0.012500000000000001p 0 0.025000000000000001p 0 0.037499999999999999p 0 0.050000000000000003p 0 0.0625p 0 0.074999999999999997p 0 0.087500000000000008p 0 0.10000000000000001p 0 0.1125p 0 0.125p 0 0.13749999999999998p 0 0.14999999999999999p 0 0.16249999999999998p 0 0.17500000000000002p 0 0.1875p 0 0.20000000000000001p 0 0.21249999999999999p 0
+ 0.22500000000000001p 0 0.23749999999999999p 0 0.25p 0 0.26250000000000001p 0 0.27499999999999997p 0 0.28749999999999998p 0 0.29999999999999999p 0 0.3125p 0 0.32499999999999996p 0 0.33749999999999997p 0 0.35000000000000003p 0 0.36250000000000004p 0 0.375p 0 0.38750000000000001p 0 0.40000000000000002p 0 0.41250000000000003p 0 0.42499999999999999p 0 0.4375p 0
+ 0.45000000000000001p 0 0.46250000000000002p 0 0.47499999999999998p 0 0.48749999999999999p 0 0.5p 0 0.51249999999999996p 0 0.52500000000000002p 0 0.53749999999999998p 0 0.54999999999999993p 0 0.5625p 0 0.57499999999999996p 0 0.58750000000000002p 0 0.59999999999999998p 0 0.61249999999999993p 0 0.625p 0 0.63749999999999996p 0 0.64999999999999991p 0 0.66249999999999998p 0
+ 0.67499999999999993p 0 0.6875p 0 0.70000000000000007p 0 0.71250000000000002p 0 0.72500000000000009p 0 0.73750000000000004p 0 0.75p 0 0.76250000000000007p 0 0.77500000000000002p 0 0.78749999999999998p 0 0.80000000000000004p 0 0.8125p 0 0.82500000000000007p 0 0.83750000000000002p 0 0.84999999999999998p 0 0.86250000000000004p 0 0.875p 0 0.88749999999999996p 0
+ 0.90000000000000002p 0 0.91249999999999998p 0 0.92500000000000004p 0 0.9375p 0 0.94999999999999996p 0 0.96250000000000002p 0 0.97499999999999998p 0 0.98749999999999993p 0 1p 0 1.0125p 0 1.0249999999999999p 0 1.0374999999999999p 0 1.05p 0 1.0625p 0 1.075p 0 1.0874999999999999p 0 1.0999999999999999p 0 1.1125p 0
+ 1.125p 0 1.1375p 0 1.1499999999999999p 0 1.1624999999999999p 0 1.175p 0 1.1875p 0 1.2p 0 1.2124999999999999p 0 1.2249999999999999p 0 1.2374999999999998p 0 1.25p 0 1.2625p 0 1.2749999999999999p 0 1.2874999999999999p 0 1.2999999999999998p 0 1.3125p 0 1.325p 0 1.3374999999999999p 0
+ 1.3499999999999999p 0 1.3624999999999998p 0 1.375p 0 1.3875000000000002p 0 1.4000000000000001p 0 1.4125000000000001p 0 1.425p 0 1.4375p 0 1.4500000000000002p 0 1.4625000000000001p 0 1.4750000000000001p 0 1.4875p 0 1.5p 0 1.5125000000000002p 0 1.5250000000000001p 0 1.5375000000000001p 0 1.55p 0 1.5625p 0
+ 1.575p 0 1.5875000000000001p 0 1.6000000000000001p 0 1.6125p 0 1.625p 0 1.6375p 0 1.6500000000000001p 0 1.6625000000000001p 0 1.675p 0 1.6875p 0 1.7p 0 1.7125000000000001p 0 1.7250000000000001p 0 1.7375p 0 1.75p 0 1.7625p 0 1.7749999999999999p 0 1.7875000000000001p 0
+ 1.8p 0 1.8125p 0 1.825p 0 1.8375000000000001p 0 1.8625000000000003p 0 1.875p 0 1.8875000000000002p 0 1.8999999999999999p 0 1.9125000000000001p 0 1.925p 0 1.9375000000000002p 0 1.95p 0 1.9625000000000001p 0 1.9749999999999999p 0 1.9875000000000003p 0 2p 0 2.0125000000000002p 0 2.0249999999999999p 0
+ 2.0375000000000001p 0 2.0499999999999998p 0 2.0625p 0 2.0749999999999997p 0 2.0875000000000004p 0 2.1000000000000001p 0 2.1125000000000003p 0 2.125p 0 2.1375000000000002p 0 2.1499999999999999p 0 2.1625000000000001p 0 2.1749999999999998p 0 2.1875p 0 2.1999999999999997p 0 2.2124999999999999p 0 2.2250000000000001p 0 2.2375000000000003p 0 2.25p 0
+ 2.2625000000000002p 0 2.2749999999999999p 0 2.2875000000000001p 0 2.2999999999999998p 0 2.3125p 0 2.3249999999999997p 0 2.3374999999999999p 0 2.3500000000000001p 0 2.3625000000000003p 0 2.375p 0 2.3875000000000002p 0 2.3999999999999999p 0 2.4125000000000001p 0 2.4249999999999998p 0 2.4375p 0 2.4499999999999997p 0 2.4624999999999999p 0 2.4749999999999996p 0
+ 2.4875000000000003p 0 2.5p 0 2.5125000000000002p 0 2.5249999999999999p 0 2.5375000000000001p 0 2.5499999999999998p 0 2.5625p 0 2.5749999999999997p 0 2.5874999999999999p 0 2.5999999999999996p 0 2.6124999999999998p 0 2.625p 0 2.6375000000000002p 0 2.6499999999999999p 0 2.6625000000000001p 0 2.6749999999999998p 0 2.6875p 0 2.6999999999999997p 0
+ 2.7124999999999999p 0 2.7249999999999996p 0 2.7374999999999998p 0 2.75p 0 2.7625000000000002p 0 2.7750000000000004p 0 2.7875000000000001p 0 2.8000000000000003p 0 2.8125p 0 2.8250000000000002p 0 2.8374999999999999p 0 2.8500000000000001p 0 2.8624999999999998p 0 2.875p 0 2.8875000000000002p 0 2.9000000000000004p 0 2.9125000000000001p 0 2.9250000000000003p 0
+ 2.9375p 0 2.9500000000000002p 0 2.9624999999999999p 0 2.9750000000000001p 0 2.9874999999999998p 0 3p 0 3.0124999999999997p 0 3.0250000000000004p 0 3.0375000000000001p 0 3.0500000000000003p 0 3.0625p 0 3.0750000000000002p 0 3.0874999999999999p 0 3.1000000000000001p 0 3.1124999999999998p 0 3.125p 0 3.1374999999999997p 0 3.1499999999999999p 0
+ 3.1625000000000001p 0 3.1750000000000003p 0 3.1875p 0 3.2000000000000002p 0 3.2124999999999999p 0 3.2250000000000001p 0 3.2374999999999998p 0 3.25p 0 3.2624999999999997p 0 3.2749999999999999p 0 3.2875000000000001p 0 3.3000000000000003p 0 3.3125p 0 3.3250000000000002p 0 3.3374999999999999p 0 3.3500000000000001p 0 3.3624999999999998p 0 3.375p 0
+ 3.3874999999999997p 0 3.3999999999999999p 0 3.4124999999999996p 0 3.4250000000000003p 0 3.4375p 0 3.4500000000000002p 0 3.4624999999999999p 0 3.4750000000000001p 0 3.4874999999999998p 0 3.5p 0 3.5124999999999997p 0 3.5249999999999999p 0 3.5374999999999996p 0 3.5499999999999998p 0 3.5625p 0 3.5750000000000002p 0 3.5874999999999999p 0 3.6000000000000001p 0
+ 3.6124999999999998p 0 3.625p 0 3.6374999999999997p 0 3.6499999999999999p 0 3.6624999999999996p 0 3.6750000000000003p 0 3.6875p 0 3.7000000000000002p 0 3.7124999999999999p 0 3.7250000000000005p 0 3.7375000000000003p 0 3.75p 0 3.7624999999999997p 0 3.7750000000000004p 0 3.7875000000000001p 0 3.7999999999999998p 0 3.8124999999999996p 0 3.8250000000000002p 0
+ 3.8375000000000004p 0 3.8500000000000001p 0 3.8624999999999998p 0 3.8750000000000004p 0 3.8875000000000002p 0 3.8999999999999999p 0 3.9124999999999996p 0 3.9250000000000003p 0 3.9375p 0 3.9499999999999997p 0 3.9624999999999999p 0 3.9750000000000005p 0 3.9875000000000003p 0 4p 0 4.0124999999999993p 0 4.0250000000000004p 0 4.0375000000000005p 0 4.0499999999999998p 0
+ 4.0625p 0 4.0750000000000002p 0 4.0875000000000004p 0 4.0999999999999996p 0 4.1124999999999998p 0 4.125p 0 4.1375000000000002p 0 4.1499999999999995p 0 4.1624999999999996p 0 4.1750000000000007p 0 4.1875p 0 4.2000000000000002p 0 4.2124999999999995p 0 4.2250000000000005p 0 4.2374999999999998p 0 4.25p 0 4.2624999999999993p 0 4.2750000000000004p 0
+ 4.2874999999999996p 0 4.2999999999999998p 0 4.3125p 0 4.3250000000000002p 0 4.3375000000000004p 0 4.3499999999999996p 0 4.3624999999999998p 0 4.375p 0 4.3875000000000002p 0 4.3999999999999995p 0 4.4124999999999996p 0 4.4249999999999998p 0 4.4375p 0 4.4500000000000002p 0 4.4624999999999995p 0 4.4750000000000005p 0 4.4874999999999998p 0 4.5p 0
+ 4.5124999999999993p 0 4.5250000000000004p 0 4.5374999999999996p 0 4.5499999999999998p 0 4.5625p 0 4.5750000000000002p 0 4.5875000000000004p 0 4.5999999999999996p 0 4.6125000000000007p 0 4.625p 0 4.6375000000000002p 0 4.6499999999999995p 0 4.6625000000000005p 0 4.6749999999999998p 0 4.6875p 0 4.7000000000000002p 0 4.7125000000000004p 0 4.7250000000000005p 0
+ 4.7374999999999998p 0 4.75p 0 4.7625000000000002p 0 4.7750000000000004p 0 4.7874999999999996p 0 4.7999999999999998p 0 4.8125p 0 4.8250000000000002p 0 4.8375000000000004p 0 4.8499999999999996p 0 4.8625000000000007p 0 4.875p 0 4.8875000000000002p 0 4.8999999999999995p 0 4.9125000000000005p 0 4.9249999999999998p 0 4.9375p 0 4.9499999999999993p 0
+ 4.9625000000000004p 0 4.9750000000000005p 0 4.9874999999999998p 0 5p 0 5.0125000000000002p 0 5.0250000000000004p 0 5.0374999999999996p 0 5.0499999999999998p 0 5.0625p 0 5.0750000000000002p 0 5.0874999999999995p 0 5.0999999999999996p 0 5.1125000000000007p 0 5.125p 0 5.1375000000000002p 0 5.1499999999999995p 0 5.1625000000000005p 0 5.1749999999999998p 0
+ 5.1875p 0 5.1999999999999993p 0 5.2125000000000004p 0 5.2249999999999996p 0 5.2374999999999998p 0 5.25p 0 5.2625000000000002p 0 5.2750000000000004p 0 5.2874999999999996p 0 5.2999999999999998p 0 5.3125p 0 5.3250000000000002p 0 5.3374999999999995p 0 5.3499999999999996p 0 5.3624999999999998p 0 5.375p 0 5.3875000000000002p 0 5.3999999999999995p 0
+ 5.4125000000000005p 0 5.4249999999999998p 0 5.4375p 0 5.4499999999999993p 0 5.4625000000000004p 0 5.4749999999999996p 0 5.4874999999999998p 0 5.5p 0 5.5125000000000002p 0 5.5250000000000004p 0 5.5374999999999996p 0 5.5500000000000007p 0 5.5625p 0 5.5750000000000002p 0 5.5874999999999995p 0 5.6000000000000005p 0 5.6124999999999998p 0 5.625p 0
+ 5.6375000000000002p 0 5.6500000000000004p 0 5.6625000000000005p 0 5.6749999999999998p 0 5.6875p 0 5.7000000000000002p 0 5.7125000000000004p 0 5.7249999999999996p 0 5.7374999999999998p 0 5.75p 0 5.7625000000000002p 0 5.7750000000000004p 0 5.7874999999999996p 0 5.8000000000000007p 0 5.8125p 0 5.8250000000000002p 0 5.8374999999999995p 0 5.8500000000000005p 0
+ 5.8624999999999998p 0 5.875p 0 5.8874999999999993p 0 5.9000000000000004p 0 5.9125000000000005p 0 5.9249999999999998p 0 5.9375p 0 5.9500000000000002p 0 5.9625000000000004p 0 5.9749999999999996p 0 5.9874999999999998p 0 6p 0 6.0125000000000002p 0 6.0249999999999995p 0 6.0374999999999996p 0 6.0500000000000007p 0 6.0625p 0 6.0750000000000002p 0
+ 6.0874999999999995p 0 6.1000000000000005p 0 6.1124999999999998p 0 6.125p 0 6.1374999999999993p 0 6.1500000000000004p 0 6.1624999999999996p 0 6.1749999999999998p 0 6.1875p 0 6.2000000000000002p 0 6.2125000000000004p 0 6.2249999999999996p 0 6.2374999999999998p 0 6.25p 0 6.2625000000000002p 0 6.2749999999999995p 0 6.2874999999999996p 0 6.2999999999999998p 0
+ 6.3125p 0 6.3250000000000002p 0 6.3374999999999995p 0 6.3500000000000005p 0 6.3624999999999998p 0 6.375p 0 6.3875000000000002p 0 6.4000000000000004p 0 6.4124999999999996p 0 6.4249999999999998p 0 6.4375p 0 6.4500000000000002p 0 6.4625000000000004p 0 6.4749999999999996p 0 6.4875000000000007p 0 6.5p 0 6.5125000000000002p 0 6.5249999999999995p 0
+ 6.5375000000000005p 0 6.5499999999999998p 0 6.5625p 0 6.5750000000000002p 0 6.5875000000000004p 0 6.6000000000000005p 0 6.6124999999999998p 0 6.625p 0 6.6375000000000002p 0 6.6500000000000004p 0 6.6624999999999996p 0 6.6749999999999998p 0 6.6875p 0 6.7000000000000002p 0 6.7125000000000004p 0 6.7249999999999996p 0 6.7375000000000007p 0 6.75p 0
+ 6.7625000000000002p 0 6.7749999999999995p 0 6.7875000000000005p 0 6.7999999999999998p 0 6.8125p 0 6.8249999999999993p 0 6.8375000000000004p 0 6.8500000000000005p 0 6.8624999999999998p 0 6.875p 0 6.8875000000000002p 0 6.9000000000000004p 0 6.9124999999999996p 0 6.9249999999999998p 0 6.9375p 0 6.9500000000000002p 0 6.9624999999999995p 0 6.9749999999999996p 0
+ 6.9874999999999998p 0 7p 0 7.0125000000000002p 0 7.0249999999999995p 0 7.0375000000000005p 0 7.0499999999999998p 0 7.0625p 0 7.0749999999999993p 0 7.0875000000000004p 0 7.0999999999999996p 0 7.1124999999999998p 0 7.125p 0 7.1375000000000002p 0 7.1500000000000004p 0 7.1624999999999996p 0 7.1749999999999998p 0 7.1875p 0 7.2000000000000002p 0
+ 7.2124999999999995p 0 7.2249999999999996p 0 7.2374999999999998p 0 7.25p 0 7.2625000000000002p 0 7.2749999999999995p 0 7.2874999999999996p 0 7.2999999999999998p 0 7.3125000000000009p 0 7.3249999999999993p 0 7.3375000000000004p 0 7.3500000000000005p 0 7.3624999999999998p 0 7.375p 0 7.3874999999999993p 0 7.4000000000000004p 0 7.4125000000000005p 0 7.4249999999999998p 0
+ 7.4375p 0 7.4500000000000011p 0 7.4624999999999995p 0 7.4750000000000005p 0 7.4874999999999989p 0 7.5p 0 7.5125000000000002p 0 7.5249999999999995p 0 7.5375000000000005p 0 7.5500000000000007p 0 7.5625p 0 7.5750000000000002p 0 7.5874999999999995p 0 7.5999999999999996p 0 7.6125000000000007p 0 7.6249999999999991p 0 7.6375000000000002p 0 7.6500000000000004p 0
+ 7.6624999999999996p 0 7.6750000000000007p 0 7.6874999999999991p 0 7.7000000000000002p 0 7.7125000000000004p 0 7.7249999999999996p 0 7.7374999999999998p 0 7.7500000000000009p 0 7.7624999999999993p 0 7.7750000000000004p 0 7.7874999999999996p 0 7.7999999999999998p 0 7.8125000000000009p 0 7.8249999999999993p 0 7.8375000000000004p 0 7.8500000000000005p 0 7.8624999999999998p 0 7.875p 0
+ 7.8874999999999993p 0 7.8999999999999995p 0 7.9125000000000005p 0 7.9249999999999998p 0 7.9375p 0 7.9500000000000011p 0 7.9624999999999995p 0 7.9750000000000005p 0 7.9874999999999989p 0 8p 0 8.0125000000000011p 0 8.0249999999999986p 0 8.0374999999999996p 0 8.0500000000000007p 0 8.0625p 0 8.0750000000000011p 0 8.0874999999999986p 0 8.0999999999999996p 0
+ 8.1125000000000007p 0 8.125p 0 8.1374999999999993p 0 8.1500000000000004p 0 8.1624999999999996p 0 8.1750000000000007p 0 8.1875p 0 8.1999999999999993p 0 8.2125000000000004p 0 8.2249999999999996p 0 8.2375000000000007p 0 8.25p 0 8.2624999999999993p 0 8.2750000000000004p 0 8.2875000000000014p 0 8.2999999999999989p 0 8.3125p 0 8.3249999999999993p 0
+ 8.3375000000000004p 0 8.3500000000000014p 0 8.3624999999999989p 0 8.375p 0 8.3875000000000011p 0 8.4000000000000004p 0 8.4124999999999996p 0 8.4249999999999989p 0 8.4375p 0 8.4500000000000011p 0 8.4625000000000004p 0 8.4749999999999996p 0 8.4875000000000007p 0 8.5p 0 8.5125000000000011p 0 8.5249999999999986p 0 8.5374999999999996p 0 8.5500000000000007p 0
+ 8.5625p 0 8.5749999999999993p 0 8.5875000000000004p 0 8.5999999999999996p 0 8.6125000000000007p 0 8.625p 0 8.6374999999999993p 0 8.6500000000000004p 0 8.6624999999999996p 0 8.6750000000000007p 0 8.6875p 0 8.6999999999999993p 0 8.7125000000000004p 0 8.7249999999999996p 0 8.7375000000000007p 0 8.75p 0 8.7624999999999993p 0 8.7750000000000004p 0
+ 8.7875000000000014p 0 8.7999999999999989p 0 8.8125p 0 8.8249999999999993p 0 8.8375000000000004p 0 8.8499999999999996p 0 8.8624999999999989p 0 8.875p 0 8.8875000000000011p 0 8.9000000000000004p 0 8.9124999999999996p 0 8.9249999999999989p 0 8.9375p 0 8.9500000000000011p 0 8.9624999999999986p 0 8.9749999999999996p 0 8.9875000000000007p 0 9p 0
+ 9.0125000000000011p 0 9.0249999999999986p 0 9.0374999999999996p 0 9.0500000000000007p 0 9.0625p 0 9.0749999999999993p 0 9.0875000000000004p 0 9.0999999999999996p 0 9.1125000000000007p 0 9.125p 0 9.1374999999999993p 0 9.1500000000000004p 0 9.1624999999999996p 0 9.1750000000000007p 0 9.1875p 0 9.1999999999999993p 0 9.2125000000000004p 0 9.2250000000000014p 0
+ 9.2374999999999989p 0 9.25p 0 9.2624999999999993p 0 9.2750000000000004p 0 9.2875000000000014p 0 9.2999999999999989p 0 9.3125p 0 9.3250000000000011p 0 9.3375000000000004p 0 9.3499999999999996p 0 9.3624999999999989p 0 9.375p 0 9.3875000000000011p 0 9.4000000000000004p 0 9.4124999999999996p 0 9.4250000000000007p 0 9.4375p 0 9.4500000000000011p 0
+ 9.4624999999999986p 0 9.4749999999999996p 0 9.4875000000000007p 0 9.5p 0 9.5124999999999993p 0 9.5250000000000004p 0 9.5374999999999996p 0 9.5500000000000007p 0 9.5625p 0 9.5749999999999993p 0 9.5875000000000004p 0 9.5999999999999996p 0 9.6125000000000007p 0 9.625p 0 9.6374999999999993p 0 9.6500000000000004p 0 9.6624999999999996p 0 9.6750000000000007p 0
+ 9.6875p 0 9.6999999999999993p 0 9.7125000000000004p 0 9.7250000000000014p 0 9.7374999999999989p 0 9.75p 0 9.7624999999999993p 0 9.7750000000000004p 0 9.7874999999999996p 0 9.7999999999999989p 0 9.8125p 0 9.8250000000000011p 0 9.8375000000000004p 0 9.8499999999999996p 0 9.8624999999999989p 0 9.875p 0 9.8875000000000011p 0 9.8999999999999986p 0
+ 9.9124999999999996p 0 9.9250000000000007p 0 9.9375p 0 9.9500000000000011p 0 9.9624999999999986p 0 9.9749999999999996p 0 9.9875000000000007p 0 10p 5.0939030000000001e-20 10.012499999999999p 3.9412170000000001e-07 10.025p 7.5903300000000002e-07 10.0375p 1.093568e-06 10.050000000000001p 1.3984240000000001e-06 10.0625p 1.674946e-06 10.074999999999999p 1.9247099999999998e-06 10.0875p 2.1493770000000001e-06 10.1p 2.3506340000000001e-06 10.112500000000001p 2.53017e-06 10.125p 2.6896609999999998e-06
+ 10.137499999999999p 2.8307610000000001e-06 10.15p 2.9550909999999998e-06 10.162500000000001p 3.064236e-06 10.174999999999999p 3.1597340000000001e-06 10.1875p 3.243074e-06 10.199999999999999p 3.3156870000000001e-06 10.2125p 3.378946e-06 10.225000000000001p 3.4341599999999998e-06 10.237499999999999p 3.4825690000000001e-06 10.25p 3.5253450000000001e-06 10.262500000000001p 3.5635880000000002e-06 10.275p 3.598327e-06 10.2875p 3.6305140000000002e-06 10.299999999999999p 3.6610289999999999e-06 10.3125p 3.6906770000000001e-06 10.325000000000001p 3.7201889999999999e-06 10.3375p 3.7502250000000002e-06 10.35p 3.7813710000000002e-06
+ 10.362500000000001p 3.814146e-06 10.375p 3.8489980000000003e-06 10.387500000000001p 3.8863109999999996e-06 10.399999999999999p 3.9264049999999997e-06 10.4125p 3.9695379999999996e-06 10.425000000000001p 4.0159129999999997e-06 10.4375p 4.0656749999999998e-06 10.449999999999999p 4.118919e-06 10.4625p 4.1756899999999998e-06 10.475p 4.235987e-06 10.487500000000001p 4.2997679999999999e-06 10.5p 4.3669529999999996e-06 10.512499999999999p 4.4374250000000001e-06 10.525p 4.5110340000000002e-06 10.5375p 4.587604e-06 10.550000000000001p 4.666931e-06 10.5625p 4.7487909999999997e-06 10.574999999999999p 4.8329389999999999e-06
+ 10.5875p 4.919114e-06 10.6p 5.0070429999999998e-06 10.612500000000001p 5.0964419999999999e-06 10.625p 5.1870200000000002e-06 10.637499999999999p 5.2784789999999996e-06 10.65p 5.3705209999999996e-06 10.662500000000001p 5.4628469999999998e-06 10.674999999999999p 5.5551600000000004e-06 10.6875p 5.6471660000000002e-06 10.699999999999999p 5.7385780000000002e-06 10.7125p 5.8291169999999996e-06 10.725p 5.9185110000000003e-06 10.737499999999999p 6.0065010000000002e-06 10.75p 6.0928390000000004e-06 10.762500000000001p 6.1772900000000003e-06 10.775p 6.2596339999999998e-06 10.7875p 6.3396640000000003e-06 10.799999999999999p 6.4171900000000003e-06
+ 10.8125p 6.4920370000000002e-06 10.825000000000001p 6.5640500000000003e-06 10.837499999999999p 6.6330870000000003e-06 10.85p 6.6990249999999998e-06 10.862500000000001p 6.7617580000000003e-06 10.875p 6.8211989999999998e-06 10.887500000000001p 6.8772760000000004e-06 10.899999999999999p 6.9299359999999996e-06 10.9125p 6.9791410000000003e-06 10.925000000000001p 7.0248720000000004e-06 10.9375p 7.0671240000000003e-06 10.949999999999999p 7.1059089999999996e-06 10.9625p 7.1412520000000001e-06 10.975p 7.1731960000000001e-06 10.987500000000001p 7.2017949999999999e-06 11p 7.2271179999999999e-06 11.012499999999999p 6.8551239999999996e-06 11.025p 6.5092380000000001e-06
+ 11.0375p 6.1907279999999998e-06 11.050000000000001p 5.8990130000000003e-06 11.0625p 5.6328690000000001e-06 11.074999999999999p 5.3908530000000001e-06 11.0875p 5.1714430000000003e-06 11.100000000000001p 4.9730999999999999e-06 11.112499999999999p 4.794286e-06 11.125p 4.6334829999999999e-06 11.137499999999999p 4.4892000000000001e-06 11.15p 4.3599800000000001e-06 11.162500000000001p 4.244409e-06 11.174999999999999p 4.1411190000000004e-06 11.1875p 4.0487919999999999e-06 11.200000000000001p 3.9661699999999998e-06 11.2125p 3.8920530000000002e-06 11.225p 3.8253030000000003e-06 11.237499999999999p 3.7648489999999998e-06 11.25p 3.7096890000000002e-06
+ 11.262500000000001p 3.6588859999999999e-06 11.275p 3.6115749999999998e-06 11.2875p 3.5669620000000001e-06 11.300000000000001p 3.52432e-06 11.3125p 3.482995e-06 11.325000000000001p 3.4423999999999999e-06 11.337499999999999p 3.4020140000000002e-06 11.35p 3.3613840000000001e-06 11.362500000000001p 3.3201199999999999e-06 11.375p 3.2778950000000001e-06 11.387499999999999p 3.2344400000000002e-06 11.4p 3.1895440000000001e-06 11.4125p 3.1430490000000001e-06 11.425000000000001p 3.0948500000000001e-06 11.4375p 3.0448890000000002e-06 11.449999999999999p 2.9931530000000002e-06 11.4625p 2.9396729999999999e-06 11.475p 2.8845169999999999e-06
+ 11.487500000000001p 2.8277890000000002e-06 11.5p 2.769626e-06 11.512499999999999p 2.7101929999999999e-06 11.525p 2.6496820000000002e-06 11.5375p 2.5883069999999998e-06 11.550000000000001p 2.5263019999999999e-06 11.5625p 2.4639190000000001e-06 11.574999999999999p 2.401423e-06 11.5875p 2.3390879999999999e-06 11.600000000000001p 2.2772e-06 11.612499999999999p 2.2160480000000001e-06 11.625p 2.155925e-06 11.637499999999999p 2.0971280000000001e-06 11.65p 2.039947e-06 11.6625p 1.9846750000000002e-06 11.674999999999999p 1.9315960000000002e-06 11.6875p 1.880989e-06 11.700000000000001p 1.8331240000000001e-06
+ 11.7125p 1.7882610000000001e-06 11.725p 1.74665e-06 11.737499999999999p 1.7085259999999999e-06 11.75p 1.674115e-06 11.762500000000001p 1.643623e-06 11.774999999999999p 1.617247e-06 11.7875p 1.595163e-06 11.800000000000001p 1.577534e-06 11.8125p 1.5645049999999999e-06 11.825000000000001p 1.5562039999999999e-06 11.8375p 1.5527420000000001e-06 11.85p 1.554212e-06 11.862500000000001p 1.5606890000000001e-06 11.875p 1.572233e-06 11.887499999999999p 1.5888829999999999e-06 11.9p 1.610665e-06 11.9125p 1.637585e-06 11.925000000000001p 1.6696329999999999e-06
+ 11.9375p 1.7067840000000001e-06 11.949999999999999p 1.748997e-06 11.9625p 1.796214e-06 11.975p 1.848364e-06 11.987500000000001p 1.905362e-06 12p 1.9671089999999998e-06 12.012499999999999p 2.0334899999999998e-06 12.025p 2.1043829999999999e-06 12.037500000000001p 2.1796510000000002e-06 12.049999999999999p 2.2591449999999999e-06 12.0625p 2.342707e-06 12.074999999999999p 2.4301689999999998e-06 12.0875p 2.5213549999999999e-06 12.100000000000001p 2.6160780000000001e-06 12.112499999999999p 2.7141450000000002e-06 12.125p 2.815355e-06 12.137500000000001p 2.919501e-06 12.15p 3.02637e-06
+ 12.1625p 3.1357439999999998e-06 12.174999999999999p 3.2474e-06 12.1875p 3.361111e-06 12.200000000000001p 3.4766470000000001e-06 12.2125p 3.5937750000000002e-06 12.225p 3.712261e-06 12.237500000000001p 3.8318670000000003e-06 12.25p 3.9523560000000001e-06 12.262500000000001p 4.0734900000000002e-06 12.274999999999999p 4.1950289999999998e-06 12.2875p 4.3167370000000001e-06 12.300000000000001p 4.4383749999999997e-06 12.3125p 4.5597090000000002e-06 12.324999999999999p 4.6805049999999998e-06 12.3375p 4.8005299999999996e-06 12.35p 4.9195570000000002e-06 12.362500000000001p 5.0373589999999998e-06 12.375p 5.1537149999999997e-06
+ 12.387499999999999p 5.2684040000000004e-06 12.4p 5.381213e-06 12.4125p 5.4919319999999999e-06 12.425000000000001p 5.6003560000000003e-06 12.4375p 5.7062840000000003e-06 12.449999999999999p 5.809521e-06 12.4625p 5.9098779999999998e-06 12.475p 6.0071709999999997e-06 12.487500000000001p 6.1012239999999999e-06 12.5p 6.1918639999999998e-06 12.512499999999999p 6.2789290000000003e-06 12.525p 6.3622580000000002e-06 12.537500000000001p 6.4417030000000004e-06 12.549999999999999p 6.5171169999999997e-06 12.5625p 6.5883659999999998e-06 12.574999999999999p 6.6553179999999997e-06 12.5875p 6.717852e-06 12.6p 6.7758539999999998e-06
+ 12.612499999999999p 6.8292169999999996e-06 12.625p 6.8778410000000001e-06 12.637500000000001p 6.9216349999999998e-06 12.65p 6.9605160000000001e-06 12.6625p 6.9944070000000003e-06 12.674999999999999p 7.0232419999999998e-06 12.6875p 7.0469619999999998e-06 12.700000000000001p 7.0655130000000001e-06 12.712499999999999p 7.0788529999999999e-06 12.725p 7.0869470000000001e-06 12.737500000000001p 7.0897659999999998e-06 12.75p 7.0872919999999997e-06 12.762500000000001p 7.0795120000000001e-06 12.775p 7.0664239999999996e-06 12.7875p 7.0480309999999999e-06 12.800000000000001p 7.0243459999999998e-06 12.8125p 6.9953879999999996e-06 12.824999999999999p 6.9611860000000004e-06
+ 12.8375p 6.9217740000000001e-06 12.85p 6.8771940000000002e-06 12.862500000000001p 6.8274979999999998e-06 12.875p 6.7727429999999997e-06 12.887499999999999p 6.712993e-06 12.9p 6.6483189999999998e-06 12.9125p 6.5788020000000001e-06 12.925000000000001p 6.5045250000000002e-06 12.9375p 6.4255819999999999e-06 12.949999999999999p 6.3420700000000002e-06 12.9625p 6.2540949999999996e-06 12.975000000000001p 6.161768e-06 12.987499999999999p 6.0652059999999997e-06 13p 5.9645320000000003e-06 13.012499999999999p 5.8598740000000001e-06 13.025p 5.751366e-06 13.037500000000001p 5.6391480000000004e-06 13.049999999999999p 5.523363e-06
+ 13.0625p 5.4041609999999998e-06 13.075000000000001p 5.281694e-06 13.0875p 5.1561209999999996e-06 13.1p 5.0276029999999998e-06 13.112499999999999p 4.8963040000000001e-06 13.125p 4.7623960000000002e-06 13.137500000000001p 4.6260479999999999e-06 13.15p 4.487437e-06 13.1625p 4.3467399999999997e-06 13.175000000000001p 4.2041379999999999e-06 13.1875p 4.059812e-06 13.200000000000001p 3.9139470000000002e-06 13.212499999999999p 3.766729e-06 13.225p 3.6183440000000001e-06 13.237500000000001p 3.4689789999999998e-06 13.25p 3.3188240000000001e-06 13.262499999999999p 3.1680669999999999e-06 13.275p 3.0168960000000002e-06
+ 13.2875p 2.8654999999999999e-06 13.300000000000001p 2.7140659999999999e-06 13.3125p 2.5627800000000001e-06 13.324999999999999p 2.4118290000000001e-06 13.3375p 2.2613950000000001e-06 13.35p 2.111661e-06 13.362500000000001p 1.9628070000000001e-06 13.375p 1.815009e-06 13.387499999999999p 1.6684420000000001e-06 13.4p 1.5232789999999999e-06 13.4125p 1.3796859999999999e-06 13.425000000000001p 1.23783e-06 13.4375p 1.0978699999999999e-06 13.449999999999999p 9.5996460000000004e-07 13.4625p 8.2426589999999996e-07 13.475000000000001p 6.9092239999999997e-07 13.487499999999999p 5.6007779999999998e-07 13.5p 4.3187109999999998e-07
+ 13.512499999999999p 3.0643620000000002e-07 13.525p 1.8390190000000001e-07 13.5375p 6.4391720000000002e-08 13.549999999999999p -5.1976279999999998e-08 13.5625p -1.6508949999999999e-07 13.575000000000001p -2.7484110000000001e-07 13.5875p -3.811297e-07 13.6p -4.8385989999999995e-07 13.612499999999999p -5.829421e-07 13.625p -6.7829239999999999e-07 13.637500000000001p -7.6983310000000003e-07 13.649999999999999p -8.5749209999999998e-07 13.6625p -9.4120329999999999e-07 13.675000000000001p -1.020906e-06 13.6875p -1.096547e-06 13.700000000000001p -1.1680760000000001e-06 13.7125p -1.235452e-06 13.725p -1.2986360000000001e-06
+ 13.737500000000001p -1.3575970000000001e-06 13.75p -1.4123090000000001e-06 13.762499999999999p -1.4627509999999999e-06 13.775p -1.5089070000000001e-06 13.7875p -1.550767e-06 13.800000000000001p -1.588325e-06 13.8125p -1.621582e-06 13.824999999999999p -1.650542e-06 13.8375p -1.675212e-06 13.85p -1.6956079999999999e-06 13.862500000000001p -1.7117470000000001e-06 13.875p -1.72365e-06 13.887499999999999p -1.731345e-06 13.9p -1.7348600000000001e-06 13.912500000000001p -1.7342310000000001e-06 13.924999999999999p -1.729494e-06 13.9375p -1.7206910000000001e-06 13.949999999999999p -1.7078669999999999e-06
+ 13.9625p -1.691069e-06 13.975p -1.6703469999999999e-06 13.987499999999999p -1.6457570000000001e-06 14p -1.617355e-06 14.012500000000001p -1.5852000000000001e-06 14.025p -1.549356e-06 14.0375p -1.509888e-06 14.049999999999999p -1.4668629999999999e-06 14.0625p -1.4203509999999999e-06 14.075000000000001p -1.3704250000000001e-06 14.0875p -1.31716e-06 14.1p -1.2606339999999999e-06 14.112500000000001p -1.2009250000000001e-06 14.125p -1.1381149999999999e-06 14.137500000000001p -1.072289e-06 14.149999999999999p -1.003532e-06 14.1625p -9.3193229999999999e-07 14.175000000000001p -8.5757980000000005e-07
+ 14.1875p -7.8056689999999999e-07 14.199999999999999p -7.009877e-07 14.2125p -6.1893839999999998e-07 14.225p -5.3451719999999995e-07 14.237500000000001p -4.4782440000000002e-07 14.25p -3.5896209999999997e-07 14.262499999999999p -2.6803450000000002e-07 14.275p -1.751477e-07 14.2875p -8.0409679999999994e-08 14.300000000000001p 1.6069480000000001e-08 14.3125p 1.141779e-07 14.324999999999999p 2.1380190000000001e-07 14.3375p 3.1482569999999999e-07 14.35p 4.1713189999999999e-07 14.362500000000001p 5.2060129999999999e-07 14.375p 6.2511289999999995e-07 14.387499999999999p 7.3054390000000004e-07 14.4p 8.3677019999999998e-07
+ 14.412500000000001p 9.4366579999999999e-07 14.424999999999999p 1.0511030000000001e-06 14.4375p 1.158954e-06 14.449999999999999p 1.267088e-06 14.4625p 1.3753739999999999e-06 14.475p 1.48368e-06 14.487499999999999p 1.591871e-06 14.5p 1.699815e-06 14.512500000000001p 1.807376e-06 14.525p 1.9144190000000001e-06 14.5375p 2.020808e-06 14.549999999999999p 2.1264070000000001e-06 14.562500000000002p 2.23108e-06 14.574999999999999p 2.3346909999999998e-06 14.587499999999999p 2.437104e-06 14.6p 2.5381840000000001e-06 14.612500000000001p 2.6377979999999999e-06 14.625000000000002p 2.73581e-06
+ 14.637499999999999p 2.8320900000000001e-06 14.649999999999999p 2.926506e-06 14.6625p 3.0189290000000002e-06 14.675000000000001p 3.1092319999999998e-06 14.687500000000002p 3.197288e-06 14.700000000000001p 3.2829750000000001e-06 14.712499999999999p 3.3661720000000001e-06 14.725p 3.4467610000000002e-06 14.737500000000001p 3.524628e-06 14.75p 3.5996600000000002e-06 14.762500000000001p 3.671748e-06 14.774999999999999p 3.74079e-06 14.7875p 3.8066819999999998e-06 14.800000000000001p 3.8693289999999997e-06 14.8125p 3.928639e-06 14.825000000000001p 3.9845230000000001e-06 14.837499999999999p 4.0368970000000004e-06 14.85p 4.0856840000000001e-06
+ 14.862499999999999p 4.1308089999999999e-06 14.875p 4.1722060000000002e-06 14.887500000000001p 4.2098099999999998e-06 14.900000000000002p 4.2435640000000002e-06 14.9125p 4.273416e-06 14.924999999999999p 4.2993219999999998e-06 14.9375p 4.3212399999999996e-06 14.950000000000001p 4.3391359999999998e-06 14.962500000000002p 4.3529829999999998e-06 14.974999999999998p 4.3627590000000003e-06 14.987499999999999p 4.368448e-06 15p 4.3700410000000002e-06 15.012500000000001p 4.3675339999999998e-06 15.025p 4.3609330000000003e-06 15.037499999999998p 4.3502460000000003e-06 15.049999999999999p 4.3354900000000004e-06 15.0625p 4.316687e-06 15.075000000000001p 4.293866e-06
+ 15.0875p 4.267064e-06 15.100000000000001p 4.2363219999999998e-06 15.112499999999999p 4.2016870000000002e-06 15.125p 4.1632140000000002e-06 15.137499999999999p 4.1209629999999996e-06 15.15p 4.0750010000000002e-06 15.162500000000001p 4.0253999999999996e-06 15.174999999999999p 3.9722379999999996e-06 15.1875p 3.9155979999999998e-06 15.199999999999999p 3.8555709999999998e-06 15.2125p 3.79225e-06 15.225000000000001p 3.7257350000000001e-06 15.237499999999999p 3.6561329999999999e-06 15.249999999999998p 3.5835519999999998e-06 15.262499999999999p 3.5081069999999999e-06 15.275p 3.4299169999999998e-06 15.287500000000001p 3.3491069999999998e-06 15.300000000000001p 3.265803e-06
+ 15.312499999999998p 3.180138e-06 15.324999999999999p 3.0922459999999998e-06 15.3375p 3.0022670000000002e-06 15.350000000000001p 2.910341e-06 15.362500000000001p 2.8166150000000001e-06 15.374999999999998p 2.721236e-06 15.387499999999999p 2.624353e-06 15.4p 2.52612e-06 15.4125p 2.426691e-06 15.425000000000001p 2.3262209999999998e-06 15.437499999999998p 2.2248689999999999e-06 15.449999999999999p 2.122792e-06 15.4625p 2.0201509999999999e-06 15.475p 1.917106e-06 15.487500000000001p 1.8138159999999999e-06 15.500000000000002p 1.7104430000000001e-06 15.512499999999999p 1.6071480000000001e-06 15.524999999999999p 1.5040900000000001e-06
+ 15.5375p 1.4014269999999999e-06 15.550000000000001p 1.2993199999999999e-06 15.562500000000002p 1.1979250000000001e-06 15.574999999999999p 1.097396e-06 15.587499999999999p 9.978887000000001e-07 15.6p 8.9955400000000004e-07 15.612500000000001p 8.0254150000000003e-07 15.625000000000002p 7.069982e-07 15.637500000000001p 6.1306849999999998e-07 15.649999999999999p 5.2089369999999998e-07 15.6625p 4.3061190000000003e-07 15.675000000000001p 3.42358e-07 15.6875p 2.5626320000000001e-07 15.700000000000001p 1.7245510000000001e-07 15.712499999999999p 9.1057149999999994e-08 15.725p 1.218882e-08 15.737500000000001p -6.4034730000000004e-08 15.75p -1.3750270000000001e-07
+ 15.762500000000001p -2.0810909999999999e-07 15.774999999999999p -2.757522e-07 15.7875p -3.4033560000000002e-07 15.799999999999999p -4.0176740000000002e-07 15.8125p -4.5996110000000002e-07 15.825000000000001p -5.148349e-07 15.837500000000002p -5.6631259999999995e-07 15.85p -6.1432310000000003e-07 15.862499999999999p -6.588006e-07 15.875p -6.9968470000000003e-07 15.887500000000001p -7.3692030000000004e-07 15.900000000000002p -7.7045799999999998e-07 15.912499999999998p -8.0025349999999997e-07 15.924999999999999p -8.2626819999999998e-07 15.9375p -8.4846880000000001e-07 15.950000000000001p -8.6682770000000001e-07 15.9625p -8.8132230000000004e-07 15.974999999999998p -8.9193580000000004e-07
+ 15.987499999999999p -8.9865659999999998e-07 16p -9.0147830000000002e-07 16.012499999999999p -9.0039990000000005e-07 16.025000000000002p -8.9542569999999998e-07 16.037500000000001p -8.8656489999999995e-07 16.049999999999997p -8.7383189999999999e-07 16.0625p -8.5724639999999999e-07 16.074999999999999p -8.3683250000000003e-07 16.087500000000002p -8.1261960000000001e-07 16.100000000000001p -7.8464179999999998e-07 16.112499999999997p -7.5293760000000005e-07 16.125p -7.1755039999999998e-07 16.137499999999999p -6.7852799999999997e-07 16.150000000000002p -6.3592269999999999e-07 16.162500000000001p -5.8979100000000002e-07 16.174999999999997p -5.4019349999999996e-07 16.1875p -4.8719509999999998e-07 16.199999999999999p -4.3086469999999998e-07
+ 16.212499999999999p -3.7127499999999999e-07 16.225000000000001p -3.0850250000000001e-07 16.237500000000001p -2.426273e-07 16.25p -1.737332e-07 16.262499999999999p -1.019073e-07 16.274999999999999p -2.724012e-08 16.287500000000001p 5.0174640000000002e-08 16.300000000000001p 1.3024019999999999e-07 16.3125p 2.1285689999999999e-07 16.324999999999999p 2.979221e-07 16.337499999999999p 3.8533059999999998e-07 16.350000000000001p 4.7497449999999999e-07 16.362500000000001p 5.6674359999999999e-07 16.375p 6.6052539999999999e-07 16.387499999999999p 7.5620510000000003e-07 16.399999999999999p 8.5366599999999999e-07 16.412500000000001p 9.5278950000000004e-07 16.425000000000001p 1.053455e-06
+ 16.4375p 1.1555420000000001e-06 16.449999999999999p 1.258925e-06 16.462499999999999p 1.3634820000000001e-06 16.475000000000001p 1.4690850000000001e-06 16.487500000000001p 1.575609e-06 16.5p 1.6829260000000001e-06 16.512499999999999p 1.7909089999999999e-06 16.524999999999999p 1.8994279999999999e-06 16.537500000000001p 2.0083560000000002e-06 16.550000000000001p 2.1175640000000001e-06 16.5625p 2.226924e-06 16.575000000000003p 2.3363060000000001e-06 16.587499999999999p 2.4455819999999999e-06 16.599999999999998p 2.5546270000000002e-06 16.612500000000001p 2.6633119999999999e-06 16.625p 2.7715110000000002e-06 16.637500000000003p 2.8791009999999999e-06 16.649999999999999p 2.9859559999999999e-06
+ 16.662499999999998p 3.0919559999999998e-06 16.675000000000001p 3.1969779999999999e-06 16.6875p 3.3009029999999999e-06 16.700000000000003p 3.4036139999999999e-06 16.712499999999999p 3.5049940000000002e-06 16.724999999999998p 3.60493e-06 16.737500000000001p 3.7033089999999998e-06 16.75p 3.800021e-06 16.762499999999999p 3.8949590000000003e-06 16.775000000000002p 3.9880179999999998e-06 16.787499999999998p 4.0790929999999996e-06 16.800000000000001p 4.1680840000000004e-06 16.8125p 4.254894e-06 16.824999999999999p 4.339427e-06 16.837500000000002p 4.4215890000000001e-06 16.849999999999998p 4.501291e-06 16.862500000000001p 4.5784449999999998e-06 16.875p 4.6529669999999999e-06
+ 16.887499999999999p 4.724775e-06 16.900000000000002p 4.7937899999999999e-06 16.912499999999998p 4.8599370000000002e-06 16.925000000000001p 4.9231439999999999e-06 16.9375p 4.9833399999999996e-06 16.949999999999999p 5.04046e-06 16.962500000000002p 5.0944400000000001e-06 16.975000000000001p 5.1452210000000003e-06 16.987499999999997p 5.1927469999999997e-06 17p 5.2369650000000001e-06 17.012499999999999p 5.277826e-06 17.025000000000002p 5.3152840000000002e-06 17.037500000000001p 5.3492959999999996e-06 17.049999999999997p 5.379826e-06 17.0625p 5.406837e-06 17.074999999999999p 5.4303009999999997e-06 17.087500000000002p 5.4501900000000001e-06 17.100000000000001p 5.4664809999999998e-06
+ 17.112499999999997p 5.4791569999999999e-06 17.125p 5.4882030000000001e-06 17.137499999999999p 5.4936089999999998e-06 17.149999999999999p 5.4953690000000001e-06 17.162500000000001p 5.4934819999999999e-06 17.175000000000001p 5.4879509999999999e-06 17.1875p 5.4787840000000004e-06 17.199999999999999p 5.4659929999999999e-06 17.212499999999999p 5.449595e-06 17.225000000000001p 5.4296100000000003e-06 17.237500000000001p 5.4060660000000001e-06 17.25p 5.378991e-06 17.262499999999999p 5.3484219999999997e-06 17.274999999999999p 5.3143979999999998e-06 17.287500000000001p 5.2769640000000003e-06 17.300000000000001p 5.2361679999999999e-06 17.3125p 5.1920649999999999e-06 17.324999999999999p 5.1447120000000004e-06
+ 17.337499999999999p 5.0941710000000001e-06 17.350000000000001p 5.0405110000000004e-06 17.362500000000001p 4.9838009999999999e-06 17.375p 4.9241169999999998e-06 17.387499999999999p 4.8615400000000002e-06 17.399999999999999p 4.7961510000000001e-06 17.412500000000001p 4.7280390000000003e-06 17.425000000000001p 4.6572960000000002e-06 17.4375p 4.5840139999999996e-06 17.449999999999999p 4.5082939999999999e-06 17.462499999999999p 4.4302350000000003e-06 17.475000000000001p 4.3499429999999998e-06 17.487500000000001p 4.267524e-06 17.5p 4.18309e-06 17.512500000000003p 4.0967519999999998e-06 17.524999999999999p 4.0086260000000003e-06 17.537499999999998p 3.9188280000000004e-06 17.550000000000001p 3.827478e-06
+ 17.5625p 3.7346959999999999e-06 17.575000000000003p 3.6406049999999998e-06 17.587499999999999p 3.545326e-06 17.599999999999998p 3.448986e-06 17.612500000000001p 3.3517079999999998e-06 17.625p 3.2536180000000001e-06 17.637500000000003p 3.154843e-06 17.649999999999999p 3.0555070000000002e-06 17.662499999999998p 2.9557380000000001e-06 17.675000000000001p 2.8556600000000002e-06 17.6875p 2.7553979999999999e-06 17.699999999999999p 2.655076e-06 17.712500000000002p 2.5548169999999999e-06 17.724999999999998p 2.4547430000000001e-06 17.737500000000001p 2.3549749999999998e-06 17.75p 2.25563e-06 17.762499999999999p 2.1568269999999999e-06 17.775000000000002p 2.0586789999999999e-06
+ 17.787499999999998p 1.9613000000000002e-06 17.800000000000001p 1.8647999999999999e-06 17.8125p 1.769288e-06 17.824999999999999p 1.674867e-06 17.837500000000002p 1.5816419999999999e-06 17.849999999999998p 1.489712e-06 17.862500000000001p 1.399173e-06 17.875p 1.3101200000000001e-06 17.887499999999999p 1.2226430000000001e-06 17.900000000000002p 1.136828e-06 17.912500000000001p 1.0527600000000001e-06 17.924999999999997p 9.7051929999999999e-07 17.9375p 8.9018259999999995e-07 17.949999999999999p 8.1182319999999999e-07 17.962500000000002p 7.3551110000000002e-07 17.975000000000001p 6.6131229999999996e-07 17.987499999999997p 5.892894e-07 18p 5.195015e-07
+ 18.012499999999999p 4.5200379999999999e-07 18.025000000000002p 3.8684790000000001e-07 18.037500000000001p 3.2408199999999998e-07 18.049999999999997p 2.6375039999999998e-07 18.0625p 2.058941e-07 18.074999999999999p 1.5055030000000001e-07 18.087499999999999p 9.7752819999999997e-08 18.100000000000001p 4.7532030000000001e-08 18.112500000000001p -8.5157969999999998e-11 18.125p -4.5075220000000002e-08 18.137499999999999p -8.7417919999999997e-08 18.149999999999999p -1.2709629999999999e-07 18.162500000000001p -1.640966e-07 18.175000000000001p -1.984081e-07 18.1875p -2.3002339999999999e-07 18.199999999999999p -2.5893779999999997e-07 18.212499999999999p -2.8514970000000001e-07 18.225000000000001p -3.0866039999999998e-07
+ 18.237500000000001p -3.2947390000000001e-07 18.25p -3.4759689999999999e-07 18.262499999999999p -3.6303900000000003e-07 18.274999999999999p -3.7581199999999998e-07 18.287500000000001p -3.8593070000000001e-07 18.300000000000001p -3.9341189999999998e-07 18.3125p -3.982751e-07 18.324999999999999p -4.005422e-07 18.337499999999999p -4.002372e-07 18.350000000000001p -3.9738630000000001e-07 18.362500000000001p -3.9201799999999998e-07 18.375p -3.8416309999999999e-07 18.387499999999999p -3.7385399999999998e-07 18.399999999999999p -3.6112549999999999e-07 18.412500000000001p -3.4601449999999998e-07 18.425000000000001p -3.2855940000000002e-07 18.4375p -3.0880089999999999e-07 18.450000000000003p -2.8678139999999997e-07
+ 18.462499999999999p -2.6254529999999998e-07 18.474999999999998p -2.3613869999999999e-07 18.487500000000001p -2.0760940000000001e-07 18.5p -1.7700710000000001e-07 18.512500000000003p -1.4438319999999999e-07 18.524999999999999p -1.097909e-07 18.537499999999998p -7.3284950000000001e-08 18.550000000000001p -3.4921789999999999e-08 18.5625p 5.2404440000000002e-09 18.575000000000003p 4.7142019999999999e-08 18.587499999999999p 9.0721579999999995e-08 18.599999999999998p 1.359162e-07 18.612500000000001p 1.8266139999999999e-07 18.625p 2.3089120000000001e-07 18.637499999999999p 2.8053799999999999e-07 18.650000000000002p 3.3153289999999999e-07 18.662499999999998p 3.838052e-07 18.675000000000001p 4.3728330000000002e-07
+ 18.6875p 4.9189359999999998e-07 18.699999999999999p 5.4756170000000004e-07 18.712500000000002p 6.0421160000000002e-07 18.724999999999998p 6.6176590000000003e-07 18.737500000000001p 7.2014630000000002e-07 18.75p 7.7927310000000004e-07 18.762499999999999p 8.3906559999999998e-07 18.775000000000002p 8.9944180000000003e-07 18.787499999999998p 9.6031909999999998e-07 18.800000000000001p 1.0216140000000001e-06 18.8125p 1.0832409999999999e-06 18.824999999999999p 1.145115e-06 18.837500000000002p 1.20715e-06 18.850000000000001p 1.26926e-06 18.862499999999997p 1.3313569999999999e-06 18.875p 1.393353e-06 18.887499999999999p 1.455161e-06 18.900000000000002p 1.516692e-06
+ 18.912500000000001p 1.577857e-06 18.924999999999997p 1.6385690000000001e-06 18.9375p 1.6987389999999999e-06 18.949999999999999p 1.758279e-06 18.962500000000002p 1.817101e-06 18.975000000000001p 1.8751189999999999e-06 18.987499999999997p 1.9322439999999998e-06 19p 1.9883929999999999e-06 19.012499999999999p 2.0434790000000001e-06 19.024999999999999p 2.0974180000000001e-06 19.037500000000001p 2.1501279999999999e-06 19.050000000000001p 2.2015259999999999e-06 19.0625p 2.251534e-06 19.074999999999999p 2.3000710000000001e-06 19.087499999999999p 2.3470620000000002e-06 19.100000000000001p 2.3924300000000001e-06 19.112500000000001p 2.436104e-06 19.125p 2.4780109999999999e-06
+ 19.137499999999999p 2.518082e-06 19.149999999999999p 2.5562530000000002e-06 19.162500000000001p 2.592457e-06 19.175000000000001p 2.6266340000000001e-06 19.1875p 2.6587259999999999e-06 19.199999999999999p 2.688676e-06 19.212499999999999p 2.716432e-06 19.225000000000001p 2.7419439999999999e-06 19.237500000000001p 2.7651649999999999e-06 19.25p 2.7860530000000001e-06 19.262499999999999p 2.8045660000000001e-06 19.274999999999999p 2.8206690000000001e-06 19.287500000000001p 2.8343289999999999e-06 19.300000000000001p 2.8455160000000001e-06 19.3125p 2.8542050000000001e-06 19.324999999999999p 2.8603739999999999e-06 19.337499999999999p 2.8640049999999999e-06 19.350000000000001p 2.8650830000000001e-06
+ 19.362500000000001p 2.8635990000000002e-06 19.375p 2.8595450000000001e-06 19.387500000000003p 2.85292e-06 19.399999999999999p 2.8437239999999998e-06 19.412499999999998p 2.8319630000000002e-06 19.425000000000001p 2.8176459999999999e-06 19.4375p 2.800786e-06 19.450000000000003p 2.781401e-06 19.462499999999999p 2.7595119999999999e-06 19.474999999999998p 2.735143e-06 19.487500000000001p 2.708323e-06 19.5p 2.6790850000000001e-06 19.512500000000003p 2.6474650000000002e-06 19.524999999999999p 2.6135020000000001e-06 19.537499999999998p 2.5772410000000001e-06 19.550000000000001p 2.5387279999999999e-06 19.5625p 2.498012e-06 19.574999999999999p 2.4551489999999999e-06
+ 19.587500000000002p 2.4101949999999999e-06 19.599999999999998p 2.3632090000000001e-06 19.612500000000001p 2.3142549999999998e-06 19.625p 2.2633980000000002e-06 19.637499999999999p 2.210706e-06 19.650000000000002p 2.156252e-06 19.662499999999998p 2.1001079999999998e-06 19.675000000000001p 2.04235e-06 19.6875p 1.9830560000000002e-06 19.699999999999999p 1.9223070000000002e-06 19.712500000000002p 1.860185e-06 19.724999999999998p 1.796772e-06 19.737500000000001p 1.7321549999999999e-06 19.75p 1.66642e-06 19.762499999999999p 1.5996549999999999e-06 19.775000000000002p 1.531949e-06 19.787500000000001p 1.463392e-06 19.799999999999997p 1.3940750000000001e-06
+ 19.8125p 1.324088e-06 19.824999999999999p 1.253524e-06 19.837500000000002p 1.182474e-06 19.850000000000001p 1.11103e-06 19.862499999999997p 1.0392839999999999e-06 19.875p 9.6732860000000002e-07 19.887499999999999p 8.9525389999999999e-07 19.900000000000002p 8.2315080000000005e-07 19.912500000000001p 7.511094e-07 19.924999999999997p 6.7921869999999996e-07 19.9375p 6.0756670000000003e-07 19.949999999999999p 5.362405e-07 19.962499999999999p 4.6532570000000002e-07 19.975000000000001p 3.949064e-07 19.987500000000001p 3.2506529999999998e-07 20p 2.5588349999999998e-07 20.012499999999999p -2.066816e-07 20.024999999999999p -6.3922069999999997e-07
+ 20.037500000000001p -1.0404930000000001e-06 20.050000000000001p -1.4111219999999999e-06 20.0625p -1.7523829999999999e-06 20.074999999999999p -2.065785e-06 20.087499999999999p -2.352923e-06 20.100000000000001p -2.6154220000000002e-06 20.112500000000001p -2.8549119999999999e-06 20.125p -3.073014e-06 20.137499999999999p -3.2713290000000001e-06 20.149999999999999p -3.4514289999999998e-06 20.162500000000001p -3.6148539999999999e-06 20.175000000000001p -3.7631009999999998e-06 20.1875p -3.8976179999999998e-06 20.199999999999999p -4.0198050000000004e-06 20.212499999999999p -4.1310020000000004e-06 20.225000000000001p -4.2324910000000001e-06 20.237500000000001p -4.3254890000000003e-06 20.25p -4.4111510000000003e-06
+ 20.262499999999999p -4.4905590000000002e-06 20.274999999999999p -4.5647279999999996e-06 20.287500000000001p -4.6346039999999997e-06 20.300000000000001p -4.7010609999999997e-06 20.3125p -4.7649020000000004e-06 20.325000000000003p -4.8268579999999996e-06 20.337499999999999p -4.8875939999999998e-06 20.349999999999998p -4.947703e-06 20.362500000000001p -5.0077130000000001e-06 20.375p -5.068083e-06 20.387500000000003p -5.1292129999999997e-06 20.399999999999999p -5.1914379999999997e-06 20.412499999999998p -5.2550350000000004e-06 20.425000000000001p -5.3202250000000004e-06 20.4375p -5.3871749999999998e-06 20.450000000000003p -5.4560010000000002e-06 20.462499999999999p -5.5267699999999998e-06 20.474999999999998p -5.5995060000000001e-06
+ 20.487500000000001p -5.67419e-06 20.5p -5.7507650000000002e-06 20.512499999999999p -5.829136e-06 20.525000000000002p -5.9091790000000002e-06 20.537499999999998p -5.9907379999999999e-06 20.550000000000001p -6.0736310000000004e-06 20.5625p -6.1576540000000004e-06 20.574999999999999p -6.2425820000000001e-06 20.587500000000002p -6.3281700000000003e-06 20.599999999999998p -6.414163e-06 20.612500000000001p -6.5002890000000002e-06 20.625p -6.5862709999999998e-06 20.637499999999999p -6.6718229999999998e-06 20.650000000000002p -6.7566520000000004e-06 20.662499999999998p -6.8404679999999999e-06 20.675000000000001p -6.922977e-06 20.6875p -7.0038870000000003e-06 20.699999999999999p -7.0829119999999999e-06
+ 20.712500000000002p -7.1597700000000001e-06 20.725000000000001p -7.2341849999999999e-06 20.737499999999997p -7.3058929999999998e-06 20.75p -7.374637e-06 20.762499999999999p -7.4401729999999998e-06 20.775000000000002p -7.5022690000000004e-06 20.787500000000001p -7.5607070000000003e-06 20.799999999999997p -7.6152819999999997e-06 20.8125p -7.6658069999999995e-06 20.824999999999999p -7.7121089999999999e-06 20.837500000000002p -7.7540310000000004e-06 20.850000000000001p -7.7914359999999998e-06 20.862499999999997p -7.8242009999999998e-06 20.875p -7.8522219999999993e-06 20.887499999999999p -7.8754159999999996e-06 20.899999999999999p -7.8937140000000003e-06 20.912500000000001p -7.9070659999999996e-06 20.925000000000001p -7.9154429999999998e-06
+ 20.9375p -7.9188299999999999e-06 20.949999999999999p -7.9172340000000007e-06 20.962499999999999p -7.9106780000000002e-06 20.975000000000001p -7.8992000000000005e-06 20.987500000000001p -7.8828589999999999e-06 21p -7.86173e-06 21.012499999999999p -7.4417799999999999e-06 21.024999999999999p -7.0464470000000002e-06 21.037500000000001p -6.6770200000000003e-06 21.050000000000001p -6.3329379999999997e-06 21.0625p -6.013004e-06 21.074999999999999p -5.7158070000000004e-06 21.087499999999999p -5.4398629999999998e-06 21.100000000000001p -5.1836730000000003e-06 21.112500000000001p -4.9457480000000004e-06 21.125p -4.7246219999999998e-06 21.137499999999999p -4.5188629999999997e-06 21.149999999999999p -4.3270780000000003e-06
+ 21.162500000000001p -4.1479219999999999e-06 21.175000000000001p -3.9801030000000001e-06 21.1875p -3.8223839999999996e-06 21.199999999999999p -3.6735929999999999e-06 21.212499999999999p -3.5326209999999998e-06 21.225000000000001p -3.3984310000000002e-06 21.237500000000001p -3.2700520000000002e-06 21.25p -3.1465899999999998e-06 21.262500000000003p -3.0272209999999999e-06 21.274999999999999p -2.9111989999999999e-06 21.287499999999998p -2.7978480000000002e-06 21.300000000000001p -2.6865699999999998e-06 21.3125p -2.5768379999999998e-06 21.325000000000003p -2.4681990000000001e-06 21.337499999999999p -2.360268e-06 21.349999999999998p -2.2527289999999998e-06 21.362500000000001p -2.1453349999999999e-06 21.375p -2.0378970000000001e-06
+ 21.387500000000003p -1.9302920000000002e-06 21.399999999999999p -1.8224530000000001e-06 21.412499999999998p -1.714366e-06 21.425000000000001p -1.606069e-06 21.4375p -1.4976479999999999e-06 21.449999999999999p -1.389233e-06 21.462500000000002p -1.2809939999999999e-06 21.474999999999998p -1.173138e-06 21.487500000000001p -1.0659029999999999e-06 21.5p -9.5955860000000005e-07 21.512499999999999p -8.5439849999999999e-07 21.525000000000002p -7.5073840000000003e-07 21.537499999999998p -6.489121e-07 21.550000000000001p -5.4926809999999998e-07 21.5625p -4.5216609999999999e-07 21.574999999999999p -3.5797379999999999e-07 21.587500000000002p -2.6706359999999999e-07 21.599999999999998p -1.7980980000000001e-07
+ 21.612500000000001p -9.6585260000000004e-08 21.625p -1.7759230000000001e-08 21.637499999999999p 5.6305719999999998e-08 21.650000000000002p 1.252559e-07 21.662500000000001p 1.887486e-07 21.674999999999997p 2.4645479999999998e-07 21.6875p 2.9806019999999999e-07 21.699999999999999p 3.4326760000000001e-07 21.712500000000002p 3.8179840000000001e-07 21.725000000000001p 4.1339360000000001e-07 21.737499999999997p 4.378158e-07 21.75p 4.5484940000000002e-07 21.762499999999999p 4.6430219999999998e-07 21.775000000000002p 4.6600579999999999e-07 21.787500000000001p 4.5981640000000001e-07 21.799999999999997p 4.4561500000000001e-07 21.8125p 4.2330830000000002e-07 21.824999999999999p 3.9282819999999999e-07
+ 21.837499999999999p 3.5413250000000002e-07 21.850000000000001p 3.0720429999999998e-07 21.862500000000001p 2.5205230000000002e-07 21.875p 1.887104e-07 21.887499999999999p 1.1723700000000001e-07 21.899999999999999p 3.7715140000000002e-08 21.912500000000001p -4.9748439999999998e-08 21.925000000000001p -1.450239e-07 21.9375p -2.4795879999999999e-07 21.949999999999999p -3.5837909999999997e-07 21.962499999999999p -4.7608969999999999e-07 21.975000000000001p -6.0087589999999997e-07 21.987500000000001p -7.3250329999999998e-07 22p -8.7072e-07 22.012499999999999p -1.0152569999999999e-06 22.024999999999999p -1.1658280000000001e-06 22.037500000000001p -1.3221330000000001e-06 22.050000000000001p -1.483858e-06
+ 22.0625p -1.6506769999999999e-06 22.074999999999999p -1.82225e-06 22.087499999999999p -1.9982280000000001e-06 22.100000000000001p -2.1782530000000001e-06 22.112500000000001p -2.3619580000000001e-06 22.125p -2.5489689999999999e-06 22.137499999999999p -2.7389059999999999e-06 22.149999999999999p -2.931386e-06 22.162500000000001p -3.1260179999999999e-06 22.175000000000001p -3.3224129999999999e-06 22.1875p -3.520178e-06 22.200000000000003p -3.718921e-06 22.212499999999999p -3.9182479999999997e-06 22.224999999999998p -4.117769e-06 22.237500000000001p -4.3170959999999996e-06 22.25p -4.5158430000000002e-06 22.262500000000003p -4.7136320000000001e-06 22.274999999999999p -4.9100859999999998e-06
+ 22.287499999999998p -5.1048370000000002e-06 22.300000000000001p -5.2975230000000001e-06 22.3125p -5.4877900000000004e-06 22.325000000000003p -5.6752910000000001e-06 22.337499999999999p -5.8596910000000004e-06 22.349999999999998p -6.0406619999999998e-06 22.362500000000001p -6.2178869999999996e-06 22.375p -6.3910600000000003e-06 22.387499999999999p -6.5598880000000002e-06 22.400000000000002p -6.724087e-06 22.412499999999998p -6.8833870000000003e-06 22.425000000000001p -7.0375290000000001e-06 22.4375p -7.1862680000000001e-06 22.449999999999999p -7.329373e-06 22.462500000000002p -7.4666239999999996e-06 22.474999999999998p -7.5978159999999999e-06 22.487500000000001p -7.7227559999999996e-06 22.5p -7.8412670000000004e-06
+ 22.512499999999999p -7.9531830000000005e-06 22.525000000000002p -8.0583539999999998e-06 22.537499999999998p -8.1566409999999996e-06 22.550000000000001p -8.2479210000000002e-06 22.5625p -8.3320820000000002e-06 22.574999999999999p -8.4090280000000002e-06 22.587500000000002p -8.4786720000000007e-06 22.600000000000001p -8.5409440000000002e-06 22.612499999999997p -8.5957830000000001e-06 22.625p -8.6431420000000002e-06 22.637499999999999p -8.6829850000000004e-06 22.650000000000002p -8.7152889999999993e-06 22.662500000000001p -8.7400400000000004e-06 22.674999999999997p -8.7572359999999999e-06 22.6875p -8.7668860000000008e-06 22.699999999999999p -8.7690080000000005e-06 22.712500000000002p -8.7636300000000007e-06 22.725000000000001p -8.7507900000000003e-06
+ 22.737500000000001p -8.7305330000000008e-06 22.75p -8.7029159999999997e-06 22.762499999999999p -8.6680000000000007e-06 22.774999999999999p -8.6258559999999995e-06 22.787500000000001p -8.5765630000000006e-06 22.800000000000001p -8.5202050000000005e-06 22.8125p -8.4568729999999998e-06 22.824999999999999p -8.3866670000000003e-06 22.837499999999999p -8.3096889999999993e-06 22.850000000000001p -8.2260480000000002e-06 22.862500000000001p -8.1358609999999995e-06 22.875p -8.039246e-06 22.887499999999999p -7.9363280000000005e-06 22.899999999999999p -7.8272369999999997e-06 22.912500000000001p -7.7121050000000006e-06 22.925000000000001p -7.5910709999999999e-06 22.9375p -7.4642770000000003e-06 22.949999999999999p -7.3318669999999998e-06
+ 22.962499999999999p -7.1939909999999996e-06 22.975000000000001p -7.050802e-06 22.987500000000001p -6.9024549999999998e-06 23p -6.7491110000000004e-06 23.012499999999999p -6.5909309999999997e-06 23.024999999999999p -6.4280829999999997e-06 23.037500000000001p -6.2607360000000002e-06 23.050000000000001p -6.0890609999999998e-06 23.0625p -5.9132350000000003e-06 23.074999999999999p -5.7334360000000002e-06 23.087499999999999p -5.549847e-06 23.100000000000001p -5.3626519999999999e-06 23.112500000000001p -5.17204e-06 23.125p -4.9782019999999997e-06 23.137500000000003p -4.7813329999999997e-06 23.149999999999999p -4.5816320000000004e-06 23.162499999999998p -4.3792980000000001e-06 23.175000000000001p -4.1745359999999997e-06
+ 23.1875p -3.9675539999999999e-06 23.200000000000003p -3.7585629999999999e-06 23.212499999999999p -3.5477750000000001e-06 23.224999999999998p -3.3354089999999999e-06 23.237500000000001p -3.121682e-06 23.25p -2.9068190000000002e-06 23.262500000000003p -2.6910449999999999e-06 23.274999999999999p -2.4745869999999998e-06 23.287499999999998p -2.2576760000000002e-06 23.300000000000001p -2.0405460000000002e-06 23.3125p -1.823431e-06 23.324999999999999p -1.606569e-06 23.337500000000002p -1.390199e-06 23.349999999999998p -1.1745609999999999e-06 23.362500000000001p -9.5989760000000009e-07 23.375p -7.4645060000000002e-07 23.387499999999999p -5.344638e-07 23.400000000000002p -3.2418100000000001e-07
+ 23.412499999999998p -1.15846e-07 23.425000000000001p 9.0297609999999994e-08 23.4375p 2.9400719999999998e-07 23.449999999999999p 4.9504110000000004e-07 23.462500000000002p 6.9315900000000002e-07 23.474999999999998p 8.8812280000000003e-07 23.487500000000001p 1.0796959999999999e-06 23.5p 1.267647e-06 23.512499999999999p 1.4517429999999999e-06 23.525000000000002p 1.6317599999999999e-06 23.537500000000001p 1.807474e-06 23.549999999999997p 1.9786680000000002e-06 23.5625p 2.1451279999999999e-06 23.574999999999999p 2.3066469999999999e-06 23.587500000000002p 2.4630220000000001e-06 23.600000000000001p 2.614057e-06 23.612499999999997p 2.7595640000000001e-06 23.625p 2.8993579999999998e-06
+ 23.637499999999999p 3.0332660000000002e-06 23.650000000000002p 3.1611199999999998e-06 23.662500000000001p 3.2827599999999999e-06 23.675000000000001p 3.3980349999999998e-06 23.6875p 3.5068020000000001e-06 23.699999999999999p 3.6089279999999998e-06 23.712499999999999p 3.7042890000000002e-06 23.725000000000001p 3.7927690000000001e-06 23.737500000000001p 3.8742640000000002e-06 23.75p 3.9486770000000004e-06 23.762499999999999p 4.015925e-06 23.774999999999999p 4.0759320000000003e-06 23.787500000000001p 4.1286349999999996e-06 23.800000000000001p 4.173978e-06 23.8125p 4.2119189999999997e-06 23.824999999999999p 4.2424259999999997e-06 23.837499999999999p 4.2654769999999996e-06 23.850000000000001p 4.2810610000000004e-06
+ 23.862500000000001p 4.2891789999999996e-06 23.875p 4.2898409999999996e-06 23.887499999999999p 4.2830689999999999e-06 23.899999999999999p 4.2688959999999998e-06 23.912500000000001p 4.2473659999999997e-06 23.925000000000001p 4.2185320000000004e-06 23.9375p 4.1824589999999997e-06 23.949999999999999p 4.1392220000000003e-06 23.962499999999999p 4.0889069999999999e-06 23.975000000000001p 4.0316079999999999e-06 23.987500000000001p 3.9674310000000001e-06 24p 3.8964929999999999e-06 24.012499999999999p 3.8189169999999998e-06 24.024999999999999p 3.734838e-06 24.037500000000001p 3.6444000000000002e-06 24.050000000000001p 3.547755e-06 24.0625p 3.4450640000000001e-06 24.075000000000003p 3.3364969999999999e-06
+ 24.087499999999999p 3.2222319999999999e-06 24.099999999999998p 3.1024550000000002e-06 24.112500000000001p 2.977359e-06 24.125p 2.8471440000000002e-06 24.137500000000003p 2.7120189999999999e-06 24.149999999999999p 2.5721969999999998e-06 24.162499999999998p 2.4278989999999998e-06 24.175000000000001p 2.2793509999999999e-06 24.1875p 2.1267860000000002e-06 24.200000000000003p 1.9704400000000001e-06 24.212499999999999p 1.8105559999999999e-06 24.224999999999998p 1.647381e-06 24.237500000000001p 1.481164e-06 24.25p 1.3121610000000001e-06 24.262499999999999p 1.1406280000000001e-06 24.275000000000002p 9.6682579999999999e-07 24.287499999999998p 7.9101749999999998e-07 24.300000000000001p 6.1346769999999997e-07
+ 24.3125p 4.3444239999999999e-07 24.324999999999999p 2.5420920000000001e-07 24.337500000000002p 7.3036000000000006e-08 24.349999999999998p -1.088089e-07 24.362500000000001p -2.9105730000000001e-07 24.375p -4.7344199999999999e-07 24.387499999999999p -6.5569639999999999e-07 24.400000000000002p -8.3755590000000005e-07 24.412499999999998p -1.018757e-06 24.425000000000001p -1.1990409999999999e-06 24.4375p -1.378148e-06 24.449999999999999p -1.555824e-06 24.462500000000002p -1.73182e-06 24.475000000000001p -1.9058870000000001e-06 24.487499999999997p -2.077783e-06 24.5p -2.2472709999999999e-06 24.512499999999999p -2.4141190000000002e-06 24.525000000000002p -2.5780990000000001e-06
+ 24.537500000000001p -2.7389900000000001e-06 24.549999999999997p -2.8965769999999999e-06 24.5625p -3.0506519999999998e-06 24.574999999999999p -3.2010130000000001e-06 24.587500000000002p -3.347466e-06 24.600000000000001p -3.4898219999999998e-06 24.612500000000001p -3.6279009999999998e-06 24.625p -3.7615319999999999e-06 24.637499999999999p -3.8905500000000004e-06 24.649999999999999p -4.0147970000000002e-06 24.662500000000001p -4.1341269999999996e-06 24.675000000000001p -4.2483989999999996e-06 24.6875p -4.3574809999999999e-06 24.699999999999999p -4.4612510000000001e-06 24.712499999999999p -4.5595930000000004e-06 24.725000000000001p -4.6524020000000002e-06 24.737500000000001p -4.739581e-06 24.75p -4.8210400000000003e-06
+ 24.762499999999999p -4.8966989999999998e-06 24.774999999999999p -4.9664870000000001e-06 24.787500000000001p -5.0303400000000002e-06 24.800000000000001p -5.0882039999999999e-06 24.8125p -5.140032e-06 24.824999999999999p -5.1857859999999996e-06 24.837499999999999p -5.2254349999999999e-06 24.850000000000001p -5.2589590000000003e-06 24.862500000000001p -5.2863410000000002e-06 24.875p -5.3075770000000002e-06 24.887499999999999p -5.3226660000000002e-06 24.899999999999999p -5.331618e-06 24.912500000000001p -5.3344479999999998e-06 24.925000000000001p -5.3311789999999999e-06 24.9375p -5.3218399999999999e-06 24.949999999999999p -5.3064679999999999e-06 24.962499999999999p -5.2851060000000002e-06 24.975000000000001p -5.257804e-06
+ 24.987500000000001p -5.2246160000000004e-06 25p -5.1856050000000003e-06 25.012500000000003p -5.1408379999999998e-06 25.024999999999999p -5.0903880000000001e-06 25.037499999999998p -5.0343339999999999e-06 25.050000000000001p -4.9727599999999998e-06 25.0625p -4.9057560000000002e-06 25.075000000000003p -4.8334159999999998e-06 25.087499999999999p -4.7558399999999997e-06 25.099999999999998p -4.673131e-06 25.112500000000001p -4.5854000000000002e-06 25.125p -4.4927600000000002e-06 25.137500000000003p -4.3953290000000002e-06 25.149999999999999p -4.293229e-06 25.162499999999998p -4.1865870000000001e-06 25.175000000000001p -4.0755350000000001e-06 25.1875p -3.9602069999999998e-06 25.199999999999999p -3.8407420000000002e-06
+ 25.212500000000002p -3.7172839999999999e-06 25.224999999999998p -3.589979e-06 25.237500000000001p -3.4589780000000001e-06 25.25p -3.3244349999999998e-06 25.262499999999999p -3.1865089999999999e-06 25.275000000000002p -3.0453599999999998e-06 25.287499999999998p -2.9011539999999999e-06 25.300000000000001p -2.7540580000000001e-06 25.3125p -2.6042439999999999e-06 25.324999999999999p -2.4518879999999999e-06 25.337500000000002p -2.2971660000000001e-06 25.349999999999998p -2.1402599999999998e-06 25.362500000000001p -1.981353e-06 25.375p -1.820632e-06 25.387499999999999p -1.6582850000000001e-06 25.400000000000002p -1.494505e-06 25.412500000000001p -1.3294849999999999e-06 25.424999999999997p -1.1634219999999999e-06
+ 25.4375p -9.9651270000000002e-07 25.449999999999999p -8.2895850000000004e-07 25.462500000000002p -6.6096069999999996e-07 25.475000000000001p -4.9272250000000005e-07 25.487499999999997p -3.2444820000000001e-07 25.5p -1.5634359999999999e-07 25.512499999999999p 1.1385239999999999e-08 25.525000000000002p 1.785313e-07 25.537500000000001p 3.4488730000000001e-07 25.550000000000001p 5.1024619999999999e-07 25.5625p 6.7440069999999995e-07 25.574999999999999p 8.3714440000000002e-07 25.587499999999999p 9.9827159999999993e-07 25.600000000000001p 1.1575769999999999e-06 25.612500000000001p 1.314859e-06 25.625p 1.4699140000000001e-06 25.637499999999999p 1.6225440000000001e-06 25.649999999999999p 1.7725500000000001e-06
+ 25.662500000000001p 1.9197399999999999e-06 25.675000000000001p 2.06392e-06 25.6875p 2.2049019999999999e-06 25.699999999999999p 2.3425029999999999e-06 25.712499999999999p 2.476541e-06 25.725000000000001p 2.6068390000000002e-06 25.737500000000001p 2.733225e-06 25.75p 2.8555329999999999e-06 25.762499999999999p 2.9736000000000002e-06 25.774999999999999p 3.0872700000000001e-06 25.787500000000001p 3.1963920000000002e-06 25.800000000000001p 3.3008210000000002e-06 25.8125p 3.400419e-06 25.824999999999999p 3.495053e-06 25.837499999999999p 3.5845990000000001e-06 25.850000000000001p 3.6689370000000001e-06 25.862500000000001p 3.7479569999999998e-06 25.875p 3.8215550000000002e-06
+ 25.887499999999999p 3.8896360000000001e-06 25.899999999999999p 3.9521099999999997e-06 25.912500000000001p 4.008897e-06 25.925000000000001p 4.0599249999999999e-06 25.9375p 4.1051300000000003e-06 25.950000000000003p 4.1444560000000004e-06 25.962499999999999p 4.1778559999999999e-06 25.974999999999998p 4.2052900000000004e-06 25.987500000000001p 4.2267279999999996e-06 26p 4.2421490000000003e-06 26.012500000000003p 4.2515389999999999e-06 26.024999999999999p 4.2548929999999997e-06 26.037499999999998p 4.2522170000000004e-06 26.050000000000001p 4.2435229999999997e-06 26.0625p 4.2288320000000001e-06 26.075000000000003p 4.2081740000000003e-06 26.087499999999999p 4.1815889999999998e-06 26.099999999999998p 4.1491230000000002e-06
+ 26.112500000000001p 4.1108319999999997e-06 26.125p 4.0667800000000001e-06 26.137499999999999p 4.0170389999999998e-06 26.150000000000002p 3.9616889999999996e-06 26.162499999999998p 3.9008180000000001e-06 26.175000000000001p 3.8345219999999996e-06 26.1875p 3.7629060000000002e-06 26.199999999999999p 3.6860789999999998e-06 26.212500000000002p 3.6041610000000001e-06 26.224999999999998p 3.5172759999999999e-06 26.237500000000001p 3.4255589999999998e-06 26.25p 3.3291469999999998e-06 26.262499999999999p 3.2281870000000001e-06 26.275000000000002p 3.1228310000000002e-06 26.287499999999998p 3.0132370000000002e-06 26.300000000000001p 2.8995680000000001e-06 26.3125p 2.7819949999999999e-06 26.324999999999999p 2.660692e-06
+ 26.337500000000002p 2.5358380000000001e-06 26.350000000000001p 2.4076180000000001e-06 26.362499999999997p 2.2762220000000001e-06 26.375p 2.141841e-06 26.387499999999999p 2.0046740000000002e-06 26.400000000000002p 1.864919e-06 26.412500000000001p 1.7227809999999999e-06 26.424999999999997p 1.5784659999999999e-06 26.4375p 1.432183e-06 26.449999999999999p 1.2841440000000001e-06 26.462500000000002p 1.1345600000000001e-06 26.475000000000001p 9.8364679999999993e-07 26.487500000000001p 8.3161989999999999e-07 26.5p 6.7869579999999997e-07 26.512499999999999p 5.2509159999999998e-07 26.524999999999999p 3.7102419999999999e-07 26.537500000000001p 2.1671070000000001e-07 26.550000000000001p 6.2367390000000004e-08
+ 26.5625p -9.1790310000000003e-08 26.574999999999999p -2.4554820000000001e-07 26.587499999999999p -3.986938e-07 26.600000000000001p -5.5101630000000004e-07 26.612500000000001p -7.0230750000000003e-07 26.625p -8.5236160000000002e-07 26.637499999999999p -1.000976e-06 26.649999999999999p -1.14795e-06 26.662500000000001p -1.2930890000000001e-06 26.675000000000001p -1.4361990000000001e-06 26.6875p -1.5770939999999999e-06 26.699999999999999p -1.715588e-06 26.712499999999999p -1.8515040000000001e-06 26.725000000000001p -1.9846660000000002e-06 26.737500000000001p -2.1149050000000002e-06 26.75p -2.2420580000000002e-06 26.762499999999999p -2.3659660000000002e-06 26.774999999999999p -2.486476e-06
+ 26.787500000000001p -2.6034430000000001e-06 26.800000000000001p -2.7167260000000001e-06 26.8125p -2.8261890000000001e-06 26.824999999999999p -2.931706e-06 26.837499999999999p -3.0331549999999998e-06 26.850000000000001p -3.1304210000000001e-06 26.862500000000001p -3.2233959999999998e-06 26.875p -3.311978e-06 26.887500000000003p -3.3960720000000001e-06 26.899999999999999p -3.4755910000000002e-06 26.912499999999998p -3.5504540000000001e-06 26.925000000000001p -3.6205860000000002e-06 26.9375p -3.6859210000000001e-06 26.950000000000003p -3.746397e-06 26.962499999999999p -3.801962e-06 26.974999999999998p -3.8525680000000001e-06 26.987500000000001p -3.8981750000000002e-06 27p -3.9387500000000002e-06
+ 27.012500000000003p -3.9742659999999997e-06 27.024999999999999p -4.0047029999999998e-06 27.037499999999998p -4.0300460000000004e-06 27.050000000000001p -4.0502889999999999e-06 27.0625p -4.0654299999999996e-06 27.074999999999999p -4.0754729999999997e-06 27.087500000000002p -4.0804300000000003e-06 27.099999999999998p -4.0803170000000004e-06 27.112500000000001p -4.0751570000000003e-06 27.125p -4.0649779999999999e-06 27.137499999999999p -4.0498139999999997e-06 27.150000000000002p -4.0297039999999998e-06 27.162499999999998p -4.0046919999999997e-06 27.175000000000001p -3.9748280000000004e-06 27.1875p -3.9401669999999997e-06 27.199999999999999p -3.900768e-06 27.212500000000002p -3.8566959999999997e-06 27.224999999999998p -3.8080199999999999e-06
+ 27.237500000000001p -3.7548130000000002e-06 27.25p -3.6971550000000002e-06 27.262499999999999p -3.635126e-06 27.275000000000002p -3.5688149999999998e-06 27.287500000000001p -3.4983119999999999e-06 27.299999999999997p -3.4237130000000001e-06 27.3125p -3.345116e-06 27.324999999999999p -3.2626240000000001e-06 27.337500000000002p -3.1763439999999999e-06 27.350000000000001p -3.0863859999999998e-06 27.362499999999997p -2.992864e-06 27.375p -2.895896e-06 27.387499999999999p -2.7956029999999998e-06 27.400000000000002p -2.6921090000000001e-06 27.412500000000001p -2.5855410000000001e-06 27.425000000000001p -2.4760309999999999e-06 27.4375p -2.3637119999999998e-06 27.449999999999999p -2.2487199999999999e-06
+ 27.462499999999999p -2.1311970000000002e-06 27.475000000000001p -2.0112829999999999e-06 27.487500000000001p -1.8891259999999999e-06 27.5p -1.7648719999999999e-06 27.512499999999999p -1.638673e-06 27.524999999999999p -1.5106810000000001e-06 27.537500000000001p -1.3810509999999999e-06 27.550000000000001p -1.249941e-06 27.5625p -1.117512e-06 27.574999999999999p -9.8392279999999993e-07 27.587499999999999p -8.4933849999999997e-07 27.600000000000001p -7.1392360000000001e-07 27.612500000000001p -5.7784470000000005e-07 27.625p -4.4126939999999997e-07 27.637499999999999p -3.043669e-07 27.649999999999999p -1.673071e-07 27.662500000000001p -3.0260759999999998e-08 27.675000000000001p 1.0660059999999999e-07
+ 27.6875p 2.4310530000000001e-07 27.699999999999999p 3.790811e-07 27.712499999999999p 5.143561e-07 27.725000000000001p 6.4875829999999997e-07 27.737500000000001p 7.8211639999999998e-07 27.75p 9.1425980000000005e-07 27.762499999999999p 1.045018e-06 27.774999999999999p 1.1742239999999999e-06 27.787500000000001p 1.301709e-06 27.800000000000001p 1.4273080000000001e-06 27.8125p 1.5508559999999999e-06 27.825000000000003p 1.6721940000000001e-06 27.837499999999999p 1.7911610000000001e-06 27.849999999999998p 1.907601e-06 27.862500000000001p 2.02136e-06 27.875p 2.132288e-06 27.887500000000003p 2.2402379999999999e-06 27.899999999999999p 2.3450669999999999e-06
+ 27.912499999999998p 2.4466340000000001e-06 27.925000000000001p 2.5448050000000001e-06 27.9375p 2.639449e-06 27.949999999999999p 2.7304390000000002e-06 27.962499999999999p 2.8176540000000001e-06 27.974999999999998p 2.9009769999999998e-06 27.987500000000001p 2.9802970000000002e-06 28p 3.055508e-06 28.012499999999999p 3.1265090000000001e-06 28.025000000000002p 3.1932059999999999e-06 28.037499999999998p 3.2555110000000001e-06 28.050000000000001p 3.3133410000000002e-06 28.0625p 3.3666199999999998e-06 28.074999999999999p 3.4152770000000001e-06 28.087500000000002p 3.4592510000000002e-06 28.099999999999998p 3.4984829999999998e-06 28.112500000000001p 3.5329250000000001e-06 28.125p 3.5625319999999998e-06
+ 28.137499999999999p 3.5872690000000001e-06 28.150000000000002p 3.6071059999999999e-06 28.162499999999998p 3.622022e-06 28.175000000000001p 3.6319989999999999e-06 28.1875p 3.6370309999999999e-06 28.199999999999999p 3.6371159999999999e-06 28.212500000000002p 3.6322600000000001e-06 28.225000000000001p 3.6224759999999998e-06 28.237499999999997p 3.6077830000000002e-06 28.25p 3.5882089999999998e-06 28.262499999999999p 3.5637869999999999e-06 28.275000000000002p 3.5345589999999999e-06 28.287500000000001p 3.5005720000000001e-06 28.299999999999997p 3.4618809999999999e-06 28.3125p 3.4185450000000001e-06 28.324999999999999p 3.3706340000000001e-06 28.337500000000002p 3.31822e-06 28.350000000000001p 3.261385e-06
+ 28.362500000000001p 3.2002150000000001e-06 28.375p 3.1348020000000001e-06 28.387499999999999p 3.0652459999999999e-06 28.399999999999999p 2.99165e-06 28.412500000000001p 2.914124e-06 28.425000000000001p 2.8327840000000002e-06 28.4375p 2.7477509999999999e-06 28.449999999999999p 2.659149e-06 28.462499999999999p 2.5671099999999998e-06 28.475000000000001p 2.4717680000000002e-06 28.487500000000001p 2.3732640000000001e-06 28.5p 2.27174e-06 28.512499999999999p 2.167346e-06 28.524999999999999p 2.060231e-06 28.537500000000001p 1.950552e-06 28.550000000000001p 1.838467e-06 28.5625p 1.7241369999999999e-06 28.574999999999999p 1.607727e-06
+ 28.587499999999999p 1.4894019999999999e-06 28.600000000000001p 1.369333e-06 28.612500000000001p 1.2476900000000001e-06 28.625p 1.124646e-06 28.637499999999999p 1.000376e-06 28.649999999999999p 8.7505360000000003e-07 28.662500000000001p 7.4885639999999996e-07 28.675000000000001p 6.219612e-07 28.6875p 4.9454529999999999e-07 28.699999999999999p 3.667862e-07 28.712499999999999p 2.3886099999999998e-07 28.725000000000001p 1.109466e-07 28.737500000000001p -1.678097e-08 28.75p -1.4414660000000001e-07 28.762500000000003p -2.7097660000000001e-07 28.774999999999999p -3.9709870000000002e-07 28.787499999999998p -5.2234249999999997e-07 28.800000000000001p -6.465395e-07
+ 28.8125p -7.6952389999999998e-07 28.825000000000003p -8.9113199999999996e-07 28.837499999999999p -1.011203e-06 28.849999999999998p -1.12958e-06 28.862500000000001p -1.246108e-06 28.875p -1.3606350000000001e-06 28.887499999999999p -1.4730159999999999e-06 28.899999999999999p -1.5831060000000001e-06 28.912499999999998p -1.6907669999999999e-06 28.925000000000001p -1.7958630000000001e-06 28.9375p -1.8982629999999999e-06 28.949999999999999p -1.9978420000000001e-06 28.962500000000002p -2.0944790000000001e-06 28.974999999999998p -2.1880559999999999e-06 28.987500000000001p -2.2784629999999999e-06 29p -2.3655940000000001e-06 29.012499999999999p -2.4493469999999998e-06 29.025000000000002p -2.529627e-06
+ 29.037499999999998p -2.6063419999999998e-06 29.050000000000001p -2.67941e-06 29.0625p -2.7487489999999999e-06 29.074999999999999p -2.8142859999999999e-06 29.087500000000002p -2.8759540000000001e-06 29.099999999999998p -2.9336900000000001e-06 29.112500000000001p -2.9874360000000001e-06 29.125000000000004p -3.0371410000000002e-06 29.137499999999999p -3.0827600000000001e-06 29.149999999999999p -3.1242539999999999e-06 29.162500000000001p -3.161586e-06 29.174999999999997p -3.1947300000000001e-06 29.187500000000004p -3.2236610000000001e-06 29.199999999999999p -3.2483630000000001e-06 29.212499999999999p -3.2688209999999999e-06 29.225000000000001p -3.2850299999999999e-06 29.237499999999997p -3.2969889999999999e-06 29.250000000000004p -3.3046999999999999e-06
+ 29.262499999999999p -3.308172e-06 29.274999999999999p -3.30742e-06 29.287500000000001p -3.3024610000000001e-06 29.299999999999997p -3.2933209999999998e-06 29.312500000000004p -3.280027e-06 29.324999999999999p -3.262613e-06 29.337499999999999p -3.2411160000000002e-06 29.350000000000001p -3.2155800000000001e-06 29.362499999999997p -3.1860500000000002e-06 29.375000000000004p -3.1525790000000002e-06 29.387499999999999p -3.1152210000000002e-06 29.400000000000002p -3.0740359999999999e-06 29.412500000000001p -3.029088e-06 29.424999999999997p -2.9804450000000001e-06 29.4375p -2.9281770000000002e-06 29.449999999999999p -2.8723590000000002e-06 29.462500000000002p -2.8130719999999999e-06 29.475000000000001p -2.750395e-06
+ 29.487499999999997p -2.6844169999999999e-06 29.5p -2.615225e-06 29.512499999999999p -2.5429120000000002e-06 29.525000000000002p -2.4675730000000002e-06 29.537500000000001p -2.3893079999999999e-06 29.549999999999997p -2.308217e-06 29.5625p -2.2244050000000002e-06 29.574999999999999p -2.1379790000000002e-06 29.587500000000002p -2.0490499999999999e-06 29.600000000000001p -1.9577290000000001e-06 29.612499999999997p -1.8641329999999999e-06 29.625p -1.7683779999999999e-06 29.637499999999999p -1.6705830000000001e-06 29.650000000000002p -1.570873e-06 29.662500000000001p -1.4693690000000001e-06 29.674999999999997p -1.3661989999999999e-06 29.6875p -1.2614910000000001e-06 29.699999999999999p -1.1553749999999999e-06
+ 29.712500000000002p -1.0479810000000001e-06 29.724999999999998p -9.3944389999999996e-07 29.737499999999997p -8.2989759999999996e-07 29.75p -7.1947810000000002e-07 29.762499999999999p -6.0832259999999999e-07 29.775000000000002p -4.9656920000000002e-07 29.787499999999998p -3.8435719999999999e-07 29.800000000000004p -2.7182639999999998e-07 29.8125p -1.591174e-07 29.824999999999999p -4.6371340000000001e-08 29.837500000000002p 6.6270370000000003e-08 29.849999999999998p 1.7866610000000001e-07 29.862500000000004p 2.9067429999999998e-07 29.875p 4.0215339999999998e-07 29.887499999999999p 5.1296209999999995e-07 29.900000000000002p 6.2295999999999996e-07 29.912499999999998p 7.3200680000000004e-07 29.925000000000004p 8.3996340000000001e-07
+ 29.9375p 9.4669170000000004e-07 29.949999999999996p 1.0520550000000001e-06 29.962500000000002p 1.1559170000000001e-06 29.974999999999998p 1.258144e-06 29.987500000000001p 1.3586049999999999e-06 30p 1.457168e-06 30.012499999999996p 1.553706e-06 30.025000000000002p 1.648093e-06 30.037499999999998p 1.740206e-06 30.050000000000001p 1.8299250000000001e-06 30.0625p 1.9171330000000001e-06 30.074999999999996p 2.001713e-06 30.087500000000002p 2.0835570000000001e-06 30.099999999999998p 2.1625559999999999e-06 30.112500000000001p 2.2386059999999998e-06 30.125p 2.311607e-06 30.137500000000003p 2.3814620000000002e-06 30.150000000000002p 2.448081e-06
+ 30.162499999999998p 2.5113750000000002e-06 30.175000000000001p 2.57126e-06 30.1875p 2.627658e-06 30.200000000000003p 2.6804959999999999e-06 30.212500000000002p 2.7297030000000002e-06 30.224999999999998p 2.7752160000000001e-06 30.237500000000001p 2.8169749999999998e-06 30.25p 2.8549270000000001e-06 30.262500000000003p 2.889022e-06 30.274999999999999p 2.919218e-06 30.287499999999998p 2.945477e-06 30.300000000000001p 2.9677649999999999e-06 30.3125p 2.986057e-06 30.325000000000003p 3.0003299999999999e-06 30.337499999999999p 3.01057e-06 30.349999999999998p 3.016766e-06 30.362500000000001p 3.018914e-06 30.375p 3.0170160000000001e-06
+ 30.387500000000003p 3.0110769999999999e-06 30.399999999999999p 3.0011130000000001e-06 30.412499999999998p 2.98714e-06 30.425000000000001p 2.969183e-06 30.4375p 2.947271e-06 30.450000000000003p 2.9214410000000002e-06 30.462499999999999p 2.8917319999999998e-06 30.474999999999998p 2.858191e-06 30.487500000000001p 2.8208690000000002e-06 30.499999999999996p 2.7798239999999999e-06 30.512500000000003p 2.7351179999999999e-06 30.524999999999999p 2.6868170000000001e-06 30.537500000000001p 2.634994e-06 30.550000000000001p 2.5797259999999999e-06 30.562499999999996p 2.521095e-06 30.575000000000003p 2.459187e-06 30.587499999999999p 2.3940939999999999e-06 30.600000000000001p 2.3259090000000001e-06
+ 30.612500000000001p 2.2547339999999999e-06 30.624999999999996p 2.180671e-06 30.637500000000003p 2.103828e-06 30.649999999999999p 2.0243159999999998e-06 30.662500000000001p 1.9422499999999999e-06 30.675000000000001p 1.8577480000000001e-06 30.687499999999996p 1.7709310000000001e-06 30.700000000000003p 1.6819229999999999e-06 30.712499999999999p 1.590851e-06 30.725000000000001p 1.4978460000000001e-06 30.737500000000001p 1.4030379999999999e-06 30.749999999999996p 1.3065619999999999e-06 30.762499999999999p 1.208555e-06 30.774999999999999p 1.1091549999999999e-06 30.787500000000001p 1.0085e-06 30.800000000000001p 9.0673210000000001e-07 30.812499999999996p 8.0399319999999995e-07 30.824999999999999p 7.0042610000000002e-07
+ 30.837499999999999p 5.9617459999999998e-07 30.850000000000001p 4.9138280000000004e-07 30.862500000000001p 3.8619500000000002e-07 30.874999999999996p 2.8075589999999998e-07 30.887499999999999p 1.752095e-07 30.899999999999999p 6.9699940000000003e-08 30.912500000000001p -3.562966e-08 30.925000000000001p -1.4063680000000001e-07 30.937500000000004p -2.4517999999999998e-07 30.949999999999999p -3.491192e-07 30.962499999999999p -4.523155e-07 30.975000000000001p -5.546318e-07 30.987500000000001p -6.5593280000000002e-07 31.000000000000004p -7.5608540000000003e-07 31.012499999999999p -8.5495840000000005e-07 31.024999999999999p -9.5242319999999996e-07 31.037500000000001p -1.048354e-06 31.049999999999997p -1.142627e-06
+ 31.062500000000004p -1.235122e-06 31.074999999999999p -1.325722e-06 31.087499999999999p -1.4143120000000001e-06 31.100000000000001p -1.500782e-06 31.112499999999997p -1.5850249999999999e-06 31.125000000000004p -1.666936e-06 31.137499999999999p -1.746417e-06 31.149999999999999p -1.82337e-06 31.162500000000001p -1.897704e-06 31.174999999999997p -1.9693310000000002e-06 31.187500000000004p -2.0381660000000001e-06 31.199999999999999p -2.1041310000000001e-06 31.212499999999999p -2.1671500000000001e-06 31.225000000000001p -2.2271510000000002e-06 31.237499999999997p -2.2840690000000001e-06 31.250000000000004p -2.337841e-06 31.262499999999999p -2.3884089999999999e-06 31.275000000000002p -2.4357210000000002e-06
+ 31.287500000000001p -2.4797280000000001e-06 31.299999999999997p -2.5203849999999998e-06 31.3125p -2.5576549999999999e-06 31.324999999999999p -2.5915020000000001e-06 31.337500000000002p -2.6218949999999999e-06 31.350000000000001p -2.6488099999999998e-06 31.362499999999997p -2.6722259999999999e-06 31.375p -2.6921250000000001e-06 31.387499999999999p -2.7084970000000001e-06 31.400000000000002p -2.721333e-06 31.412500000000001p -2.730631e-06 31.424999999999997p -2.7363930000000002e-06 31.4375p -2.7386229999999999e-06 31.449999999999999p -2.7373329999999999e-06 31.462500000000002p -2.7325370000000001e-06 31.475000000000001p -2.7242519999999998e-06 31.487499999999997p -2.7125030000000002e-06 31.5p -2.697316e-06
+ 31.512499999999999p -2.6787209999999998e-06 31.525000000000002p -2.6567540000000001e-06 31.537500000000001p -2.6314529999999999e-06 31.549999999999997p -2.6028599999999998e-06 31.5625p -2.5710219999999998e-06 31.574999999999999p -2.5359889999999999e-06 31.587500000000002p -2.4978130000000002e-06 31.599999999999998p -2.4565519999999999e-06 31.612499999999997p -2.4122660000000001e-06 31.625p -2.3650190000000001e-06 31.637499999999999p -2.3148770000000001e-06 31.650000000000002p -2.2619100000000002e-06 31.662499999999998p -2.2061910000000001e-06 31.675000000000004p -2.1477970000000001e-06 31.6875p -2.0868059999999998e-06 31.699999999999999p -2.023301e-06 31.712500000000002p -1.957364e-06 31.724999999999998p -1.8890850000000001e-06
+ 31.737500000000004p -1.818551e-06 31.75p -1.7458559999999999e-06 31.762499999999999p -1.671093e-06 31.775000000000002p -1.5943600000000001e-06 31.787499999999998p -1.515755e-06 31.800000000000004p -1.4353799999999999e-06 31.8125p -1.353336e-06 31.824999999999996p -1.2697290000000001e-06 31.837500000000002p -1.184666e-06 31.849999999999998p -1.0982539999999999e-06 31.862500000000001p -1.010603e-06 31.875p -9.2182389999999999e-07 31.887499999999996p -8.3202980000000004e-07 31.900000000000002p -7.4133410000000003e-07 31.912499999999998p -6.4985149999999995e-07 31.925000000000001p -5.5769769999999999e-07 31.9375p -4.6498919999999999e-07 31.949999999999996p -3.7184329999999998e-07
+ 31.962500000000002p -2.7837789999999999e-07 31.974999999999998p -1.847113e-07 31.987500000000001p -9.0962160000000002e-08 32p 2.7506770000000001e-09 32.012500000000003p 9.6308320000000001e-08 32.024999999999999p 1.895919e-07 32.037500000000001p 2.82483e-07 32.050000000000004p 3.7486320000000002e-07 32.0625p 4.6661490000000001e-07 32.075000000000003p 5.5762100000000001e-07 32.087499999999999p 6.4776529999999998e-07 32.099999999999994p 7.3693259999999998e-07 32.112500000000004p 8.2500870000000005e-07 32.125p 9.1188069999999998e-07 32.137500000000003p 9.9743720000000002e-07 32.149999999999999p 1.0815679999999999e-06 32.162499999999994p 1.1641650000000001e-06 32.175000000000004p 1.2451229999999999e-06
+ 32.1875p 1.3243359999999999e-06 32.200000000000003p 1.4017029999999999e-06 32.212499999999999p 1.477123e-06 32.224999999999994p 1.5505e-06 32.237500000000004p 1.6217380000000001e-06 32.25p 1.690746e-06 32.262500000000003p 1.757435e-06 32.274999999999999p 1.8217179999999999e-06 32.287499999999994p 1.883512e-06 32.300000000000004p 1.9427379999999998e-06 32.3125p 1.9993200000000002e-06 32.325000000000003p 2.0531840000000001e-06 32.337499999999999p 2.1042609999999999e-06 32.349999999999994p 2.152487e-06 32.362499999999997p 2.1977979999999999e-06 32.375p 2.240139e-06 32.387500000000003p 2.2794550000000002e-06 32.399999999999999p 2.315696e-06
+ 32.412500000000001p 2.3488170000000001e-06 32.424999999999997p 2.3787779999999998e-06 32.4375p 2.4055410000000002e-06 32.450000000000003p 2.4290739999999999e-06 32.462499999999999p 2.4493489999999999e-06 32.475000000000001p 2.4663430000000001e-06 32.487499999999997p 2.4800369999999999e-06 32.5p 2.4904159999999999e-06 32.512500000000003p 2.4974719999999999e-06 32.524999999999999p 2.5011979999999998e-06 32.537500000000001p 2.5015940000000002e-06 32.549999999999997p 2.4986640000000002e-06 32.5625p 2.4924180000000001e-06 32.575000000000003p 2.4828679999999999e-06 32.587499999999999p 2.4700320000000001e-06 32.600000000000001p 2.453932e-06 32.612499999999997p 2.4345959999999998e-06 32.625p 2.412055e-06
+ 32.637500000000003p 2.3863450000000001e-06 32.649999999999999p 2.357506e-06 32.662500000000001p 2.3255820000000002e-06 32.674999999999997p 2.2906230000000001e-06 32.6875p 2.2526810000000002e-06 32.700000000000003p 2.2118129999999999e-06 32.712499999999999p 2.1680799999999999e-06 32.725000000000001p 2.121548e-06 32.737499999999997p 2.0722849999999998e-06 32.75p 2.020362e-06 32.762500000000003p 1.9658580000000002e-06 32.774999999999999p 1.9088499999999999e-06 32.787500000000001p 1.849421e-06 32.799999999999997p 1.787659e-06 32.8125p 1.72365e-06 32.825000000000003p 1.6574889999999999e-06 32.837499999999999p 1.589269e-06 32.850000000000001p 1.5190889999999999e-06
+ 32.862499999999997p 1.4470469999999999e-06 32.875p 1.3732470000000001e-06 32.887500000000003p 1.2977929999999999e-06 32.899999999999999p 1.220791e-06 32.912500000000001p 1.14235e-06 32.924999999999997p 1.0625809999999999e-06 32.9375p 9.8159370000000007e-07 32.950000000000003p 8.9950280000000002e-07 32.962499999999999p 8.1642210000000005e-07 32.975000000000001p 7.3246669999999999e-07 32.987499999999997p 6.4775279999999995e-07 33p 5.6239720000000001e-07 33.012500000000003p 4.7651719999999999e-07 33.024999999999999p 3.9023039999999999e-07 33.037500000000001p 3.0365450000000001e-07 33.049999999999997p 2.1690720000000001e-07 33.0625p 1.3010610000000001e-07 33.075000000000003p 4.336837e-08
+ 33.087499999999999p -4.3189490000000001e-08 33.100000000000001p -1.294515e-07 33.112499999999997p -2.1530279999999999e-07 33.125p -3.0062930000000001e-07 33.137500000000003p -3.8531829999999999e-07 33.150000000000006p -4.6925839999999997e-07 33.162500000000001p -5.5233980000000005e-07 33.174999999999997p -6.3445420000000001e-07 33.1875p -7.1549529999999997e-07 33.199999999999996p -7.953586e-07 33.212500000000006p -8.7394189999999996e-07 33.225000000000001p -9.5114499999999996e-07 33.237499999999997p -1.0268700000000001e-06 33.25p -1.1010220000000001e-06 33.262499999999996p -1.1735089999999999e-06 33.275000000000006p -1.2442399999999999e-06 33.287500000000001p -1.3131279999999999e-06 33.299999999999997p -1.380089e-06
+ 33.3125p -1.445042e-06 33.324999999999996p -1.507908e-06 33.337500000000006p -1.5686140000000001e-06 33.350000000000001p -1.6270869999999999e-06 33.362499999999997p -1.683259e-06 33.375p -1.737066e-06 33.387499999999996p -1.7884450000000001e-06 33.400000000000006p -1.837339e-06 33.412500000000001p -1.8836939999999999e-06 33.424999999999997p -1.9274590000000001e-06 33.4375p -1.9685860000000001e-06 33.449999999999996p -2.0070340000000001e-06 33.462499999999999p -2.0427599999999999e-06 33.475000000000001p -2.0757310000000001e-06 33.487499999999997p -2.1059130000000002e-06 33.5p -2.133277e-06 33.512499999999996p -2.1577999999999999e-06 33.524999999999999p -2.179459e-06
+ 33.537500000000001p -2.1982380000000002e-06 33.550000000000004p -2.2141230000000001e-06 33.5625p -2.2271030000000001e-06 33.574999999999996p -2.2371729999999998e-06 33.587499999999999p -2.244329e-06 33.600000000000001p -2.2485740000000001e-06 33.612500000000004p -2.2499100000000001e-06 33.625p -2.248347e-06 33.637499999999996p -2.2438960000000001e-06 33.649999999999999p -2.2365710000000002e-06 33.662500000000001p -2.2263920000000002e-06 33.675000000000004p -2.213381e-06 33.6875p -2.1975620000000002e-06 33.699999999999996p -2.1789640000000001e-06 33.712499999999999p -2.1576190000000002e-06 33.725000000000001p -2.133562e-06 33.737500000000004p -2.1068310000000001e-06 33.75p -2.0774670000000002e-06
+ 33.762499999999996p -2.0455129999999999e-06 33.774999999999999p -2.011018e-06 33.787500000000001p -1.9740309999999999e-06 33.800000000000004p -1.934605e-06 33.8125p -1.892795e-06 33.824999999999996p -1.8486599999999999e-06 33.837499999999999p -1.802259e-06 33.850000000000001p -1.7536569999999999e-06 33.862500000000004p -1.70292e-06 33.875p -1.6501150000000001e-06 33.887500000000003p -1.5953129999999999e-06 33.899999999999999p -1.538586e-06 33.912500000000001p -1.4800100000000001e-06 33.925000000000004p -1.4196609999999999e-06 33.9375p -1.357619e-06 33.950000000000003p -1.2939630000000001e-06 33.962499999999999p -1.228778e-06 33.974999999999994p -1.1621470000000001e-06
+ 33.987500000000004p -1.0941560000000001e-06 34p -1.0248929999999999e-06 34.012500000000003p -9.5444720000000003e-07 34.024999999999999p -8.8290890000000004e-07 34.037499999999994p -8.1036989999999998e-07 34.050000000000004p -7.3692310000000003e-07 34.0625p -6.6266259999999999e-07 34.075000000000003p -5.8768320000000005e-07 34.087499999999999p -5.1208100000000004e-07 34.099999999999994p -4.3595240000000001e-07 34.112500000000004p -3.5939489999999998e-07 34.125p -2.8250619999999999e-07 34.137500000000003p -2.053845e-07 34.149999999999999p -1.281286e-07 34.162499999999994p -5.0837159999999999e-08 34.175000000000004p 2.6390909999999999e-08 34.1875p 1.034568e-07 34.200000000000003p 1.802617e-07
+ 34.212499999999999p 2.5670729999999997e-07 34.224999999999994p 3.3269549999999999e-07 34.237499999999997p 4.0812879999999998e-07 34.25p 4.8291029999999995e-07 34.262500000000003p 5.5694399999999996e-07 34.274999999999999p 6.3013469999999999e-07 34.287500000000001p 7.0238809999999997e-07 34.299999999999997p 7.7361130000000001e-07 34.3125p 8.4371249999999999e-07 34.325000000000003p 9.1260139999999995e-07 34.337499999999999p 9.8018910000000001e-07 34.350000000000001p 1.0463879999999999e-06 34.362499999999997p 1.111114e-06 34.375p 1.1742820000000001e-06 34.387500000000003p 1.235812e-06 34.399999999999999p 1.2956229999999999e-06 34.412500000000001p 1.3536390000000001e-06 34.424999999999997p 1.409784e-06
+ 34.4375p 1.463988e-06 34.450000000000003p 1.516179e-06 34.462499999999999p 1.5662900000000001e-06 34.475000000000001p 1.6142580000000001e-06 34.487499999999997p 1.6600209999999999e-06 34.5p 1.703521e-06 34.512500000000003p 1.7447020000000001e-06 34.524999999999999p 1.783511e-06 34.537500000000001p 1.8198999999999999e-06 34.549999999999997p 1.8538229999999999e-06 34.5625p 1.8852369999999999e-06 34.575000000000003p 1.9141040000000001e-06 34.587499999999999p 1.9403880000000002e-06 34.600000000000001p 1.9640569999999998e-06 34.612499999999997p 1.985083e-06 34.625p 2.0034409999999998e-06 34.637500000000003p 2.0191089999999999e-06 34.649999999999999p 2.0320709999999998e-06
+ 34.662500000000001p 2.0423119999999998e-06 34.674999999999997p 2.0498240000000001e-06 34.6875p 2.054599e-06 34.700000000000003p 2.0566360000000001e-06 34.712499999999999p 2.055935e-06 34.725000000000001p 2.0525030000000001e-06 34.737499999999997p 2.0463479999999998e-06 34.75p 2.0374830000000001e-06 34.762500000000003p 2.0259229999999999e-06 34.774999999999999p 2.0116910000000001e-06 34.787500000000001p 1.994809e-06 34.799999999999997p 1.9753040000000001e-06 34.8125p 1.9532089999999998e-06 34.825000000000003p 1.9285569999999999e-06 34.837499999999999p 1.901386e-06 34.850000000000001p 1.8717400000000001e-06 34.862499999999997p 1.8396609999999999e-06 34.875p 1.8051990000000001e-06
+ 34.887500000000003p 1.768404e-06 34.899999999999999p 1.729333e-06 34.912500000000001p 1.6880420000000001e-06 34.924999999999997p 1.6445910000000001e-06 34.9375p 1.5990460000000001e-06 34.950000000000003p 1.5514709999999999e-06 34.962499999999999p 1.5019359999999999e-06 34.975000000000001p 1.450512e-06 34.987499999999997p 1.3972740000000001e-06 35p 1.342298e-06 35.012500000000003p 1.285662e-06 35.025000000000006p 1.2274479999999999e-06 35.037500000000001p 1.1677380000000001e-06 35.049999999999997p 1.106617e-06 35.0625p 1.0441709999999999e-06 35.074999999999996p 9.8048770000000003e-07 35.087500000000006p 9.1565720000000004e-07 35.100000000000001p 8.4977009999999996e-07
+ 35.112499999999997p 7.8291830000000005e-07 35.125p 7.1519500000000002e-07 35.137499999999996p 6.4669400000000003e-07 35.150000000000006p 5.7751020000000003e-07 35.162500000000001p 5.0773900000000004e-07 35.174999999999997p 4.374763e-07 35.1875p 3.6681850000000001e-07 35.199999999999996p 2.9586190000000001e-07 35.212500000000006p 2.2470320000000001e-07 35.225000000000001p 1.5343890000000001e-07 35.237499999999997p 8.2165320000000004e-08 35.25p 1.0978410000000001e-08 35.262499999999996p -6.002634e-08 35.275000000000006p -1.307541e-07 35.287500000000001p -2.0111060000000001e-07 35.299999999999997p -2.7100280000000002e-07 35.3125p -3.403385e-07 35.324999999999996p -4.0902640000000002e-07
+ 35.337499999999999p -4.769769e-07 35.350000000000001p -5.4410159999999999e-07 35.362499999999997p -6.1031349999999995e-07 35.375p -6.7552729999999996e-07 35.387499999999996p -7.3965950000000003e-07 35.399999999999999p -8.0262849999999999e-07 35.412500000000001p -8.6435450000000005e-07 35.425000000000004p -9.2475979999999999e-07 35.4375p -9.8376879999999991e-07 35.449999999999996p -1.0413080000000001e-06 35.462499999999999p -1.097307e-06 35.475000000000001p -1.151697e-06 35.487500000000004p -1.204412e-06 35.5p -1.255388e-06 35.512499999999996p -1.304564e-06 35.524999999999999p -1.3518820000000001e-06 35.537500000000001p -1.397288e-06 35.550000000000004p -1.4407269999999999e-06
+ 35.5625p -1.4821510000000001e-06 35.574999999999996p -1.5215120000000001e-06 35.587499999999999p -1.5587659999999999e-06 35.600000000000001p -1.593873e-06 35.612500000000004p -1.6267949999999999e-06 35.625p -1.6574959999999999e-06 35.637499999999996p -1.685945e-06 35.649999999999999p -1.712113e-06 35.662500000000001p -1.7359739999999999e-06 35.675000000000004p -1.7575060000000001e-06 35.6875p -1.776688e-06 35.699999999999996p -1.793505e-06 35.712499999999999p -1.807944e-06 35.725000000000001p -1.819993e-06 35.737500000000004p -1.829646e-06 35.75p -1.8368980000000001e-06 35.762500000000003p -1.841749e-06 35.774999999999999p -1.844199e-06
+ 35.787500000000001p -1.8442550000000001e-06 35.800000000000004p -1.8419239999999999e-06 35.8125p -1.837216e-06 35.825000000000003p -1.8301460000000001e-06 35.837499999999999p -1.8207289999999999e-06 35.849999999999994p -1.808986e-06 35.862500000000004p -1.7949369999999999e-06 35.875p -1.778609e-06 35.887500000000003p -1.760028e-06 35.899999999999999p -1.7392250000000001e-06 35.912499999999994p -1.716232e-06 35.925000000000004p -1.691084e-06 35.9375p -1.663821e-06 35.950000000000003p -1.6344810000000001e-06 35.962499999999999p -1.6031069999999999e-06 35.974999999999994p -1.5697439999999999e-06 35.987500000000004p -1.5344399999999999e-06 36p -1.497243e-06
+ 36.012500000000003p -1.458206e-06 36.024999999999999p -1.4173819999999999e-06 36.037499999999994p -1.374826e-06 36.050000000000004p -1.3305969999999999e-06 36.0625p -1.2847529999999999e-06 36.075000000000003p -1.237355e-06 36.087499999999999p -1.1884680000000001e-06 36.099999999999994p -1.138155e-06 36.112499999999997p -1.0864840000000001e-06 36.125p -1.0335200000000001e-06 36.137500000000003p -9.7933509999999994e-07 36.149999999999999p -9.2399850000000003e-07 36.162500000000001p -8.6758239999999996e-07 36.174999999999997p -8.1016009999999999e-07 36.1875p -7.51806e-07 36.200000000000003p -6.925952e-07 36.212499999999999p -6.3260430000000002e-07 36.225000000000001p -5.7191049999999995e-07
+ 36.237499999999997p -5.1059180000000004e-07 36.25p -4.4872709999999998e-07 36.262500000000003p -3.8639569999999998e-07 36.274999999999999p -3.2367749999999998e-07 36.287500000000001p -2.6065300000000002e-07 36.299999999999997p -1.9740300000000001e-07 36.3125p -1.3400850000000001e-07 36.325000000000003p -7.0550569999999996e-08 36.337499999999999p -7.1106060000000001e-09 36.350000000000001p 5.6230190000000002e-08 36.362499999999997p 1.1939070000000001e-07 36.375p 1.8229e-07 36.387500000000003p 2.4484750000000001e-07 36.399999999999999p 3.0698299999999999e-07 36.412500000000001p 3.68617e-07 36.424999999999997p 4.2967029999999999e-07 36.4375p 4.9006459999999999e-07 36.450000000000003p 5.4972249999999999e-07
+ 36.462499999999999p 6.0856739999999999e-07 36.475000000000001p 6.6652380000000004e-07 36.487499999999997p 7.2351719999999996e-07 36.5p 7.794744e-07 36.512500000000003p 8.3432350000000001e-07 36.524999999999999p 8.879941e-07 36.537500000000001p 9.404173e-07 36.549999999999997p 9.9152560000000007e-07 36.5625p 1.0412540000000001e-06 36.575000000000003p 1.0895370000000001e-06 36.587499999999999p 1.136315e-06 36.600000000000001p 1.1815259999999999e-06 36.612499999999997p 1.2251130000000001e-06 36.625p 1.26702e-06 36.637500000000003p 1.307194e-06 36.649999999999999p 1.345583e-06 36.662500000000001p 1.3821390000000001e-06 36.674999999999997p 1.4168140000000001e-06
+ 36.6875p 1.449566e-06 36.700000000000003p 1.480353e-06 36.712499999999999p 1.509136e-06 36.725000000000001p 1.535879e-06 36.737499999999997p 1.560549e-06 36.75p 1.5831159999999999e-06 36.762500000000003p 1.6035519999999999e-06 36.774999999999999p 1.6218329999999999e-06 36.787500000000001p 1.637937e-06 36.799999999999997p 1.651844e-06 36.8125p 1.6635400000000001e-06 36.825000000000003p 1.673012e-06 36.837499999999999p 1.6802490000000001e-06 36.850000000000001p 1.685246e-06 36.862499999999997p 1.6879989999999999e-06 36.875p 1.688507e-06 36.887499999999996p 1.686774e-06 36.900000000000006p 1.6828030000000001e-06
+ 36.912500000000001p 1.6766050000000001e-06 36.924999999999997p 1.668192e-06 36.9375p 1.657577e-06 36.949999999999996p 1.644779e-06 36.962500000000006p 1.6298179999999999e-06 36.975000000000001p 1.6127189999999999e-06 36.987499999999997p 1.5935070000000001e-06 37p 1.5722130000000001e-06 37.012499999999996p 1.5488680000000001e-06 37.025000000000006p 1.5235089999999999e-06 37.037500000000001p 1.496172e-06 37.049999999999997p 1.4668990000000001e-06 37.0625p 1.4357310000000001e-06 37.074999999999996p 1.4027159999999999e-06 37.087500000000006p 1.3679010000000001e-06 37.100000000000001p 1.331336e-06 37.112499999999997p 1.2930749999999999e-06 37.125p 1.253173e-06
+ 37.137499999999996p 1.211686e-06 37.150000000000006p 1.1686740000000001e-06 37.162500000000001p 1.1241979999999999e-06 37.174999999999997p 1.0783220000000001e-06 37.1875p 1.0311110000000001e-06 37.199999999999996p 9.8263010000000005e-07 37.212499999999999p 9.3294890000000003e-07 37.225000000000001p 8.8213670000000003e-07 37.237499999999997p 8.3026469999999997e-07 37.25p 7.7740530000000002e-07 37.262499999999996p 7.2363210000000002e-07 37.274999999999999p 6.6901969999999996e-07 37.287500000000001p 6.1364369999999996e-07 37.300000000000004p 5.5758049999999995e-07 37.3125p 5.009074e-07 37.324999999999996p 4.4370209999999998e-07 37.337499999999999p 3.8604290000000002e-07 37.350000000000001p 3.2800859999999999e-07
+ 37.362500000000004p 2.6967800000000001e-07 37.375p 2.1113040000000001e-07 37.387499999999996p 1.5244489999999999e-07 37.399999999999999p 9.3700520000000006e-08 37.412500000000001p 3.4976330000000001e-08 37.425000000000004p -2.3649080000000001e-08 37.4375p -8.2097440000000005e-08 37.449999999999996p -1.40291e-07 37.462499999999999p -1.9815270000000001e-07 37.475000000000001p -2.5560619999999998e-07 37.487500000000004p -3.1257569999999998e-07 37.5p -3.6898680000000001e-07 37.512499999999996p -4.2476580000000002e-07 37.524999999999999p -4.7984019999999997e-07 37.537500000000001p -5.3413889999999997e-07 37.550000000000004p -5.8759190000000005e-07 37.5625p -6.4013059999999996e-07 37.574999999999996p -6.9168819999999995e-07
+ 37.587499999999999p -7.4219909999999998e-07 37.600000000000001p -7.9159970000000004e-07 37.612500000000004p -8.3982789999999998e-07 37.625p -8.8682359999999998e-07 37.637500000000003p -9.3252839999999997e-07 37.649999999999999p -9.7688620000000004e-07 37.662500000000001p -1.0198430000000001e-06 37.675000000000004p -1.0613450000000001e-06 37.6875p -1.1013440000000001e-06 37.700000000000003p -1.1397920000000001e-06 37.712499999999999p -1.176643e-06 37.724999999999994p -1.211853e-06 37.737500000000004p -1.2453819999999999e-06 37.75p -1.277192e-06 37.762500000000003p -1.3072449999999999e-06 37.774999999999999p -1.335509e-06 37.787499999999994p -1.361952e-06 37.800000000000004p -1.386546e-06
+ 37.8125p -1.4092650000000001e-06 37.825000000000003p -1.4300840000000001e-06 37.837499999999999p -1.448983e-06 37.849999999999994p -1.465944e-06 37.862500000000004p -1.48095e-06 37.875p -1.4939880000000001e-06 37.887500000000003p -1.505048e-06 37.899999999999999p -1.514121e-06 37.912499999999994p -1.521202e-06 37.925000000000004p -1.526287e-06 37.9375p -1.5293769999999999e-06 37.950000000000003p -1.5304739999999999e-06 37.962499999999999p -1.529581e-06 37.974999999999994p -1.5267060000000001e-06 37.987499999999997p -1.5218589999999999e-06 38p -1.5150520000000001e-06 38.012500000000003p -1.5062990000000001e-06 38.024999999999999p -1.4956159999999999e-06
+ 38.037500000000001p -1.4830240000000001e-06 38.049999999999997p -1.4685429999999999e-06 38.0625p -1.452197e-06 38.075000000000003p -1.4340130000000001e-06 38.087499999999999p -1.414019e-06 38.100000000000001p -1.3922439999999999e-06 38.112499999999997p -1.3687220000000001e-06 38.125p -1.343487e-06 38.137500000000003p -1.316575e-06 38.149999999999999p -1.288025e-06 38.162500000000001p -1.2578780000000001e-06 38.174999999999997p -1.226176e-06 38.1875p -1.1929630000000001e-06 38.200000000000003p -1.158285e-06 38.212499999999999p -1.1221889999999999e-06 38.225000000000001p -1.084724e-06 38.237499999999997p -1.0459419999999999e-06 38.25p -1.005895e-06
+ 38.262500000000003p -9.6463609999999992e-07 38.274999999999999p -9.2222069999999995e-07 38.287500000000001p -8.7870519999999996e-07 38.299999999999997p -8.341472e-07 38.3125p -7.8860569999999998e-07 38.325000000000003p -7.4214059999999995e-07 38.337499999999999p -6.9481279999999995e-07 38.350000000000001p -6.4668449999999998e-07 38.362499999999997p -5.9781839999999996e-07 38.375p -5.4827829999999996e-07 38.387500000000003p -4.9812860000000003e-07 38.399999999999999p -4.474344e-07 38.412500000000001p -3.9626140000000003e-07 38.424999999999997p -3.4467599999999998e-07 38.4375p -2.9274480000000001e-07 38.450000000000003p -2.4053479999999999e-07 38.462499999999999p -1.8811329999999999e-07 38.475000000000001p -1.3554799999999999e-07
+ 38.487499999999997p -8.2906469999999999e-08 38.5p -3.0256410000000001e-08 38.512500000000003p 2.233451e-08 38.524999999999999p 7.4798729999999994e-08 38.537500000000001p 1.2706889999999999e-07 38.549999999999997p 1.790781e-07 38.5625p 2.307594e-07 38.575000000000003p 2.820468e-07 38.587499999999999p 3.3287450000000001e-07 38.600000000000001p 3.831775e-07 38.612499999999997p 4.328914e-07 38.625p 4.8195260000000001e-07 38.637500000000003p 5.3029840000000005e-07 38.649999999999999p 5.7786700000000005e-07 38.662500000000001p 6.2459770000000004e-07 38.674999999999997p 6.7043090000000004e-07 38.6875p 7.1530799999999996e-07 38.700000000000003p 7.5917200000000004e-07
+ 38.712499999999999p 8.0196700000000005e-07 38.725000000000001p 8.4363849999999996e-07 38.737499999999997p 8.8413350000000001e-07 38.75p 9.2340079999999996e-07 38.762499999999996p 9.6139060000000001e-07 38.775000000000006p 9.9805470000000002e-07 38.787500000000001p 1.0333469999999999e-06 38.799999999999997p 1.0672229999999999e-06 38.8125p 1.0996400000000001e-06 38.824999999999996p 1.1305569999999999e-06 38.837500000000006p 1.159936e-06 38.850000000000001p 1.1877409999999999e-06 38.862499999999997p 1.2139360000000001e-06 38.875p 1.238489e-06 38.887499999999996p 1.2613709999999999e-06 38.900000000000006p 1.282554e-06 38.912500000000001p 1.3020110000000001e-06 38.924999999999997p 1.319721e-06
+ 38.9375p 1.335661e-06 38.949999999999996p 1.3498129999999999e-06 38.962500000000006p 1.3621620000000001e-06 38.975000000000001p 1.372694e-06 38.987499999999997p 1.3813969999999999e-06 39p 1.3882629999999999e-06 39.012499999999996p 1.3932860000000001e-06 39.025000000000006p 1.3964610000000001e-06 39.037500000000001p 1.3977880000000001e-06 39.049999999999997p 1.3972679999999999e-06 39.0625p 1.3949040000000001e-06 39.074999999999996p 1.390704e-06 39.087499999999999p 1.384675e-06 39.100000000000001p 1.3768290000000001e-06 39.112500000000004p 1.3671790000000001e-06 39.125p 1.3557420000000001e-06 39.137499999999996p 1.342535e-06 39.149999999999999p 1.3275809999999999e-06
+ 39.162500000000001p 1.3109020000000001e-06 39.175000000000004p 1.2925229999999999e-06 39.1875p 1.272473e-06 39.199999999999996p 1.2507810000000001e-06 39.212499999999999p 1.22748e-06 39.225000000000001p 1.202603e-06 39.237500000000004p 1.1761879999999999e-06 39.25p 1.1482719999999999e-06 39.262499999999996p 1.1188969999999999e-06 39.274999999999999p 1.0881039999999999e-06 39.287500000000001p 1.0559379999999999e-06 39.300000000000004p 1.0224440000000001e-06 39.3125p 9.8767010000000005e-07 39.324999999999996p 9.516659e-07 39.337499999999999p 9.1448200000000002e-07 39.350000000000001p 8.7617089999999997e-07 39.362500000000004p 8.367862e-07 39.375p 7.9638310000000001e-07
+ 39.387499999999996p 7.550179e-07 39.399999999999999p 7.1274820000000001e-07 39.412500000000001p 6.6963270000000005e-07 39.425000000000004p 6.2573080000000002e-07 39.4375p 5.811032e-07 39.449999999999996p 5.3581130000000004e-07 39.462499999999999p 4.8991700000000001e-07 39.475000000000001p 4.4348320000000001e-07 39.487500000000004p 3.9657320000000002e-07 39.5p 3.4925080000000002e-07 39.512500000000003p 3.0157999999999998e-07 39.524999999999999p 2.5362540000000002e-07 39.537500000000001p 2.054514e-07 39.550000000000004p 1.57123e-07 39.5625p 1.087047e-07 39.575000000000003p 6.0261220000000003e-08 39.587499999999999p 1.1857060000000001e-08 39.599999999999994p -3.644359e-08
+ 39.612500000000004p -8.4576859999999999e-08 39.625p -1.3247930000000001e-07 39.637500000000003p -1.8008810000000001e-07 39.649999999999999p -2.2734080000000001e-07 39.662499999999994p -2.7417599999999998e-07 39.675000000000004p -3.2053270000000003e-07 39.6875p -3.6635100000000002e-07 39.700000000000003p -4.1157189999999998e-07 39.712499999999999p -4.5613730000000001e-07 39.724999999999994p -4.999902e-07 39.737500000000004p -5.4307490000000005e-07 39.75p -5.8533689999999995e-07 39.762500000000003p -6.2672270000000004e-07 39.774999999999999p -6.6718070000000002e-07 39.787499999999994p -7.0666019999999999e-07 39.800000000000004p -7.4511219999999997e-07 39.8125p -7.8248940000000001e-07 39.825000000000003p -8.1874590000000005e-07
+ 39.837499999999999p -8.5383740000000002e-07 39.849999999999994p -8.8772150000000005e-07 39.862499999999997p -9.2035739999999996e-07 39.875p -9.5170619999999997e-07 39.887500000000003p -9.8173079999999998e-07 39.899999999999999p -1.010396e-06 39.912500000000001p -1.037668e-06 39.924999999999997p -1.0635160000000001e-06 39.9375p -1.0879110000000001e-06 39.950000000000003p -1.110824e-06 39.962499999999999p -1.1322309999999999e-06 39.975000000000001p -1.152108e-06 39.987499999999997p -1.1704339999999999e-06 40p -1.18719e-06 40.012500000000003p -1.2023590000000001e-06 40.024999999999999p -1.2159249999999999e-06 40.037500000000001p -1.2278759999999999e-06 40.049999999999997p -1.2382010000000001e-06
+ 40.0625p -1.2468920000000001e-06 40.075000000000003p -1.253941e-06 40.087499999999999p -1.2593449999999999e-06 40.100000000000001p -1.2631010000000001e-06 40.112499999999997p -1.265208e-06 40.125p -1.26567e-06 40.137500000000003p -1.264489e-06 40.149999999999999p -1.261673e-06 40.162500000000001p -1.2572279999999999e-06 40.174999999999997p -1.2511650000000001e-06 40.1875p -1.2434959999999999e-06 40.200000000000003p -1.2342359999999999e-06 40.212499999999999p -1.2234e-06 40.225000000000001p -1.2110060000000001e-06 40.237499999999997p -1.1970750000000001e-06 40.25p -1.1816269999999999e-06 40.262500000000003p -1.1646869999999999e-06 40.274999999999999p -1.146281e-06
+ 40.287500000000001p -1.126434e-06 40.299999999999997p -1.105177e-06 40.3125p -1.082539e-06 40.325000000000003p -1.0585530000000001e-06 40.337499999999999p -1.0332530000000001e-06 40.350000000000001p -1.006674e-06 40.362499999999997p -9.788536000000001e-07 40.375p -9.4982949999999996e-07 40.387500000000003p -9.1964170000000002e-07 40.399999999999999p -8.8833140000000001e-07 40.412500000000001p -8.55941e-07 40.424999999999997p -8.2251450000000004e-07 40.4375p -7.8809659999999997e-07 40.450000000000003p -7.5273360000000003e-07 40.462499999999999p -7.1647259999999996e-07 40.475000000000001p -6.7936189999999997e-07 40.487499999999997p -6.4145070000000001e-07 40.5p -6.0278930000000001e-07
+ 40.512500000000003p -5.6342859999999996e-07 40.524999999999999p -5.2342040000000003e-07 40.537500000000001p -4.8281739999999997e-07 40.549999999999997p -4.4167270000000001e-07 40.5625p -4.0004020000000001e-07 40.575000000000003p -3.579743e-07 40.587499999999999p -3.1552989999999998e-07 40.600000000000001p -2.727622e-07 40.612499999999997p -2.29727e-07 40.625p -1.8647989999999999e-07 40.637499999999996p -1.4307730000000001e-07 40.650000000000006p -9.957528e-08 40.662500000000001p -5.603021e-08 40.674999999999997p -1.249841e-08 40.6875p 3.0963890000000003e-08 40.699999999999996p 7.4300579999999997e-08 40.712500000000006p 1.1745580000000001e-07 40.725000000000001p 1.6037379999999999e-07
+ 40.737499999999997p 2.0299949999999999e-07 40.75p 2.4527799999999998e-07 40.762499999999996p 2.8715490000000001e-07 40.775000000000006p 3.285765e-07 40.787500000000001p 3.6948959999999999e-07 40.799999999999997p 4.0984179999999999e-07 40.8125p 4.4958129999999998e-07 40.824999999999996p 4.8865740000000003e-07 40.837500000000006p 5.2702009999999996e-07 40.850000000000001p 5.6462030000000001e-07 40.862499999999997p 6.0141020000000002e-07 40.875p 6.373429e-07 40.887499999999996p 6.7237269999999998e-07 40.900000000000006p 7.0645520000000005e-07 40.912500000000001p 7.3954710000000004e-07 40.924999999999997p 7.7160650000000002e-07 40.9375p 8.0259310000000001e-07 40.949999999999996p 8.3246779999999995e-07
+ 40.962499999999999p 8.6119309999999997e-07 40.975000000000001p 8.8873289999999998e-07 40.987500000000004p 9.1505309999999995e-07 41p 9.4012070000000003e-07 41.012499999999996p 9.6390489999999998e-07 41.024999999999999p 9.8637629999999999e-07 41.037500000000001p 1.0075070000000001e-06 41.050000000000004p 1.027272e-06 41.0625p 1.045648e-06 41.074999999999996p 1.0626110000000001e-06 41.087499999999999p 1.078143e-06 41.100000000000001p 1.0922239999999999e-06 41.112500000000004p 1.104839e-06 41.125p 1.1159739999999999e-06 41.137499999999996p 1.1256160000000001e-06 41.149999999999999p 1.1337559999999999e-06 41.162500000000001p 1.1403849999999999e-06 41.175000000000004p 1.145497e-06
+ 41.1875p 1.149087e-06 41.199999999999996p 1.1511549999999999e-06 41.212499999999999p 1.1516999999999999e-06 41.225000000000001p 1.1507249999999999e-06 41.237500000000004p 1.1482319999999999e-06 41.25p 1.14423e-06 41.262499999999996p 1.1387250000000001e-06 41.274999999999999p 1.131728e-06 41.287500000000001p 1.1232520000000001e-06 41.300000000000004p 1.1133110000000001e-06 41.3125p 1.1019199999999999e-06 41.324999999999996p 1.0890990000000001e-06 41.337499999999999p 1.074866e-06 41.350000000000001p 1.0592449999999999e-06 41.362500000000004p 1.0422580000000001e-06 41.375p 1.0239320000000001e-06 41.387500000000003p 1.0042930000000001e-06 41.399999999999999p 9.8337179999999996e-07
+ 41.412500000000001p 9.6119769999999992e-07 41.425000000000004p 9.3780350000000004e-07 41.4375p 9.1322319999999998e-07 41.450000000000003p 8.8749240000000004e-07 41.462499999999999p 8.6064809999999996e-07 41.474999999999994p 8.3272859999999997e-07 41.487500000000004p 8.0377370000000003e-07 41.5p 7.7382459999999999e-07 41.512500000000003p 7.4292370000000001e-07 41.524999999999999p 7.1111439999999999e-07 41.537499999999994p 6.7844150000000002e-07 41.550000000000004p 6.4495069999999996e-07 41.5625p 6.1068879999999996e-07 41.575000000000003p 5.7570329999999995e-07 41.587499999999999p 5.4004279999999995e-07 41.599999999999994p 5.0375659999999995e-07 41.612500000000004p 4.6689459999999998e-07 41.625p 4.2950760000000002e-07
+ 41.637500000000003p 3.9164669999999998e-07 41.649999999999999p 3.5336370000000001e-07 41.662499999999994p 3.147106e-07 41.675000000000004p 2.7574000000000001e-07 41.6875p 2.365045e-07 41.700000000000003p 1.970572e-07 41.712499999999999p 1.5745109999999999e-07 41.724999999999994p 1.177393e-07 41.737499999999997p 7.7974849999999994e-08 41.75p 3.8210790000000003e-08 41.762500000000003p -1.5000690000000001e-09 41.774999999999999p -4.1105169999999998e-08 41.787500000000001p -8.0552270000000006e-08 41.799999999999997p -1.197895e-07 41.8125p -1.587654e-07 41.825000000000003p -1.974292e-07 41.837499999999999p -2.3573060000000001e-07 41.850000000000001p -2.736198e-07
+ 41.862499999999997p -3.1104810000000001e-07 41.875p -3.479674e-07 41.887500000000003p -3.8433019999999999e-07 41.899999999999999p -4.2009040000000002e-07 41.912500000000001p -4.5520260000000001e-07 41.924999999999997p -4.8962230000000004e-07 41.9375p -5.2330639999999996e-07 41.950000000000003p -5.5621260000000004e-07 41.962499999999999p -5.8830009999999999e-07 41.975000000000001p -6.1952909999999995e-07 41.987499999999997p -6.4986119999999998e-07 42p -6.7925929999999996e-07 42.012500000000003p -7.0768760000000004e-07 42.024999999999999p -7.3511190000000003e-07 42.037500000000001p -7.6149930000000004e-07 42.049999999999997p -7.8681830000000003e-07 42.0625p -8.1103899999999996e-07 42.075000000000003p -8.3413329999999997e-07
+ 42.087499999999999p -8.5607419999999995e-07 42.100000000000001p -8.7683669999999995e-07 42.112499999999997p -8.9639720000000001e-07 42.125p -9.1473380000000001e-07 42.137500000000003p -9.3182639999999996e-07 42.149999999999999p -9.4765650000000001e-07 42.162500000000001p -9.622071e-07 42.174999999999997p -9.7546319999999994e-07 42.1875p -9.8741150000000007e-07 42.200000000000003p -9.9804019999999994e-07 42.212499999999999p -1.0073390000000001e-06 42.225000000000001p -1.0153010000000001e-06 42.237499999999997p -1.021919e-06 42.25p -1.0271869999999999e-06 42.262500000000003p -1.0311050000000001e-06 42.274999999999999p -1.0336689999999999e-06 42.287500000000001p -1.0348809999999999e-06 42.299999999999997p -1.0347419999999999e-06
+ 42.3125p -1.033257e-06 42.325000000000003p -1.0304319999999999e-06 42.337499999999999p -1.0262739999999999e-06 42.350000000000001p -1.020791e-06 42.362499999999997p -1.013994e-06 42.375p -1.0058960000000001e-06 42.387500000000003p -9.965103e-07 42.399999999999999p -9.8585229999999993e-07 42.412500000000001p -9.7393920000000001e-07 42.424999999999997p -9.6078940000000006e-07 42.4375p -9.4642299999999995e-07 42.450000000000003p -9.3086140000000001e-07 42.462499999999999p -9.1412760000000002e-07 42.475000000000001p -8.9624590000000005e-07 42.487499999999997p -8.7724209999999998e-07 42.5p -8.5714320000000003e-07 42.512499999999996p -8.3597770000000002e-07 42.525000000000006p -8.1377510000000004e-07
+ 42.537500000000001p -7.9056639999999998e-07 42.549999999999997p -7.6638359999999999e-07 42.5625p -7.4125990000000002e-07 42.574999999999996p -7.1522980000000005e-07 42.587500000000006p -6.8832840000000004e-07 42.600000000000001p -6.6059240000000004e-07 42.612499999999997p -6.3205910000000003e-07 42.625p -6.0276669999999998e-07 42.637499999999996p -5.727546e-07 42.650000000000006p -5.4206269999999997e-07 42.662500000000001p -5.1073179999999999e-07 42.674999999999997p -4.7880360000000001e-07 42.6875p -4.4632030000000002e-07 42.699999999999996p -4.133247e-07 42.712500000000006p -3.7986029999999999e-07 42.725000000000001p -3.4597119999999998e-07 42.737499999999997p -3.117016e-07 42.75p -2.7709670000000001e-07
+ 42.762499999999996p -2.4220150000000003e-07 42.775000000000006p -2.0706160000000001e-07 42.787500000000001p -1.7172289999999999e-07 42.799999999999997p -1.3623139999999999e-07 42.8125p -1.006331e-07 42.824999999999996p -6.4974459999999998e-08 42.837499999999999p -2.9301579999999998e-08 42.850000000000001p 6.339276e-09 42.862500000000004p 4.1901960000000001e-08 42.875p 7.7340470000000001e-08 42.887499999999996p 1.12609e-07 42.899999999999999p 1.4766210000000001e-07 42.912500000000001p 1.8245449999999999e-07 42.925000000000004p 2.1694140000000001e-07 42.9375p 2.5107830000000002e-07 42.949999999999996p 2.8482139999999998e-07 42.962499999999999p 3.181274e-07 42.975000000000001p 3.509534e-07
+ 42.987500000000004p 3.832574e-07 43p 4.149979e-07 43.012499999999996p 4.461345e-07 43.024999999999999p 4.7662720000000001e-07 43.037500000000001p 5.0643719999999998e-07 43.050000000000004p 5.3552640000000005e-07 43.0625p 5.6385789999999997e-07 43.074999999999996p 5.9139570000000003e-07 43.087499999999999p 6.181048e-07 43.100000000000001p 6.4395139999999999e-07 43.112500000000004p 6.689029e-07 43.125p 6.9292789999999995e-07 43.137499999999996p 7.1599619999999999e-07 43.149999999999999p 7.3807889999999998e-07 43.162500000000001p 7.5914839999999998e-07 43.175000000000004p 7.7917850000000003e-07 43.1875p 7.9814449999999999e-07 43.199999999999996p 8.16023e-07
+ 43.212499999999999p 8.3279219999999997e-07 43.225000000000001p 8.4843159999999996e-07 43.237500000000004p 8.6292239999999997e-07 43.25p 8.7624730000000003e-07 43.262500000000003p 8.8839049999999999e-07 43.274999999999999p 8.99338e-07 43.287499999999994p 9.0907709999999995e-07 43.300000000000004p 9.1759709999999997e-07 43.3125p 9.2488870000000001e-07 43.325000000000003p 9.3094430000000003e-07 43.337499999999999p 9.3575800000000001e-07 43.349999999999994p 9.3932550000000002e-07 43.362500000000004p 9.4164429999999999e-07 43.375p 9.4271359999999999e-07 43.387500000000003p 9.4253410000000001e-07 43.399999999999999p 9.4110830000000002e-07 43.412499999999994p 9.384404e-07 43.425000000000004p 9.3453620000000004e-07
+ 43.4375p 9.2940329999999995e-07 43.450000000000003p 9.230507e-07 43.462499999999999p 9.1548919999999996e-07 43.474999999999994p 9.0673129999999997e-07 43.487500000000004p 8.9679089999999995e-07 43.5p 8.8568359999999996e-07 43.512500000000003p 8.7342649999999996e-07 43.524999999999999p 8.600382e-07 43.537499999999994p 8.4553889999999997e-07 43.550000000000004p 8.2995019999999997e-07 43.5625p 8.1329510000000002e-07 43.575000000000003p 7.95598e-07 43.587499999999999p 7.7688479999999995e-07 43.599999999999994p 7.5718260000000002e-07 43.612499999999997p 7.365198e-07 43.625p 7.1492610000000005e-07 43.637500000000003p 6.9243229999999999e-07 43.649999999999999p 6.6907050000000001e-07
+ 43.662500000000001p 6.4487369999999995e-07 43.674999999999997p 6.1987620000000005e-07 43.6875p 5.9411299999999999e-07 43.700000000000003p 5.6762050000000001e-07 43.712499999999999p 5.4043549999999997e-07 43.725000000000001p 5.1259610000000001e-07 43.737499999999997p 4.8414089999999998e-07 43.75p 4.5510930000000001e-07 43.762500000000003p 4.2554150000000003e-07 43.774999999999999p 3.9547809999999998e-07 43.787500000000001p 3.6496060000000001e-07 43.799999999999997p 3.3403069999999998e-07 43.8125p 3.0273070000000001e-07 43.825000000000003p 2.7110329999999999e-07 43.837499999999999p 2.3919130000000002e-07 43.850000000000001p 2.070381e-07 43.862499999999997p 1.7468719999999999e-07 43.875p 1.42182e-07
+ 43.887500000000003p 1.0956630000000001e-07 43.899999999999999p 7.6883880000000004e-08 43.912500000000001p 4.4178279999999997e-08 43.924999999999997p 1.1493109999999999e-08 43.9375p -2.11282e-08 43.950000000000003p -5.3642470000000002e-08 43.962499999999999p -8.6006780000000006e-08 43.975000000000001p -1.181785e-07 43.987499999999997p -1.5011550000000001e-07 44p -1.81776e-07 44.012500000000003p -2.1311869999999999e-07 44.024999999999999p -2.44103e-07 44.037500000000001p -2.7468880000000002e-07 44.049999999999997p -3.0483660000000002e-07 44.0625p -3.3450770000000002e-07 44.075000000000003p -3.636642e-07 44.087499999999999p -3.9226899999999998e-07 44.100000000000001p -4.2028580000000002e-07
+ 44.112499999999997p -4.4767920000000001e-07 44.125p -4.7441469999999997e-07 44.137500000000003p -5.0045900000000005e-07 44.149999999999999p -5.2577969999999996e-07 44.162500000000001p -5.5034530000000005e-07 44.174999999999997p -5.7412580000000003e-07 44.1875p -5.9709190000000002e-07 44.200000000000003p -6.1921570000000003e-07 44.212499999999999p -6.4047060000000002e-07 44.225000000000001p -6.6083110000000004e-07 44.237499999999997p -6.8027290000000003e-07 44.25p -6.9877319999999996e-07 44.262500000000003p -7.1631030000000002e-07 44.274999999999999p -7.3286399999999996e-07 44.287500000000001p -7.4841530000000002e-07 44.299999999999997p -7.6294679999999997e-07 44.3125p -7.7644219999999997e-07 44.325000000000003p -7.888869e-07
+ 44.337499999999999p -8.0026750000000004e-07 44.350000000000001p -8.1057210000000003e-07 44.362499999999997p -8.1979030000000004e-07 44.375p -8.2791310000000003e-07 44.387499999999996p -8.3493289999999996e-07 44.400000000000006p -8.4084349999999999e-07 44.412500000000001p -8.4564040000000002e-07 44.424999999999997p -8.4932039999999995e-07 44.4375p -8.5188169999999995e-07 44.449999999999996p -8.5332399999999997e-07 44.462500000000006p -8.5364850000000004e-07 44.475000000000001p -8.5285759999999995e-07 44.487499999999997p -8.5095550000000003e-07 44.5p -8.479475e-07 44.512499999999996p -8.4384050000000003e-07 44.525000000000006p -8.3864259999999995e-07 44.537500000000001p -8.3236339999999997e-07 44.549999999999997p -8.2501380000000002e-07
+ 44.5625p -8.1660610000000005e-07 44.574999999999996p -8.0715379999999999e-07 44.587500000000006p -7.9667180000000002e-07 44.600000000000001p -7.8517630000000002e-07 44.612499999999997p -7.7268459999999997e-07 44.625p -7.5921520000000005e-07 44.637499999999996p -7.4478800000000004e-07 44.650000000000006p -7.2942399999999998e-07 44.662500000000001p -7.1314510000000002e-07 44.674999999999997p -6.9597470000000001e-07 44.6875p -6.7793690000000003e-07 44.699999999999996p -6.5905700000000005e-07 44.712499999999999p -6.3936140000000003e-07 44.725000000000001p -6.1887730000000005e-07 44.737500000000004p -5.9763290000000002e-07 44.75p -5.756574e-07 44.762499999999996p -5.5298070000000002e-07 44.774999999999999p -5.2963359999999999e-07
+ 44.787500000000001p -5.056477e-07 44.800000000000004p -4.8105529999999999e-07 44.8125p -4.5588929999999999e-07 44.824999999999996p -4.3018359999999999e-07 44.837499999999999p -4.0397240000000001e-07 44.850000000000001p -3.7729050000000003e-07 44.862500000000004p -3.5017350000000001e-07 44.875p -3.2265699999999998e-07 44.887499999999996p -2.9477760000000003e-07 44.899999999999999p -2.6657189999999999e-07 44.912500000000001p -2.38077e-07 44.925000000000004p -2.0933030000000001e-07 44.9375p -1.8036950000000001e-07 44.949999999999996p -1.5123229999999999e-07 44.962499999999999p -1.2195689999999999e-07 44.975000000000001p -9.2581380000000002e-08 44.987500000000004p -6.3143929999999997e-08 45p -3.36828e-08
+ 45.012499999999996p -4.2362129999999999e-09 45.024999999999999p 2.51577e-08 45.037500000000001p 5.4460920000000001e-08 45.050000000000004p 8.3635579999999994e-08 45.0625p 1.126441e-07 45.074999999999996p 1.4144900000000001e-07 45.087499999999999p 1.700133e-07 45.100000000000001p 1.983003e-07 45.112500000000004p 2.2627360000000001e-07 45.125p 2.538975e-07 45.137500000000003p 2.811365e-07 45.149999999999999p 3.0795590000000002e-07 45.162499999999994p 3.343213e-07 45.175000000000004p 3.6019920000000002e-07 45.1875p 3.8555670000000001e-07 45.200000000000003p 4.1036160000000001e-07 45.212499999999999p 4.345823e-07 45.224999999999994p 4.5818819999999998e-07
+ 45.237500000000004p 4.8114950000000003e-07 45.25p 5.0343719999999997e-07 45.262500000000003p 5.2502329999999998e-07 45.274999999999999p 5.4588059999999997e-07 45.287499999999994p 5.6598309999999996e-07 45.300000000000004p 5.8530569999999996e-07 45.3125p 6.038243e-07 45.325000000000003p 6.2151600000000002e-07 45.337499999999999p 6.3835889999999999e-07 45.349999999999994p 6.5433229999999999e-07 45.362500000000004p 6.6941670000000002e-07 45.375p 6.8359379999999996e-07 45.387500000000003p 6.9684640000000001e-07 45.399999999999999p 7.0915859999999998e-07 45.412499999999994p 7.205159e-07 45.425000000000004p 7.3090489999999995e-07 45.4375p 7.4031360000000003e-07 45.450000000000003p 7.4873129999999996e-07
+ 45.462499999999999p 7.5614850000000002e-07 45.475000000000001p 7.6255719999999997e-07 45.487499999999997p 7.6795069999999999e-07 45.5p 7.7232359999999995e-07 45.512500000000003p 7.7567209999999995e-07 45.524999999999999p 7.7799339999999999e-07 45.537500000000001p 7.7928629999999996e-07 45.549999999999997p 7.7955100000000004e-07 45.5625p 7.7878890000000003e-07 45.575000000000003p 7.7700300000000001e-07 45.587499999999999p 7.7419749999999997e-07 45.600000000000001p 7.7037790000000005e-07 45.612499999999997p 7.6555109999999999e-07 45.625p 7.5972560000000001e-07 45.637500000000003p 7.5291069999999998e-07 45.649999999999999p 7.4511759999999997e-07 45.662500000000001p 7.3635820000000005e-07 45.674999999999997p 7.266461e-07
+ 45.6875p 7.1599610000000005e-07 45.700000000000003p 7.0442400000000001e-07 45.712499999999999p 6.9194700000000002e-07 45.725000000000001p 6.7858339999999998e-07 45.737499999999997p 6.6435269999999999e-07 45.75p 6.4927559999999998e-07 45.762500000000003p 6.3337379999999998e-07 45.774999999999999p 6.1666990000000004e-07 45.787500000000001p 5.9918780000000002e-07 45.799999999999997p 5.8095240000000005e-07 45.8125p 5.6198939999999996e-07 45.825000000000003p 5.4232529999999996e-07 45.837499999999999p 5.2198800000000003e-07 45.850000000000001p 5.0100560000000004e-07 45.862499999999997p 4.7940750000000001e-07 45.875p 4.572236e-07 45.887500000000003p 4.3448460000000002e-07 45.899999999999999p 4.1122190000000001e-07
+ 45.912500000000001p 3.8746740000000001e-07 45.924999999999997p 3.6325379999999999e-07 45.9375p 3.3861430000000002e-07 45.950000000000003p 3.1358230000000001e-07 45.962499999999999p 2.881919e-07 45.975000000000001p 2.6247770000000003e-07 45.987499999999997p 2.364744e-07 46p 2.102171e-07 46.012500000000003p 1.8374119999999999e-07 46.024999999999999p 1.5708219999999999e-07 46.037500000000001p 1.302759e-07 46.049999999999997p 1.03358e-07 46.0625p 7.6364459999999996e-08 46.075000000000003p 4.9331119999999999e-08 46.087499999999999p 2.229381e-08 46.100000000000001p -4.7117339999999999e-09 46.112499999999997p -3.1649899999999997e-08 46.125p -5.8485289999999997e-08
+ 46.137500000000003p -8.5182730000000002e-08 46.149999999999999p -1.117073e-07 46.162500000000001p -1.3802450000000001e-07 46.174999999999997p -1.6410010000000001e-07 46.1875p -1.899003e-07 46.200000000000003p -2.1539179999999999e-07 46.212499999999999p -2.4054180000000003e-07 46.225000000000001p -2.6531809999999999e-07 46.237499999999997p -2.8968900000000002e-07 46.25p -3.1362350000000002e-07 46.262499999999996p -3.3709120000000002e-07 46.275000000000006p -3.6006239999999998e-07 46.287500000000001p -3.8250829999999998e-07 46.299999999999997p -4.0440069999999999e-07 46.3125p -4.257122e-07 46.324999999999996p -4.4641650000000001e-07 46.337500000000006p -4.664879e-07 46.350000000000001p -4.8590180000000005e-07
+ 46.362499999999997p -5.0463439999999996e-07 46.375p -5.2266289999999998e-07 46.387499999999996p -5.3996550000000002e-07 46.400000000000006p -5.5652159999999999e-07 46.412500000000001p -5.7231130000000002e-07 46.424999999999997p -5.8731599999999999e-07 46.4375p -6.0151820000000004e-07 46.449999999999996p -6.1490129999999998e-07 46.462500000000006p -6.2745000000000002e-07 46.475000000000001p -6.3914999999999995e-07 46.487499999999997p -6.4998839999999998e-07 46.5p -6.5995310000000005e-07 46.512499999999996p -6.6903350000000005e-07 46.525000000000006p -6.7721999999999997e-07 46.537500000000001p -6.8450410000000002e-07 46.549999999999997p -6.9087879999999999e-07 46.5625p -6.9633810000000004e-07 46.574999999999996p -7.0087709999999998e-07
+ 46.587499999999999p -7.0449230000000001e-07 46.600000000000001p -7.0718130000000001e-07 46.612500000000004p -7.0894300000000002e-07 46.625p -7.0977740000000004e-07 46.637499999999996p -7.0968580000000001e-07 46.649999999999999p -7.0867050000000002e-07 46.662500000000001p -7.067351e-07 46.675000000000004p -7.0388450000000005e-07 46.6875p -7.0012450000000002e-07 46.699999999999996p -6.9546229999999999e-07 46.712499999999999p -6.8990609999999995e-07 46.725000000000001p -6.8346530000000002e-07 46.737500000000004p -6.7615019999999996e-07 46.75p -6.6797260000000003e-07 46.762499999999996p -6.5894500000000003e-07 46.774999999999999p -6.4908110000000001e-07 46.787500000000001p -6.3839560000000003e-07 46.800000000000004p -6.2690439999999996e-07
+ 46.8125p -6.1462409999999998e-07 46.824999999999996p -6.0157240000000003e-07 46.837499999999999p -5.8776799999999997e-07 46.850000000000001p -5.7323049999999997e-07 46.862500000000004p -5.579803e-07 46.875p -5.4203879999999999e-07 46.887499999999996p -5.2542800000000001e-07 46.899999999999999p -5.0817110000000005e-07 46.912500000000001p -4.9029169999999995e-07 46.925000000000004p -4.7181430000000002e-07 46.9375p -4.5276409999999998e-07 46.949999999999996p -4.3316699999999998e-07 46.962499999999999p -4.130495e-07 46.975000000000001p -3.9243869999999998e-07 46.987500000000004p -3.7136239999999998e-07 47p -3.4984880000000001e-07 47.012500000000003p -3.2792669999999999e-07 47.024999999999999p -3.0562520000000002e-07
+ 47.037499999999994p -2.829741e-07 47.050000000000004p -2.600034e-07 47.0625p -2.3674340000000001e-07 47.075000000000003p -2.1322500000000001e-07 47.087499999999999p -1.89479e-07 47.099999999999994p -1.655368e-07 47.112500000000004p -1.4142969999999999e-07 47.125p -1.1718929999999999e-07 47.137500000000003p -9.284738e-08 47.149999999999999p -6.8435660000000002e-08 47.162499999999994p -4.3985969999999998e-08 47.175000000000004p -1.9530119999999999e-08 47.1875p 4.9001150000000003e-09 47.200000000000003p 2.9273059999999999e-08 47.212499999999999p 5.3557139999999999e-08 47.224999999999994p 7.7720969999999995e-08 47.237500000000004p 1.017333e-07 47.25p 1.255633e-07
+ 47.262500000000003p 1.4918029999999999e-07 47.274999999999999p 1.7255379999999999e-07 47.287499999999994p 1.9565389999999999e-07 47.300000000000004p 2.1845109999999999e-07 47.3125p 2.409161e-07 47.325000000000003p 2.630204e-07 47.337499999999999p 2.8473580000000001e-07 47.350000000000001p 3.0603460000000001e-07 47.362499999999997p 3.268898e-07 47.375p 3.4727509999999998e-07 47.387500000000003p 3.6716460000000002e-07 47.399999999999999p 3.8653330000000001e-07 47.412500000000001p 4.053569e-07 47.424999999999997p 4.2361169999999999e-07 47.4375p 4.4127500000000001e-07 47.450000000000003p 4.583246e-07 47.462499999999999p 4.7473950000000001e-07 47.475000000000001p 4.9049940000000005e-07
+ 47.487499999999997p 5.0558469999999995e-07 47.5p 5.19977e-07 47.512500000000003p 5.3365869999999997e-07 47.524999999999999p 5.4661329999999995e-07 47.537500000000001p 5.5882510000000005e-07 47.549999999999997p 5.7027939999999999e-07 47.5625p 5.8096279999999997e-07 47.575000000000003p 5.9086259999999999e-07 47.587499999999999p 5.9996730000000004e-07 47.600000000000001p 6.0826660000000003e-07 47.612499999999997p 6.1575100000000002e-07 47.625p 6.224123e-07 47.637500000000003p 6.2824330000000003e-07 47.649999999999999p 6.3323809999999996e-07 47.662500000000001p 6.3739169999999999e-07 47.674999999999997p 6.4070020000000005e-07 47.6875p 6.4316100000000002e-07 47.700000000000003p 6.4477270000000002e-07
+ 47.712499999999999p 6.4553469999999999e-07 47.725000000000001p 6.4544779999999996e-07 47.737499999999997p 6.4451389999999995e-07 47.75p 6.4273579999999996e-07 47.762500000000003p 6.401178e-07 47.774999999999999p 6.3666499999999996e-07 47.787500000000001p 6.3238370000000003e-07 47.799999999999997p 6.2728130000000005e-07 47.8125p 6.2136630000000004e-07 47.825000000000003p 6.146481e-07 47.837499999999999p 6.071376e-07 47.850000000000001p 5.9884610000000003e-07 47.862499999999997p 5.8978639999999995e-07 47.875p 5.7997220000000001e-07 47.887500000000003p 5.6941799999999997e-07 47.899999999999999p 5.5813939999999999e-07 47.912500000000001p 5.4615300000000003e-07 47.924999999999997p 5.3347609999999997e-07
+ 47.9375p 5.2012719999999999e-07 47.950000000000003p 5.0612520000000005e-07 47.962499999999999p 4.9149030000000005e-07 47.975000000000001p 4.762432e-07 47.987499999999997p 4.6040550000000001e-07 48p 4.4399949999999999e-07 48.012500000000003p 4.2704819999999998e-07 48.024999999999999p 4.0957529999999999e-07 48.037500000000001p 3.9160500000000002e-07 48.049999999999997p 3.7316240000000001e-07 48.0625p 3.542728e-07 48.075000000000003p 3.3496249999999999e-07 48.087499999999999p 3.1525779999999999e-07 48.100000000000001p 2.951857e-07 48.112499999999997p 2.7477369999999999e-07 48.125p 2.5404950000000001e-07 48.137499999999996p 2.3304130000000001e-07 48.150000000000006p 2.1177760000000001e-07
+ 48.162500000000001p 1.902869e-07 48.174999999999997p 1.6859829999999999e-07 48.1875p 1.4674079999999999e-07 48.199999999999996p 1.2474369999999999e-07 48.212500000000006p 1.0263649999999999e-07 48.225000000000001p 8.0448379999999996e-08 48.237499999999997p 5.8208949999999999e-08 48.25p 3.5947620000000003e-08 48.262499999999996p 1.3693779999999999e-08 48.275000000000006p -8.5232780000000006e-09 48.287500000000001p -3.0674400000000002e-08 48.299999999999997p -5.2730580000000003e-08 48.3125p -7.4663060000000004e-08 48.324999999999996p -9.6443290000000005e-08 48.337500000000006p -1.1804299999999999e-07 48.350000000000001p -1.3943430000000001e-07 48.362499999999997p -1.6058970000000001e-07 48.375p -1.8148189999999999e-07
+ 48.387499999999996p -2.0208409999999999e-07 48.400000000000006p -2.2237020000000001e-07 48.412500000000001p -2.4231429999999998e-07 48.424999999999997p -2.6189109999999999e-07 48.4375p -2.8107600000000002e-07 48.449999999999996p -2.998449e-07 48.462499999999999p -3.1817419999999999e-07 48.475000000000001p -3.360411e-07 48.487500000000004p -3.5342349999999999e-07 48.5p -3.7029979999999999e-07 48.512499999999996p -3.8664939999999998e-07 48.524999999999999p -4.0245229999999999e-07 48.537500000000001p -4.1768929999999998e-07 48.550000000000004p -4.3234189999999998e-07 48.5625p -4.4639249999999998e-07 48.574999999999996p -4.5982450000000002e-07 48.587499999999999p -4.7262200000000001e-07 48.600000000000001p -4.8476980000000003e-07
+ 48.612500000000004p -4.9625400000000002e-07 48.625p -5.0706119999999995e-07 48.637499999999996p -5.1717920000000004e-07 48.649999999999999p -5.2659660000000002e-07 48.662500000000001p -5.3530299999999996e-07 48.675000000000004p -5.4328890000000002e-07 48.6875p -5.5054590000000002e-07 48.699999999999996p -5.5706629999999997e-07 48.712499999999999p -5.6284360000000001e-07 48.725000000000001p -5.6787229999999999e-07 48.737500000000004p -5.7214770000000002e-07 48.75p -5.7566629999999999e-07 48.762499999999996p -5.7842530000000002e-07 48.774999999999999p -5.8042319999999997e-07 48.787500000000001p -5.8165930000000004e-07 48.800000000000004p -5.8213399999999999e-07 48.8125p -5.8184850000000005e-07 48.824999999999996p -5.8080509999999998e-07
+ 48.837499999999999p -5.7900710000000001e-07 48.850000000000001p -5.7645879999999995e-07 48.862500000000004p -5.7316520000000005e-07 48.875p -5.6913259999999997e-07 48.887500000000003p -5.6436780000000003e-07 48.899999999999999p -5.5887900000000001e-07 48.912499999999994p -5.5267490000000003e-07 48.925000000000004p -5.4576539999999999e-07 48.9375p -5.3816110000000002e-07 48.950000000000003p -5.2987350000000001e-07 48.962499999999999p -5.2091499999999995e-07 48.974999999999994p -5.1129870000000003e-07 48.987500000000004p -5.0103879999999998e-07 49p -4.9014979999999999e-07 49.012500000000003p -4.786475e-07 49.024999999999999p -4.6654819999999999e-07 49.037499999999994p -4.5386880000000001e-07 49.050000000000004p -4.406272e-07
+ 49.0625p -4.268417e-07 49.075000000000003p -4.1253149999999999e-07 49.087499999999999p -3.9771620000000002e-07 49.099999999999994p -3.8241619999999999e-07 49.112500000000004p -3.6665239999999999e-07 49.125p -3.504462e-07 49.137500000000003p -3.3381969999999998e-07 49.149999999999999p -3.1679519999999998e-07 49.162499999999994p -2.9939570000000001e-07 49.175000000000004p -2.8164459999999998e-07 49.1875p -2.6356569999999999e-07 49.200000000000003p -2.4518319999999999e-07 49.212499999999999p -2.2652139999999999e-07 49.225000000000001p -2.0760529999999999e-07 49.237499999999997p -1.8845989999999999e-07 49.25p -1.6911059999999999e-07 49.262500000000003p -1.49583e-07 49.274999999999999p -1.2990280000000001e-07
+ 49.287500000000001p -1.100958e-07 49.299999999999997p -9.0188190000000001e-08 49.3125p -7.0205990000000004e-08 49.325000000000003p -5.017538e-08 49.337499999999999p -3.0122539999999997e-08 49.350000000000001p -1.0073619999999999e-08 49.362499999999997p 9.9452540000000006e-09 49.375p 2.9908050000000002e-08 49.387500000000003p 4.9788839999999999e-08 49.399999999999999p 6.9561849999999996e-08 49.412500000000001p 8.9201489999999997e-08 49.424999999999997p 1.086824e-07 49.4375p 1.2797940000000001e-07 49.450000000000003p 1.470677e-07 49.462499999999999p 1.659226e-07 49.475000000000001p 1.8452010000000001e-07 49.487499999999997p 2.0283630000000001e-07 49.5p 2.208476e-07
+ 49.512500000000003p 2.3853130000000001e-07 49.524999999999999p 2.5586459999999997e-07 49.537500000000001p 2.7282560000000002e-07 49.549999999999997p 2.8939280000000002e-07 49.5625p 3.0554519999999999e-07 49.575000000000003p 3.2126229999999998e-07 49.587499999999999p 3.3652440000000002e-07 49.600000000000001p 3.5131240000000001e-07 49.612499999999997p 3.6560770000000002e-07 49.625p 3.7939239999999998e-07 49.637500000000003p 3.926495e-07 49.649999999999999p 4.053624e-07 49.662500000000001p 4.1751570000000001e-07 49.674999999999997p 4.2909419999999998e-07 49.6875p 4.4008400000000001e-07 49.700000000000003p 4.5047160000000002e-07 49.712499999999999p 4.6024460000000001e-07 49.725000000000001p 4.693913e-07
+ 49.737499999999997p 4.7790079999999995e-07 49.75p 4.8576319999999999e-07 49.762500000000003p 4.929693e-07 49.774999999999999p 4.9951100000000003e-07 49.787500000000001p 5.0538099999999996e-07 49.799999999999997p 5.1057280000000004e-07 49.8125p 5.1508090000000001e-07 49.825000000000003p 5.1890079999999996e-07 49.837499999999999p 5.2202880000000001e-07 49.850000000000001p 5.2446209999999997e-07 49.862499999999997p 5.2619900000000001e-07 49.875p 5.2723850000000001e-07 49.887500000000003p 5.2758079999999995e-07 49.899999999999999p 5.2722669999999998e-07 49.912500000000001p 5.2617829999999999e-07 49.924999999999997p 5.2443839999999997e-07 49.9375p 5.220107e-07 49.950000000000003p 5.1889980000000004e-07
+ 49.962499999999999p 5.1511140000000001e-07 49.975000000000001p 5.1065190000000005e-07 49.987499999999997p 5.055287e-07 50p 4.9974979999999997e-07 50.012499999999996p 4.9332459999999998e-07 50.025000000000006p 4.8626279999999995e-07 50.037500000000001p 4.7857509999999995e-07 50.049999999999997p 4.7027329999999999e-07 50.0625p 4.6136959999999999e-07 50.074999999999996p 4.518772e-07 50.087500000000006p 4.4180990000000002e-07 50.100000000000001p 4.3118249999999999e-07 50.112499999999997p 4.2001029999999999e-07 50.125p 4.0830929999999998e-07 50.137499999999996p 3.9609619999999999e-07 50.150000000000006p 3.8338850000000001e-07 50.162500000000001p 3.7020420000000001e-07 50.174999999999997p 3.5656169999999998e-07
+ 50.1875p 3.424804e-07 50.199999999999996p 3.2797980000000002e-07 50.212500000000006p 3.1308019999999998e-07 50.225000000000001p 2.978024e-07 50.237499999999997p 2.8216739999999998e-07 50.25p 2.6619690000000002e-07 50.262499999999996p 2.4991279999999999e-07 50.275000000000006p 2.3333750000000001e-07 50.287500000000001p 2.1649360000000001e-07 50.299999999999997p 1.9940419999999999e-07 50.3125p 1.820925e-07 50.324999999999996p 1.6458200000000001e-07 50.337499999999999p 1.468963e-07 50.350000000000001p 1.2905940000000001e-07 50.362500000000004p 1.110952e-07 50.375p 9.3027799999999993e-08 50.387499999999996p 7.4881449999999998e-08 50.399999999999999p 5.6680350000000001e-08
+ 50.412500000000001p 3.8448710000000003e-08 50.425000000000004p 2.0210750000000001e-08 50.4375p 1.990593e-09 50.449999999999996p -1.6187699999999999e-08 50.462499999999999p -3.4300189999999997e-08 50.475000000000001p -5.2323120000000003e-08 50.487500000000004p -7.0232890000000002e-08 50.5p -8.8006140000000006e-08 50.512499999999996p -1.056197e-07 50.524999999999999p -1.230508e-07 50.537500000000001p -1.4027689999999999e-07 50.550000000000004p -1.5727570000000001e-07 50.5625p -1.7402550000000001e-07 50.574999999999996p -1.9050480000000001e-07 50.587499999999999p -2.066925e-07 50.600000000000001p -2.225682e-07 50.612500000000004p -2.3811170000000001e-07 50.625p -2.5330329999999998e-07
+ 50.637499999999996p -2.6812409999999999e-07 50.649999999999999p -2.8255549999999999e-07 50.662500000000001p -2.965796e-07 50.675000000000004p -3.1017879999999998e-07 50.6875p -3.2333659999999998e-07 50.699999999999996p -3.3603680000000002e-07 50.712499999999999p -3.4826379999999999e-07 50.725000000000001p -3.6000300000000002e-07 50.737500000000004p -3.7123999999999998e-07 50.75p -3.8196159999999999e-07 50.762500000000003p -3.9215500000000001e-07 50.774999999999999p -4.018082e-07 50.787499999999994p -4.1091000000000002e-07 50.800000000000004p -4.1944990000000002e-07 50.8125p -4.2741819999999998e-07 50.825000000000003p -4.3480590000000002e-07 50.837499999999999p -4.4160490000000002e-07 50.849999999999994p -4.478078e-07
+ 50.862500000000004p -4.5340810000000002e-07 50.875p -4.5839989999999998e-07 50.887500000000003p -4.6277839999999999e-07 50.899999999999999p -4.665393e-07 50.912499999999994p -4.696794e-07 50.925000000000004p -4.7219609999999999e-07 50.9375p -4.740877e-07 50.950000000000003p -4.7535339999999998e-07 50.962499999999999p -4.7599309999999998e-07 50.974999999999994p -4.7600760000000001e-07 50.987500000000004p -4.7539830000000001e-07 51p -4.7416769999999999e-07 51.012500000000003p -4.7231880000000002e-07 51.024999999999999p -4.6985570000000002e-07 51.037499999999994p -4.6678310000000002e-07 51.050000000000004p -4.6310639999999999e-07 51.0625p -4.5883199999999999e-07 51.075000000000003p -4.5396680000000002e-07
+ 51.087499999999999p -4.485186e-07 51.100000000000001p -4.424959e-07 51.112499999999997p -4.3590799999999999e-07 51.125p -4.2876469999999999e-07 51.137500000000003p -4.2107660000000001e-07 51.149999999999999p -4.1285510000000002e-07 51.162500000000001p -4.0411209999999998e-07 51.174999999999997p -3.9486010000000002e-07 51.1875p -3.851125e-07 51.200000000000003p -3.7488290000000002e-07 51.212499999999999p -3.6418579999999999e-07 51.225000000000001p -3.5303609999999998e-07 51.237499999999997p -3.4144950000000002e-07 51.25p -3.2944189999999997e-07 51.262500000000003p -3.1702989999999998e-07 51.274999999999999p -3.0423049999999998e-07 51.287500000000001p -2.9106120000000003e-07 51.299999999999997p -2.7753999999999998e-07
+ 51.3125p -2.6368510000000001e-07 51.325000000000003p -2.4951540000000002e-07 51.337499999999999p -2.3504990000000001e-07 51.350000000000001p -2.203082e-07 51.362499999999997p -2.0530979999999999e-07 51.375p -1.9007500000000001e-07 51.387500000000003p -1.7462399999999999e-07 51.399999999999999p -1.5897730000000001e-07 51.412500000000001p -1.431558e-07 51.424999999999997p -1.271804e-07 51.4375p -1.110722e-07 51.450000000000003p -9.4852440000000003e-08 51.462499999999999p -7.8542479999999997e-08 51.475000000000001p -6.2163750000000006e-08 51.487499999999997p -4.5737719999999999e-08 51.5p -2.928589e-08 51.512500000000003p -1.2829769999999999e-08 51.524999999999999p 3.6091890000000001e-09
+ 51.537500000000001p 2.000958e-08 51.549999999999997p 3.635009e-08 51.5625p 5.2609499999999999e-08 51.575000000000003p 6.8766759999999999e-08 51.587499999999999p 8.480098e-08 51.600000000000001p 1.0069140000000001e-07 51.612499999999997p 1.164177e-07 51.625p 1.3195939999999999e-07 51.637500000000003p 1.472967e-07 51.649999999999999p 1.6241000000000001e-07 51.662500000000001p 1.7727970000000001e-07 51.674999999999997p 1.918871e-07 51.6875p 2.0621339999999999e-07 51.700000000000003p 2.2024039999999999e-07 51.712499999999999p 2.339503e-07 51.725000000000001p 2.4732579999999999e-07 51.737499999999997p 2.6034989999999998e-07 51.75p 2.7300630000000001e-07
+ 51.762500000000003p 2.852789e-07 51.774999999999999p 2.971525e-07 51.787500000000001p 3.086122e-07 51.799999999999997p 3.196437e-07 51.8125p 3.3023340000000001e-07 51.825000000000003p 3.4036810000000001e-07 51.837500000000006p 3.5003529999999997e-07 51.850000000000001p 3.5922330000000002e-07 51.862499999999997p 3.6792090000000001e-07 51.875p 3.7611749999999999e-07 51.887499999999996p 3.8380329999999999e-07 51.900000000000006p 3.9096909999999998e-07 51.912500000000001p 3.9760649999999998e-07 51.924999999999997p 4.0370769999999997e-07 51.9375p 4.0926559999999999e-07 51.949999999999996p 4.1427410000000001e-07 51.962500000000006p 4.1872739999999998e-07 51.975000000000001p 4.226208e-07
+ 51.987499999999997p 4.259503e-07 52p 4.287124e-07 52.012499999999996p 4.3090459999999998e-07 52.025000000000006p 4.3252509999999998e-07 52.037500000000001p 4.3357279999999998e-07 52.049999999999997p 4.3404749999999998e-07 52.0625p 4.3394970000000001e-07 52.074999999999996p 4.3328049999999999e-07 52.087500000000006p 4.3204190000000001e-07 52.100000000000001p 4.3023670000000001e-07 52.112499999999997p 4.278684e-07 52.125p 4.2494110000000001e-07 52.137499999999996p 4.2145990000000002e-07 52.150000000000006p 4.1743040000000002e-07 52.162500000000001p 4.1285910000000002e-07 52.174999999999997p 4.0775300000000001e-07 52.1875p 4.0211990000000001e-07 52.199999999999996p 3.9596839999999998e-07
+ 52.212499999999999p 3.8930760000000001e-07 52.225000000000001p 3.8214730000000002e-07 52.237500000000004p 3.7449810000000001e-07 52.25p 3.6637099999999999e-07 52.262499999999996p 3.5777769999999999e-07 52.274999999999999p 3.4873059999999998e-07 52.287500000000001p 3.3924249999999998e-07 52.300000000000004p 3.2932689999999998e-07 52.3125p 3.1899789999999999e-07 52.324999999999996p 3.082699e-07 52.337499999999999p 2.971579e-07 52.350000000000001p 2.8567739999999999e-07 52.362500000000004p 2.7384449999999999e-07 52.375p 2.6167549999999998e-07 52.387499999999996p 2.4918709999999999e-07 52.399999999999999p 2.3639669999999999e-07 52.412500000000001p 2.2332169999999999e-07 52.425000000000004p 2.0998e-07
+ 52.4375p 1.9638990000000001e-07 52.449999999999996p 1.8256990000000001e-07 52.462499999999999p 1.6853869999999999e-07 52.475000000000001p 1.5431529999999999e-07 52.487500000000004p 1.399189e-07 52.5p 1.2536910000000001e-07 52.512499999999996p 1.106852e-07 52.524999999999999p 9.5887019999999997e-08 52.537500000000001p 8.0994350000000003e-08 52.550000000000004p 6.6027049999999996e-08 52.5625p 5.1005059999999998e-08 52.574999999999996p 3.5948320000000001e-08 52.587499999999999p 2.0876780000000002e-08 52.600000000000001p 5.8103650000000001e-09 52.612500000000004p -9.2310630000000003e-09 52.625p -2.422772e-08 52.637500000000003p -3.9159940000000002e-08 52.649999999999999p -5.4008180000000001e-08
+ 52.662499999999994p -6.875306e-08 52.675000000000004p -8.3375390000000002e-08 52.6875p -9.7856190000000001e-08 52.700000000000003p -1.121767e-07 52.712499999999999p -1.2631849999999999e-07 52.724999999999994p -1.4026329999999999e-07 52.737500000000004p -1.5399320000000001e-07 52.75p -1.674907e-07 52.762500000000003p -1.8073859999999999e-07 52.774999999999999p -1.9372010000000001e-07 52.787499999999994p -2.064186e-07 52.800000000000004p -2.1881820000000001e-07 52.8125p -2.309032e-07 52.825000000000003p -2.4265859999999998e-07 52.837499999999999p -2.5406970000000002e-07 52.849999999999994p -2.6512240000000001e-07 52.862500000000004p -2.7580280000000001e-07 52.875p -2.8609809999999999e-07
+ 52.887500000000003p -2.9599539999999999e-07 52.899999999999999p -3.0548289999999999e-07 52.912499999999994p -3.1454899999999999e-07 52.925000000000004p -3.231829e-07 52.9375p -3.3137420000000002e-07 52.950000000000003p -3.3911329999999998e-07 52.962499999999999p -3.4639119999999998e-07 52.975000000000001p -3.5319940000000001e-07 52.987499999999997p -3.5953009999999998e-07 53p -3.6537609999999999e-07 53.012500000000003p -3.7073100000000001e-07 53.024999999999999p -3.7558890000000002e-07 53.037500000000001p -3.799447e-07 53.049999999999997p -3.8379379999999999e-07 53.0625p -3.8713240000000002e-07 53.075000000000003p -3.8995729999999998e-07 53.087499999999999p -3.9226609999999999e-07 53.100000000000001p -3.9405699999999999e-07
+ 53.112499999999997p -3.9532890000000001e-07 53.125p -3.960812e-07 53.137500000000003p -3.9631430000000001e-07 53.149999999999999p -3.9602900000000001e-07 53.162500000000001p -3.95227e-07 53.174999999999997p -3.9391039999999998e-07 53.1875p -3.9208219999999999e-07 53.200000000000003p -3.89746e-07 53.212499999999999p -3.8690590000000002e-07 53.225000000000001p -3.8356680000000003e-07 53.237499999999997p -3.7973430000000001e-07 53.25p -3.7541440000000002e-07 53.262500000000003p -3.7061390000000002e-07 53.274999999999999p -3.6534010000000001e-07 53.287500000000001p -3.5960099999999999e-07 53.299999999999997p -3.534051e-07 53.3125p -3.4676140000000001e-07 53.325000000000003p -3.3967970000000001e-07
+ 53.337499999999999p -3.3217019999999997e-07 53.350000000000001p -3.242434e-07 53.362499999999997p -3.1591080000000002e-07 53.375p -3.0718399999999998e-07 53.387500000000003p -2.9807529999999998e-07 53.399999999999999p -2.8859740000000002e-07 53.412500000000001p -2.787633e-07 53.424999999999997p -2.6858669999999999e-07 53.4375p -2.5808149999999998e-07 53.450000000000003p -2.4726219999999999e-07 53.462499999999999p -2.3614339999999999e-07 53.475000000000001p -2.2474029999999999e-07 53.487499999999997p -2.1306840000000001e-07 53.5p -2.0114329999999999e-07 53.512500000000003p -1.8898110000000001e-07 53.524999999999999p -1.7659819999999999e-07 53.537500000000001p -1.6401120000000001e-07 53.549999999999997p -1.5123680000000001e-07
+ 53.5625p -1.3829200000000001e-07 53.575000000000003p -1.2519409999999999e-07 53.587499999999999p -1.119604e-07 53.600000000000001p -9.86084e-08 53.612499999999997p -8.5155760000000001e-08 53.625p -7.1620180000000007e-08 53.637500000000003p -5.8019450000000003e-08 53.649999999999999p -4.4371409999999999e-08 53.662500000000001p -3.0693930000000001e-08 53.674999999999997p -1.700489e-08 53.6875p -3.3221219999999999e-09 53.700000000000003p 1.0336550000000001e-08 53.712500000000006p 2.3953380000000002e-08 53.725000000000001p 3.7510709999999998e-08 53.737499999999997p 5.0991000000000003e-08 53.75p 6.437683e-08 53.762499999999996p 7.7650940000000006e-08 53.775000000000006p 9.0796249999999995e-08
+ 53.787500000000001p 1.0379590000000001e-07 53.799999999999997p 1.166331e-07 53.8125p 1.292916e-07 53.824999999999996p 1.417552e-07 53.837500000000006p 1.5400789999999999e-07 53.850000000000001p 1.6603429999999999e-07 53.862499999999997p 1.7781900000000001e-07 53.875p 1.8934719999999999e-07 53.887499999999996p 2.0060429999999999e-07 53.900000000000006p 2.1157610000000001e-07 53.912500000000001p 2.222489e-07 53.924999999999997p 2.3260929999999999e-07 53.9375p 2.4264439999999998e-07 53.949999999999996p 2.5234180000000001e-07 53.962500000000006p 2.6168930000000001e-07 53.975000000000001p 2.7067550000000002e-07 53.987499999999997p 2.792894e-07 54p 2.8752039999999999e-07
+ 54.012499999999996p 2.9535849999999998e-07 54.025000000000006p 3.0279420000000002e-07 54.037500000000001p 3.0981860000000001e-07 54.049999999999997p 3.1642340000000002e-07 54.0625p 3.226006e-07 54.074999999999996p 3.2834310000000001e-07 54.087499999999999p 3.336443e-07 54.100000000000001p 3.3849800000000002e-07 54.112500000000004p 3.4289880000000002e-07 54.125p 3.4684190000000001e-07 54.137499999999996p 3.5032300000000001e-07 54.149999999999999p 3.5333839999999998e-07 54.162500000000001p 3.558852e-07 54.175000000000004p 3.5796099999999999e-07 54.1875p 3.5956399999999998e-07 54.199999999999996p 3.606931e-07 54.212499999999999p 3.6134770000000001e-07 54.225000000000001p 3.6152810000000003e-07
+ 54.237500000000004p 3.612349e-07 54.25p 3.6046939999999999e-07 54.262499999999996p 3.5923379999999999e-07 54.274999999999999p 3.5753050000000001e-07 54.287500000000001p 3.5536280000000002e-07 54.300000000000004p 3.5273460000000002e-07 54.3125p 3.496501e-07 54.324999999999996p 3.4611459999999998e-07 54.337499999999999p 3.4213340000000001e-07 54.350000000000001p 3.3771290000000001e-07 54.362500000000004p 3.328597e-07 54.375p 3.2758119999999998e-07 54.387499999999996p 3.2188509999999999e-07 54.399999999999999p 3.1577999999999999e-07 54.412500000000001p 3.0927470000000002e-07 54.425000000000004p 3.023785e-07 54.4375p 2.9510149999999998e-07 54.449999999999996p 2.87454e-07
+ 54.462499999999999p 2.7944690000000001e-07 54.475000000000001p 2.7109140000000002e-07 54.487500000000004p 2.6239940000000001e-07 54.5p 2.5338299999999999e-07 54.512500000000003p 2.4405470000000002e-07 54.524999999999999p 2.344275e-07 54.537499999999994p 2.2451480000000001e-07 54.550000000000004p 2.143302e-07 54.5625p 2.0388760000000001e-07 54.575000000000003p 1.932015e-07 54.587499999999999p 1.822863e-07 54.599999999999994p 1.7115690000000001e-07 54.612500000000004p 1.5982850000000001e-07 54.625p 1.4831640000000001e-07 54.637500000000003p 1.366361e-07 54.649999999999999p 1.2480330000000001e-07 54.662499999999994p 1.128339e-07 54.675000000000004p 1.0074400000000001e-07
+ 54.6875p 8.8549719999999999e-08 54.700000000000003p 7.6267270000000004e-08 54.712499999999999p 6.3913009999999995e-08 54.724999999999994p 5.1503310000000001e-08 54.737500000000004p 3.905458e-08 54.75p 2.6583240000000001e-08 54.762500000000003p 1.4105709999999999e-08 54.774999999999999p 1.6383580000000001e-09 54.787499999999994p -1.0802480000000001e-08 54.800000000000004p -2.3200559999999999e-08 54.8125p -3.5539740000000002e-08 54.825000000000003p -4.7803969999999999e-08 54.837499999999999p -5.9977379999999997e-08 54.850000000000001p -7.2044219999999997e-08 54.862499999999997p -8.3988950000000002e-08 54.875p -9.5796200000000004e-08 54.887500000000003p -1.074509e-07 54.899999999999999p -1.18938e-07
+ 54.912500000000001p -1.302431e-07 54.924999999999997p -1.4135160000000001e-07 54.9375p -1.522497e-07 54.950000000000003p -1.629234e-07 54.962499999999999p -1.7335940000000001e-07 54.975000000000001p -1.8354469999999999e-07 54.987499999999997p -1.9346650000000001e-07 55p -2.0311239999999999e-07 55.012500000000003p -2.124706e-07 55.024999999999999p -2.2152950000000001e-07 55.037500000000001p -2.3027799999999999e-07 55.049999999999997p -2.3870539999999999e-07 55.0625p -2.4680159999999999e-07 55.075000000000003p -2.5455660000000003e-07 55.087499999999999p -2.619613e-07 55.100000000000001p -2.6900689999999998e-07 55.112499999999997p -2.7568489999999998e-07 55.125p -2.8198770000000002e-07
+ 55.137500000000003p -2.879078e-07 55.149999999999999p -2.9343839999999998e-07 55.162500000000001p -2.985734e-07 55.174999999999997p -3.0330690000000001e-07 55.1875p -3.0763379999999998e-07 55.200000000000003p -3.1154949999999999e-07 55.212499999999999p -3.1504969999999998e-07 55.225000000000001p -3.1813089999999999e-07 55.237499999999997p -3.2079019999999999e-07 55.25p -3.2302500000000002e-07 55.262500000000003p -3.2483360000000001e-07 55.274999999999999p -3.2621450000000003e-07 55.287500000000001p -3.2716690000000002e-07 55.299999999999997p -3.2769069999999999e-07 55.3125p -3.2778619999999998e-07 55.325000000000003p -3.2745430000000002e-07 55.337499999999999p -3.266964e-07 55.350000000000001p -3.2551460000000002e-07
+ 55.362499999999997p -3.239113e-07 55.375p -3.2188960000000001e-07 55.387500000000003p -3.1945319999999998e-07 55.399999999999999p -3.1660620000000001e-07 55.412500000000001p -3.1335329999999999e-07 55.424999999999997p -3.0969960000000001e-07 55.4375p -3.0565079999999998e-07 55.450000000000003p -3.012131e-07 55.462499999999999p -2.9639329999999998e-07 55.475000000000001p -2.9119829999999999e-07 55.487499999999997p -2.8563590000000001e-07 55.5p -2.797142e-07 55.512500000000003p -2.7344149999999998e-07 55.524999999999999p -2.6682709999999998e-07 55.537500000000001p -2.5988010000000001e-07 55.549999999999997p -2.5261040000000001e-07 55.5625p -2.450282e-07 55.575000000000003p -2.3714409999999999e-07
+ 55.587500000000006p -2.289689e-07 55.600000000000001p -2.2051400000000001e-07 55.612499999999997p -2.1179110000000001e-07 55.625p -2.02812e-07 55.637499999999996p -1.93589e-07 55.650000000000006p -1.8413460000000001e-07 55.662500000000001p -1.7446180000000001e-07 55.674999999999997p -1.645835e-07 55.6875p -1.5451309999999999e-07 55.699999999999996p -1.4426409999999999e-07 55.712500000000006p -1.3385020000000001e-07 55.725000000000001p -1.232854e-07 55.737499999999997p -1.125838e-07 55.75p -1.017596e-07 55.762499999999996p -9.0827100000000002e-08 55.775000000000006p -7.9800889999999999e-08 55.787500000000001p -6.8695520000000001e-08 55.799999999999997p -5.752562e-08
+ 55.8125p -4.6305899999999999e-08 55.824999999999996p -3.5051099999999999e-08 55.837500000000006p -2.3775980000000001e-08 55.850000000000001p -1.249528e-08 55.862499999999997p -1.2237450000000001e-09 55.875p 1.002394e-08 55.887499999999996p 2.123315e-08 55.899999999999999p 3.2389329999999999e-08 55.912500000000001p 4.3478009999999997e-08 55.924999999999997p 5.4484869999999999e-08 55.9375p 6.5395699999999996e-08 55.949999999999996p 7.6196449999999994e-08 55.962499999999999p 8.6873220000000004e-08 55.975000000000001p 9.7412340000000002e-08 55.987500000000004p 1.078003e-07 56p 1.1802390000000001e-07 56.012499999999996p 1.2807000000000001e-07 56.024999999999999p 1.3792589999999999e-07
+ 56.037500000000001p 1.4757909999999999e-07 56.050000000000004p 1.570175e-07 56.0625p 1.66229e-07 56.074999999999996p 1.752021e-07 56.087499999999999p 1.8392560000000001e-07 56.100000000000001p 1.9238859999999999e-07 56.112500000000004p 2.0058059999999999e-07 56.125p 2.0849129999999999e-07 56.137499999999996p 2.16111e-07 56.149999999999999p 2.234304e-07 56.162500000000001p 2.3044040000000001e-07 56.175000000000004p 2.3713259999999999e-07 56.1875p 2.4349890000000001e-07 56.199999999999996p 2.4953149999999997e-07 56.212499999999999p 2.5522339999999998e-07 56.225000000000001p 2.6056780000000002e-07 56.237500000000004p 2.6555829999999998e-07 56.25p 2.7018920000000002e-07
+ 56.262499999999996p 2.7445529999999998e-07 56.274999999999999p 2.7835159999999998e-07 56.287500000000001p 2.8187399999999997e-07 56.300000000000004p 2.8501850000000001e-07 56.3125p 2.8778180000000002e-07 56.324999999999996p 2.901613e-07 56.337499999999999p 2.921545e-07 56.350000000000001p 2.9375969999999998e-07 56.362500000000004p 2.9497569999999998e-07 56.375p 2.9580170000000001e-07 56.387500000000003p 2.9623749999999999e-07 56.399999999999999p 2.962834e-07 56.412499999999994p 2.9594030000000002e-07 56.425000000000004p 2.9520930000000001e-07 56.4375p 2.9409250000000002e-07 56.450000000000003p 2.92592e-07 56.462499999999999p 2.9071079999999998e-07 56.474999999999994p 2.8845220000000001e-07
+ 56.487500000000004p 2.8582009999999999e-07 56.5p 2.8281869999999998e-07 56.512500000000003p 2.7945280000000002e-07 56.524999999999999p 2.7572780000000001e-07 56.537499999999994p 2.7164940000000002e-07 56.550000000000004p 2.6722370000000001e-07 56.5625p 2.6245739999999997e-07 56.575000000000003p 2.5735750000000001e-07 56.587499999999999p 2.5193159999999999e-07 56.599999999999994p 2.4618759999999999e-07 56.612500000000004p 2.4013379999999999e-07 56.625p 2.337789e-07 56.637500000000003p 2.27132e-07 56.649999999999999p 2.2020249999999999e-07 56.662499999999994p 2.1300029999999999e-07 56.675000000000004p 2.0553550000000001e-07 56.6875p 1.9781860000000001e-07 56.700000000000003p 1.8986030000000001e-07
+ 56.712499999999999p 1.8167170000000001e-07 56.725000000000001p 1.732641e-07 56.737499999999997p 1.6464930000000001e-07 56.75p 1.558389e-07 56.762500000000003p 1.468452e-07 56.774999999999999p 1.3768039999999999e-07 56.787500000000001p 1.2835699999999999e-07 56.799999999999997p 1.188877e-07 56.8125p 1.0928530000000001e-07 56.825000000000003p 9.9562789999999995e-08 56.837499999999999p 8.973331e-08 56.850000000000001p 7.9810039999999998e-08 56.862499999999997p 6.98063e-08 56.875p 5.973546e-08 56.887500000000003p 4.9610949999999997e-08 56.899999999999999p 3.9446230000000002e-08 56.912500000000001p 2.9254799999999999e-08 56.924999999999997p 1.905014e-08
+ 56.9375p 8.8457079999999998e-09 56.950000000000003p -1.345059e-09 56.962499999999999p -1.150878e-08 56.975000000000001p -2.1632159999999999e-08 56.987499999999997p -3.1701969999999999e-08 57p -4.1705100000000001e-08 57.012500000000003p -5.1628570000000001e-08 57.024999999999999p -6.1459510000000005e-08 57.037500000000001p -7.1185250000000005e-08 57.049999999999997p -8.0793260000000004e-08 57.0625p -9.0271209999999996e-08 57.075000000000003p -9.9606979999999993e-08 57.087499999999999p -1.087886e-07 57.100000000000001p -1.1780460000000001e-07 57.112499999999997p -1.2664330000000001e-07 57.125p -1.352936e-07 57.137500000000003p -1.4374480000000001e-07 57.149999999999999p -1.5198609999999999e-07
+ 57.162500000000001p -1.6000740000000001e-07 57.174999999999997p -1.6779849999999999e-07 57.1875p -1.7534999999999999e-07 57.200000000000003p -1.8265240000000001e-07 57.212499999999999p -1.8969689999999999e-07 57.225000000000001p -1.964749e-07 57.237499999999997p -2.029781e-07 57.25p -2.0919880000000001e-07 57.262500000000003p -2.1512939999999999e-07 57.274999999999999p -2.20763e-07 57.287500000000001p -2.2609289999999999e-07 57.299999999999997p -2.3111289999999999e-07 57.3125p -2.3581720000000001e-07 57.325000000000003p -2.4020040000000002e-07 57.337499999999999p -2.4425770000000001e-07 57.350000000000001p -2.4798449999999999e-07 57.362499999999997p -2.5137670000000001e-07 57.375p -2.5443080000000003e-07
+ 57.387500000000003p -2.5714360000000002e-07 57.399999999999999p -2.595124e-07 57.412500000000001p -2.6153489999999997e-07 57.424999999999997p -2.6320950000000003e-07 57.4375p -2.645347e-07 57.450000000000003p -2.6550959999999998e-07 57.462500000000006p -2.6613400000000002e-07 57.475000000000001p -2.6640769999999998e-07 57.487499999999997p -2.6633140000000003e-07 57.5p -2.6590589999999998e-07 57.512499999999996p -2.6513269999999999e-07 57.525000000000006p -2.6401359999999998e-07 57.537500000000001p -2.6255100000000001e-07 57.549999999999997p -2.6074749999999999e-07 57.5625p -2.5860639999999998e-07 57.574999999999996p -2.5613120000000002e-07 57.587500000000006p -2.53326e-07 57.600000000000001p -2.5019520000000001e-07
+ 57.612499999999997p -2.4674370000000003e-07 57.625p -2.4297680000000001e-07 57.637499999999996p -2.3890009999999999e-07 57.650000000000006p -2.3451970000000001e-07 57.662500000000001p -2.29842e-07 57.674999999999997p -2.2487379999999999e-07 57.6875p -2.1962230000000001e-07 57.699999999999996p -2.1409489999999999e-07 57.712500000000006p -2.082997e-07 57.725000000000001p -2.022446e-07 57.737499999999997p -1.9593829999999999e-07 57.75p -1.8938949999999999e-07 57.762499999999996p -1.8260729999999999e-07 57.774999999999999p -1.756012e-07 57.787500000000001p -1.6838079999999999e-07 57.799999999999997p -1.60956e-07 57.8125p -1.533369e-07 57.824999999999996p -1.4553400000000001e-07
+ 57.837499999999999p -1.375579e-07 57.850000000000001p -1.2941930000000001e-07 57.862500000000004p -1.2112920000000001e-07 57.875p -1.126989e-07 57.887499999999996p -1.041396e-07 57.899999999999999p -9.5462779999999995e-08 57.912500000000001p -8.6680109999999995e-08 57.925000000000004p -7.7803260000000002e-08 57.9375p -6.884405e-08 57.949999999999996p -5.9814379999999998e-08 57.962499999999999p -5.0726199999999998e-08 57.975000000000001p -4.1591530000000002e-08 57.987500000000004p -3.2422419999999999e-08 58p -2.3230949999999999e-08 58.012499999999996p -1.402919e-08 58.024999999999999p -4.8292070000000004e-09 58.037500000000001p 4.3569500000000003e-09 58.050000000000004p 1.3517289999999999e-08
+ 58.0625p 2.2639850000000001e-08 58.074999999999996p 3.1712779999999997e-08 58.087499999999999p 4.0724279999999998e-08 58.100000000000001p 4.9662680000000003e-08 58.112500000000004p 5.8516409999999998e-08 58.125p 6.727403e-08 58.137499999999996p 7.5924269999999999e-08 58.149999999999999p 8.4455990000000002e-08 58.162500000000001p 9.285826e-08 58.175000000000004p 1.011203e-07 58.1875p 1.092316e-07 58.199999999999996p 1.1718169999999999e-07 58.212499999999991p 1.249607e-07 58.225000000000001p 1.325585e-07 58.237500000000004p 1.3996569999999999e-07 58.250000000000007p 1.4717280000000001e-07 58.262499999999996p 1.5417089999999999e-07 58.274999999999999p 1.60951e-07
+ 58.287500000000001p 1.6750480000000001e-07 58.299999999999997p 1.7382419999999999e-07 58.3125p 1.799012e-07 58.325000000000003p 1.8572830000000001e-07 58.337499999999991p 1.9129850000000001e-07 58.349999999999994p 1.9660489999999999e-07 58.362500000000004p 2.01641e-07 58.375000000000007p 2.0640080000000001e-07 58.387499999999996p 2.108786e-07 58.399999999999999p 2.15069e-07 58.412500000000001p 2.1896719999999999e-07 58.424999999999997p 2.225685e-07 58.4375p 2.2586880000000001e-07 58.450000000000003p 2.2886449999999999e-07 58.462500000000006p 2.315521e-07 58.474999999999994p 2.3392879999999999e-07 58.487500000000004p 2.3599200000000001e-07 58.500000000000007p 2.3773970000000001e-07
+ 58.512499999999996p 2.3917019999999997e-07 58.524999999999999p 2.4028230000000001e-07 58.537500000000001p 2.410751e-07 58.549999999999997p 2.4154840000000001e-07 58.5625p 2.41702e-07 58.575000000000003p 2.4153659999999998e-07 58.587500000000006p 2.410528e-07 58.599999999999994p 2.4025209999999999e-07 58.612499999999997p 2.3913619999999999e-07 58.625000000000007p 2.3770720000000001e-07 58.637499999999996p 2.359675e-07 58.649999999999999p 2.339203e-07 58.662500000000001p 2.315687e-07 58.674999999999997p 2.2891670000000001e-07 58.6875p 2.2596820000000001e-07 58.700000000000003p 2.227278e-07 58.712500000000006p 2.192004e-07 58.724999999999994p 2.153913e-07
+ 58.737499999999997p 2.1130609999999999e-07 58.750000000000007p 2.069508e-07 58.762499999999996p 2.0233170000000001e-07 58.774999999999999p 1.974555e-07 58.787500000000001p 1.9232920000000001e-07 58.800000000000004p 1.8696e-07 58.8125p 1.813557e-07 58.825000000000003p 1.75524e-07 58.837500000000006p 1.694733e-07 58.849999999999994p 1.632119e-07 58.862499999999997p 1.5674869999999999e-07 58.875p 1.5009250000000001e-07 58.887499999999996p 1.4325269999999999e-07 58.899999999999999p 1.3623860000000001e-07 58.912500000000001p 1.290599e-07 58.925000000000004p 1.2172640000000001e-07 58.9375p 1.142482e-07 58.950000000000003p 1.066355e-07
+ 58.962500000000006p 9.8898580000000003e-08 58.974999999999994p 9.1047989999999999e-08 58.987499999999997p 8.3094350000000002e-08 59p 7.504838e-08 59.012499999999996p 6.6920930000000005e-08 59.024999999999999p 5.872289e-08 59.037500000000001p 5.0465259999999999e-08 59.050000000000004p 4.215908e-08 59.062499999999993p 3.3815419999999997e-08 59.075000000000003p 2.5445369999999999e-08 59.087500000000006p 1.7060060000000001e-08 59.099999999999994p 8.6705669999999996e-09 59.112499999999997p 2.8798630000000001e-10 59.125p -8.0766399999999995e-09 59.13750000000001p -1.6412320000000001e-08 59.149999999999999p -2.470812e-08 59.162500000000001p -3.2953180000000002e-08 59.175000000000004p -4.1136760000000003e-08
+ 59.187499999999993p -4.9248200000000003e-08 59.200000000000003p -5.7276970000000001e-08 59.212500000000006p -6.5212679999999994e-08 59.224999999999994p -7.3045070000000006e-08 59.237499999999997p -8.0764069999999997e-08 59.25p -8.8359770000000005e-08 59.262500000000003p -9.5822440000000004e-08 59.274999999999999p -1.031426e-07 59.287500000000001p -1.103108e-07 59.300000000000004p -1.173181e-07 59.312499999999993p -1.241556e-07 59.325000000000003p -1.3081469999999999e-07 59.337500000000006p -1.37287e-07 59.349999999999994p -1.4356449999999999e-07 59.362499999999997p -1.4963930000000001e-07 59.375p -1.555039e-07 59.387500000000003p -1.611511e-07 59.399999999999999p -1.665739e-07
+ 59.412500000000001p -1.7176590000000001e-07 59.425000000000004p -1.767205e-07 59.437499999999993p -1.8143200000000001e-07 59.449999999999996p -1.8589470000000001e-07 59.462500000000006p -1.901032e-07 59.474999999999994p -1.9405269999999999e-07 59.487499999999997p -1.9773850000000001e-07 59.5p -2.0115649999999999e-07 59.512500000000003p -2.043027e-07 59.524999999999999p -2.071736e-07 59.537500000000001p -2.0976609999999999e-07 59.550000000000004p -2.1207749999999999e-07 59.562499999999993p -2.141053e-07 59.574999999999996p -2.1584759999999999e-07 59.587500000000006p -2.1730269999999999e-07 59.600000000000009p -2.184693e-07 59.612499999999997p -2.1934670000000001e-07 59.625p -2.199342e-07
+ 59.637500000000003p -2.202318e-07 59.649999999999999p -2.2023980000000001e-07 59.662500000000001p -2.1995869999999999e-07 59.675000000000004p -2.193897e-07 59.687499999999993p -2.1853410000000001e-07 59.699999999999996p -2.173936e-07 59.712499999999999p -2.1597050000000001e-07 59.725000000000009p -2.1426720000000001e-07 59.737499999999997p -2.1228650000000001e-07 59.75p -2.1003170000000001e-07 59.762500000000003p -2.075064e-07 59.774999999999999p -2.0471440000000001e-07 59.787500000000001p -2.016599e-07 59.800000000000004p -1.983476e-07 59.812499999999993p -1.947824e-07 59.824999999999996p -1.9096950000000001e-07 59.837499999999999p -1.8691430000000001e-07 59.850000000000009p -1.826228e-07
+ 59.862499999999997p -1.7810110000000001e-07 59.875p -1.7335549999999999e-07 59.887500000000003p -1.683929e-07 59.899999999999991p -1.6322e-07 59.912500000000001p -1.578442e-07 59.925000000000004p -1.5227290000000001e-07 59.937500000000007p -1.465138e-07 59.949999999999996p -1.4057479999999999e-07 59.962499999999999p -1.344641e-07 59.975000000000001p -1.2819000000000001e-07 59.987499999999997p -1.2176120000000001e-07 60p -1.1518619999999999e-07 60.012500000000003p -1.08474e-07 60.024999999999991p -1.0163370000000001e-07 60.037500000000001p -9.4674409999999996e-08 60.050000000000004p -8.7605560000000002e-08 60.062500000000007p -8.0436580000000006e-08 60.074999999999996p -7.317706e-08
+ 60.087499999999999p -6.5836649999999997e-08 60.100000000000001p -5.8425120000000001e-08 60.112499999999997p -5.0952300000000002e-08 60.125p -4.3428080000000003e-08 60.137500000000003p -3.5862389999999999e-08 60.149999999999991p -2.8265209999999999e-08 60.162499999999994p -2.0646519999999999e-08 60.175000000000004p -1.301632e-08 60.187500000000007p -5.3846149999999996e-09 60.199999999999996p 2.2386289999999998e-09 60.212499999999999p 9.8434669999999992e-09 60.225000000000001p 1.742e-08 60.237499999999997p 2.495837e-08 60.25p 3.2448819999999997e-08 60.262500000000003p 3.988165e-08 60.275000000000006p 4.7247260000000003e-08 60.287499999999994p 5.4536159999999998e-08 60.300000000000004p 6.1738970000000005e-08
+ 60.312500000000007p 6.8846449999999998e-08 60.324999999999996p 7.5849499999999994e-08 60.337499999999999p 8.2739170000000005e-08 60.350000000000001p 8.9506670000000003e-08 60.362499999999997p 9.6143409999999994e-08 60.375p 1.02641e-07 60.387500000000003p 1.0899110000000001e-07 60.400000000000006p 1.151858e-07 60.412499999999994p 1.212173e-07 60.425000000000004p 1.2707809999999999e-07 60.437500000000007p 1.327607e-07 60.449999999999996p 1.3825810000000001e-07 60.462499999999999p 1.4356349999999999e-07 60.475000000000001p 1.4867039999999999e-07 60.487499999999997p 1.535723e-07 60.5p 1.5826339999999999e-07 60.512500000000003p 1.6273789999999999e-07 60.525000000000006p 1.6699040000000001e-07
+ 60.537499999999994p 1.710157e-07 60.549999999999997p 1.7480910000000001e-07 60.562500000000007p 1.7836590000000001e-07 60.574999999999996p 1.8168209999999999e-07 60.587499999999999p 1.847538e-07 60.600000000000001p 1.8757740000000001e-07 60.612499999999997p 1.9014969999999999e-07 60.625p 1.9246790000000001e-07 60.637500000000003p 1.945295e-07 60.650000000000006p 1.9633210000000001e-07 60.662499999999994p 1.9787410000000001e-07 60.674999999999997p 1.9915389999999999e-07 60.687500000000007p 2.001703e-07 60.699999999999996p 2.0092260000000001e-07 60.712499999999999p 2.0141020000000001e-07 60.725000000000001p 2.016332e-07 60.737500000000004p 2.0159169999999999e-07 60.75p 2.012863e-07
+ 60.762500000000003p 2.0071789999999999e-07 60.775000000000006p 1.998879e-07 60.787499999999994p 1.9879779999999999e-07 60.799999999999997p 1.9744959999999999e-07 60.8125p 1.958456e-07 60.824999999999996p 1.939884e-07 60.837499999999999p 1.91881e-07 60.850000000000001p 1.8952660000000001e-07 60.862500000000004p 1.869289e-07 60.875p 1.8409179999999999e-07 60.887500000000003p 1.8101940000000001e-07 60.900000000000006p 1.777163e-07 60.912499999999994p 1.7418720000000001e-07 60.924999999999997p 1.704374e-07 60.9375p 1.664721e-07 60.949999999999996p 1.6229699999999999e-07 60.962499999999999p 1.5791809999999999e-07 60.975000000000001p 1.5334139999999999e-07
+ 60.987500000000004p 1.4857340000000001e-07 60.999999999999993p 1.436208e-07 61.012500000000003p 1.3849050000000001e-07 61.025000000000006p 1.331895e-07 61.037499999999994p 1.2772510000000001e-07 61.049999999999997p 1.2210499999999999e-07 61.0625p 1.163366e-07 61.075000000000003p 1.1042809999999999e-07 61.087499999999999p 1.043873e-07 61.100000000000001p 9.8222559999999998e-08 61.112500000000004p 9.1942139999999995e-08 61.124999999999993p 8.5554549999999996e-08 61.137500000000003p 7.9068380000000006e-08 61.150000000000006p 7.2492370000000004e-08 61.162499999999994p 6.5835310000000006e-08 61.174999999999997p 5.9106119999999999e-08 61.1875p 5.2313759999999997e-08 61.200000000000003p 4.5467269999999999e-08
+ 61.212499999999999p 3.8575750000000001e-08 61.225000000000001p 3.1648320000000003e-08 61.237500000000004p 2.4694140000000001e-08 61.249999999999993p 1.772238e-08 61.262499999999996p 1.07422e-08 61.275000000000006p 3.7627770000000004e-09 61.287499999999994p -3.206758e-09 61.299999999999997p -1.0157299999999999e-08 61.3125p -1.7079780000000001e-08 61.325000000000003p -2.3965200000000001e-08 61.337499999999999p -3.0804629999999998e-08 61.350000000000001p -3.7589219999999997e-08 61.362500000000004p -4.4310200000000002e-08 61.374999999999993p -5.0958929999999997e-08 61.387499999999996p -5.7526850000000001e-08 61.400000000000006p -6.4005560000000003e-08 61.412500000000009p -7.0386780000000003e-08 61.424999999999997p -7.6662369999999994e-08
+ 61.4375p -8.2824359999999997e-08 61.450000000000003p -8.8864949999999999e-08 61.462499999999999p -9.4776509999999998e-08 61.475000000000001p -1.005516e-07 61.487500000000004p -1.0618300000000001e-07 61.499999999999993p -1.116636e-07 61.512499999999996p -1.1698660000000001e-07 61.524999999999999p -1.2214540000000001e-07 61.537500000000009p -1.271337e-07 61.549999999999997p -1.3194530000000001e-07 61.5625p -1.365742e-07 61.575000000000003p -1.41015e-07 61.587499999999999p -1.452622e-07 61.600000000000001p -1.4931060000000001e-07 61.612500000000004p -1.5315550000000001e-07 61.624999999999993p -1.567923e-07 61.637499999999996p -1.6021670000000001e-07 61.649999999999999p -1.6342469999999999e-07
+ 61.662500000000009p -1.664126e-07 61.674999999999997p -1.691771e-07 61.6875p -1.7171490000000001e-07 61.700000000000003p -1.7402339999999999e-07 61.712499999999991p -1.760999e-07 61.725000000000001p -1.7794239999999999e-07 61.737500000000004p -1.7954899999999999e-07 61.749999999999993p -1.8091800000000001e-07 61.762499999999996p -1.820482e-07 61.774999999999999p -1.8293880000000001e-07 61.787500000000009p -1.8358899999999999e-07 61.799999999999997p -1.8399860000000001e-07 61.8125p -1.8416759999999999e-07 61.825000000000003p -1.8409630000000001e-07 61.837499999999991p -1.837853e-07 61.850000000000001p -1.8323559999999999e-07 61.862500000000004p -1.8244839999999999e-07 61.875000000000007p -1.814253e-07
+ 61.887499999999996p -1.8016809999999999e-07 61.899999999999999p -1.786791e-07 61.912500000000001p -1.769606e-07 61.924999999999997p -1.750154e-07 61.9375p -1.7284659999999999e-07 61.950000000000003p -1.7045749999999999e-07 61.962499999999991p -1.6785170000000001e-07 61.975000000000001p -1.6503299999999999e-07 61.987500000000004p -1.620057e-07 62.000000000000007p -1.5877399999999999e-07 62.012499999999996p -1.5534280000000001e-07 62.024999999999999p -1.5171689999999999e-07 62.037500000000001p -1.4790139999999999e-07 62.049999999999997p -1.439018e-07 62.0625p -1.3972370000000001e-07 62.075000000000003p -1.3537279999999999e-07 62.087499999999991p -1.3085529999999999e-07 62.099999999999994p -1.2617749999999999e-07
+ 62.112500000000004p -1.213457e-07 62.125000000000007p -1.163665e-07 62.137499999999996p -1.112469e-07 62.149999999999999p -1.0599380000000001e-07 62.162500000000001p -1.006142e-07 62.174999999999997p -9.5115639999999994e-08 62.1875p -8.9505360000000002e-08 62.200000000000003p -8.3790969999999996e-08 62.212500000000006p -7.7980140000000006e-08 62.224999999999994p -7.2080660000000006e-08 62.237500000000004p -6.6100409999999995e-08 62.250000000000007p -6.0047360000000004e-08 62.262499999999996p -5.3929550000000003e-08 62.274999999999999p -4.7755099999999999e-08 62.287500000000001p -4.1532189999999999e-08 62.299999999999997p -3.5269040000000003e-08 62.3125p -2.897388e-08 62.325000000000003p -2.265501e-08
+ 62.337500000000006p -1.6320700000000001e-08 62.349999999999994p -9.9792649999999997e-09 62.362499999999997p -3.6389739999999999e-09 62.375000000000007p 2.6919029999999999e-09 62.387499999999996p 9.0051300000000003e-09 62.399999999999999p 1.5292509999999999e-08 62.412500000000001p 2.1545900000000001e-08 62.424999999999997p 2.7757219999999999e-08 62.4375p 3.3918449999999998e-08 62.450000000000003p 4.0021659999999997e-08 62.462500000000006p 4.6059020000000002e-08 62.474999999999994p 5.2022790000000001e-08 62.487499999999997p 5.790535e-08 62.500000000000007p 6.3699200000000004e-08 62.512499999999996p 6.9396970000000006e-08 62.524999999999999p 7.4991429999999998e-08 62.537500000000001p 8.0475499999999998e-08 62.550000000000004p 8.5842259999999999e-08
+ 62.5625p 9.1084959999999999e-08 62.575000000000003p 9.6197030000000001e-08 62.587500000000006p 1.0117210000000001e-07 62.599999999999994p 1.060039e-07 62.612499999999997p 1.106865e-07 62.625p 1.1521409999999999e-07 62.637499999999996p 1.1958110000000001e-07 62.649999999999999p 1.2378210000000001e-07 62.662500000000001p 1.278121e-07 62.675000000000004p 1.3166619999999999e-07 62.6875p 1.353396e-07 62.700000000000003p 1.38828e-07 62.712500000000006p 1.4212729999999999e-07 62.724999999999994p 1.452335e-07 62.737499999999997p 1.4814300000000001e-07 62.75p 1.5085249999999999e-07 62.762499999999996p 1.5335880000000001e-07 62.774999999999999p 1.556591e-07
+ 62.787500000000001p 1.5775099999999999e-07 62.800000000000004p 1.5963200000000001e-07 62.812499999999993p 1.6130020000000001e-07 62.825000000000003p 1.6275390000000001e-07 62.837500000000006p 1.6399179999999999e-07 62.849999999999994p 1.650126e-07 62.862499999999997p 1.6581549999999999e-07 62.875p 1.6639989999999999e-07 62.88750000000001p 1.667656e-07 62.899999999999999p 1.669127e-07 62.912500000000001p 1.6684130000000001e-07 62.925000000000004p 1.6655220000000001e-07 62.937499999999993p 1.660461e-07 62.950000000000003p 1.6532419999999999e-07 62.962500000000006p 1.64388e-07 62.974999999999994p 1.6323920000000001e-07 62.987499999999997p 1.6187980000000001e-07 63p 1.6031200000000001e-07
+ 63.012500000000003p 1.585385e-07 63.024999999999999p 1.565619e-07 63.037500000000001p 1.5438529999999999e-07 63.050000000000004p 1.5201209999999999e-07 63.062499999999993p 1.4944590000000001e-07 63.075000000000003p 1.4669039999999999e-07 63.087500000000006p 1.437497e-07 63.099999999999994p 1.406281e-07 63.112499999999997p 1.3733e-07 63.125p 1.338604e-07 63.137500000000003p 1.3022399999999999e-07 63.149999999999999p 1.26426e-07 63.162500000000001p 1.2247189999999999e-07 63.175000000000004p 1.183671e-07 63.187499999999993p 1.141175e-07 63.199999999999996p 1.0972880000000001e-07 63.212500000000006p 1.0520719999999999e-07 63.224999999999994p 1.0055899999999999e-07
+ 63.237499999999997p 9.5790509999999997e-08 63.25p 9.0908290000000002e-08 63.262500000000003p 8.591901e-08 63.274999999999999p 8.082947e-08 63.287500000000001p 7.5646580000000001e-08 63.300000000000004p 7.0377360000000004e-08 63.312499999999993p 6.5028930000000004e-08 63.324999999999996p 5.9608469999999998e-08 63.337500000000006p 5.4123279999999998e-08 63.350000000000009p 4.8580689999999997e-08 63.362499999999997p 4.2988110000000003e-08 63.375p 3.7352979999999997e-08 63.387500000000003p 3.1682800000000002e-08 63.399999999999999p 2.598508e-08 63.412500000000001p 2.0267350000000001e-08 63.425000000000004p 1.453715e-08 63.437499999999993p 8.8020170000000005e-09 63.449999999999996p 3.0694769999999999e-09
+ 63.462499999999999p -2.652968e-09 63.475000000000009p -8.357846e-09 63.487499999999997p -1.403773e-08 63.5p -1.9685240000000001e-08 63.512500000000003p -2.529306e-08 63.524999999999999p -3.0853949999999997e-08 63.537500000000001p -3.636074e-08 63.550000000000004p -4.180634e-08 63.562499999999993p -4.7183800000000003e-08 63.574999999999996p -5.2486220000000002e-08 63.587499999999999p -5.770685e-08 63.600000000000009p -6.283907e-08 63.612499999999997p -6.7876369999999997e-08 63.625p -7.2812399999999999e-08 63.637500000000003p -7.7640939999999994e-08 63.649999999999991p -8.2355939999999994e-08 63.662500000000001p -8.6951510000000006e-08 63.675000000000004p -9.1421929999999994e-08
+ 63.687500000000007p -9.5761670000000001e-08 63.699999999999996p -9.9965370000000001e-08 63.712499999999999p -1.040279e-07 63.725000000000001p -1.079442e-07 63.737499999999997p -1.117096e-07 63.75p -1.153195e-07 63.762500000000003p -1.187695e-07 63.774999999999991p -1.2205569999999999e-07 63.787500000000001p -1.2517400000000001e-07 63.800000000000004p -1.281208e-07 63.812500000000007p -1.3089260000000001e-07 63.824999999999996p -1.334864e-07 63.837499999999999p -1.3589910000000001e-07 63.850000000000001p -1.3812790000000001e-07 63.862499999999997p -1.401706e-07 63.875p -1.420247e-07 63.887500000000003p -1.436885e-07 63.899999999999991p -1.451601e-07
+ 63.912499999999994p -1.464381e-07 63.925000000000004p -1.4752129999999999e-07 63.937500000000007p -1.484088e-07 63.949999999999996p -1.4909990000000001e-07 63.962499999999999p -1.495941e-07 63.975000000000001p -1.498914e-07 63.987499999999997p -1.4999170000000001e-07 64p -1.4989549999999999e-07 64.012500000000003p -1.496033e-07 64.025000000000006p -1.491159e-07 64.037499999999994p -1.484346e-07 64.049999999999997p -1.475607e-07 64.0625p -1.464956e-07 64.075000000000003p -1.4524139999999999e-07 64.087500000000006p -1.4380019999999999e-07 64.100000000000009p -1.4217410000000001e-07 64.112499999999997p -1.4036579999999999e-07 64.125p -1.3837820000000001e-07
+ 64.137500000000003p -1.362141e-07 64.150000000000006p -1.33877e-07 64.162499999999994p -1.313702e-07 64.174999999999997p -1.286974e-07 64.1875p -1.2586250000000001e-07 64.199999999999989p -1.228695e-07 64.212500000000006p -1.197229e-07 64.225000000000009p -1.16427e-07 64.237499999999997p -1.129866e-07 64.25p -1.094064e-07 64.262500000000003p -1.056914e-07 64.275000000000006p -1.0184690000000001e-07 64.287499999999994p -9.7878170000000006e-08 64.299999999999997p -9.3790670000000003e-08 64.3125p -8.9590039999999996e-08 64.324999999999989p -8.5282029999999999e-08 64.337500000000006p -8.0872530000000001e-08 64.350000000000009p -7.6367549999999995e-08
+ 64.362499999999997p -7.1773209999999998e-08 64.375p -6.7095710000000001e-08 64.387500000000003p -6.2341369999999994e-08 64.400000000000006p -5.7516600000000003e-08 64.412499999999994p -5.2627869999999998e-08 64.424999999999997p -4.7681730000000003e-08 64.4375p -4.2684779999999997e-08 64.449999999999989p -3.76437e-08 64.462499999999991p -3.2565170000000002e-08 64.475000000000009p -2.7455939999999999e-08 64.487500000000011p -2.232278e-08 64.5p -1.7172450000000001e-08 64.512500000000003p -1.201176e-08 64.525000000000006p -6.847485e-09 64.537499999999994p -1.686405e-09 64.549999999999997p 3.4647209999999999e-09 64.5625p 8.5991599999999995e-09 64.574999999999989p 1.3710220000000001e-08
+ 64.587499999999991p 1.879124e-08 64.600000000000009p 2.383563e-08 64.612500000000011p 2.883686e-08 64.625p 3.3788459999999999e-08 64.637500000000003p 3.868403e-08 64.650000000000006p 4.3517289999999998e-08 64.662499999999994p 4.8282029999999998e-08 64.674999999999997p 5.2972130000000001e-08 64.6875p 5.7581619999999997e-08 64.699999999999989p 6.2104610000000001e-08 64.712499999999991p 6.6535369999999999e-08 64.724999999999994p 7.0868269999999996e-08 64.737500000000011p 7.5097840000000004e-08 64.75p 7.9218749999999996e-08 64.762500000000003p 8.3225829999999999e-08 64.775000000000006p 8.7114060000000001e-08 64.787499999999994p 9.0878599999999994e-08 64.799999999999997p 9.4514769999999996e-08
+ 64.8125p 9.8018079999999997e-08 64.825000000000003p 1.013842e-07 64.837499999999991p 1.0460899999999999e-07 64.849999999999994p 1.076887e-07 64.862500000000011p 1.106193e-07 64.875p 1.1339749999999999e-07 64.887500000000003p 1.160199e-07 64.900000000000006p 1.1848330000000001e-07 64.912499999999994p 1.2078500000000001e-07 64.924999999999997p 1.229223e-07 64.9375p 1.2489260000000001e-07 64.950000000000003p 1.266938e-07 64.962499999999991p 1.2832379999999999e-07 64.974999999999994p 1.2978099999999999e-07 64.987500000000011p 1.310638e-07 65p 1.3217079999999999e-07 65.012500000000003p 1.33101e-07 65.025000000000006p 1.338537e-07
+ 65.037499999999994p 1.3442810000000001e-07 65.049999999999997p 1.348239e-07 65.0625p 1.3504109999999999e-07 65.075000000000003p 1.3507970000000001e-07 65.087499999999991p 1.3493999999999999e-07 65.099999999999994p 1.346227e-07 65.112499999999997p 1.3412869999999999e-07 65.125p 1.3345879999999999e-07 65.137500000000003p 1.3261439999999999e-07 65.150000000000006p 1.315971e-07 65.162500000000009p 1.3040859999999999e-07 65.174999999999997p 1.2905070000000001e-07 65.1875p 1.275257e-07 65.200000000000003p 1.2583610000000001e-07 65.212499999999991p 1.2398430000000001e-07 65.224999999999994p 1.2197319999999999e-07 65.237499999999997p 1.198058e-07 65.25p 1.174853e-07
+ 65.262500000000003p 1.150152e-07 65.275000000000006p 1.123991e-07 65.287500000000009p 1.096406e-07 65.299999999999997p 1.067439e-07 65.3125p 1.03713e-07 65.325000000000003p 1.005523e-07 65.337499999999991p 9.7266240000000003e-08 65.349999999999994p 9.3859409999999999e-08 65.362499999999997p 9.0336600000000002e-08 65.375p 8.6702740000000002e-08 65.387500000000003p 8.2962889999999998e-08 65.400000000000006p 7.9122220000000003e-08 65.412500000000009p 7.5186039999999995e-08 65.424999999999997p 7.1159769999999996e-08 65.4375p 6.7048930000000005e-08 65.450000000000003p 6.2859139999999999e-08 65.462499999999991p 5.8596129999999999e-08 65.474999999999994p 5.4265680000000002e-08
+ 65.487499999999997p 4.9873679999999998e-08 65.5p 4.5426070000000002e-08 65.512500000000003p 4.0928839999999997e-08 65.525000000000006p 3.6388040000000001e-08 65.537500000000009p 3.1809780000000001e-08 65.549999999999997p 2.720019e-08 65.5625p 2.2565409999999999e-08 65.575000000000003p 1.791163e-08 65.587499999999991p 1.324503e-08 65.599999999999994p 8.571806e-09 65.612499999999997p 3.8981329999999998e-09 65.625p -7.6981919999999999e-10 65.637500000000003p -5.4259050000000004e-09 65.650000000000006p -1.006401e-08 65.662500000000009p -1.467806e-08 65.674999999999997p -1.926202e-08 65.6875p -2.3809910000000001e-08 65.700000000000003p -2.8315829999999999e-08
+ 65.712499999999991p -3.2773929999999997e-08 65.724999999999994p -3.7178450000000002e-08 65.737499999999997p -4.1523690000000002e-08 65.75p -4.5804079999999997e-08 65.762500000000003p -5.0014119999999999e-08 65.775000000000006p -5.4148430000000001e-08 65.787500000000009p -5.8201730000000001e-08 65.799999999999997p -6.2168879999999994e-08 65.8125p -6.6044850000000005e-08 65.825000000000003p -6.9824749999999998e-08 65.837499999999991p -7.3503820000000003e-08 65.849999999999994p -7.707745e-08 65.862499999999997p -8.0541179999999998e-08 65.875p -8.389071e-08 65.887500000000003p -8.7121890000000002e-08 65.900000000000006p -9.0230750000000002e-08 65.912500000000009p -9.3213479999999996e-08 65.924999999999997p -9.6066440000000003e-08
+ 65.9375p -9.8786189999999996e-08 65.950000000000003p -1.013695e-07 65.962500000000006p -1.038132e-07 65.974999999999994p -1.061144e-07 65.987499999999997p -1.082705e-07 66p -1.102789e-07 66.012499999999989p -1.121374e-07 66.025000000000006p -1.138438e-07 66.037500000000009p -1.153963e-07 66.049999999999997p -1.167932e-07 66.0625p -1.18033e-07 66.075000000000003p -1.191144e-07 66.087500000000006p -1.200364e-07 66.099999999999994p -1.2079810000000001e-07 66.112499999999997p -1.213989e-07 66.125p -1.218384e-07 66.137499999999989p -1.2211630000000001e-07 66.150000000000006p -1.222327e-07
+ 66.162500000000009p -1.221878e-07 66.174999999999997p -1.2198199999999999e-07 66.1875p -1.21616e-07 66.200000000000003p -1.2109059999999999e-07 66.212500000000006p -1.2040679999999999e-07 66.224999999999994p -1.1956590000000001e-07 66.237499999999997p -1.185693e-07 66.25p -1.174188e-07 66.262499999999989p -1.161162e-07 66.275000000000006p -1.146635e-07 66.287500000000009p -1.13063e-07 66.300000000000011p -1.113171e-07 66.3125p -1.094284e-07 66.325000000000003p -1.0739970000000001e-07 66.337500000000006p -1.05234e-07 66.349999999999994p -1.029344e-07 66.362499999999997p -1.005043e-07 66.375p -9.7947170000000005e-08
+ 66.387499999999989p -9.5266570000000004e-08 66.399999999999991p -9.2466310000000002e-08 66.412500000000009p -8.9550339999999994e-08 66.425000000000011p -8.6522739999999996e-08 66.4375p -8.3387730000000005e-08 66.450000000000003p -8.0149640000000004e-08 66.462500000000006p -7.6812960000000001e-08 66.474999999999994p -7.3382260000000005e-08 66.487499999999997p -6.9862269999999994e-08 66.5p -6.6257790000000003e-08 66.512499999999989p -6.2573720000000005e-08 66.524999999999991p -5.8815069999999997e-08 66.537500000000009p -5.4986940000000002e-08 66.550000000000011p -5.1094489999999998e-08 66.5625p -4.7142960000000001e-08 66.575000000000003p -4.313767e-08 66.587500000000006p -3.9083980000000001e-08 66.599999999999994p -3.498731e-08
+ 66.612499999999997p -3.085313e-08 66.625p -2.668694e-08 66.637500000000003p -2.2494279999999999e-08 66.649999999999991p -1.828069e-08 66.662499999999994p -1.405176e-08 66.675000000000011p -9.8130530000000003e-09 66.6875p -5.5701609999999996e-09 66.700000000000003p -1.328656e-09 66.712500000000006p 2.9058990000000002e-09 66.724999999999994p 7.127963e-09 66.737499999999997p 1.133202e-08 66.75p 1.55126e-08 66.762500000000003p 1.966425e-08 66.774999999999991p 2.3781589999999999e-08 66.787499999999994p 2.7859290000000001e-08 66.800000000000011p 3.1892070000000001e-08 66.8125p 3.5874750000000002e-08 66.825000000000003p 3.9802179999999999e-08
+ 66.837500000000006p 4.3669329999999998e-08 66.849999999999994p 4.7471250000000002e-08 66.862499999999997p 5.1203079999999998e-08 66.875p 5.4860049999999999e-08 66.887500000000003p 5.8437529999999999e-08 66.899999999999991p 6.1930979999999994e-08 66.912499999999994p 6.5335980000000004e-08 66.924999999999997p 6.8648240000000004e-08 66.9375p 7.1863589999999996e-08 66.950000000000003p 7.4978009999999995e-08 66.962500000000006p 7.7987609999999998e-08 66.974999999999994p 8.0888660000000001e-08 66.987499999999997p 8.3677559999999995e-08 67p 8.6350869999999995e-08 67.012500000000003p 8.8905310000000001e-08 67.024999999999991p 9.1337759999999997e-08 67.037499999999994p 9.3645289999999996e-08 67.049999999999997p 9.5825089999999995e-08
+ 67.0625p 9.7874569999999997e-08 67.075000000000003p 9.97913e-08 67.087500000000006p 1.0157300000000001e-07 67.100000000000009p 1.032176e-07 67.112499999999997p 1.0472329999999999e-07 67.125p 1.0608830000000001e-07 67.137500000000003p 1.0731110000000001e-07 67.149999999999991p 1.083904e-07 67.162499999999994p 1.093251e-07 67.174999999999997p 1.101142e-07 67.1875p 1.10757e-07 67.200000000000003p 1.112529e-07 67.212500000000006p 1.116015e-07 67.225000000000009p 1.118028e-07 67.237499999999997p 1.118566e-07 67.25p 1.117634e-07 67.262500000000003p 1.1152339999999999e-07 67.274999999999991p 1.111373e-07
+ 67.287499999999994p 1.1060579999999999e-07 67.299999999999997p 1.0993000000000001e-07 67.3125p 1.091111e-07 67.325000000000003p 1.081503e-07 67.337500000000006p 1.070493e-07 67.350000000000009p 1.0580979999999999e-07 67.362499999999997p 1.044337e-07 67.375p 1.02923e-07 67.387500000000003p 1.0128e-07 67.399999999999991p 9.9507230000000006e-08 67.412499999999994p 9.7607160000000006e-08 67.424999999999997p 9.5582570000000005e-08 67.4375p 9.3436390000000002e-08 67.450000000000003p 9.1171669999999998e-08 67.462500000000006p 8.879163e-08 67.475000000000009p 8.6299630000000006e-08 67.487499999999997p 8.3699180000000005e-08 67.5p 8.0993899999999998e-08
+ 67.512500000000003p 7.818757e-08 67.524999999999991p 7.528408e-08 67.537499999999994p 7.2287430000000002e-08 67.549999999999997p 6.9201760000000003e-08 67.5625p 6.6031299999999994e-08 67.575000000000003p 6.2780389999999996e-08 67.587500000000006p 5.9453459999999997e-08 67.600000000000009p 5.6055040000000001e-08 67.612499999999997p 5.258974e-08 67.625p 4.906225e-08 67.637500000000003p 4.547732e-08 67.649999999999991p 4.1839779999999999e-08 67.662499999999994p 3.8154519999999999e-08 67.674999999999997p 3.4426480000000001e-08 67.6875p 3.0660639999999997e-08 67.700000000000003p 2.6862009999999999e-08 67.712500000000006p 2.3035659999999999e-08 67.725000000000009p 1.9186669999999999e-08
+ 67.737499999999997p 1.5320139999999999e-08 67.75p 1.1441169999999999e-08 67.762500000000003p 7.5548819999999993e-09 67.775000000000006p 3.6663969999999999e-09 67.787499999999994p -2.1918120000000001e-10 67.799999999999997p -4.0967590000000003e-09 67.8125p -7.9612659999999997e-09 67.825000000000003p -1.180766e-08 67.837500000000006p -1.563093e-08 67.850000000000009p -1.942611e-08 67.862499999999997p -2.3188279999999999e-08 67.875p -2.6912579999999999e-08 67.887500000000003p -3.05942e-08 67.900000000000006p -3.4228400000000002e-08 67.912499999999994p -3.7810519999999999e-08 67.924999999999997p -4.1335969999999997e-08 67.9375p -4.4800249999999998e-08 67.949999999999989p -4.8198940000000001e-08
+ 67.962500000000006p -5.1527730000000003e-08 67.975000000000009p -5.4782400000000002e-08 67.987499999999997p -5.7958850000000002e-08 68p -6.105307e-08 68.012500000000003p -6.4061189999999995e-08 68.025000000000006p -6.6979440000000002e-08 68.037499999999994p -6.9804200000000005e-08 68.049999999999997p -7.2531960000000004e-08 68.0625p -7.5159350000000004e-08 68.074999999999989p -7.7683149999999996e-08 68.087500000000006p -8.0100269999999996e-08 68.100000000000009p -8.2407759999999995e-08 68.112499999999997p -8.4602850000000005e-08 68.125p -8.6682900000000004e-08 68.137500000000003p -8.8645429999999995e-08 68.150000000000006p -9.0488109999999998e-08 68.162499999999994p -9.2208789999999995e-08 68.174999999999997p -9.3805490000000003e-08
+ 68.1875p -9.5276359999999995e-08 68.199999999999989p -9.6619760000000004e-08 68.212499999999991p -9.7834190000000002e-08 68.225000000000009p -9.8918349999999998e-08 68.237500000000011p -9.9871090000000004e-08 68.25p -1.0069140000000001e-07 68.262500000000003p -1.013786e-07 68.275000000000006p -1.01932e-07 68.287499999999994p -1.0235110000000001e-07 68.299999999999997p -1.026358e-07 68.3125p -1.0278579999999999e-07 68.324999999999989p -1.028014e-07 68.337499999999991p -1.026827e-07 68.350000000000009p -1.024303e-07 68.362500000000011p -1.020446e-07 68.375p -1.015266e-07 68.387500000000003p -1.008771e-07 68.400000000000006p -1.0009739999999999e-07
+ 68.412499999999994p -9.9188570000000004e-08 68.424999999999997p -9.8152230000000005e-08 68.4375p -9.6989950000000001e-08 68.449999999999989p -9.5703529999999997e-08 68.462499999999991p -9.4294900000000006e-08 68.474999999999994p -9.2766159999999996e-08 68.487500000000011p -9.1119560000000003e-08 68.5p -8.9357509999999995e-08 68.512500000000003p -8.7482530000000006e-08 68.525000000000006p -8.5497329999999994e-08 68.537499999999994p -8.3404720000000001e-08 68.549999999999997p -8.1207660000000006e-08 68.5625p -7.8909240000000006e-08 68.575000000000003p -7.6512669999999999e-08 68.587499999999991p -7.4021290000000005e-08 68.599999999999994p -7.1438539999999994e-08 68.612500000000011p -6.8767990000000001e-08 68.625p -6.60133e-08
+ 68.637500000000003p -6.3178260000000002e-08 68.650000000000006p -6.0266719999999996e-08 68.662499999999994p -5.7282640000000002e-08 68.674999999999997p -5.4230080000000002e-08 68.6875p -5.1113149999999997e-08 68.700000000000003p -4.7936050000000003e-08 68.712499999999991p -4.4703070000000002e-08 68.724999999999994p -4.1418520000000001e-08 68.737500000000011p -3.8086810000000001e-08 68.75p -3.4712380000000002e-08 68.762500000000003p -3.1299710000000003e-08 68.775000000000006p -2.7853340000000001e-08 68.787499999999994p -2.437784e-08 68.799999999999997p -2.0877789999999999e-08 68.8125p -1.7357820000000001e-08 68.825000000000003p -1.382255e-08 68.837499999999991p -1.0276629999999999e-08 68.849999999999994p -6.7247009999999996e-09
+ 68.862499999999997p -3.1714109999999998e-09 68.875p 3.786058e-10 68.887500000000003p 3.9207260000000003e-09 68.900000000000006p 7.4503490000000001e-09 68.912500000000009p 1.09629e-08 68.924999999999997p 1.445383e-08 68.9375p 1.7918630000000001e-08 68.950000000000003p 2.1352850000000001e-08 68.962499999999991p 2.4752070000000001e-08 68.974999999999994p 2.8111930000000001e-08 68.987499999999997p 3.1428129999999997e-08 69p 3.4696440000000003e-08 69.012500000000003p 3.79127e-08 69.025000000000006p 4.1072820000000002e-08 69.037500000000009p 4.417281e-08 69.049999999999997p 4.7208739999999999e-08 69.0625p 5.0176800000000002e-08 69.075000000000003p 5.3073259999999998e-08
+ 69.087499999999991p 5.5894490000000001e-08 69.099999999999994p 5.8636970000000001e-08 69.112499999999997p 6.1297290000000003e-08 69.125p 6.3872160000000002e-08 69.137500000000003p 6.6358409999999996e-08 69.150000000000006p 6.8752970000000004e-08 69.162500000000009p 7.1052919999999995e-08 69.174999999999997p 7.3255460000000004e-08 69.1875p 7.5357930000000003e-08 69.200000000000003p 7.7357799999999999e-08 69.212499999999991p 7.9252680000000006e-08 69.224999999999994p 8.1040319999999999e-08 69.237499999999997p 8.2718619999999999e-08 69.25p 8.4285620000000002e-08 69.262500000000003p 8.5739530000000001e-08 69.275000000000006p 8.7078689999999996e-08 69.287500000000009p 8.8301590000000001e-08 69.299999999999997p 8.9406889999999999e-08
+ 69.3125p 9.0393419999999996e-08 69.325000000000003p 9.1260119999999996e-08 69.337499999999991p 9.2006140000000002e-08 69.349999999999994p 9.2630759999999994e-08 69.362499999999997p 9.3133430000000002e-08 69.375p 9.3513760000000002e-08 69.387500000000003p 9.3771530000000003e-08 69.400000000000006p 9.3906649999999996e-08 69.412500000000009p 9.3919219999999999e-08 69.424999999999997p 9.3809500000000004e-08 69.4375p 9.3577890000000004e-08 69.450000000000003p 9.322497e-08 69.462499999999991p 9.2751459999999996e-08 69.474999999999994p 9.2158239999999994e-08 69.487499999999997p 9.1446360000000006e-08 69.5p 9.061699e-08 69.512500000000003p 8.9671499999999997e-08 69.525000000000006p 8.8611359999999994e-08
+ 69.537500000000009p 8.7438209999999999e-08 69.549999999999997p 8.6153839999999994e-08 69.5625p 8.4760169999999994e-08 69.575000000000003p 8.3259249999999998e-08 69.587499999999991p 8.16533e-08 69.599999999999994p 7.9944639999999997e-08 69.612499999999997p 7.8135730000000006e-08 69.625p 7.6229150000000002e-08 69.637500000000003p 7.4227609999999996e-08 69.650000000000006p 7.2133950000000006e-08 69.662500000000009p 6.9951089999999998e-08 69.674999999999997p 6.7682090000000006e-08 69.6875p 6.5330099999999995e-08 69.700000000000003p 6.2898389999999997e-08 69.712500000000006p 6.0390300000000003e-08 69.724999999999994p 5.7809280000000002e-08 69.737499999999997p 5.5158870000000003e-08 69.75p 5.2442679999999999e-08
+ 69.762499999999989p 4.9664409999999999e-08 69.775000000000006p 4.6827820000000003e-08 69.787500000000009p 4.3936760000000001e-08 69.799999999999997p 4.0995109999999999e-08 69.8125p 3.8006830000000003e-08 69.825000000000003p 3.4975940000000002e-08 69.837500000000006p 3.1906469999999999e-08 69.849999999999994p 2.8802539999999999e-08 69.862499999999997p 2.5668259999999999e-08 69.875p 2.2507800000000001e-08 69.887499999999989p 1.9325339999999999e-08 69.900000000000006p 1.6125079999999999e-08 69.912500000000009p 1.2911249999999999e-08 69.924999999999997p 9.6880610000000001e-09 69.9375p 6.4597489999999998e-09 69.950000000000003p 3.2305359999999999e-09 69.962500000000006p 4.6365290000000001e-12 69.974999999999994p -3.2137480000000002e-09
+ 69.987499999999997p -6.4204350000000003e-09 70p -9.6112690000000006e-09 70.012499999999989p -1.278212e-08 70.025000000000006p -1.5928910000000001e-08 70.037500000000009p -1.9047580000000001e-08 70.050000000000011p -2.213413e-08 70.0625p -2.5184599999999998e-08 70.075000000000003p -2.8195110000000001e-08 70.087500000000006p -3.116182e-08 70.099999999999994p -3.408096e-08 70.112499999999997p -3.6948839999999997e-08 70.125p -3.9761839999999998e-08 70.137499999999989p -4.251641e-08 70.149999999999991p -4.520911e-08 70.162500000000009p -4.7836559999999999e-08 70.175000000000011p -5.0395500000000003e-08 70.1875p -5.2882740000000001e-08 70.200000000000003p -5.5295219999999997e-08
+ 70.212500000000006p -5.7629960000000001e-08 70.224999999999994p -5.9884100000000001e-08 70.237499999999997p -6.2054889999999994e-08 70.25p -6.4139709999999997e-08 70.262499999999989p -6.6136029999999994e-08 70.274999999999991p -6.8041459999999995e-08 70.287500000000009p -6.9853729999999998e-08 70.300000000000011p -7.1570699999999996e-08 70.3125p -7.3190349999999995e-08 70.325000000000003p -7.4710809999999999e-08 70.337500000000006p -7.613033e-08 70.349999999999994p -7.7447289999999998e-08 70.362499999999997p -7.8660230000000005e-08 70.375p -7.9767800000000006e-08 70.387500000000003p -8.0768809999999999e-08 70.399999999999991p -8.1662219999999998e-08 70.412499999999994p -8.2447109999999999e-08 70.425000000000011p -8.3122710000000003e-08
+ 70.4375p -8.3688410000000006e-08 70.450000000000003p -8.4143730000000002e-08 70.462500000000006p -8.4488330000000001e-08 70.474999999999994p -8.4722029999999999e-08 70.487499999999997p -8.4844789999999996e-08 70.5p -8.4856719999999994e-08 70.512500000000003p -8.4758050000000006e-08 70.524999999999991p -8.4549189999999999e-08 70.537499999999994p -8.4230660000000006e-08 70.550000000000011p -8.3803150000000001e-08 70.5625p -8.3267460000000001e-08 70.575000000000003p -8.2624560000000006e-08 70.587500000000006p -8.187553e-08 70.599999999999994p -8.1021609999999997e-08 70.612499999999997p -8.0064160000000006e-08 70.625p -7.9004670000000006e-08 70.637500000000003p -7.7844770000000006e-08 70.649999999999991p -7.6586210000000002e-08
+ 70.662499999999994p -7.5230869999999999e-08 70.674999999999997p -7.3780740000000001e-08 70.6875p -7.2237939999999995e-08 70.700000000000003p -7.06047e-08 70.712500000000006p -6.8883370000000001e-08 70.724999999999994p -6.7076410000000003e-08 70.737499999999997p -6.5186370000000004e-08 70.75p -6.3215920000000003e-08 70.762500000000003p -6.1167820000000004e-08 70.774999999999991p -5.9044930000000001e-08 70.787499999999994p -5.68502e-08 70.799999999999997p -5.4586660000000002e-08 70.8125p -5.2257430000000001e-08 70.825000000000003p -4.9865709999999998e-08 70.837500000000006p -4.7414760000000001e-08 70.850000000000009p -4.4907940000000002e-08 70.862499999999997p -4.2348640000000002e-08 70.875p -3.9740330000000003e-08
+ 70.887500000000003p -3.7086539999999999e-08 70.899999999999991p -3.4390829999999999e-08 70.912499999999994p -3.1656839999999999e-08 70.924999999999997p -2.8888220000000001e-08 70.9375p -2.608867e-08 70.950000000000003p -2.3261930000000001e-08 70.962500000000006p -2.0411750000000001e-08 70.975000000000009p -1.754192e-08 70.987499999999997p -1.465622e-08 71p -1.1758479999999999e-08 71.012500000000003p -8.8525069999999999e-09 71.024999999999991p -5.9421220000000004e-09 71.037499999999994p -3.0311409999999998e-09 71.049999999999997p -1.2337390000000001e-10 71.0625p 2.7773839999999998e-09 71.075000000000003p 5.6673559999999997e-09 71.087500000000006p 8.5427850000000001e-09 71.100000000000009p 1.139994e-08
+ 71.112499999999997p 1.423514e-08 71.125p 1.7044699999999998e-08 71.137500000000003p 1.982503e-08 71.149999999999991p 2.2572549999999999e-08 71.162499999999994p 2.528373e-08 71.174999999999997p 2.795513e-08 71.1875p 3.0583319999999999e-08 71.200000000000003p 3.316498e-08 71.212500000000006p 3.5696820000000001e-08 71.225000000000009p 3.8175669999999998e-08 71.237499999999997p 4.0598379999999999e-08 71.25p 4.2961919999999999e-08 71.262500000000003p 4.5263340000000002e-08 71.274999999999991p 4.7499759999999998e-08 71.287499999999994p 4.966842e-08 71.299999999999997p 5.1766620000000001e-08 71.3125p 5.3791779999999999e-08 71.325000000000003p 5.5741430000000001e-08
+ 71.337500000000006p 5.7613190000000002e-08 71.350000000000009p 5.9404779999999998e-08 71.362499999999997p 6.1114060000000006e-08 71.375p 6.2738970000000001e-08 71.387500000000003p 6.427758e-08 71.399999999999991p 6.5728080000000004e-08 71.412499999999994p 6.7088779999999995e-08 71.424999999999997p 6.8358109999999998e-08 71.4375p 6.9534620000000005e-08 71.450000000000003p 7.0616990000000006e-08 71.462500000000006p 7.1604020000000004e-08 71.475000000000009p 7.2494650000000003e-08 71.487499999999997p 7.3287939999999995e-08 71.5p 7.3983069999999997e-08 71.512500000000003p 7.4579389999999994e-08 71.525000000000006p 7.5076329999999996e-08 71.537499999999994p 7.5473479999999998e-08 71.549999999999997p 7.5770569999999999e-08
+ 71.5625p 7.5967440000000003e-08 71.575000000000003p 7.6064089999999994e-08 71.587500000000006p 7.6060609999999997e-08 71.600000000000009p 7.595726e-08 71.612499999999997p 7.5754420000000006e-08 71.625p 7.5452590000000002e-08 71.637500000000003p 7.5052409999999994e-08 71.650000000000006p 7.4554649999999996e-08 71.662499999999994p 7.3960189999999996e-08 71.674999999999997p 7.327006e-08 71.6875p 7.2485380000000006e-08 71.699999999999989p 7.1607420000000002e-08 71.712500000000006p 7.0637570000000002e-08 71.725000000000009p 6.9577329999999994e-08 71.737499999999997p 6.8428290000000002e-08 71.75p 6.7192210000000004e-08 71.762500000000003p 6.5870900000000003e-08 71.775000000000006p 6.4466329999999996e-08
+ 71.787499999999994p 6.2980530000000002e-08 71.799999999999997p 6.1415670000000006e-08 71.8125p 5.9773990000000006e-08 71.824999999999989p 5.8057839999999998e-08 71.837500000000006p 5.6269659999999998e-08 71.850000000000009p 5.4411990000000001e-08 71.862500000000011p 5.2487429999999997e-08 71.875p 5.0498679999999998e-08 71.887500000000003p 4.8448519999999998e-08 71.900000000000006p 4.6339790000000003e-08 71.912499999999994p 4.4175419999999998e-08 71.924999999999997p 4.195838e-08 71.9375p 3.9691739999999999e-08 71.949999999999989p 3.7378579999999999e-08 71.962499999999991p 3.5022069999999997e-08 71.975000000000009p 3.2625419999999998e-08 71.987500000000011p 3.0191879999999998e-08 72p 2.7724740000000002e-08
+ 72.012500000000003p 2.5227340000000001e-08 72.025000000000006p 2.2703040000000001e-08 72.037499999999994p 2.0155220000000001e-08 72.049999999999997p 1.758729e-08 72.0625p 1.5002689999999999e-08 72.074999999999989p 1.2404859999999999e-08 72.087499999999991p 9.7972560000000005e-09 72.100000000000009p 7.1833240000000004e-09 72.112500000000011p 4.5665259999999999e-09 72.125p 1.9503119999999999e-09 72.137500000000003p -6.618758e-10 72.150000000000006p -3.2666079999999999e-09 72.162499999999994p -5.8604760000000004e-09 72.174999999999997p -8.4400910000000007e-09 72.1875p -1.100209e-08 72.199999999999989p -1.3543160000000001e-08 72.212499999999991p -1.605999e-08 72.224999999999994p -1.8549329999999999e-08
+ 72.237500000000011p -2.1007979999999999e-08 72.25p -2.3432770000000002e-08 72.262500000000003p -2.5820600000000002e-08 72.275000000000006p -2.816841e-08 72.287499999999994p -3.0473220000000002e-08 72.299999999999997p -3.2732099999999997e-08 72.3125p -3.4942180000000001e-08 72.325000000000003p -3.710068e-08 72.337499999999991p -3.9204889999999997e-08 72.349999999999994p -4.1252160000000002e-08 72.362500000000011p -4.3239949999999999e-08 72.375p -4.5165790000000001e-08 72.387500000000003p -4.7027290000000001e-08 72.400000000000006p -4.882215e-08 72.412499999999994p -5.0548189999999998e-08 72.424999999999997p -5.2203299999999997e-08 72.4375p -5.3785480000000002e-08 72.450000000000003p -5.5292810000000003e-08
+ 72.462499999999991p -5.6723510000000002e-08 72.474999999999994p -5.8075870000000002e-08 72.487500000000011p -5.9348299999999999e-08 72.5p -6.0539330000000003e-08 72.512500000000003p -6.1647590000000005e-08 72.525000000000006p -6.2671810000000006e-08 72.537499999999994p -6.3610859999999995e-08 72.549999999999997p -6.4463709999999994e-08 72.5625p -6.5229440000000003e-08 72.575000000000003p -6.5907250000000003e-08 72.587499999999991p -6.649647e-08 72.599999999999994p -6.6996530000000003e-08 72.612499999999997p -6.7406990000000006e-08 72.625p -6.7727529999999998e-08 72.637500000000003p -6.7957930000000003e-08 72.650000000000006p -6.8098109999999994e-08 72.662500000000009p -6.8148109999999998e-08 72.674999999999997p -6.8108059999999996e-08
+ 72.6875p -6.7978249999999995e-08 72.700000000000003p -6.7759040000000004e-08 72.712499999999991p -6.7450950000000004e-08 72.724999999999994p -6.7054589999999996e-08 72.737499999999997p -6.6570679999999998e-08 72.75p -6.6000079999999994e-08 72.762500000000003p -6.5343730000000006e-08 72.775000000000006p -6.4602699999999997e-08 72.787500000000009p -6.3778169999999998e-08 72.799999999999997p -6.2871419999999996e-08 72.8125p -6.1883819999999996e-08 72.825000000000003p -6.0816869999999999e-08 72.837499999999991p -5.9672160000000005e-08 72.849999999999994p -5.8451369999999997e-08 72.862499999999997p -5.7156289999999999e-08 72.875p -5.5788789999999997e-08 72.887500000000003p -5.4350839999999997e-08 72.900000000000006p -5.2844489999999997e-08
+ 72.912500000000009p -5.1271879999999999e-08 72.924999999999997p -4.9635239999999998e-08 72.9375p -4.7936860000000003e-08 72.950000000000003p -4.6179110000000001e-08 72.962499999999991p -4.436446e-08 72.974999999999994p -4.2495410000000003e-08 72.987499999999997p -4.057455e-08 73p -3.860452e-08 73.012500000000003p -3.6588020000000003e-08 73.025000000000006p -3.4527830000000002e-08 73.037500000000009p -3.242674e-08 73.049999999999997p -3.0287610000000001e-08 73.0625p -2.8113340000000001e-08 73.075000000000003p -2.590688e-08 73.087499999999991p -2.3671200000000002e-08 73.099999999999994p -2.140931e-08 73.112499999999997p -1.912424e-08 73.125p -1.6819059999999999e-08
+ 73.137500000000003p -1.4496829999999999e-08 73.150000000000006p -1.216067e-08 73.162500000000009p -9.8136710000000004e-09 73.174999999999997p -7.4589499999999998e-09 73.1875p -5.0996240000000003e-09 73.200000000000003p -2.7388109999999999e-09 73.212499999999991p -3.7962290000000002e-10 73.224999999999994p 1.974838e-09 73.237499999999997p 4.3214800000000003e-09 73.25p 6.6572309999999997e-09 73.262500000000003p 8.9790379999999994e-09 73.275000000000006p 1.128387e-08 73.287500000000009p 1.356874e-08 73.299999999999997p 1.5830659999999999e-08 73.3125p 1.8066719999999999e-08 73.325000000000003p 2.027402e-08 73.337499999999991p 2.2449709999999999e-08 73.349999999999994p 2.4591010000000002e-08
+ 73.362499999999997p 2.669515e-08 73.375p 2.8759450000000001e-08 73.387500000000003p 3.0781270000000003e-08 73.400000000000006p 3.2758040000000001e-08 73.412500000000009p 3.4687249999999998e-08 73.424999999999997p 3.6566459999999999e-08 73.4375p 3.8393300000000001e-08 73.450000000000003p 4.0165459999999997e-08 73.462500000000006p 4.1880739999999999e-08 73.474999999999994p 4.3536989999999998e-08 73.487499999999997p 4.5132160000000001e-08 73.5p 4.6664259999999997e-08 73.512499999999989p 4.8131410000000001e-08 73.525000000000006p 4.9531819999999999e-08 73.537500000000009p 5.0863780000000001e-08 73.549999999999997p 5.212567e-08 73.5625p 5.3315979999999999e-08 73.575000000000003p 5.4433299999999998e-08
+ 73.587500000000006p 5.5476300000000003e-08 73.599999999999994p 5.6443749999999999e-08 73.612499999999997p 5.7334560000000002e-08 73.625p 5.8147689999999999e-08 73.637499999999989p 5.8882240000000001e-08 73.650000000000006p 5.9537400000000001e-08 73.662500000000009p 6.0112479999999997e-08 73.674999999999997p 6.0606890000000006e-08 73.6875p 6.1020140000000005e-08 73.700000000000003p 6.1351850000000004e-08 73.712500000000006p 6.1601760000000001e-08 73.724999999999994p 6.1769709999999997e-08 73.737499999999997p 6.1855649999999996e-08 73.75p 6.1859629999999994e-08 73.762499999999989p 6.1781819999999999e-08 73.774999999999991p 6.1622489999999998e-08 73.787500000000009p 6.1382020000000006e-08 73.800000000000011p 6.1060909999999998e-08
+ 73.8125p 6.0659730000000002e-08 73.825000000000003p 6.0179180000000004e-08 73.837500000000006p 5.9620070000000003e-08 73.849999999999994p 5.8983289999999999e-08 73.862499999999997p 5.8269849999999997e-08 73.875p 5.7480839999999999e-08 73.887499999999989p 5.6617470000000001e-08 73.899999999999991p 5.5681020000000001e-08 73.912500000000009p 5.4672879999999997e-08 73.925000000000011p 5.359453e-08 73.9375p 5.2447550000000003e-08 73.950000000000003p 5.1233579999999999e-08 73.962500000000006p 4.9954360000000001e-08 73.974999999999994p 4.8611729999999999e-08 73.987499999999997p 4.7207569999999997e-08 74p 4.5743879999999997e-08 74.012499999999989p 4.4222700000000002e-08 74.024999999999991p 4.2646169999999998e-08
+ 74.037500000000009p 4.1016460000000003e-08 74.050000000000011p 3.9335859999999997e-08 74.0625p 3.7606670000000001e-08 74.075000000000003p 3.5831280000000002e-08 74.087500000000006p 3.4012130000000002e-08 74.099999999999994p 3.2151710000000002e-08 74.112499999999997p 3.0252550000000002e-08 74.125p 2.8317239999999998e-08 74.137500000000003p 2.634841e-08 74.149999999999991p 2.4348729999999998e-08 74.162499999999994p 2.232089e-08 74.175000000000011p 2.0267630000000001e-08 74.1875p 1.8191709999999999e-08 74.200000000000003p 1.6095909999999998e-08 74.212500000000006p 1.398304e-08 74.224999999999994p 1.185591e-08 74.237499999999997p 9.7173650000000008e-09 74.25p 7.5702449999999996e-09
+ 74.262500000000003p 5.4173960000000003e-09 74.274999999999991p 3.2616680000000002e-09 74.287499999999994p 1.10591e-09 74.300000000000011p -1.047039e-09 74.3125p -3.1943459999999998e-09 74.325000000000003p -5.3331949999999998e-09 74.337500000000006p -7.4607840000000004e-09 74.349999999999994p -9.5743330000000005e-09 74.362499999999997p -1.167109e-08 74.375p -1.374832e-08 74.387500000000003p -1.5803329999999999e-08 74.399999999999991p -1.7833469999999999e-08 74.412499999999994p -1.9836099999999999e-08 74.424999999999997p -2.1808650000000001e-08 74.4375p -2.3748590000000001e-08 74.450000000000003p -2.565342e-08 74.462500000000006p -2.7520719999999999e-08 74.474999999999994p -2.9348090000000001e-08
+ 74.487499999999997p -3.1133220000000002e-08 74.5p -3.2873849999999999e-08 74.512500000000003p -3.4567779999999998e-08 74.524999999999991p -3.621287e-08 74.537499999999994p -3.7807060000000002e-08 74.549999999999997p -3.9348359999999998e-08 74.5625p -4.0834840000000003e-08 74.575000000000003p -4.2264679999999999e-08 74.587500000000006p -4.3636089999999997e-08 74.600000000000009p -4.4947409999999997e-08 74.612499999999997p -4.6197030000000003e-08 74.625p -4.738343e-08 74.637500000000003p -4.8505180000000001e-08 74.649999999999991p -4.9560939999999997e-08 74.662499999999994p -5.0549470000000002e-08 74.674999999999997p -5.1469589999999999e-08 74.6875p -5.2320239999999998e-08 74.700000000000003p -5.3100449999999997e-08
+ 74.712500000000006p -5.3809330000000002e-08 74.725000000000009p -5.4446100000000002e-08 74.737499999999997p -5.5010069999999997e-08 74.75p -5.550064e-08 74.762500000000003p -5.5917330000000003e-08 74.774999999999991p -5.6259739999999999e-08 74.787499999999994p -5.6527569999999997e-08 74.799999999999997p -5.6720630000000003e-08 74.8125p -5.6838799999999999e-08 74.825000000000003p -5.6882090000000002e-08 74.837500000000006p -5.6850589999999999e-08 74.850000000000009p -5.6744500000000002e-08 74.862499999999997p -5.6564109999999998e-08 74.875p -5.6309809999999998e-08 74.887500000000003p -5.5982079999999997e-08 74.899999999999991p -5.55815e-08 74.912499999999994p -5.5108739999999997e-08 74.924999999999997p -5.4564570000000001e-08
+ 74.9375p -5.3949850000000002e-08 74.950000000000003p -5.3265529999999998e-08 74.962500000000006p -5.251264e-08 74.975000000000009p -5.169232e-08 74.987499999999997p -5.0805769999999998e-08 75p -4.9854289999999997e-08 75.012500000000003p -4.8839249999999998e-08 75.024999999999991p -4.776212e-08 75.037499999999994p -4.6624440000000002e-08 75.049999999999997p -4.5427810000000001e-08 75.0625p -4.4173919999999997e-08 75.075000000000003p -4.2864530000000003e-08 75.087500000000006p -4.150147e-08 75.100000000000009p -4.0086630000000001e-08 75.112499999999997p -3.862196e-08 75.125p -3.7109499999999999e-08 75.137500000000003p -3.5551300000000002e-08 75.149999999999991p -3.3949509999999999e-08
+ 75.162499999999994p -3.2306300000000001e-08 75.174999999999997p -3.0623919999999998e-08 75.1875p -2.8904640000000001e-08 75.200000000000003p -2.7150779999999999e-08 75.212500000000006p -2.5364719999999999e-08 75.225000000000009p -2.354885e-08 75.237499999999997p -2.1705620000000001e-08 75.25p -1.9837469999999998e-08 75.262500000000003p -1.7946919999999999e-08 75.275000000000006p -1.603648e-08 75.287499999999994p -1.410868e-08 75.299999999999997p -1.216609e-08 75.3125p -1.021127e-08 75.325000000000003p -8.2468010000000004e-09 75.337500000000006p -6.2752799999999999e-09 75.350000000000009p -4.2992949999999999e-09 75.362499999999997p -2.3214389999999999e-09 75.375p -3.4430250000000001e-10
+ 75.387500000000003p 1.629531e-09 75.400000000000006p 3.5974879999999999e-09 75.412499999999994p 5.5570070000000003e-09 75.424999999999997p 7.5055420000000008e-09 75.4375p 9.4405679999999996e-09 75.449999999999989p 1.1359580000000001e-08 75.462500000000006p 1.326011e-08 75.475000000000009p 1.5139699999999999e-08 75.487499999999997p 1.699594e-08 75.5p 1.882646e-08 75.512500000000003p 2.06289e-08 75.525000000000006p 2.240097e-08 75.537499999999994p 2.4140410000000001e-08 75.549999999999997p 2.5845020000000001e-08 75.5625p 2.7512630000000001e-08 75.574999999999989p 2.9141150000000001e-08 75.587500000000006p 3.0728520000000003e-08 75.600000000000009p 3.2272759999999997e-08
+ 75.612500000000011p 3.3771920000000001e-08 75.625p 3.5224140000000003e-08 75.637500000000003p 3.6627609999999997e-08 75.650000000000006p 3.7980610000000002e-08 75.662499999999994p 3.9281449999999997e-08 75.674999999999997p 4.0528559999999997e-08 75.6875p 4.1720400000000001e-08 75.699999999999989p 4.2855529999999999e-08 75.712499999999991p 4.3932579999999999e-08 75.725000000000009p 4.4950259999999999e-08 75.737500000000011p 4.5907359999999998e-08 75.75p 4.6802749999999999e-08 75.762500000000003p 4.7635379999999998e-08 75.775000000000006p 4.8404290000000001e-08 75.787499999999994p 4.9108610000000001e-08 75.799999999999997p 4.9747540000000002e-08 75.8125p 5.0320379999999999e-08 75.824999999999989p 5.0826520000000002e-08
+ 75.837499999999991p 5.1265430000000001e-08 75.850000000000009p 5.1636670000000002e-08 75.862500000000011p 5.1939889999999999e-08 75.875p 5.2174830000000001e-08 75.887500000000003p 5.2341329999999998e-08 75.900000000000006p 5.24393e-08 75.912499999999994p 5.2468749999999998e-08 75.924999999999997p 5.242979e-08 75.9375p 5.2322600000000003e-08 75.949999999999989p 5.2147459999999998e-08 75.962499999999991p 5.1904739999999997e-08 75.974999999999994p 5.1594880000000001e-08 75.987500000000011p 5.1218439999999997e-08 76p 5.077603e-08 76.012500000000003p 5.0268370000000003e-08 76.025000000000006p 4.9696249999999997e-08 76.037499999999994p 4.9060550000000001e-08 76.049999999999997p 4.836223e-08
+ 76.0625p 4.7602320000000001e-08 76.075000000000003p 4.6781960000000002e-08 76.087499999999991p 4.5902310000000003e-08 76.099999999999994p 4.496467e-08 76.112500000000011p 4.3970370000000001e-08 76.125p 4.2920810000000003e-08 76.137500000000003p 4.1817490000000001e-08 76.150000000000006p 4.0661959999999998e-08 76.162499999999994p 3.9455820000000002e-08 76.174999999999997p 3.8200760000000002e-08 76.1875p 3.6898510000000001e-08 76.200000000000003p 3.5550869999999997e-08 76.212499999999991p 3.4159690000000003e-08 76.224999999999994p 3.2726880000000001e-08 76.237500000000011p 3.1254379999999999e-08 76.25p 2.9744209999999999e-08 76.262500000000003p 2.8198400000000001e-08 76.275000000000006p 2.6619050000000001e-08
+ 76.287499999999994p 2.5008290000000001e-08 76.299999999999997p 2.3368280000000001e-08 76.3125p 2.1701220000000001e-08 76.325000000000003p 2.000934e-08 76.337499999999991p 1.8294900000000001e-08 76.349999999999994p 1.6560169999999999e-08 76.362499999999997p 1.4807470000000001e-08 76.375p 1.303912e-08 76.387500000000003p 1.1257450000000001e-08 76.400000000000006p 9.4648049999999998e-09 76.412500000000009p 7.6635560000000007e-09 76.424999999999997p 5.8560620000000004e-09 76.4375p 4.0446940000000001e-09 76.450000000000003p 2.231818e-09 76.462499999999991p 4.1979919999999999e-10 76.474999999999994p -1.389003e-09 76.487499999999997p -3.1922389999999998e-09 76.5p -4.9875719999999998e-09
+ 76.512500000000003p -6.7726809999999997e-09 76.525000000000006p -8.5452620000000006e-09 76.537500000000009p -1.0303029999999999e-08 76.549999999999997p -1.204374e-08 76.5625p -1.3765149999999999e-08 76.575000000000003p -1.5465049999999999e-08 76.587499999999991p -1.7141300000000001e-08 76.599999999999994p -1.879175e-08 76.612499999999997p -2.041431e-08 76.625p -2.2006920000000001e-08 76.637500000000003p -2.3567590000000001e-08 76.650000000000006p -2.5094339999999999e-08 76.662500000000009p -2.658526e-08 76.674999999999997p -2.803849e-08 76.6875p -2.9452219999999999e-08 76.700000000000003p -3.0824699999999997e-08 76.712499999999991p -3.2154220000000002e-08 76.724999999999994p -3.3439159999999997e-08
+ 76.737499999999997p -3.4677929999999999e-08 76.75p -3.5869029999999998e-08 76.762500000000003p -3.7011010000000003e-08 76.775000000000006p -3.8102489999999997e-08 76.787500000000009p -3.9142159999999999e-08 76.799999999999997p -4.0128779999999998e-08 76.8125p -4.1061190000000001e-08 76.825000000000003p -4.1938279999999998e-08 76.837499999999991p -4.2759050000000002e-08 76.849999999999994p -4.3522550000000001e-08 76.862499999999997p -4.4227910000000002e-08 76.875p -4.4874339999999998e-08 76.887500000000003p -4.5461139999999998e-08 76.900000000000006p -4.5987659999999999e-08 76.912500000000009p -4.6453360000000001e-08 76.924999999999997p -4.6857770000000001e-08 76.9375p -4.72005e-08 76.950000000000003p -4.7481230000000001e-08
+ 76.962499999999991p -4.7699749999999997e-08 76.974999999999994p -4.785591e-08 76.987499999999997p -4.794964e-08 77p -4.7980959999999998e-08 77.012500000000003p -4.794997e-08 77.025000000000006p -4.7856850000000001e-08 77.037500000000009p -4.7701860000000001e-08 77.049999999999997p -4.7485340000000001e-08 77.0625p -4.7207710000000002e-08 77.075000000000003p -4.6869460000000002e-08 77.087499999999991p -4.6471179999999998e-08 77.099999999999994p -4.6013519999999997e-08 77.112499999999997p -4.5497210000000001e-08 77.125p -4.4923050000000001e-08 77.137500000000003p -4.4291910000000002e-08 77.150000000000006p -4.3604760000000002e-08 77.162500000000009p -4.2862600000000003e-08 77.174999999999997p -4.2066529999999998e-08
+ 77.1875p -4.1217709999999999e-08 77.200000000000003p -4.0317359999999999e-08 77.212500000000006p -3.9366760000000001e-08 77.224999999999994p -3.8367279999999999e-08 77.237499999999997p -3.7320320000000002e-08 77.25p -3.6227350000000003e-08 77.262499999999989p -3.5089890000000003e-08 77.275000000000006p -3.3909540000000003e-08 77.287500000000009p -3.2687920000000002e-08 77.299999999999997p -3.1426710000000001e-08 77.3125p -3.0127649999999998e-08 77.325000000000003p -2.8792520000000001e-08 77.337500000000006p -2.7423129999999999e-08 77.349999999999994p -2.6021340000000001e-08 77.362499999999997p -2.4589059999999999e-08 77.375p -2.3128220000000001e-08 77.387499999999989p -2.1640780000000001e-08 77.400000000000006p -2.0128740000000001e-08
+ 77.412500000000009p -1.8594119999999999e-08 77.424999999999997p -1.7038980000000001e-08 77.4375p -1.5465389999999998e-08 77.450000000000003p -1.387543e-08 77.462500000000006p -1.227121e-08 77.474999999999994p -1.065486e-08 77.487499999999997p -9.0285110000000006e-09 77.5p -7.3942940000000001e-09 77.512499999999989p -5.7543609999999999e-09 77.524999999999991p -4.1108590000000001e-09 77.537500000000009p -2.4659359999999998e-09 77.550000000000011p -8.2173669999999998e-10 77.5625p 8.195989e-10 77.575000000000003p 2.455941e-09 77.587500000000006p 4.0851700000000003e-09 77.599999999999994p 5.7051799999999999e-09 77.612499999999997p 7.3138849999999999e-09 77.625p 8.9092149999999996e-09
+ 77.637499999999989p 1.0489120000000001e-08 77.649999999999991p 1.2051589999999999e-08 77.662500000000009p 1.359462e-08 77.675000000000011p 1.5116240000000002e-08 77.6875p 1.6614539999999999e-08 77.700000000000003p 1.8087600000000001e-08 77.712500000000006p 1.953357e-08 77.724999999999994p 2.0950640000000001e-08 77.737499999999997p 2.233701e-08 77.75p 2.3690960000000001e-08 77.762499999999989p 2.5010800000000001e-08 77.774999999999991p 2.6294899999999999e-08 77.787500000000009p 2.754165e-08 77.800000000000011p 2.8749540000000002e-08 77.8125p 2.9917060000000002e-08 77.825000000000003p 3.1042810000000001e-08 77.837500000000006p 3.21254e-08 77.849999999999994p 3.3163539999999997e-08
+ 77.862499999999997p 3.4155970000000002e-08 77.875p 3.5101519999999998e-08 77.887500000000003p 3.599905e-08 77.899999999999991p 3.6847519999999999e-08 77.912499999999994p 3.7645939999999999e-08 77.925000000000011p 3.839338e-08 77.9375p 3.9088989999999997e-08 77.950000000000003p 3.9732000000000001e-08 77.962500000000006p 4.0321690000000002e-08 77.974999999999994p 4.0857409999999998e-08 77.987499999999997p 4.1338609999999999e-08 78p 4.176478e-08 78.012500000000003p 4.2135509999999997e-08 78.024999999999991p 4.2450440000000001e-08 78.037499999999994p 4.2709299999999999e-08 78.050000000000011p 4.2911880000000002e-08 78.0625p 4.3058070000000003e-08 78.075000000000003p 4.3147810000000003e-08
+ 78.087500000000006p 4.3181110000000003e-08 78.099999999999994p 4.3158080000000001e-08 78.112499999999997p 4.307888e-08 78.125p 4.2943749999999997e-08 78.137500000000003p 4.2753010000000002e-08 78.149999999999991p 4.2507039999999998e-08 78.162499999999994p 4.220631e-08 78.174999999999997p 4.1851330000000001e-08 78.1875p 4.1442710000000003e-08 78.200000000000003p 4.0981109999999997e-08 78.212500000000006p 4.0467259999999998e-08 78.225000000000009p 3.9901969999999999e-08 78.237499999999997p 3.9286110000000001e-08 78.25p 3.8620599999999997e-08 78.262500000000003p 3.790643e-08 78.274999999999991p 3.714467e-08 78.287499999999994p 3.6336419999999997e-08 78.299999999999997p 3.5482860000000003e-08
+ 78.3125p 3.4585210000000002e-08 78.325000000000003p 3.3644759999999997e-08 78.337500000000006p 3.2662849999999998e-08 78.350000000000009p 3.164086e-08 78.362499999999997p 3.058023e-08 78.375p 2.948244e-08 78.387500000000003p 2.8349020000000001e-08 78.399999999999991p 2.718154e-08 78.412499999999994p 2.5981619999999999e-08 78.424999999999997p 2.4750909999999999e-08 78.4375p 2.3491080000000001e-08 78.450000000000003p 2.220387e-08 78.462500000000006p 2.0891030000000001e-08 78.475000000000009p 1.955433e-08 78.487499999999997p 1.8195590000000001e-08 78.5p 1.6816639999999999e-08 78.512500000000003p 1.541933e-08 78.524999999999991p 1.400555e-08
+ 78.537499999999994p 1.257717e-08 78.549999999999997p 1.113611e-08 78.5625p 9.6842859999999994e-09 78.575000000000003p 8.223622e-09 78.587500000000006p 6.7560529999999998e-09 78.600000000000009p 5.2835179999999997e-09 78.612499999999997p 3.8079560000000001e-09 78.625p 2.3313070000000002e-09 78.637500000000003p 8.555052e-10 78.649999999999991p -6.1751890000000001e-10 78.662499999999994p -2.0858439999999999e-09 78.674999999999997p -3.547561e-09 78.6875p -5.0007710000000002e-09 78.700000000000003p -6.4435949999999996e-09 78.712500000000006p -7.8741680000000005e-09 78.725000000000009p -9.2906509999999999e-09 78.737499999999997p -1.069122e-08 78.75p -1.207409e-08
+ 78.762500000000003p -1.3437490000000001e-08 78.774999999999991p -1.477968e-08 78.787499999999994p -1.6098960000000001e-08 78.799999999999997p -1.7393660000000001e-08 78.8125p -1.866215e-08 78.825000000000003p -1.9902829999999998e-08 78.837500000000006p -2.1114150000000001e-08 78.850000000000009p -2.229459e-08 78.862499999999997p -2.3442690000000001e-08 78.875p -2.4557019999999999e-08 78.887500000000003p -2.5636219999999999e-08 78.899999999999991p -2.6678950000000001e-08 78.912499999999994p -2.7683949999999999e-08 78.924999999999997p -2.8649989999999999e-08 78.9375p -2.9575900000000001e-08 78.950000000000003p -3.0460569999999999e-08 78.962500000000006p -3.130296e-08 78.975000000000009p -3.2102050000000001e-08
+ 78.987499999999997p -3.2856920000000002e-08 79p -3.3566689999999999e-08 79.012500000000003p -3.423053e-08 79.025000000000006p -3.4847699999999999e-08 79.037499999999994p -3.5417510000000003e-08 79.049999999999997p -3.5939330000000001e-08 79.0625p -3.6412589999999998e-08 79.075000000000003p -3.6836799999999997e-08 79.087500000000006p -3.7211520000000002e-08 79.100000000000009p -3.7536400000000001e-08 79.112499999999997p -3.7811119999999999e-08 79.125p -3.8035459999999997e-08 79.137500000000003p -3.8209239999999999e-08 79.150000000000006p -3.8332379999999997e-08 79.162499999999994p -3.8404820000000001e-08 79.174999999999997p -3.8426609999999999e-08 79.1875p -3.8397850000000003e-08 79.199999999999989p -3.8318699999999998e-08
+ 79.212500000000006p -3.8189380000000001e-08 79.225000000000009p -3.8010210000000002e-08 79.237499999999997p -3.778152e-08 79.25p -3.7503759999999999e-08 79.262500000000003p -3.7177410000000001e-08 79.275000000000006p -3.6803009999999999e-08 79.287499999999994p -3.6381190000000001e-08 79.299999999999997p -3.5912599999999997e-08 79.3125p -3.5397990000000001e-08 79.324999999999989p -3.4838140000000002e-08 79.337500000000006p -3.4233909999999998e-08 79.350000000000009p -3.3586190000000001e-08 79.362500000000011p -3.2895950000000003e-08 79.375p -3.21642e-08 79.387500000000003p -3.1391989999999998e-08 79.400000000000006p -3.0580460000000001e-08 79.412499999999994p -2.973076e-08 79.424999999999997p -2.8844099999999999e-08
+ 79.4375p -2.792173e-08 79.449999999999989p -2.6964970000000001e-08 79.462499999999991p -2.5975150000000001e-08 79.475000000000009p -2.495366e-08 79.487500000000011p -2.3901909999999999e-08 79.5p -2.2821359999999999e-08 79.512500000000003p -2.1713510000000001e-08 79.525000000000006p -2.0579880000000001e-08 79.537499999999994p -1.942202e-08 79.549999999999997p -1.8241520000000001e-08 79.5625p -1.7039989999999999e-08 79.574999999999989p -1.581905e-08 79.587499999999991p -1.4580359999999999e-08 79.600000000000009p -1.332559e-08 79.612500000000011p -1.205644e-08 79.625p -1.077461e-08 79.637500000000003p -9.481823e-09 79.650000000000006p -8.1797989999999999e-09
+ 79.662499999999994p -6.8702790000000001e-09 79.674999999999997p -5.5550060000000002e-09 79.6875p -4.2357249999999999e-09 79.699999999999989p -2.914184e-09 79.712499999999991p -1.5921290000000001e-09 79.724999999999994p -2.7130339999999998e-10 79.737500000000011p 1.0465559999999999e-09 79.75p 2.3597200000000002e-09 79.762500000000003p 3.6664700000000001e-09 79.775000000000006p 4.9650979999999999e-09 79.787499999999994p 6.2539120000000002e-09 79.799999999999997p 7.5312369999999992e-09 79.8125p 8.7954169999999993e-09 79.825000000000003p 1.004482e-08 79.837499999999991p 1.1277820000000001e-08 79.849999999999994p 1.249285e-08 79.862500000000011p 1.3688329999999999e-08 79.875p 1.486275e-08
+ 79.887500000000003p 1.60146e-08 79.900000000000006p 1.7142410000000001e-08 79.912499999999994p 1.8244759999999999e-08 79.924999999999997p 1.9320250000000001e-08 79.9375p 2.036752e-08 79.950000000000003p 2.1385259999999999e-08 79.962499999999991p 2.2372200000000001e-08 79.974999999999994p 2.33271e-08 79.987499999999997p 2.424878e-08 80p 2.51361e-08 80.012500000000003p 2.5987980000000001e-08 80.025000000000006p 2.6803360000000001e-08 80.037499999999994p 2.7581260000000001e-08 80.049999999999997p 2.8320749999999999e-08 80.0625p 2.902092e-08 80.075000000000003p 2.968095e-08 80.087499999999991p 3.0300070000000002e-08 80.099999999999994p 3.0877539999999999e-08
+ 80.112499999999997p 3.1412709999999998e-08 80.125p 3.1904969999999997e-08 80.137500000000003p 3.2353749999999999e-08 80.150000000000006p 3.2758589999999997e-08 80.162500000000009p 3.3119030000000003e-08 80.174999999999997p 3.3434710000000001e-08 80.1875p 3.3705310000000003e-08 80.200000000000003p 3.393058e-08 80.212499999999991p 3.4110329999999998e-08 80.224999999999994p 3.4244429999999997e-08 80.237499999999997p 3.4332800000000003e-08 80.25p 3.4375440000000003e-08 80.262500000000003p 3.4372389999999997e-08 80.275000000000006p 3.432376e-08 80.287500000000009p 3.422972e-08 80.299999999999997p 3.409051e-08 80.3125p 3.3906400000000001e-08 80.325000000000003p 3.3677749999999999e-08
+ 80.337499999999991p 3.3404960000000001e-08 80.349999999999994p 3.3088499999999999e-08 80.362499999999997p 3.272887e-08 80.375p 3.2326670000000003e-08 80.387500000000003p 3.1882509999999998e-08 80.400000000000006p 3.1397079999999999e-08 80.412500000000009p 3.0871130000000001e-08 80.424999999999997p 3.0305420000000001e-08 80.4375p 2.9700820000000001e-08 80.450000000000003p 2.9058199999999999e-08 80.462499999999991p 2.8378500000000002e-08 80.474999999999994p 2.7662710000000001e-08 80.487499999999997p 2.6911850000000002e-08 80.5p 2.6127e-08 80.512500000000003p 2.5309279999999998e-08 80.525000000000006p 2.4459840000000001e-08 80.537500000000009p 2.3579880000000002e-08 80.549999999999997p 2.2670639999999999e-08
+ 80.5625p 2.1733369999999999e-08 80.575000000000003p 2.0769400000000001e-08 80.587499999999991p 1.9780039999999999e-08 80.599999999999994p 1.8766679999999999e-08 80.612499999999997p 1.7730699999999999e-08 80.625p 1.667353e-08 80.637500000000003p 1.5596609999999999e-08 80.650000000000006p 1.450142e-08 80.662500000000009p 1.338945e-08 80.674999999999997p 1.22622e-08 80.6875p 1.11212e-08 80.700000000000003p 9.9679929999999997e-09 80.712499999999991p 8.8041350000000006e-09 80.724999999999994p 7.6311870000000007e-09 80.737499999999997p 6.4507220000000001e-09 80.75p 5.2643200000000003e-09 80.762500000000003p 4.0735650000000001e-09 80.775000000000006p 2.8800409999999998e-09
+ 80.787500000000009p 1.685335e-09 80.799999999999997p 4.9102970000000002e-10 80.8125p -7.0129459999999998e-10 80.825000000000003p -1.8900649999999999e-09 80.837499999999991p -3.0737150000000001e-09 80.849999999999994p -4.2506919999999997e-09 80.862499999999997p -5.4194519999999997e-09 80.875p -6.5784659999999999e-09 80.887500000000003p -7.7262239999999994e-09 80.900000000000006p -8.8612309999999999e-09 80.912500000000009p -9.9820140000000008e-09 80.924999999999997p -1.108712e-08 80.9375p -1.217513e-08 80.950000000000003p -1.324463e-08 80.962500000000006p -1.4294250000000001e-08 80.974999999999994p -1.5322649999999999e-08 80.987499999999997p -1.6328509999999999e-08 81p -1.7310550000000001e-08
+ 81.012499999999989p -1.8267530000000001e-08 81.025000000000006p -1.9198230000000001e-08 81.037500000000009p -2.010149e-08 81.049999999999997p -2.097616e-08 81.0625p -2.1821149999999999e-08 81.075000000000003p -2.2635409999999999e-08 81.087500000000006p -2.3417929999999999e-08 81.099999999999994p -2.4167750000000001e-08 81.112499999999997p -2.488394e-08 81.125p -2.556562e-08 81.137499999999989p -2.621198e-08 81.150000000000006p -2.6822240000000001e-08 81.162500000000009p -2.739566e-08 81.174999999999997p -2.793156e-08 81.1875p -2.8429329999999999e-08 81.200000000000003p -2.8888369999999999e-08 81.212500000000006p -2.9308180000000001e-08 81.224999999999994p -2.9688270000000001e-08
+ 81.237499999999997p -3.002824e-08 81.25p -3.0327709999999999e-08 81.262499999999989p -3.0586380000000002e-08 81.274999999999991p -3.0803989999999999e-08 81.287500000000009p -3.0980339999999999e-08 81.300000000000011p -3.1115280000000001e-08 81.3125p -3.1208729999999998e-08 81.325000000000003p -3.1260649999999999e-08 81.337500000000006p -3.1271060000000002e-08 81.349999999999994p -3.124002e-08 81.362499999999997p -3.1167680000000002e-08 81.375p -3.1054199999999999e-08 81.387499999999989p -3.0899829999999998e-08 81.399999999999991p -3.0704859999999998e-08 81.412500000000009p -3.0469619999999999e-08 81.425000000000011p -3.0194510000000003e-08 81.4375p -2.9879969999999997e-08 81.450000000000003p -2.952651e-08
+ 81.462500000000006p -2.913466e-08 81.474999999999994p -2.8705030000000001e-08 81.487499999999997p -2.8238260000000001e-08 81.5p -2.7735039999999999e-08 81.512499999999989p -2.7196109999999999e-08 81.524999999999991p -2.6622259999999999e-08 81.537500000000009p -2.60143e-08 81.550000000000011p -2.537311e-08 81.5625p -2.4699610000000001e-08 81.575000000000003p -2.3994750000000001e-08 81.587500000000006p -2.325952e-08 81.599999999999994p -2.2494950000000001e-08 81.612499999999997p -2.170211e-08 81.625p -2.08821e-08 81.637500000000003p -2.0036060000000001e-08 81.649999999999991p -1.9165150000000001e-08 81.662499999999994p -1.8270570000000001e-08 81.675000000000011p -1.735354e-08
+ 81.6875p -1.6415320000000001e-08 81.700000000000003p -1.5457189999999998e-08 81.712500000000006p -1.4480450000000001e-08 81.724999999999994p -1.3486430000000001e-08 81.737499999999997p -1.247645e-08 81.75p -1.14519e-08 81.762500000000003p -1.041414e-08 81.774999999999991p -9.3645620000000008e-09 81.787499999999994p -8.3045809999999994e-09 81.800000000000011p -7.2356080000000002e-09 81.8125p -6.1590689999999996e-09 81.825000000000003p -5.0763949999999996e-09 81.837500000000006p -3.9890230000000001e-09 81.849999999999994p -2.8983930000000001e-09 81.862499999999997p -1.8059479999999999e-09 81.875p -7.1312669999999998e-10 81.887500000000003p 3.7863069999999998e-10 81.899999999999991p 1.46789e-09
+ 81.912499999999994p 2.553224e-09 81.924999999999997p 3.633211e-09 81.9375p 4.7064420000000004e-09 81.950000000000003p 5.771519e-09 81.962500000000006p 6.8270549999999999e-09 81.975000000000009p 7.8716820000000005e-09 81.987499999999997p 8.9040459999999996e-09 82p 9.9228139999999992e-09 82.012500000000003p 1.092667e-08 82.024999999999991p 1.1914329999999999e-08 82.037499999999994p 1.288452e-08 82.049999999999997p 1.3836000000000001e-08 82.0625p 1.4767550000000001e-08 82.075000000000003p 1.5678e-08 82.087500000000006p 1.6566169999999999e-08 82.100000000000009p 1.743096e-08 82.112499999999997p 1.8271259999999999e-08 82.125p 1.908601e-08
+ 82.137500000000003p 1.9874210000000001e-08 82.149999999999991p 2.0634850000000001e-08 82.162499999999994p 2.1366999999999999e-08 82.174999999999997p 2.2069740000000002e-08 82.1875p 2.274222e-08 82.200000000000003p 2.3383590000000001e-08 82.212500000000006p 2.3993090000000001e-08 82.225000000000009p 2.4569970000000001e-08 82.237499999999997p 2.5113520000000002e-08 82.25p 2.5623109999999999e-08 82.262500000000003p 2.6098130000000002e-08 82.274999999999991p 2.6538019999999999e-08 82.287499999999994p 2.6942260000000001e-08 82.299999999999997p 2.7310399999999999e-08 82.3125p 2.764201e-08 82.325000000000003p 2.793674e-08 82.337500000000006p 2.8194260000000001e-08 82.350000000000009p 2.8414299999999999e-08
+ 82.362499999999997p 2.8596659999999999e-08 82.375p 2.8741150000000001e-08 82.387500000000003p 2.8847659999999999e-08 82.399999999999991p 2.8916130000000001e-08 82.412499999999994p 2.894652e-08 82.424999999999997p 2.893889e-08 82.4375p 2.8893289999999999e-08 82.450000000000003p 2.8809879999999999e-08 82.462500000000006p 2.8688819999999999e-08 82.475000000000009p 2.853035e-08 82.487499999999997p 2.8334739999999998e-08 82.5p 2.8102329999999998e-08 82.512500000000003p 2.7833469999999999e-08 82.524999999999991p 2.7528599999999999e-08 82.537499999999994p 2.7188179999999999e-08 82.549999999999997p 2.681273e-08 82.5625p 2.6402790000000001e-08 82.575000000000003p 2.5958980000000001e-08
+ 82.587500000000006p 2.548194e-08 82.600000000000009p 2.4972349999999999e-08 82.612499999999997p 2.4430949999999999e-08 82.625p 2.3858500000000002e-08 82.637500000000003p 2.3255809999999999e-08 82.649999999999991p 2.2623730000000001e-08 82.662499999999994p 2.1963130000000001e-08 82.674999999999997p 2.1274950000000001e-08 82.6875p 2.0560119999999999e-08 82.700000000000003p 1.9819649999999999e-08 82.712500000000006p 1.905454e-08 82.725000000000009p 1.8265840000000002e-08 82.737499999999997p 1.7454630000000001e-08 82.75p 1.6622010000000001e-08 82.762500000000003p 1.5769119999999999e-08 82.775000000000006p 1.48971e-08 82.787499999999994p 1.4007139999999999e-08 82.799999999999997p 1.310043e-08
+ 82.8125p 1.2178189999999999e-08 82.825000000000003p 1.124166e-08 82.837500000000006p 1.0292089999999999e-08 82.850000000000009p 9.3307400000000008e-09 82.862499999999997p 8.3588960000000005e-09 82.875p 7.3778459999999997e-09 82.887500000000003p 6.3888919999999997e-09 82.900000000000006p 5.3933399999999999e-09 82.912499999999994p 4.3925050000000002e-09 82.924999999999997p 3.3877050000000001e-09 82.9375p 2.3802610000000001e-09 82.949999999999989p 1.371494e-09 82.962500000000006p 3.6272570000000002e-10 82.975000000000009p -6.4472669999999999e-10 82.987499999999997p -1.649549e-09 83p -2.6504339999999999e-09 83.012500000000003p -3.6460820000000001e-09 83.025000000000006p -4.6352019999999997e-09
+ 83.037499999999994p -5.616515e-09 83.049999999999997p -6.5887539999999996e-09 83.0625p -7.5506679999999993e-09 83.074999999999989p -8.5010199999999992e-09 83.087500000000006p -9.438592e-09 83.100000000000009p -1.036219e-08 83.112500000000011p -1.127062e-08 83.125p -1.2162739999999999e-08 83.137500000000003p -1.3037419999999999e-08 83.150000000000006p -1.3893540000000001e-08 83.162499999999994p -1.473002e-08 83.174999999999997p -1.5545810000000001e-08 83.1875p -1.6339900000000001e-08 83.199999999999989p -1.711127e-08 83.212499999999991p -1.7858980000000002e-08 83.225000000000009p -1.8582089999999999e-08 83.237500000000011p -1.9279710000000001e-08 83.25p -1.9950970000000001e-08
+ 83.262500000000003p -2.0595059999999999e-08 83.275000000000006p -2.1211190000000001e-08 83.287499999999994p -2.17986e-08 83.299999999999997p -2.2356600000000001e-08 83.3125p -2.2884499999999999e-08 83.324999999999989p -2.3381690000000001e-08 83.337499999999991p -2.3847570000000001e-08 83.350000000000009p -2.428159e-08 83.362500000000011p -2.468327e-08 83.375p -2.505212e-08 83.387500000000003p -2.5387749999999998e-08 83.400000000000006p -2.568978e-08 83.412499999999994p -2.5957880000000001e-08 83.424999999999997p -2.619177e-08 83.4375p -2.6391209999999999e-08 83.449999999999989p -2.6556019999999999e-08 83.462499999999991p -2.6686040000000001e-08 83.474999999999994p -2.6781180000000001e-08
+ 83.487500000000011p -2.6841380000000001e-08 83.5p -2.6866629999999999e-08 83.512500000000003p -2.685698e-08 83.525000000000006p -2.681249e-08 83.537499999999994p -2.6733310000000001e-08 83.549999999999997p -2.6619600000000001e-08 83.5625p -2.6471579999999999e-08 83.575000000000003p -2.6289519999999998e-08 83.587499999999991p -2.6073709999999999e-08 83.599999999999994p -2.5824500000000001e-08 83.612500000000011p -2.5542290000000001e-08 83.625p -2.5227519999999999e-08 83.637500000000003p -2.4880650000000001e-08 83.650000000000006p -2.4502200000000001e-08 83.662499999999994p -2.4092739999999999e-08 83.674999999999997p -2.3652839999999999e-08 83.6875p -2.3183160000000001e-08 83.700000000000003p -2.2684349999999999e-08
+ 83.712499999999991p -2.215713e-08 83.724999999999994p -2.1602240000000001e-08 83.737499999999997p -2.102046e-08 83.75p -2.04126e-08 83.762500000000003p -1.9779499999999999e-08 83.775000000000006p -1.912204e-08 83.787499999999994p -1.8441120000000001e-08 83.799999999999997p -1.773768e-08 83.8125p -1.7012669999999999e-08 83.825000000000003p -1.6267079999999998e-08 83.837499999999991p -1.550192e-08 83.849999999999994p -1.471824e-08 83.862499999999997p -1.3917070000000001e-08 83.875p -1.3099510000000001e-08 83.887500000000003p -1.2266649999999999e-08 83.900000000000006p -1.1419590000000001e-08 83.912500000000009p -1.055948e-08 83.924999999999997p -9.6874529999999998e-09
+ 83.9375p -8.8046669999999998e-09 83.950000000000003p -7.9122920000000004e-09 83.962499999999991p -7.0115070000000002e-09 83.974999999999994p -6.1034999999999999e-09 83.987499999999997p -5.189464e-09 84p -4.2705999999999997e-09 84.012500000000003p -3.3481099999999999e-09 84.025000000000006p -2.423201e-09 84.037500000000009p -1.4970759999999999e-09 84.049999999999997p -5.7094319999999998e-10 84.0625p 3.5399710000000002e-10 84.075000000000003p 1.2765460000000001e-09 84.087499999999991p 2.1955109999999999e-09 84.099999999999994p 3.1097069999999999e-09 84.112499999999997p 4.0179579999999998e-09 84.125p 4.9190970000000004e-09 84.137500000000003p 5.8119699999999997e-09 84.150000000000006p 6.6954350000000003e-09
+ 84.162500000000009p 7.5683669999999999e-09 84.174999999999997p 8.4296540000000006e-09 84.1875p 9.2782049999999996e-09 84.200000000000003p 1.011294e-08 84.212499999999991p 1.093282e-08 84.224999999999994p 1.17368e-08 84.237499999999997p 1.252388e-08 84.25p 1.329306e-08 84.262500000000003p 1.4043400000000001e-08 84.275000000000006p 1.4773949999999999e-08 84.287500000000009p 1.548382e-08 84.299999999999997p 1.6172129999999999e-08 84.3125p 1.6838030000000001e-08 84.325000000000003p 1.748071e-08 84.337499999999991p 1.8099380000000001e-08 84.349999999999994p 1.869329e-08 84.362499999999997p 1.9261740000000001e-08 84.375p 1.9804029999999999e-08
+ 84.387500000000003p 2.0319519999999999e-08 84.400000000000006p 2.0807610000000002e-08 84.412500000000009p 2.1267709999999999e-08 84.424999999999997p 2.1699300000000001e-08 84.4375p 2.210188e-08 84.450000000000003p 2.2474980000000001e-08 84.462499999999991p 2.281821e-08 84.474999999999994p 2.3131159999999999e-08 84.487499999999997p 2.341351e-08 84.5p 2.3664970000000001e-08 84.512500000000003p 2.3885259999999999e-08 84.525000000000006p 2.4074179999999999e-08 84.537500000000009p 2.423155e-08 84.549999999999997p 2.4357250000000001e-08 84.5625p 2.445117e-08 84.575000000000003p 2.4513269999999999e-08 84.587500000000006p 2.454355e-08 84.599999999999994p 2.4542029999999999e-08
+ 84.612499999999997p 2.4508780000000001e-08 84.625p 2.4443940000000001e-08 84.637500000000003p 2.4347650000000002e-08 84.650000000000006p 2.42201e-08 84.662500000000009p 2.4061549999999999e-08 84.674999999999997p 2.3872250000000001e-08 84.6875p 2.3652539999999999e-08 84.700000000000003p 2.3402770000000001e-08 84.712500000000006p 2.3123330000000001e-08 84.724999999999994p 2.281465e-08 84.737499999999997p 2.2477200000000001e-08 84.75p 2.2111489999999999e-08 84.762499999999989p 2.1718059999999999e-08 84.775000000000006p 2.129748e-08 84.787500000000009p 2.085036e-08 84.799999999999997p 2.037735e-08 84.8125p 1.9879120000000001e-08 84.825000000000003p 1.935638e-08
+ 84.837500000000006p 1.8809859999999999e-08 84.849999999999994p 1.8240329999999999e-08 84.862499999999997p 1.764858e-08 84.875p 1.7035440000000001e-08 84.887499999999989p 1.640175e-08 84.900000000000006p 1.5748379999999999e-08 84.912500000000009p 1.5076229999999999e-08 84.924999999999997p 1.438622e-08 84.9375p 1.367928e-08 84.950000000000003p 1.2956380000000001e-08 84.962500000000006p 1.221849e-08 84.974999999999994p 1.1466599999999999e-08 84.987499999999997p 1.070173e-08 85p 9.9249040000000004e-09 85.012499999999989p 9.1371540000000005e-09 85.024999999999991p 8.3395320000000003e-09 85.037500000000009p 7.5330980000000002e-09 85.050000000000011p 6.7189219999999996e-09
+ 85.0625p 5.89808e-09 85.075000000000003p 5.0716549999999999e-09 85.087500000000006p 4.2407340000000001e-09 85.099999999999994p 3.4064079999999998e-09 85.112499999999997p 2.5697699999999999e-09 85.125p 1.731911e-09 85.137499999999989p 8.9392480000000003e-10 85.149999999999991p 5.68998e-11 85.162500000000009p -7.7807830000000004e-10 85.175000000000011p -1.6099289999999999e-09 85.1875p -2.4375789999999999e-09 85.200000000000003p -3.2599630000000001e-09 85.212500000000006p -4.0760250000000001e-09 85.224999999999994p -4.8847179999999998e-09 85.237499999999997p -5.6850110000000003e-09 85.25p -6.4758839999999998e-09 85.262499999999989p -7.2563310000000002e-09 85.274999999999991p -8.0253639999999993e-09
+ 85.287500000000009p -8.7820100000000004e-09 85.300000000000011p -9.5253169999999994e-09 85.3125p -1.0254349999999999e-08 85.325000000000003p -1.09682e-08 85.337500000000006p -1.166597e-08 85.349999999999994p -1.23468e-08 85.362499999999997p -1.3009840000000001e-08 85.375p -1.3654279999999999e-08 85.387500000000003p -1.4279319999999999e-08 85.399999999999991p -1.48842e-08 85.412499999999994p -1.5468180000000001e-08 85.425000000000011p -1.6030559999999998e-08 85.4375p -1.6570650000000001e-08 85.450000000000003p -1.708781e-08 85.462500000000006p -1.7581429999999999e-08 85.474999999999994p -1.8050920000000002e-08 85.487499999999997p -1.8495729999999999e-08 85.5p -1.891535e-08
+ 85.512500000000003p -1.9309290000000001e-08 85.524999999999991p -1.967711e-08 85.537499999999994p -2.001838e-08 85.550000000000011p -2.0332740000000001e-08 85.5625p -2.0619850000000001e-08 85.575000000000003p -2.087939e-08 85.587500000000006p -2.1111099999999998e-08 85.599999999999994p -2.1314749999999999e-08 85.612499999999997p -2.1490150000000001e-08 85.625p -2.1637139999999999e-08 85.637500000000003p -2.1755600000000001e-08 85.649999999999991p -2.1845449999999999e-08 85.662499999999994p -2.190664e-08 85.674999999999997p -2.193917e-08 85.6875p -2.1943069999999999e-08 85.700000000000003p -2.191841e-08 85.712500000000006p -2.1865290000000001e-08 85.725000000000009p -2.178385e-08
+ 85.737499999999997p -2.1674279999999999e-08 85.75p -2.1536779999999999e-08 85.762500000000003p -2.1371619999999999e-08 85.774999999999991p -2.117907e-08 85.787499999999994p -2.095946e-08 85.799999999999997p -2.071314e-08 85.8125p -2.044051e-08 85.825000000000003p -2.0141989999999999e-08 85.837500000000006p -1.9818019999999999e-08 85.850000000000009p -1.9469119999999999e-08 85.862499999999997p -1.909578e-08 85.875p -1.8698569999999999e-08 85.887500000000003p -1.8278049999999999e-08 85.899999999999991p -1.7834859999999999e-08 85.912499999999994p -1.7369610000000001e-08 85.924999999999997p -1.688297e-08 85.9375p -1.6375640000000002e-08 85.950000000000003p -1.584833e-08
+ 85.962500000000006p -1.530179e-08 85.975000000000009p -1.4736769999999999e-08 85.987499999999997p -1.415406e-08 86p -1.3554479999999999e-08 86.012500000000003p -1.293884e-08 86.024999999999991p -1.2308e-08 86.037499999999994p -1.1662810000000001e-08 86.049999999999997p -1.100417e-08 86.0625p -1.0332959999999999e-08 86.075000000000003p -9.6500969999999999e-09 86.087500000000006p -8.9565049999999998e-09 86.100000000000009p -8.2531199999999997e-09 86.112499999999997p -7.5408859999999996e-09 86.125p -6.8207580000000001e-09 86.137500000000003p -6.0937009999999997e-09 86.149999999999991p -5.3606840000000002e-09 86.162499999999994p -4.6226819999999998e-09 86.174999999999997p -3.8806739999999996e-09
+ 86.1875p -3.1356429999999999e-09 86.200000000000003p -2.388572e-09 86.212500000000006p -1.640446e-09 86.225000000000009p -8.9224720000000003e-10 86.237499999999997p -1.4495610000000001e-10 86.25p 6.0045009999999996e-10 86.262500000000003p 1.3429989999999999e-09 86.274999999999991p 2.081726e-09 86.287499999999994p 2.815671e-09 86.299999999999997p 3.543884e-09 86.3125p 4.2654259999999998e-09 86.325000000000003p 4.9793680000000001e-09 86.337500000000006p 5.6847930000000003e-09 86.350000000000009p 6.3807980000000003e-09 86.362499999999997p 7.0664930000000002e-09 86.375p 7.7410070000000002e-09 86.387500000000003p 8.4034829999999993e-09 86.399999999999991p 9.0530819999999997e-09
+ 86.412499999999994p 9.6889860000000004e-09 86.424999999999997p 1.0310399999999999e-08 86.4375p 1.091653e-08 86.450000000000003p 1.1506639999999999e-08 86.462500000000006p 1.207999e-08 86.475000000000009p 1.263586e-08 86.487499999999997p 1.317358e-08 86.5p 1.369248e-08 86.512500000000003p 1.419193e-08 86.525000000000006p 1.467133e-08 86.537499999999994p 1.5130099999999999e-08 86.549999999999997p 1.5567680000000001e-08 86.5625p 1.5983560000000001e-08 86.574999999999989p 1.6377259999999999e-08 86.587500000000006p 1.6748299999999999e-08 86.600000000000009p 1.709626e-08 86.612499999999997p 1.7420740000000001e-08 86.625p 1.7721369999999999e-08
+ 86.637500000000003p 1.7997829999999999e-08 86.650000000000006p 1.824981e-08 86.662499999999994p 1.847705e-08 86.674999999999997p 1.8679300000000001e-08 86.6875p 1.8856379999999999e-08 86.699999999999989p 1.9008099999999999e-08 86.712500000000006p 1.913434e-08 86.725000000000009p 1.9235e-08 86.737499999999997p 1.9310009999999999e-08 86.75p 1.9359340000000001e-08 86.762500000000003p 1.9382989999999999e-08 86.775000000000006p 1.938099e-08 86.787499999999994p 1.935342e-08 86.799999999999997p 1.9300379999999999e-08 86.8125p 1.9222010000000002e-08 86.824999999999989p 1.911847e-08 86.837500000000006p 1.898997e-08 86.850000000000009p 1.8836729999999998e-08
+ 86.862500000000011p 1.8659040000000001e-08 86.875p 1.8457179999999999e-08 86.887500000000003p 1.823148e-08 86.900000000000006p 1.7982300000000001e-08 86.912499999999994p 1.7710040000000001e-08 86.924999999999997p 1.7415109999999999e-08 86.9375p 1.7097969999999999e-08 86.949999999999989p 1.6759070000000001e-08 86.962499999999991p 1.6398940000000001e-08 86.975000000000009p 1.60181e-08 86.987500000000011p 1.5617099999999999e-08 87p 1.5196529999999999e-08 87.012500000000003p 1.475699e-08 87.025000000000006p 1.429912e-08 87.037499999999994p 1.382357e-08 87.049999999999997p 1.3331e-08 87.0625p 1.2822109999999999e-08 87.074999999999989p 1.229763e-08
+ 87.087499999999991p 1.175827e-08 87.100000000000009p 1.1204789999999999e-08 87.112500000000011p 1.0637969999999999e-08 87.125p 1.005857e-08 87.137500000000003p 9.467411e-09 87.150000000000006p 8.8652900000000001e-09 87.162499999999994p 8.2530350000000008e-09 87.174999999999997p 7.6314810000000001e-09 87.1875p 7.0014730000000004e-09 87.199999999999989p 6.3638669999999997e-09 87.212499999999991p 5.7195239999999997e-09 87.224999999999994p 5.0693150000000001e-09 87.237500000000011p 4.414112e-09 87.25p 3.7547970000000002e-09 87.262500000000003p 3.0922509999999999e-09 87.275000000000006p 2.4273589999999999e-09 87.287499999999994p 1.7610060000000001e-09 87.299999999999997p 1.094078e-09
+ 87.3125p 4.2745819999999998e-10 87.325000000000003p -2.379721e-10 87.337499999999991p -9.0133539999999999e-10 87.349999999999994p -1.5617590000000001e-09 87.362500000000011p -2.2183769999999998e-09 87.375p -2.870329e-09 87.387500000000003p -3.5167640000000002e-09 87.400000000000006p -4.1568410000000002e-09 87.412499999999994p -4.7897289999999998e-09 87.424999999999997p -5.4146069999999996e-09 87.4375p -6.0306689999999999e-09 87.450000000000003p -6.6371200000000003e-09 87.462499999999991p -7.2331820000000003e-09 87.474999999999994p -7.8180930000000008e-09 87.487499999999997p -8.3911040000000006e-09 87.5p -8.9514859999999996e-09 87.512500000000003p -9.4985300000000003e-09 87.525000000000006p -1.0031540000000001e-08
+ 87.537499999999994p -1.054985e-08 87.549999999999997p -1.105281e-08 87.5625p -1.153979e-08 87.575000000000003p -1.2010190000000001e-08 87.587499999999991p -1.246341e-08 87.599999999999994p -1.289891e-08 87.612499999999997p -1.331615e-08 87.625p -1.371462e-08 87.637500000000003p -1.4093840000000001e-08 87.650000000000006p -1.4453359999999999e-08 87.662500000000009p -1.479274e-08 87.674999999999997p -1.5111579999999998e-08 87.6875p -1.540952e-08 87.700000000000003p -1.56862e-08 87.712499999999991p -1.594132e-08 87.724999999999994p -1.6174579999999999e-08 87.737499999999997p -1.6385739999999998e-08 87.75p -1.657455e-08
+ 87.762500000000003p -1.674083e-08 87.775000000000006p -1.6884409999999999e-08 87.787500000000009p -1.7005150000000001e-08 87.799999999999997p -1.7102950000000002e-08 87.8125p -1.717774e-08 87.825000000000003p -1.7229449999999999e-08 87.837499999999991p -1.72581e-08 87.849999999999994p -1.7263679999999999e-08 87.862499999999997p -1.7246240000000001e-08 87.875p -1.720587e-08 87.887500000000003p -1.7142670000000001e-08 87.900000000000006p -1.7056780000000001e-08 87.912500000000009p -1.694836e-08 87.924999999999997p -1.681761e-08 87.9375p -1.666476e-08 87.950000000000003p -1.649005e-08 87.962499999999991p -1.629378e-08 87.974999999999994p -1.6076240000000002e-08
+ 87.987499999999997p -1.5837779999999999e-08 88p -1.557877e-08 88.012500000000003p -1.529958e-08 88.025000000000006p -1.5000650000000001e-08 88.037500000000009p -1.4682400000000001e-08 88.049999999999997p -1.43453e-08 88.0625p -1.398985e-08 88.075000000000003p -1.3616560000000001e-08 88.087499999999991p -1.3225959999999999e-08 88.099999999999994p -1.28186e-08 88.112499999999997p -1.239508e-08 88.125p -1.195597e-08 88.137500000000003p -1.150191e-08 88.150000000000006p -1.1033520000000001e-08 88.162500000000009p -1.0551450000000001e-08 88.174999999999997p -1.0056389999999999e-08 88.1875p -9.5490039999999996e-09 88.200000000000003p -9.0300019999999994e-09
+ 88.212499999999991p -8.5000950000000005e-09 88.224999999999994p -7.9600099999999997e-09 88.237499999999997p -7.4104840000000003e-09 88.25p -6.8522669999999998e-09 88.262500000000003p -6.2861180000000004e-09 88.275000000000006p -5.7128029999999997e-09 88.287500000000009p -5.1330989999999997e-09 88.299999999999997p -4.5477879999999998e-09 88.3125p -3.9576579999999999e-09 88.325000000000003p -3.3635010000000001e-09 88.337500000000006p -2.7661130000000002e-09 88.349999999999994p -2.1662930000000001e-09 88.362499999999997p -1.5648430000000001e-09 88.375p -9.6256070000000005e-10 88.387500000000003p -3.6024820000000002e-10 88.400000000000006p 2.4129670000000002e-10 88.412500000000009p 8.4127829999999999e-10 88.424999999999997p 1.438905e-09
+ 88.4375p 2.0333879999999999e-09 88.450000000000003p 2.623948e-09 88.462500000000006p 3.2098100000000001e-09 88.474999999999994p 3.7902059999999998e-09 88.487499999999997p 4.3643799999999998e-09 88.5p 4.9315830000000002e-09 88.512499999999989p 5.4910769999999999e-09 88.525000000000006p 6.0421370000000003e-09 88.537500000000009p 6.5840510000000001e-09 88.549999999999997p 7.1161180000000002e-09 88.5625p 7.6376539999999992e-09 88.575000000000003p 8.1479889999999994e-09 88.587500000000006p 8.6464699999999994e-09 88.599999999999994p 9.1324589999999994e-09 88.612499999999997p 9.6053399999999998e-09 88.625p 1.006451e-08 88.637499999999989p 1.050939e-08 88.650000000000006p 1.0939419999999999e-08
+ 88.662500000000009p 1.135406e-08 88.674999999999997p 1.175279e-08 88.6875p 1.2135109999999999e-08 88.700000000000003p 1.2500559999999999e-08 88.712500000000006p 1.284867e-08 88.724999999999994p 1.317902e-08 88.737499999999997p 1.349122e-08 88.75p 1.378488e-08 88.762499999999989p 1.4059650000000001e-08 88.774999999999991p 1.43152e-08 88.787500000000009p 1.4551239999999999e-08 88.800000000000011p 1.476748e-08 88.8125p 1.4963680000000001e-08 88.825000000000003p 1.513963e-08 88.837500000000006p 1.5295120000000001e-08 88.849999999999994p 1.542998e-08 88.862499999999997p 1.5544089999999999e-08 88.875p 1.5637339999999999e-08
+ 88.887499999999989p 1.5709620000000001e-08 88.899999999999991p 1.5760899999999999e-08 88.912500000000009p 1.5791140000000001e-08 88.925000000000011p 1.5800350000000002e-08 88.9375p 1.5788549999999999e-08 88.950000000000003p 1.5755790000000001e-08 88.962500000000006p 1.5702169999999999e-08 88.974999999999994p 1.5627789999999999e-08 88.987499999999997p 1.553279e-08 89p 1.5417330000000001e-08 89.012499999999989p 1.5281609999999999e-08 89.024999999999991p 1.5125840000000001e-08 89.037500000000009p 1.4950259999999998e-08 89.050000000000011p 1.475515e-08 89.0625p 1.454081e-08 89.075000000000003p 1.430754e-08 89.087500000000006p 1.4055700000000001e-08 89.099999999999994p 1.3785649999999999e-08
+ 89.112499999999997p 1.3497780000000001e-08 89.125p 1.319251e-08 89.137500000000003p 1.287027e-08 89.149999999999991p 1.253152e-08 89.162499999999994p 1.217674e-08 89.175000000000011p 1.180642e-08 89.1875p 1.1421090000000001e-08 89.200000000000003p 1.102127e-08 89.212500000000006p 1.060754e-08 89.224999999999994p 1.018045e-08 89.237499999999997p 9.740592e-09 89.25p 9.2885789999999995e-09 89.262500000000003p 8.8250249999999993e-09 89.274999999999991p 8.3505639999999998e-09 89.287499999999994p 7.8658409999999997e-09 89.300000000000011p 7.3715160000000002e-09 89.3125p 6.8682580000000002e-09 89.325000000000003p 6.3567480000000002e-09
+ 89.337500000000006p 5.8376749999999997e-09 89.349999999999994p 5.3117379999999999e-09 89.362499999999997p 4.7796449999999998e-09 89.375p 4.2421059999999999e-09 89.387500000000003p 3.699843e-09 89.399999999999991p 3.1535770000000001e-09 89.412499999999994p 2.6040369999999999e-09 89.424999999999997p 2.0519529999999999e-09 89.4375p 1.498057e-09 89.450000000000003p 9.430835000000001e-10 89.462500000000006p 3.8776520000000002e-10 89.475000000000009p -1.6716549999999999e-10 89.487499999999997p -7.2097789999999998e-10 89.5p -1.272944e-09 89.512500000000003p -1.822341e-09 89.524999999999991p -2.36845e-09 89.537499999999994p -2.9105559999999999e-09 89.549999999999997p -3.4479539999999999e-09
+ 89.5625p -3.9799440000000003e-09 89.575000000000003p -4.5058350000000003e-09 89.587500000000006p -5.0249459999999997e-09 89.600000000000009p -5.5366069999999998e-09 89.612499999999997p -6.0401570000000002e-09 89.625p -6.5349480000000003e-09 89.637500000000003p -7.0203439999999998e-09 89.649999999999991p -7.4957239999999995e-09 89.662499999999994p -7.9604809999999993e-09 89.674999999999997p -8.4140230000000008e-09 89.6875p -8.8557720000000001e-09 89.700000000000003p -9.2851689999999994e-09 89.712500000000006p -9.7016719999999995e-09 89.725000000000009p -1.010476e-08 89.737499999999997p -1.0493920000000001e-08 89.75p -1.086866e-08 89.762500000000003p -1.122853e-08 89.774999999999991p -1.1573079999999999e-08
+ 89.787499999999994p -1.1901879999999999e-08 89.799999999999997p -1.221452e-08 89.8125p -1.251062e-08 89.825000000000003p -1.2789839999999999e-08 89.837500000000006p -1.3051820000000001e-08 89.850000000000009p -1.3296250000000001e-08 89.862499999999997p -1.352286e-08 89.875p -1.373136e-08 89.887500000000003p -1.392152e-08 89.899999999999991p -1.4093119999999999e-08 89.912499999999994p -1.4245969999999999e-08 89.924999999999997p -1.437991e-08 89.9375p -1.4494779999999999e-08 89.950000000000003p -1.459047e-08 89.962500000000006p -1.4666899999999999e-08 89.975000000000009p -1.4724e-08 89.987499999999997p -1.476172e-08 90p -1.478004e-08
+ 90.012500000000003p -1.477899e-08 90.024999999999991p -1.47586e-08 90.037499999999994p -1.471892e-08 90.049999999999997p -1.466004e-08 90.0625p -1.458208e-08 90.075000000000003p -1.448517e-08 90.087500000000006p -1.436947e-08 90.100000000000009p -1.4235159999999999e-08 90.112499999999997p -1.4082459999999999e-08 90.125p -1.3911600000000001e-08 90.137500000000003p -1.372282e-08 90.149999999999991p -1.351642e-08 90.162499999999994p -1.3292690000000001e-08 90.174999999999997p -1.3051950000000001e-08 90.1875p -1.279455e-08 90.200000000000003p -1.252086e-08 90.212500000000006p -1.2231260000000001e-08 90.225000000000009p -1.192616e-08
+ 90.237499999999997p -1.160599e-08 90.25p -1.127118e-08 90.262500000000003p -1.0922209999999999e-08 90.275000000000006p -1.055956e-08 90.287499999999994p -1.0183710000000001e-08 90.299999999999997p -9.7951989999999999e-09 90.3125p -9.394541e-09 90.324999999999989p -8.9822840000000002e-09 90.337500000000006p -8.5589869999999999e-09 90.350000000000009p -8.1252219999999996e-09 90.362499999999997p -7.6815740000000004e-09 90.375p -7.2286389999999997e-09 90.387500000000003p -6.767025e-09 90.400000000000006p -6.29735e-09 90.412499999999994p -5.8202390000000003e-09 90.424999999999997p -5.3363299999999999e-09 90.4375p -4.8462630000000003e-09 90.449999999999989p -4.3506910000000003e-09
+ 90.462500000000006p -3.850268e-09 90.475000000000009p -3.345654e-09 90.487499999999997p -2.8375159999999999e-09 90.5p -2.3265220000000002e-09 90.512500000000003p -1.8133420000000001e-09 90.525000000000006p -1.298648e-09 90.537499999999994p -7.8311449999999998e-10 90.549999999999997p -2.6741310000000002e-10 90.5625p 2.4778430000000002e-10 90.574999999999989p 7.6180769999999997e-10 90.587500000000006p 1.2739900000000001e-09 90.600000000000009p 1.783669e-09 90.612500000000011p 2.290185e-09 90.625p 2.7928849999999999e-09 90.637500000000003p 3.2911219999999999e-09 90.650000000000006p 3.7842570000000002e-09 90.662499999999994p 4.2716559999999997e-09 90.674999999999997p 4.7526969999999998e-09
+ 90.6875p 5.2267660000000001e-09 90.699999999999989p 5.6932600000000003e-09 90.712499999999991p 6.1515850000000003e-09 90.725000000000009p 6.6011620000000002e-09 90.737500000000011p 7.0414219999999997e-09 90.75p 7.4718099999999997e-09 90.762500000000003p 7.8917849999999998e-09 90.775000000000006p 8.3008220000000005e-09 90.787499999999994p 8.6984080000000006e-09 90.799999999999997p 9.0840489999999996e-09 90.8125p 9.4572660000000003e-09 90.824999999999989p 9.8175969999999996e-09 90.837499999999991p 1.01646e-08 90.850000000000009p 1.0497849999999999e-08 90.862500000000011p 1.0816929999999999e-08 90.875p 1.112147e-08 90.887500000000003p 1.1411089999999999e-08 90.900000000000006p 1.168545e-08
+ 90.912499999999994p 1.194421e-08 90.924999999999997p 1.2187079999999999e-08 90.9375p 1.2413760000000001e-08 90.950000000000003p 1.262399e-08 90.962499999999991p 1.281754e-08 90.974999999999994p 1.299418e-08 90.987500000000011p 1.315372e-08 91p 1.3295980000000001e-08 91.012500000000003p 1.3420810000000001e-08 91.025000000000006p 1.3528089999999999e-08 91.037499999999994p 1.36177e-08 91.049999999999997p 1.3689559999999999e-08 91.0625p 1.374363e-08 91.075000000000003p 1.377985e-08 91.087499999999991p 1.379822e-08 91.099999999999994p 1.379876e-08 91.112500000000011p 1.378148e-08 91.125p 1.3746460000000001e-08
+ 91.137500000000003p 1.369377e-08 91.150000000000006p 1.3623509999999999e-08 91.162499999999994p 1.353582e-08 91.174999999999997p 1.343083e-08 91.1875p 1.330872e-08 91.200000000000003p 1.316968e-08 91.212499999999991p 1.3013919999999999e-08 91.224999999999994p 1.2841680000000001e-08 91.237499999999997p 1.265322e-08 91.25p 1.244881e-08 91.262500000000003p 1.222875e-08 91.275000000000006p 1.1993349999999999e-08 91.287499999999994p 1.174296e-08 91.299999999999997p 1.147791e-08 91.3125p 1.11986e-08 91.325000000000003p 1.0905400000000001e-08 91.337499999999991p 1.0598729999999999e-08 91.349999999999994p 1.027901e-08
+ 91.362499999999997p 9.9466750000000003e-09 91.375p 9.6021889999999996e-09 91.387500000000003p 9.2460210000000006e-09 91.400000000000006p 8.8786550000000005e-09 91.412500000000009p 8.5005890000000008e-09 91.424999999999997p 8.1123349999999994e-09 91.4375p 7.7144150000000004e-09 91.450000000000003p 7.3073659999999997e-09 91.462499999999991p 6.8917320000000004e-09 91.474999999999994p 6.4680690000000001e-09 91.487499999999997p 6.0369429999999998e-09 91.5p 5.5989250000000003e-09 91.512500000000003p 5.1545979999999997e-09 91.525000000000006p 4.7045489999999999e-09 91.537500000000009p 4.249372e-09 91.549999999999997p 3.7896670000000001e-09 91.5625p 3.3260389999999999e-09 91.575000000000003p 2.8590939999999999e-09
+ 91.587499999999991p 2.389444e-09 91.599999999999994p 1.9177029999999998e-09 91.612499999999997p 1.4444830000000001e-09 91.625p 9.7040180000000004e-10 91.637500000000003p 4.9607269999999996e-10 91.650000000000006p 2.2109849999999999e-11 91.662500000000009p -4.5087459999999998e-10 91.674999999999997p -9.2227129999999996e-10 91.6875p -1.391474e-09 91.700000000000003p -1.8578809999999999e-09 91.712499999999991p -2.3208960000000001e-09 91.724999999999994p -2.7799269999999998e-09 91.737499999999997p -3.2343890000000001e-09 91.75p -3.6837049999999999e-09 91.762500000000003p -4.1273060000000003e-09 91.775000000000006p -4.5646300000000002e-09 91.787500000000009p -4.9951259999999999e-09 91.799999999999997p -5.4182529999999997e-09
+ 91.8125p -5.83348e-09 91.825000000000003p -6.2402879999999999e-09 91.837499999999991p -6.63817e-09 91.849999999999994p -7.0266309999999997e-09 91.862499999999997p -7.4051900000000002e-09 91.875p -7.7733799999999999e-09 91.887500000000003p -8.1307489999999995e-09 91.900000000000006p -8.4768590000000001e-09 91.912500000000009p -8.8112870000000008e-09 91.924999999999997p -9.1336290000000001e-09 91.9375p -9.4434949999999996e-09 91.950000000000003p -9.7405119999999993e-09 91.962499999999991p -1.002433e-08 91.974999999999994p -1.02946e-08 91.987499999999997p -1.0551019999999999e-08 92p -1.0793279999999999e-08 92.012500000000003p -1.10211e-08 92.025000000000006p -1.1234220000000001e-08
+ 92.037500000000009p -1.14324e-08 92.049999999999997p -1.161541e-08 92.0625p -1.178307e-08 92.075000000000003p -1.193517e-08 92.087500000000006p -1.2071580000000001e-08 92.099999999999994p -1.2192129999999999e-08 92.112499999999997p -1.2296719999999999e-08 92.125p -1.238526e-08 92.137500000000003p -1.2457650000000001e-08 92.150000000000006p -1.2513840000000001e-08 92.162500000000009p -1.255381e-08 92.174999999999997p -1.2577540000000001e-08 92.1875p -1.258503e-08 92.200000000000003p -1.2576320000000001e-08 92.212500000000006p -1.2551450000000001e-08 92.224999999999994p -1.25105e-08 92.237499999999997p -1.2453550000000001e-08 92.25p -1.238072e-08
+ 92.262499999999989p -1.229215e-08 92.275000000000006p -1.218797e-08 92.287500000000009p -1.206838e-08 92.299999999999997p -1.193355e-08 92.3125p -1.17837e-08 92.325000000000003p -1.1619060000000001e-08 92.337500000000006p -1.143987e-08 92.349999999999994p -1.124642e-08 92.362499999999997p -1.1038970000000001e-08 92.375p -1.081784e-08 92.387499999999989p -1.058334e-08 92.400000000000006p -1.033581e-08 92.412500000000009p -1.00756e-08 92.424999999999997p -9.8030799999999992e-09 92.4375p -9.5186350000000002e-09 92.450000000000003p -9.2226600000000001e-09 92.462500000000006p -8.9155679999999998e-09 92.474999999999994p -8.5977839999999993e-09
+ 92.487499999999997p -8.2697460000000007e-09 92.5p -7.9319040000000003e-09 92.512499999999989p -7.5847199999999998e-09 92.524999999999991p -7.2286679999999998e-09 92.537500000000009p -6.86423e-09 92.550000000000011p -6.4919010000000002e-09 92.5625p -6.1121810000000002e-09 92.575000000000003p -5.7255820000000002e-09 92.587500000000006p -5.332622e-09 92.599999999999994p -4.9338259999999997e-09 92.612499999999997p -4.5297249999999999e-09 92.625p -4.1208580000000004e-09 92.637499999999989p -3.7077659999999999e-09 92.649999999999991p -3.290995e-09 92.662500000000009p -2.8710950000000002e-09 92.675000000000011p -2.4486179999999999e-09 92.6875p -2.0241189999999999e-09 92.700000000000003p -1.598153e-09
+ 92.712500000000006p -1.171277e-09 92.724999999999994p -7.4404629999999999e-10 92.737499999999997p -3.1701619999999999e-10 92.75p 1.0925979999999999e-10 92.762499999999989p 5.3423079999999997e-10 92.774999999999991p 9.5734859999999998e-10 92.787499999999994p 1.3780690000000001e-09 92.800000000000011p 1.795852e-09 92.8125p 2.2101640000000002e-09 92.825000000000003p 2.6204750000000001e-09 92.837500000000006p 3.026263e-09 92.849999999999994p 3.4270140000000002e-09 92.862499999999997p 3.8222200000000001e-09 92.875p 4.2113819999999998e-09 92.887500000000003p 4.5940109999999998e-09 92.899999999999991p 4.9696279999999997e-09 92.912499999999994p 5.3377619999999998e-09 92.925000000000011p 5.6979549999999997e-09
+ 92.9375p 6.04976e-09 92.950000000000003p 6.3927429999999997e-09 92.962500000000006p 6.7264800000000001e-09 92.974999999999994p 7.0505630000000002e-09 92.987499999999997p 7.3645960000000004e-09 93p 7.6681979999999998e-09 93.012500000000003p 7.9610009999999996e-09 93.024999999999991p 8.242653e-09 93.037499999999994p 8.5128190000000001e-09 93.050000000000011p 8.7711769999999998e-09 93.0625p 9.0174229999999998e-09 93.075000000000003p 9.2512699999999996e-09 93.087500000000006p 9.472445e-09 93.099999999999994p 9.6806959999999998e-09 93.112499999999997p 9.8757870000000002e-09 93.125p 1.0057499999999999e-08 93.137500000000003p 1.022563e-08 93.149999999999991p 1.0379999999999999e-08
+ 93.162499999999994p 1.0520440000000001e-08 93.174999999999997p 1.064682e-08 93.1875p 1.0759000000000001e-08 93.200000000000003p 1.0856870000000001e-08 93.212500000000006p 1.094035e-08 93.225000000000009p 1.100936e-08 93.237499999999997p 1.1063870000000001e-08 93.25p 1.110383e-08 93.262500000000003p 1.112923e-08 93.274999999999991p 1.114008e-08 93.287499999999994p 1.113641e-08 93.299999999999997p 1.1118259999999999e-08 93.3125p 1.108569e-08 93.325000000000003p 1.103879e-08 93.337500000000006p 1.097766e-08 93.350000000000009p 1.0902410000000001e-08 93.362499999999997p 1.081318e-08 93.375p 1.071013e-08
+ 93.387500000000003p 1.0593430000000001e-08 93.399999999999991p 1.0463270000000001e-08 93.412499999999994p 1.0319860000000001e-08 93.424999999999997p 1.016342e-08 93.4375p 9.9941949999999993e-09 93.450000000000003p 9.8124370000000008e-09 93.462500000000006p 9.6184200000000004e-09 93.475000000000009p 9.4124310000000003e-09 93.487499999999997p 9.1947739999999997e-09 93.5p 8.9657650000000002e-09 93.512500000000003p 8.7257360000000001e-09 93.524999999999991p 8.4750299999999994e-09 93.537499999999994p 8.2140049999999999e-09 93.549999999999997p 7.9430320000000007e-09 93.5625p 7.6624929999999994e-09 93.575000000000003p 7.3727809999999998e-09 93.587500000000006p 7.0743019999999997e-09 93.600000000000009p 6.7674700000000004e-09
+ 93.612499999999997p 6.4527109999999996e-09 93.625p 6.130459e-09 93.637500000000003p 5.8011569999999997e-09 93.649999999999991p 5.4652549999999999e-09 93.662499999999994p 5.1232129999999999e-09 93.674999999999997p 4.7754950000000004e-09 93.6875p 4.4225729999999997e-09 93.700000000000003p 4.0649240000000001e-09 93.712500000000006p 3.7030310000000001e-09 93.725000000000009p 3.3373780000000001e-09 93.737499999999997p 2.9684580000000001e-09 93.75p 2.5967609999999999e-09 93.762500000000003p 2.2227840000000001e-09 93.774999999999991p 1.847023e-09 93.787499999999994p 1.469977e-09 93.799999999999997p 1.0921439999999999e-09 93.8125p 7.1402170000000001e-10 93.825000000000003p 3.3610719999999998e-10
+ 93.837500000000006p -4.1103890000000002e-11 93.850000000000009p -4.171182e-10 93.862499999999997p -7.9144539999999997e-10 93.875p -1.1635990000000001e-09 93.887500000000003p -1.5330950000000001e-09 93.899999999999991p -1.8994559999999999e-09 93.912499999999994p -2.2622110000000001e-09 93.924999999999997p -2.6208909999999999e-09 93.9375p -2.975037e-09 93.950000000000003p -3.3241960000000001e-09 93.962500000000006p -3.6679239999999999e-09 93.975000000000009p -4.0057819999999996e-09 93.987499999999997p -4.3373439999999999e-09 94p -4.66219e-09 94.012500000000003p -4.9799130000000002e-09 94.025000000000006p -5.2901130000000002e-09 94.037499999999994p -5.5924049999999998e-09 94.049999999999997p -5.8864110000000001e-09
+ 94.0625p -6.171767e-09 94.074999999999989p -6.4481239999999999e-09 94.087500000000006p -6.71514e-09 94.100000000000009p -6.9724909999999997e-09 94.112499999999997p -7.2198650000000003e-09 94.125p -7.4569640000000003e-09 94.137500000000003p -7.6835019999999996e-09 94.150000000000006p -7.8992130000000002e-09 94.162499999999994p -8.1038399999999996e-09 94.174999999999997p -8.2971439999999994e-09 94.1875p -8.4789040000000002e-09 94.199999999999989p -8.6489099999999997e-09 94.212500000000006p -8.8069699999999994e-09 94.225000000000009p -8.9529100000000003e-09 94.237499999999997p -9.0865700000000008e-09 94.25p -9.2078080000000005e-09 94.262500000000003p -9.3164970000000001e-09 94.275000000000006p -9.4125290000000001e-09
+ 94.287499999999994p -9.4958120000000008e-09 94.299999999999997p -9.5662709999999998e-09 94.3125p -9.6238469999999999e-09 94.324999999999989p -9.6685010000000002e-09 94.337500000000006p -9.7002079999999993e-09 94.350000000000009p -9.718961e-09 94.362500000000011p -9.7247719999999995e-09 94.375p -9.7176679999999998e-09 94.387500000000003p -9.697693e-09 94.400000000000006p -9.664909e-09 94.412499999999994p -9.6193939999999998e-09 94.424999999999997p -9.5612419999999998e-09 94.4375p -9.4905650000000007e-09 94.449999999999989p -9.4074889999999998e-09 94.462499999999991p -9.3121590000000003e-09 94.475000000000009p -9.2047329999999996e-09 94.487500000000011p -9.0853860000000006e-09 94.5p -8.9543070000000006e-09
+ 94.512500000000003p -8.8117029999999994e-09 94.525000000000006p -8.6577910000000001e-09 94.537499999999994p -8.492807e-09 94.549999999999997p -8.3169990000000006e-09 94.5625p -8.1306270000000004e-09 94.574999999999989p -7.9339679999999998e-09 94.587499999999991p -7.7273079999999992e-09 94.600000000000009p -7.5109490000000005e-09 94.612500000000011p -7.2852020000000003e-09 94.625p -7.050391e-09 94.637500000000003p -6.8068520000000001e-09 94.650000000000006p -6.5549299999999998e-09 94.662499999999994p -6.2949820000000003e-09 94.674999999999997p -6.0273720000000003e-09 94.6875p -5.7524769999999998e-09 94.700000000000003p -5.4706790000000001e-09 94.712499999999991p -5.1823709999999997e-09 94.724999999999994p -4.8879520000000001e-09
+ 94.737500000000011p -4.5878290000000004e-09 94.75p -4.2824140000000003e-09 94.762500000000003p -3.9721260000000004e-09 94.775000000000006p -3.6573909999999998e-09 94.787499999999994p -3.3386359999999999e-09 94.799999999999997p -3.0162969999999999e-09 94.8125p -2.6908100000000001e-09 94.825000000000003p -2.3626149999999999e-09 94.837499999999991p -2.0321560000000001e-09 94.849999999999994p -1.699877e-09 94.862500000000011p -1.3662240000000001e-09 94.875p -1.0316430000000001e-09 94.887500000000003p -6.9658310000000004e-10 94.900000000000006p -3.6148920000000001e-10 94.912499999999994p -2.6807260000000001e-11 94.924999999999997p 3.070189e-10 94.9375p 6.3954770000000002e-10 94.950000000000003p 9.7034010000000001e-10
+ 94.962499999999991p 1.2989609999999999e-09 94.974999999999994p 1.6249780000000001e-09 94.987499999999997p 1.947964e-09 95p 2.2674980000000001e-09 95.012500000000003p 8.0684810000000004e-07 95.025000000000006p 1.5519619999999999e-06 95.037499999999994p 2.2353570000000001e-06 95.049999999999997p 2.8585860000000001e-06 95.0625p 3.4245209999999999e-06 95.075000000000003p 3.936495e-06 95.087499999999991p 4.3980040000000002e-06 95.099999999999994p 4.8125890000000002e-06 95.112499999999997p 5.183785e-06 95.125p 5.5150949999999996e-06 95.137500000000003p 5.8099650000000004e-06 95.150000000000006p 6.0717709999999999e-06 95.162500000000009p 6.3038060000000003e-06 95.174999999999997p 6.5092619999999999e-06
+ 95.1875p 6.691223e-06 95.200000000000003p 6.8526570000000003e-06 95.212499999999991p 6.9964020000000001e-06 95.224999999999994p 7.1251629999999996e-06 95.237499999999997p 7.2415050000000004e-06 95.25p 7.3478469999999996e-06 95.262500000000003p 7.446462e-06 95.275000000000006p 7.53947e-06 95.287500000000009p 7.6288389999999997e-06 95.299999999999997p 7.7163870000000006e-06 95.3125p 7.8037760000000008e-06 95.325000000000003p 7.8925180000000003e-06 95.337499999999991p 7.9839770000000006e-06 95.349999999999994p 8.0793719999999993e-06 95.362499999999997p 8.1797750000000008e-06 95.375p 8.2861240000000008e-06 95.387500000000003p 8.3992200000000005e-06 95.400000000000006p 8.5197359999999992e-06
+ 95.412500000000009p 8.6482219999999998e-06 95.424999999999997p 8.7851089999999996e-06 95.4375p 8.9307170000000006e-06 95.450000000000003p 9.0852620000000003e-06 95.462499999999991p 9.2488599999999994e-06 95.474999999999994p 9.4215350000000003e-06 95.487499999999997p 9.6032270000000003e-06 95.5p 9.793796e-06 95.512500000000003p 9.9930319999999999e-06 95.525000000000006p 1.0200659999999999e-05 95.537500000000009p 1.0416350000000001e-05 95.549999999999997p 1.0639720000000001e-05 95.5625p 1.087033e-05 95.575000000000003p 1.1107730000000001e-05 95.587499999999991p 1.135141e-05 95.599999999999994p 1.1600849999999999e-05 95.612499999999997p 1.1855509999999999e-05 95.625p 1.211483e-05
+ 95.637500000000003p 1.237823e-05 95.650000000000006p 1.2645159999999999e-05 95.662500000000009p 1.291503e-05 95.674999999999997p 1.318728e-05 95.6875p 1.3461349999999999e-05 95.700000000000003p 1.37367e-05 95.712499999999991p 1.4012800000000001e-05 95.724999999999994p 1.428915e-05 95.737499999999997p 1.456524e-05 95.75p 1.484063e-05 95.762500000000003p 1.5114889999999999e-05 95.775000000000006p 1.5387600000000002e-05 95.787500000000009p 1.5658399999999999e-05 95.799999999999997p 1.5926949999999998e-05 95.8125p 1.6192940000000002e-05 95.825000000000003p 1.6456120000000001e-05 95.837500000000006p 1.671623e-05 95.849999999999994p 1.6973099999999998e-05
+ 95.862499999999997p 1.7226559999999999e-05 95.875p 1.747648e-05 95.887500000000003p 1.7722799999999999e-05 95.900000000000006p 1.7965439999999999e-05 95.912500000000009p 1.8204419999999999e-05 95.924999999999997p 1.8439739999999998e-05 95.9375p 1.867147e-05 95.950000000000003p 1.8899700000000001e-05 95.962500000000006p 1.912455e-05 95.974999999999994p 1.9346190000000001e-05 95.987499999999997p 1.9564789999999999e-05 96p 1.978058e-05 96.012499999999989p 1.9189539999999999e-05 96.025000000000006p 1.8655659999999999e-05 96.037500000000009p 1.8181480000000001e-05 96.049999999999997p 1.7765780000000001e-05 96.0625p 1.740601e-05 96.075000000000003p 1.7099200000000001e-05
+ 96.087500000000006p 1.684221e-05 96.099999999999994p 1.663191e-05 96.112499999999997p 1.6465130000000001e-05 96.125p 1.63388e-05 96.137499999999989p 1.6249859999999999e-05 96.150000000000006p 1.6195369999999999e-05 96.162500000000009p 1.6172459999999999e-05 96.174999999999997p 1.617834e-05 96.1875p 1.621035e-05 96.200000000000003p 1.6265939999999999e-05 96.212500000000006p 1.6342680000000001e-05 96.224999999999994p 1.6438259999999999e-05 96.237499999999997p 1.6550510000000001e-05 96.25p 1.6677379999999999e-05 96.262499999999989p 1.6816950000000002e-05 96.274999999999991p 1.696746e-05 96.287500000000009p 1.7127269999999999e-05 96.300000000000011p 1.729486e-05
+ 96.3125p 1.7468869999999999e-05 96.325000000000003p 1.7648040000000001e-05 96.337500000000006p 1.783126e-05 96.349999999999994p 1.801752e-05 96.362499999999997p 1.8205950000000001e-05 96.375p 1.839578e-05 96.387499999999989p 1.8586359999999999e-05 96.399999999999991p 1.8777110000000001e-05 96.412500000000009p 1.896759e-05 96.425000000000011p 1.9157429999999999e-05 96.4375p 1.9346350000000002e-05 96.450000000000003p 1.9534129999999999e-05 96.462500000000006p 1.9720640000000002e-05 96.474999999999994p 1.990583e-05 96.487499999999997p 2.008968e-05 96.5p 2.0272249999999999e-05 96.512499999999989p 2.0453629999999999e-05 96.524999999999991p 2.063396e-05
+ 96.537499999999994p 2.0813420000000001e-05 96.550000000000011p 2.099222e-05 96.5625p 2.117059e-05 96.575000000000003p 2.134878e-05 96.587500000000006p 2.1527080000000001e-05 96.599999999999994p 2.1705750000000001e-05 96.612499999999997p 2.1885100000000002e-05 96.625p 2.2065429999999999e-05 96.637500000000003p 2.224702e-05 96.649999999999991p 2.2430179999999999e-05 96.662499999999994p 2.26152e-05 96.675000000000011p 2.280235e-05 96.6875p 2.299191e-05 96.700000000000003p 2.3184129999999999e-05 96.712500000000006p 2.3379250000000002e-05 96.724999999999994p 2.357751e-05 96.737499999999997p 2.3779119999999999e-05 96.75p 2.398425e-05
+ 96.762500000000003p 2.4193100000000001e-05 96.774999999999991p 2.4405799999999999e-05 96.787499999999994p 2.46225e-05 96.800000000000011p 2.48433e-05 96.8125p 2.5068290000000001e-05 96.825000000000003p 2.529756e-05 96.837500000000006p 2.553114e-05 96.849999999999994p 2.5769070000000002e-05 96.862499999999997p 2.6011370000000001e-05 96.875p 2.625803e-05 96.887500000000003p 2.6509029999999999e-05 96.899999999999991p 2.676434e-05 96.912499999999994p 2.7023910000000001e-05 96.924999999999997p 2.728766e-05 96.9375p 2.7555519999999999e-05 96.950000000000003p 2.7827410000000001e-05 96.962500000000006p 2.810321e-05 96.975000000000009p 2.8382830000000001e-05
+ 96.987499999999997p 2.8666139999999999e-05 97p 2.895302e-05 97.012500000000003p 2.9243340000000001e-05 97.024999999999991p 2.9536959999999999e-05 97.037499999999994p 2.9833759999999999e-05 97.049999999999997p 3.0133580000000001e-05 97.0625p 3.0436290000000001e-05 97.075000000000003p 3.0741760000000002e-05 97.087500000000006p 3.1049829999999997e-05 97.100000000000009p 3.1360379999999997e-05 97.112499999999997p 3.1673259999999998e-05 97.125p 3.1988349999999997e-05 97.137500000000003p 3.230553e-05 97.149999999999991p 3.2624659999999997e-05 97.162499999999994p 3.2945640000000001e-05 97.174999999999997p 3.3268359999999999e-05 97.1875p 3.3592720000000003e-05 97.200000000000003p 3.3918609999999998e-05
+ 97.212500000000006p 3.4245960000000001e-05 97.225000000000009p 3.4574689999999999e-05 97.237499999999997p 3.4904709999999999e-05 97.25p 3.5235979999999998e-05 97.262500000000003p 3.5568429999999999e-05 97.274999999999991p 3.5902029999999998e-05 97.287499999999994p 3.623672e-05 97.299999999999997p 3.6572480000000001e-05 97.3125p 3.6909300000000003e-05 97.325000000000003p 3.7247140000000001e-05 97.337500000000006p 3.7586010000000003e-05 97.350000000000009p 3.7925890000000002e-05 97.362499999999997p 3.8266809999999998e-05 97.375p 3.8608759999999999e-05 97.387500000000003p 3.8951759999999999e-05 97.399999999999991p 3.929584e-05 97.412499999999994p 3.9641010000000003e-05 97.424999999999997p 3.9987300000000003e-05
+ 97.4375p 4.0334740000000001e-05 97.450000000000003p 4.0683350000000001e-05 97.462500000000006p 4.1033169999999997e-05 97.475000000000009p 4.1384229999999998e-05 97.487499999999997p 4.1736549999999999e-05 97.5p 4.2090160000000003e-05 97.512500000000003p 4.2445070000000003e-05 97.524999999999991p 4.280131e-05 97.537499999999994p 4.3158870000000002e-05 97.549999999999997p 4.3517770000000003e-05 97.5625p 4.3877980000000001e-05 97.575000000000003p 4.4239510000000003e-05 97.587500000000006p 4.4602309999999999e-05 97.600000000000009p 4.496634e-05 97.612499999999997p 4.5331550000000001e-05 97.625p 4.5697859999999999e-05 97.637500000000003p 4.606519e-05 97.649999999999991p 4.6433420000000003e-05
+ 97.662499999999994p 4.680243e-05 97.674999999999997p 4.7172080000000001e-05 97.6875p 4.7542169999999998e-05 97.700000000000003p 4.7912530000000001e-05 97.712500000000006p 4.828293e-05 97.725000000000009p 4.8653109999999997e-05 97.737499999999997p 4.9022800000000001e-05 97.75p 4.9391690000000003e-05 97.762500000000003p 4.975945e-05 97.775000000000006p 5.0125689999999999e-05 97.787499999999994p 5.0490030000000001e-05 97.799999999999997p 5.0852010000000001e-05 97.8125p 5.1211180000000001e-05 97.824999999999989p 5.1567009999999997e-05 97.837500000000006p 5.191897e-05 97.850000000000009p 5.2266470000000003e-05 97.862499999999997p 5.2608909999999998e-05 97.875p 5.2945619999999998e-05
+ 97.887500000000003p 5.3275919999999997e-05 97.900000000000006p 5.3599089999999999e-05 97.912499999999994p 5.3914379999999999e-05 97.924999999999997p 5.422098e-05 97.9375p 5.4518090000000002e-05 97.949999999999989p 5.4804849999999998e-05 97.962500000000006p 5.5080380000000001e-05 97.975000000000009p 5.5343790000000003e-05 97.987499999999997p 5.5594160000000001e-05 98p 5.5830540000000003e-05 98.012500000000003p 5.6051970000000003e-05 98.025000000000006p 5.6257510000000002e-05 98.037499999999994p 5.644617e-05 98.049999999999997p 5.6616999999999997e-05 98.0625p 5.6769019999999999e-05 98.074999999999989p 5.6901280000000002e-05 98.087500000000006p 5.701284e-05 98.100000000000009p 5.7102799999999998e-05
+ 98.112500000000011p 5.7170270000000002e-05 98.125p 5.7214399999999999e-05 98.137500000000003p 5.7234380000000001e-05 98.150000000000006p 5.7229460000000002e-05 98.162499999999994p 5.7198940000000002e-05 98.174999999999997p 5.7142190000000003e-05 98.1875p 5.7058629999999998e-05 98.199999999999989p 5.6947780000000002e-05 98.212499999999991p 5.6809240000000001e-05 98.225000000000009p 5.6642679999999998e-05 98.237500000000011p 5.6447889999999998e-05 98.25p 5.622474e-05 98.262500000000003p 5.5973210000000002e-05 98.275000000000006p 5.5693399999999998e-05 98.287499999999994p 5.53855e-05 98.299999999999997p 5.5049829999999998e-05 98.3125p 5.4686820000000001e-05 98.324999999999989p 5.429702e-05
+ 98.337499999999991p 5.3881090000000001e-05 98.350000000000009p 5.3439809999999997e-05 98.362500000000011p 5.2974070000000003e-05 98.375p 5.2484870000000001e-05 98.387500000000003p 5.1973330000000001e-05 98.400000000000006p 5.1440660000000001e-05 98.412499999999994p 5.0888179999999997e-05 98.424999999999997p 5.0317279999999999e-05 98.4375p 4.9729460000000003e-05 98.450000000000003p 4.9126289999999997e-05 98.462499999999991p 4.85094e-05 98.474999999999994p 4.7880490000000003e-05 98.487500000000011p 4.7241319999999999e-05 98.5p 4.6593679999999999e-05 98.512500000000003p 4.5939400000000003e-05 98.525000000000006p 4.5280330000000003e-05 98.537499999999994p 4.4618320000000001e-05 98.549999999999997p 4.395526e-05
+ 98.5625p 4.3293e-05 98.575000000000003p 4.2633389999999997e-05 98.587499999999991p 4.1978250000000001e-05 98.599999999999994p 4.1329360000000002e-05 98.612500000000011p 4.068847e-05 98.625p 4.0057269999999998e-05 98.637500000000003p 3.9437390000000002e-05 98.650000000000006p 3.8830379999999999e-05 98.662499999999994p 3.8237749999999998e-05 98.674999999999997p 3.7660909999999998e-05 98.6875p 3.7101190000000002e-05 98.700000000000003p 3.6559810000000003e-05 98.712499999999991p 3.6037939999999999e-05 98.724999999999994p 3.5536630000000003e-05 98.737499999999997p 3.5056820000000001e-05 98.75p 3.4599369999999997e-05 98.762500000000003p 3.4165049999999999e-05 98.775000000000006p 3.3754499999999997e-05
+ 98.787499999999994p 3.3368270000000002e-05 98.799999999999997p 3.3006829999999999e-05 98.8125p 3.2670540000000001e-05 98.825000000000003p 3.2359649999999998e-05 98.837499999999991p 3.2074360000000003e-05 98.849999999999994p 3.1814730000000001e-05 98.862499999999997p 3.1580769999999999e-05 98.875p 3.1372399999999998e-05 98.887500000000003p 3.1189470000000001e-05 98.900000000000006p 3.103175e-05 98.912500000000009p 3.0898939999999999e-05 98.924999999999997p 3.0790700000000003e-05 98.9375p 3.0706620000000003e-05 98.950000000000003p 3.064623e-05 98.962499999999991p 3.060903e-05 98.974999999999994p 3.0594479999999998e-05 98.987499999999997p 3.0601990000000002e-05 99p 3.0630979999999997e-05
+ 99.012500000000003p 3.0680789999999999e-05 99.025000000000006p 3.0750790000000003e-05 99.037500000000009p 3.0840309999999997e-05 99.049999999999997p 3.0948690000000003e-05 99.0625p 3.107524e-05 99.075000000000003p 3.1219300000000001e-05 99.087499999999991p 3.138018e-05 99.099999999999994p 3.1557219999999998e-05 99.112499999999997p 3.1749760000000003e-05 99.125p 3.1957169999999997e-05 99.137500000000003p 3.2178799999999998e-05 99.150000000000006p 3.2414050000000002e-05 99.162500000000009p 3.2662320000000002e-05 99.174999999999997p 3.2923029999999998e-05 99.1875p 3.3195640000000001e-05 99.200000000000003p 3.3479599999999997e-05 99.212499999999991p 3.377441e-05 99.224999999999994p 3.4079570000000003e-05
+ 99.237499999999997p 3.4394609999999998e-05 99.25p 3.4719089999999997e-05 99.262500000000003p 3.5052560000000001e-05 99.275000000000006p 3.5394629999999997e-05 99.287500000000009p 3.5744880000000003e-05 99.299999999999997p 3.6102929999999998e-05 99.3125p 3.6468409999999999e-05 99.325000000000003p 3.684097e-05 99.337499999999991p 3.7220230000000002e-05 99.349999999999994p 3.7605860000000003e-05 99.362499999999997p 3.7997509999999997e-05 99.375p 3.8394820000000002e-05 99.387500000000003p 3.8797449999999999e-05 99.400000000000006p 3.9205049999999998e-05 99.412500000000009p 3.961724e-05 99.424999999999997p 4.0033670000000001e-05 99.4375p 4.0453949999999999e-05 99.450000000000003p 4.0877670000000001e-05
+ 99.462499999999991p 4.130444e-05 99.474999999999994p 4.1733819999999998e-05 99.487499999999997p 4.2165359999999998e-05 99.5p 4.2598600000000002e-05 99.512500000000003p 4.3033050000000003e-05 99.525000000000006p 4.3468199999999998e-05 99.537500000000009p 4.390354e-05 99.549999999999997p 4.4338510000000003e-05 99.5625p 4.4772550000000002e-05 99.575000000000003p 4.5205070000000003e-05 99.587500000000006p 4.5635479999999999e-05 99.599999999999994p 4.606315e-05 99.612499999999997p 4.6487470000000003e-05 99.625p 4.6907779999999997e-05 99.637500000000003p 4.7323439999999998e-05 99.650000000000006p 4.7733779999999999e-05 99.662500000000009p 4.8138150000000003e-05 99.674999999999997p 4.8535880000000003e-05
+ 99.6875p 4.8926299999999999e-05 99.700000000000003p 4.9308760000000002e-05 99.712500000000006p 4.9682589999999997e-05 99.724999999999994p 5.004714e-05 99.737499999999997p 5.0401780000000001e-05 99.75p 5.0745870000000003e-05 99.762499999999989p 5.1078809999999997e-05 99.775000000000006p 5.1399980000000001e-05 99.787500000000009p 5.1708819999999997e-05 99.799999999999997p 5.2004749999999997e-05 99.8125p 5.2287229999999998e-05 99.825000000000003p 5.2555729999999998e-05 99.837500000000006p 5.280974e-05 99.849999999999994p 5.3048789999999999e-05 99.862499999999997p 5.3272410000000002e-05 99.875p 5.3480139999999999e-05 99.887499999999989p 5.3671590000000002e-05 99.900000000000006p 5.3846330000000002e-05
+ 99.912500000000009p 5.4004e-05 99.924999999999997p 5.4144239999999998e-05 99.9375p 5.4266720000000001e-05 99.950000000000003p 5.437112e-05 99.962500000000006p 5.4457160000000002e-05 99.974999999999994p 5.4524580000000002e-05 99.987499999999997p 5.4573139999999997e-05 100p 5.460263e-05 100.01249999999999p 5.4612859999999997e-05 100.02499999999999p 5.460369e-05 100.03750000000001p 5.4574989999999998e-05 100.05000000000001p 5.452668e-05 100.0625p 5.4458710000000002e-05 100.075p 5.4371060000000003e-05 100.08750000000001p 5.4263769999999998e-05 100.09999999999999p 5.4136920000000001e-05 100.1125p 5.399064e-05 100.125p 5.382509e-05
+ 100.13749999999999p 5.3640529999999998e-05 100.14999999999999p 5.3437229999999999e-05 100.16250000000001p 5.3215550000000002e-05 100.17500000000001p 5.2975910000000003e-05 100.1875p 5.2718800000000001e-05 100.2p 5.2444780000000002e-05 100.21250000000001p 5.2154460000000001e-05 100.22499999999999p 5.1848570000000002e-05 100.2375p 5.1527879999999997e-05 100.25p 5.1193260000000001e-05 100.26249999999999p 5.0845630000000002e-05 100.27499999999999p 5.0486019999999999e-05 100.28749999999999p 5.011553e-05 100.30000000000001p 4.973533e-05 100.3125p 4.9346659999999997e-05 100.325p 4.8950860000000003e-05 100.33750000000001p 4.8549330000000002e-05 100.34999999999999p 4.8143509999999998e-05
+ 100.3625p 4.7734949999999999e-05 100.375p 4.7325230000000001e-05 100.3875p 4.6915980000000001e-05 100.39999999999999p 4.6508909999999999e-05 100.41249999999999p 4.6105739999999997e-05 100.42500000000001p 4.5708219999999999e-05 100.4375p 4.5318170000000001e-05 100.45p 4.493738e-05 100.46250000000001p 4.4567670000000002e-05 100.47499999999999p 4.421089e-05 100.4875p 4.3868829999999998e-05 100.5p 4.3543320000000002e-05 100.5125p 4.323613e-05 100.52499999999999p 4.2948999999999998e-05 100.53749999999999p 4.2683660000000003e-05 100.55000000000001p 4.2441750000000001e-05 100.5625p 4.2224870000000001e-05 100.575p 4.2034560000000003e-05
+ 100.58750000000001p 4.1872259999999999e-05 100.59999999999999p 4.1739359999999999e-05 100.6125p 4.1637129999999997e-05 100.625p 4.156675e-05 100.6375p 4.1529310000000003e-05 100.64999999999999p 4.1525749999999998e-05 100.66249999999999p 4.1556939999999998e-05 100.675p 4.1623599999999999e-05 100.6875p 4.1726310000000001e-05 100.7p 4.1865549999999998e-05 100.71250000000001p 4.2041649999999998e-05 100.72500000000001p 4.2254779999999999e-05 100.7375p 4.250499e-05 100.75p 4.2792189999999999e-05 100.7625p 4.311612e-05 100.77499999999999p 4.3476390000000002e-05 100.78749999999999p 4.387245e-05 100.8p 4.4303610000000001e-05
+ 100.8125p 4.476903e-05 100.825p 4.526769e-05 100.83750000000001p 4.5798470000000003e-05 100.85000000000001p 4.6360070000000001e-05 100.8625p 4.6951050000000002e-05 100.875p 4.7569840000000003e-05 100.8875p 4.8214699999999998e-05 100.89999999999999p 4.888378e-05 100.91249999999999p 4.9575099999999999e-05 100.925p 5.0286510000000001e-05 100.9375p 5.101579e-05 100.95p 5.1760540000000003e-05 100.96250000000001p 5.2518310000000002e-05 100.97500000000001p 5.3286479999999997e-05 100.9875p 5.4062379999999998e-05 101p 5.4843219999999998e-05 101.0125p 5.5626120000000001e-05 101.02499999999999p 5.6408159999999997e-05
+ 101.03749999999999p 5.7186309999999999e-05 101.05p 5.7957510000000003e-05 101.0625p 5.8718670000000002e-05 101.075p 5.946664e-05 101.08750000000001p 6.0198280000000001e-05 101.10000000000001p 6.0910430000000001e-05 101.1125p 6.1599960000000004e-05 101.125p 6.2263749999999995e-05 101.1375p 6.2898730000000003e-05 101.14999999999999p 6.3501909999999997e-05 101.16249999999999p 6.4070349999999999e-05 101.175p 6.4601230000000003e-05 101.1875p 6.5091849999999996e-05 101.2p 6.5539599999999998e-05 101.21250000000001p 6.5942090000000006e-05 101.22500000000001p 6.6297029999999994e-05 101.2375p 6.6602359999999995e-05 101.25p 6.6856209999999999e-05
+ 101.2625p 6.705692e-05 101.27499999999999p 6.7203090000000006e-05 101.28749999999999p 6.7293530000000004e-05 101.3p 6.7327329999999997e-05 101.3125p 6.7303839999999994e-05 101.325p 6.7222699999999996e-05 101.33750000000001p 6.7083819999999998e-05 101.35000000000001p 6.6887389999999999e-05 101.3625p 6.6633910000000007e-05 101.375p 6.6324149999999994e-05 101.3875p 6.5959169999999995e-05 101.39999999999999p 6.5540309999999994e-05 101.41249999999999p 6.5069199999999997e-05 101.425p 6.454772e-05 101.4375p 6.3977990000000002e-05 101.45p 6.3362399999999995e-05 101.46250000000001p 6.2703529999999996e-05 101.47500000000001p 6.2004199999999998e-05
+ 101.4875p 6.1267389999999995e-05 101.5p 6.0496260000000003e-05 101.5125p 5.9694110000000002e-05 101.52500000000001p 5.8864370000000003e-05 101.53749999999999p 5.801056e-05 101.55p 5.7136309999999998e-05 101.5625p 5.6245249999999998e-05 101.57499999999999p 5.5341099999999998e-05 101.58750000000001p 5.4427540000000003e-05 101.60000000000001p 5.3508280000000003e-05 101.6125p 5.258695e-05 101.625p 5.1667169999999997e-05 101.6375p 5.0752440000000002e-05 101.65000000000001p 4.9846199999999997e-05 101.66249999999999p 4.8951769999999999e-05 101.675p 4.8072329999999999e-05 101.6875p 4.7210940000000002e-05 101.69999999999999p 4.6370489999999999e-05
+ 101.71250000000001p 4.5553709999999998e-05 101.72500000000001p 4.4763160000000003e-05 101.7375p 4.4001210000000002e-05 101.75p 4.3270070000000002e-05 101.7625p 4.2571709999999998e-05 101.77500000000001p 4.1907960000000003e-05 101.78749999999999p 4.1280409999999999e-05 101.8p 4.0690479999999998e-05 101.8125p 4.0139380000000003e-05 101.82499999999999p 3.9628149999999998e-05 101.83750000000001p 3.915761e-05 101.85000000000001p 3.8728430000000002e-05 101.86250000000001p 3.8341070000000003e-05 101.875p 3.7995859999999997e-05 101.8875p 3.7692920000000001e-05 101.90000000000001p 3.743224e-05 101.91249999999999p 3.7213669999999997e-05 101.925p 3.7036899999999998e-05
+ 101.9375p 3.6901499999999999e-05 101.94999999999999p 3.6806929999999997e-05 101.96249999999999p 3.6752519999999999e-05 101.97500000000001p 3.6737509999999999e-05 101.98750000000001p 3.6761039999999999e-05 102p 3.6822169999999999e-05 102.0125p 3.6919899999999999e-05 102.02500000000001p 3.7053130000000001e-05 102.03749999999999p 3.7220739999999997e-05 102.05p 3.7421539999999997e-05 102.0625p 3.7654290000000002e-05 102.07499999999999p 3.7917750000000001e-05 102.08749999999999p 3.8210609999999997e-05 102.10000000000001p 3.853157e-05 102.11250000000001p 3.8879299999999999e-05 102.125p 3.9252450000000001e-05 102.1375p 3.964969e-05 102.15000000000001p 4.0069679999999999e-05
+ 102.16249999999999p 4.0511060000000003e-05 102.175p 4.0972510000000002e-05 102.1875p 4.1452699999999997e-05 102.2p 4.1950319999999999e-05 102.21249999999999p 4.2464069999999997e-05 102.22499999999999p 4.2992669999999997e-05 102.23750000000001p 4.3534859999999999e-05 102.25p 4.4089389999999998e-05 102.2625p 4.4655050000000002e-05 102.27500000000001p 4.5230630000000002e-05 102.28749999999999p 4.5814969999999999e-05 102.3p 4.6406889999999997e-05 102.3125p 4.7005290000000001e-05 102.325p 4.7609050000000001e-05 102.33749999999999p 4.8217100000000003e-05 102.34999999999999p 4.882837e-05 102.36250000000001p 4.9441850000000002e-05 102.375p 5.0056509999999998e-05
+ 102.3875p 5.0671380000000003e-05 102.40000000000001p 5.1285500000000002e-05 102.41249999999999p 5.1897939999999999e-05 102.425p 5.2507779999999998e-05 102.4375p 5.3114149999999997e-05 102.45p 5.3716169999999997e-05 102.46249999999999p 5.4313010000000001e-05 102.47499999999999p 5.4903849999999998e-05 102.4875p 5.5487900000000001e-05 102.5p 5.6064399999999998e-05 102.5125p 5.6632590000000003e-05 102.52500000000001p 5.7191760000000001e-05 102.53749999999999p 5.7741210000000003e-05 102.55p 5.8280260000000002e-05 102.5625p 5.8808270000000002e-05 102.575p 5.9324589999999997e-05 102.58749999999999p 5.982863e-05 102.59999999999999p 6.0319819999999999e-05
+ 102.6125p 6.0797580000000001e-05 102.625p 6.1261389999999995e-05 102.6375p 6.1710730000000001e-05 102.65000000000001p 6.2145140000000005e-05 102.66250000000001p 6.2564130000000002e-05 102.675p 6.2967280000000001e-05 102.6875p 6.3354180000000003e-05 102.7p 6.3724440000000005e-05 102.71249999999999p 6.4077699999999998e-05 102.72499999999999p 6.4413619999999997e-05 102.7375p 6.4731889999999995e-05 102.75p 6.5032209999999998e-05 102.7625p 6.5314330000000001e-05 102.77500000000001p 6.5577990000000001e-05 102.78750000000001p 6.5822979999999995e-05 102.8p 6.6049089999999997e-05 102.8125p 6.6256149999999994e-05 102.825p 6.6443980000000001e-05
+ 102.83749999999999p 6.6612439999999995e-05 102.84999999999999p 6.6761409999999995e-05 102.8625p 6.6890750000000003e-05 102.875p 6.700036e-05 102.8875p 6.7090149999999993e-05 102.90000000000001p 6.7160010000000001e-05 102.91250000000001p 6.7209870000000006e-05 102.925p 6.7239630000000001e-05 102.9375p 6.7249229999999995e-05 102.95p 6.7238569999999995e-05 102.96249999999999p 6.7207569999999995e-05 102.97499999999999p 6.7156160000000003e-05 102.9875p 6.7084250000000001e-05 103p 6.6991749999999994e-05 103.0125p 6.6878570000000005e-05 103.02500000000001p 6.6744640000000001e-05 103.03750000000001p 6.6589870000000002e-05 103.05p 6.6414180000000004e-05
+ 103.0625p 6.6217520000000002e-05 103.075p 6.5999839999999994e-05 103.08749999999999p 6.5761100000000003e-05 103.09999999999999p 6.5501310000000003e-05 103.1125p 6.5220479999999995e-05 103.125p 6.4918679999999998e-05 103.1375p 6.4596040000000006e-05 103.15000000000001p 6.4252700000000002e-05 103.16250000000001p 6.3888910000000005e-05 103.175p 6.3504950000000006e-05 103.1875p 6.3101200000000005e-05 103.2p 6.2678129999999994e-05 103.21249999999999p 6.2236299999999999e-05 103.22499999999999p 6.1776359999999998e-05 103.2375p 6.1299090000000003e-05 103.25p 6.0805360000000003e-05 103.2625p 6.02962e-05 103.27500000000001p 5.9772719999999999e-05
+ 103.28750000000001p 5.92362e-05 103.3p 5.868803e-05 103.3125p 5.8129740000000003e-05 103.325p 5.7562989999999997e-05 103.33750000000001p 5.6989569999999999e-05 103.34999999999999p 5.6411410000000001e-05 103.3625p 5.5830559999999998e-05 103.375p 5.5249169999999997e-05 103.3875p 5.4669529999999998e-05 103.40000000000001p 5.4094000000000001e-05 103.41250000000001p 5.3525059999999997e-05 103.425p 5.2965250000000003e-05 103.4375p 5.2417180000000002e-05 103.45p 5.188352e-05 103.46250000000001p 5.1366980000000003e-05 103.47499999999999p 5.0870269999999998e-05 103.4875p 5.0396129999999999e-05 103.5p 4.9947280000000001e-05
+ 103.51249999999999p 4.9526420000000002e-05 103.52500000000001p 4.9136199999999999e-05 103.53750000000001p 4.8779210000000003e-05 103.55p 4.845796e-05 103.5625p 4.8174860000000002e-05 103.575p 4.7932210000000002e-05 103.58750000000001p 4.7732199999999997e-05 103.59999999999999p 4.7576849999999998e-05 103.6125p 4.7468040000000003e-05 103.625p 4.7407470000000001e-05 103.63749999999999p 4.7396650000000003e-05 103.65000000000001p 4.743691e-05 103.66250000000001p 4.7529369999999997e-05 103.67500000000001p 4.7674910000000001e-05 103.6875p 4.7874209999999997e-05 103.7p 4.8127699999999997e-05 103.71250000000001p 4.8435569999999999e-05 103.72499999999999p 4.8797780000000001e-05
+ 103.7375p 4.9214e-05 103.75p 4.9683689999999999e-05 103.76249999999999p 5.0206030000000002e-05 103.77499999999999p 5.0779919999999999e-05 103.78750000000001p 5.1404040000000001e-05 103.80000000000001p 5.2076780000000001e-05 103.8125p 5.2796269999999999e-05 103.825p 5.3560409999999997e-05 103.83750000000001p 5.4366810000000003e-05 103.84999999999999p 5.5212859999999998e-05 103.8625p 5.6095689999999998e-05 103.875p 5.7012200000000003e-05 103.88749999999999p 5.7959050000000002e-05 103.89999999999999p 5.8932679999999998e-05 103.91250000000001p 5.9929339999999998e-05 103.92500000000001p 6.0945059999999998e-05 103.9375p 6.1975669999999995e-05 103.95p 6.3016839999999999e-05
+ 103.96250000000001p 6.4064109999999996e-05 103.97499999999999p 6.511283e-05 103.9875p 6.6158260000000004e-05 104p 6.7195539999999993e-05 104.01249999999999p 6.8219760000000004e-05 104.02499999999999p 6.9225929999999999e-05 104.03749999999999p 7.0209029999999993e-05 104.05000000000001p 7.1164050000000002e-05 104.0625p 7.2086010000000001e-05 104.075p 7.296999e-05 104.08750000000001p 7.3811129999999997e-05 104.09999999999999p 7.4604720000000002e-05 104.1125p 7.5346199999999994e-05 104.125p 7.6031190000000004e-05 104.1375p 7.6655540000000001e-05 104.14999999999999p 7.7215349999999996e-05 104.16249999999999p 7.7706990000000006e-05 104.17500000000001p 7.8127190000000006e-05
+ 104.1875p 7.8472980000000004e-05 104.2p 7.8741789999999998e-05 104.21250000000001p 7.8931459999999999e-05 104.22499999999999p 7.9040230000000005e-05 104.2375p 7.9066800000000007e-05 104.25p 7.9010289999999997e-05 104.2625p 7.8870340000000006e-05 104.27499999999999p 7.8647029999999996e-05 104.28749999999999p 7.8340929999999996e-05 104.30000000000001p 7.7953059999999995e-05 104.3125p 7.7484950000000004e-05 104.325p 7.693857e-05 104.33750000000001p 7.631631e-05 104.34999999999999p 7.5621030000000002e-05 104.3625p 7.4855949999999999e-05 104.375p 7.4024680000000002e-05 104.3875p 7.3131190000000001e-05 104.39999999999999p 7.2179729999999998e-05
+ 104.41249999999999p 7.1174849999999998e-05 104.425p 7.0121339999999998e-05 104.4375p 6.9024179999999994e-05 104.45p 6.7888510000000006e-05 104.46250000000001p 6.6719609999999998e-05 104.47500000000001p 6.5522820000000004e-05 104.4875p 6.4303529999999994e-05 104.5p 6.3067139999999994e-05 104.5125p 6.181902e-05 104.52499999999999p 6.0564450000000003e-05 104.53749999999999p 5.9308619999999998e-05 104.55p 5.8056600000000002e-05 104.5625p 5.6813269999999998e-05 104.575p 5.5583340000000003e-05 104.58750000000001p 5.4371279999999998e-05 104.60000000000001p 5.3181360000000003e-05 104.6125p 5.201758e-05 104.625p 5.0883659999999999e-05
+ 104.6375p 4.9783049999999998e-05 104.64999999999999p 4.8718930000000001e-05 104.66249999999999p 4.7694149999999998e-05 104.675p 4.671128e-05 104.6875p 4.5772590000000002e-05 104.7p 4.4880060000000001e-05 104.71250000000001p 4.4035339999999998e-05 104.72500000000001p 4.3239830000000001e-05 104.7375p 4.249463e-05 104.75p 4.1800569999999999e-05 104.7625p 4.1158210000000002e-05 104.77499999999999p 4.0567890000000001e-05 104.78749999999999p 4.002969e-05 104.8p 3.9543470000000003e-05 104.8125p 3.9108900000000001e-05 104.825p 3.8725449999999997e-05 104.83750000000001p 3.8392420000000003e-05 104.85000000000001p 3.8108970000000002e-05
+ 104.8625p 3.7874090000000003e-05 104.875p 3.7686679999999998e-05 104.8875p 3.7545520000000003e-05 104.89999999999999p 3.7449279999999999e-05 104.91249999999999p 3.73966e-05 104.925p 3.7386019999999999e-05 104.9375p 3.741606e-05 104.95p 3.7485189999999997e-05 104.96250000000001p 3.759187e-05 104.97500000000001p 3.7734539999999999e-05 104.9875p 3.7911660000000002e-05 105p 3.8121689999999997e-05 105.0125p 3.7558819999999998e-05 105.02499999999999p 3.7085300000000002e-05 105.03749999999999p 3.6701910000000002e-05 105.05p 3.6405649999999999e-05 105.0625p 3.619226e-05 105.075p 3.6057060000000001e-05
+ 105.08750000000001p 3.599524e-05 105.10000000000001p 3.6001979999999997e-05 105.1125p 3.6072519999999999e-05 105.125p 3.6202180000000002e-05 105.1375p 3.6386359999999998e-05 105.14999999999999p 3.6620579999999998e-05 105.16249999999999p 3.6900470000000001e-05 105.175p 3.7221790000000003e-05 105.1875p 3.758044e-05 105.2p 3.7972449999999999e-05 105.21250000000001p 3.8393999999999999e-05 105.22500000000001p 3.8841419999999999e-05 105.2375p 3.9311190000000003e-05 105.25p 3.9799909999999999e-05 105.2625p 4.0304359999999997e-05 105.27500000000001p 4.0821459999999999e-05 105.28749999999999p 4.1348270000000003e-05 105.3p 4.1881970000000001e-05
+ 105.3125p 4.2419909999999998e-05 105.32499999999999p 4.2959549999999998e-05 105.33750000000001p 4.3498490000000003e-05 105.35000000000001p 4.4034469999999998e-05 105.3625p 4.4565309999999999e-05 105.375p 4.5088990000000001e-05 105.3875p 4.5603589999999998e-05 105.40000000000001p 4.6107289999999997e-05 105.41249999999999p 4.6598399999999998e-05 105.425p 4.707531e-05 105.4375p 4.7536529999999997e-05 105.44999999999999p 4.7980659999999997e-05 105.46250000000001p 4.8406389999999997e-05 105.47500000000001p 4.8812530000000003e-05 105.4875p 4.9197960000000003e-05 105.5p 4.9561660000000001e-05 105.5125p 4.9902699999999999e-05 105.52500000000001p 5.0220229999999999e-05
+ 105.53749999999999p 5.0513509999999997e-05 105.55p 5.078187e-05 105.5625p 5.1024730000000002e-05 105.57499999999999p 5.1241610000000002e-05 105.58749999999999p 5.1432099999999998e-05 105.60000000000001p 5.1595879999999997e-05 105.61250000000001p 5.1732710000000001e-05 105.625p 5.1842460000000001e-05 105.6375p 5.1925049999999998e-05 105.65000000000001p 5.1980500000000001e-05 105.66249999999999p 5.2008909999999997e-05 105.675p 5.2010450000000003e-05 105.6875p 5.1985389999999998e-05 105.69999999999999p 5.1934049999999998e-05 105.71249999999999p 5.1856849999999998e-05 105.72500000000001p 5.1754249999999997e-05 105.73750000000001p 5.162682e-05 105.75p 5.1475170000000003e-05
+ 105.7625p 5.1299959999999997e-05 105.77500000000001p 5.1101950000000003e-05 105.78749999999999p 5.088192e-05 105.8p 5.0640709999999999e-05 105.8125p 5.0379210000000001e-05 105.82499999999999p 5.0098359999999999e-05 105.83749999999999p 4.9799110000000003e-05 105.85000000000001p 4.9482469999999997e-05 105.86250000000001p 4.9149459999999998e-05 105.875p 4.8801119999999997e-05 105.8875p 4.843849e-05 105.90000000000001p 4.8062639999999999e-05 105.91249999999999p 4.7674620000000001e-05 105.925p 4.7275470000000003e-05 105.9375p 4.6866239999999998e-05 105.95p 4.6447930000000002e-05 105.96249999999999p 4.6021520000000001e-05 105.97499999999999p 4.5587950000000001e-05
+ 105.98750000000001p 4.5148139999999998e-05 106p 4.4702920000000003e-05 106.0125p 4.5057359999999997e-05 106.02500000000001p 4.5348469999999999e-05 106.03749999999999p 4.5574670000000001e-05 106.05p 4.573808e-05 106.0625p 4.584211e-05 106.075p 4.5890509999999998e-05 106.08749999999999p 4.5887129999999999e-05 106.09999999999999p 4.5835750000000002e-05 106.11250000000001p 4.5740079999999998e-05 106.125p 4.5603689999999998e-05 106.1375p 4.5429980000000002e-05 106.15000000000001p 4.5222210000000003e-05 106.16249999999999p 4.4983420000000002e-05 106.175p 4.4716489999999997e-05 106.1875p 4.4424069999999998e-05 106.2p 4.4108610000000001e-05
+ 106.21249999999999p 4.3772310000000002e-05 106.22499999999999p 4.341717e-05 106.2375p 4.3044970000000003e-05 106.25p 4.2657239999999998e-05 106.2625p 4.2255310000000003e-05 106.27500000000001p 4.1840269999999998e-05 106.28749999999999p 4.1413019999999999e-05 106.3p 4.097423e-05 106.3125p 4.0524400000000001e-05 106.325p 4.0063839999999997e-05 106.33749999999999p 3.9592699999999998e-05 106.34999999999999p 3.9110960000000003e-05 106.3625p 3.8618490000000002e-05 106.375p 3.8114999999999997e-05 106.3875p 3.7600150000000003e-05 106.40000000000001p 3.7073499999999997e-05 106.41250000000001p 3.6534530000000003e-05 106.425p 3.5982699999999997e-05
+ 106.4375p 3.5417460000000002e-05 106.45p 3.4838259999999999e-05 106.46249999999999p 3.4244540000000003e-05 106.47499999999999p 3.3635830000000003e-05 106.4875p 3.301169e-05 106.5p 3.2371769999999999e-05 106.5125p 3.1715809999999999e-05 106.52500000000001p 3.1043680000000001e-05 106.53750000000001p 3.0355360000000001e-05 106.55p 2.9650969999999999e-05 106.5625p 2.893078e-05 106.575p 2.8195219999999999e-05 106.58749999999999p 2.744487e-05 106.59999999999999p 2.6680489999999999e-05 106.6125p 2.5902989999999998e-05 106.625p 2.511346e-05 106.6375p 2.4313130000000001e-05 106.65000000000001p 2.3503399999999999e-05
+ 106.66250000000001p 2.268582e-05 106.675p 2.1862049999999998e-05 106.6875p 2.103392e-05 106.7p 2.0203320000000002e-05 106.71249999999999p 1.9372279999999999e-05 106.72499999999999p 1.854287e-05 106.7375p 1.7717260000000001e-05 106.75p 1.6897639999999998e-05 106.7625p 1.6086230000000001e-05 106.77500000000001p 1.5285269999999999e-05 106.78750000000001p 1.449697e-05 106.8p 1.372353e-05 106.8125p 1.296707e-05 106.825p 1.2229679999999999e-05 106.83749999999999p 1.151334e-05 106.84999999999999p 1.081995e-05 106.8625p 1.015129e-05 106.875p 9.5089910000000003e-06
+ 106.8875p 8.8945790000000004e-06 106.90000000000001p 8.3094099999999994e-06 106.91250000000001p 7.754684e-06 106.925p 7.2314370000000003e-06 106.9375p 6.7405299999999997e-06 106.95p 6.2826450000000004e-06 106.96249999999999p 5.8582860000000003e-06 106.97499999999999p 5.467777e-06 106.9875p 5.1112570000000004e-06 107p 4.7886880000000001e-06 107.0125p 4.4998539999999999e-06 107.02500000000001p 4.2443689999999997e-06 107.03750000000001p 4.0216760000000002e-06 107.05p 3.8310609999999996e-06 107.0625p 3.6716569999999998e-06 107.075p 3.5424499999999999e-06 107.08750000000001p 3.4422939999999999e-06 107.09999999999999p 3.3699149999999999e-06
+ 107.1125p 3.3239259999999999e-06 107.125p 3.3028360000000001e-06 107.1375p 3.305058e-06 107.15000000000001p 3.3289270000000001e-06 107.16250000000001p 3.3727069999999999e-06 107.175p 3.4346039999999998e-06 107.1875p 3.5127770000000001e-06 107.2p 3.6053500000000001e-06 107.21250000000001p 3.7104239999999999e-06 107.22499999999999p 3.8260859999999997e-06 107.2375p 3.9504240000000001e-06 107.25p 4.0815319999999998e-06 107.26249999999999p 4.2175249999999999e-06 107.27500000000001p 4.3565440000000001e-06 107.28750000000001p 4.4967700000000003e-06 107.3p 4.6364299999999998e-06 107.3125p 4.773804e-06 107.325p 4.9072369999999998e-06
+ 107.33750000000001p 5.0351430000000004e-06 107.34999999999999p 5.1560100000000001e-06 107.3625p 5.2684119999999997e-06 107.375p 5.3710090000000004e-06 107.38749999999999p 5.4625559999999996e-06 107.40000000000001p 5.5419040000000004e-06 107.41250000000001p 5.608009e-06 107.42500000000001p 5.6599330000000001e-06 107.4375p 5.696845e-06 107.45p 5.7180299999999997e-06 107.46250000000001p 5.7228880000000004e-06 107.47499999999999p 5.7109340000000003e-06 107.4875p 5.6818060000000001e-06 107.5p 5.6352599999999998e-06 107.51249999999999p 5.5711760000000003e-06 107.52499999999999p 5.4895569999999998e-06 107.53750000000001p 5.3905289999999996e-06 107.55000000000001p 5.2743420000000004e-06
+ 107.5625p 5.14137e-06 107.575p 4.9921089999999996e-06 107.58750000000001p 4.8271779999999999e-06 107.59999999999999p 4.6473179999999996e-06 107.6125p 4.4533880000000001e-06 107.625p 4.2463649999999998e-06 107.63749999999999p 4.027341e-06 107.64999999999999p 3.7975180000000001e-06 107.66250000000001p 3.5582070000000001e-06 107.67500000000001p 3.3108230000000001e-06 107.6875p 3.056879e-06 107.7p 2.79798e-06 107.71250000000001p 2.535818e-06 107.72499999999999p 2.2721659999999999e-06 107.7375p 2.0088659999999999e-06 107.75p 1.7478250000000001e-06 107.76249999999999p 1.490999e-06 107.77499999999999p 1.24039e-06
+ 107.78749999999999p 9.9802869999999994e-07 107.80000000000001p 7.6596529999999997e-07 107.8125p 5.4625490000000005e-07 107.825p 3.4094459999999999e-07 107.83750000000001p 1.520586e-07 107.84999999999999p -1.8416699999999999e-08 107.8625p -1.6854830000000001e-07 107.875p -2.9647229999999999e-07 107.8875p -4.0041010000000002e-07 107.89999999999999p -4.7868460000000001e-07 107.91249999999999p -5.297357e-07 107.92500000000001p -5.5213630000000004e-07 107.9375p -5.4460709999999997e-07 107.95p -5.0603100000000001e-07 107.96250000000001p -4.3546660000000002e-07 107.97499999999999p -3.3216010000000002e-07 107.9875p -1.9555630000000001e-07 108p -2.5308179999999999e-08
+ 108.0125p 1.7871580000000001e-07 108.02499999999999p 4.1642579999999999e-07 108.03749999999999p 6.8750649999999995e-07 108.05000000000001p 9.9141550000000005e-07 108.0625p 1.327384e-06 108.075p 1.6944180000000001e-06 108.08750000000001p 2.0913050000000001e-06 108.09999999999999p 2.5166190000000001e-06 108.1125p 2.96873e-06 108.125p 3.4458169999999999e-06 108.1375p 3.9458749999999997e-06 108.14999999999999p 4.4667360000000001e-06 108.16249999999999p 5.0060809999999999e-06 108.175p 5.5614590000000004e-06 108.1875p 6.1303060000000002e-06 108.2p 6.7099620000000004e-06 108.21250000000001p 7.2976939999999999e-06 108.22500000000001p 7.8907129999999994e-06
+ 108.2375p 8.4862000000000002e-06 108.25p 9.0813230000000002e-06 108.2625p 9.6732570000000001e-06 108.27499999999999p 1.0259210000000001e-05 108.28749999999999p 1.0836430000000001e-05 108.3p 1.140224e-05 108.3125p 1.195404e-05 108.325p 1.248934e-05 108.33750000000001p 1.300577e-05 108.35000000000001p 1.3501060000000001e-05 108.3625p 1.397312e-05 108.375p 1.441999e-05 108.3875p 1.483988e-05 108.39999999999999p 1.523117e-05 108.41249999999999p 1.5592410000000001e-05 108.425p 1.592233e-05 108.4375p 1.6219860000000001e-05 108.45p 1.6484079999999999e-05
+ 108.46250000000001p 1.671429e-05 108.47500000000001p 1.6909940000000002e-05 108.4875p 1.7070689999999998e-05 108.5p 1.7196329999999999e-05 108.5125p 1.728687e-05 108.52499999999999p 1.7342440000000001e-05 108.53749999999999p 1.736335e-05 108.55p 1.735003e-05 108.5625p 1.7303060000000001e-05 108.575p 1.7223159999999999e-05 108.58750000000001p 1.7111130000000002e-05 108.60000000000001p 1.6967910000000001e-05 108.6125p 1.6794510000000001e-05 108.625p 1.6592029999999998e-05 108.6375p 1.6361639999999999e-05 108.64999999999999p 1.6104550000000002e-05 108.66249999999999p 1.5822049999999999e-05 108.675p 1.5515429999999999e-05
+ 108.6875p 1.518603e-05 108.7p 1.4835189999999999e-05 108.71250000000001p 1.446425e-05 108.72500000000001p 1.407454e-05 108.7375p 1.3667400000000001e-05 108.75p 1.3244100000000001e-05 108.7625p 1.28059e-05 108.77499999999999p 1.2354029999999999e-05 108.78749999999999p 1.1889650000000001e-05 108.8p 1.1413870000000001e-05 108.8125p 1.092774e-05 108.825p 1.043227e-05 108.83750000000001p 9.9283630000000001e-06 108.85000000000001p 9.4168829999999997e-06 108.8625p 8.8986109999999999e-06 108.875p 8.3742580000000006e-06 108.8875p 7.8444650000000001e-06 108.89999999999999p 7.3098010000000001e-06
+ 108.91249999999999p 6.7707679999999996e-06 108.925p 6.2278010000000001e-06 108.9375p 5.6812739999999998e-06 108.95p 5.1315020000000004e-06 108.96250000000001p 4.5787449999999996e-06 108.97500000000001p 4.0232169999999997e-06 108.9875p 3.4650899999999998e-06 109p 2.9044990000000001e-06 109.0125p 2.3415500000000001e-06 109.02500000000001p 1.7763269999999999e-06 109.03749999999999p 1.208899e-06 109.05p 6.3932830000000002e-07 109.0625p 6.7675369999999994e-08 109.07499999999999p -5.0599140000000004e-07 109.08750000000001p -1.0815900000000001e-06 109.10000000000001p -1.6590159999999999e-06 109.1125p -2.2381409999999999e-06 109.125p -2.8188e-06
+ 109.1375p -3.400789e-06 109.15000000000001p -3.9838620000000003e-06 109.16249999999999p -4.5677229999999999e-06 109.175p -5.1520239999999998e-06 109.1875p -5.7363620000000001e-06 109.19999999999999p -6.3202769999999999e-06 109.21250000000001p -6.9032490000000001e-06 109.22500000000001p -7.4846999999999997e-06 109.2375p -8.0639909999999998e-06 109.25p -8.6404279999999994e-06 109.2625p -9.213256e-06 109.27500000000001p -9.7816710000000006e-06 109.28749999999999p -1.034481e-05 109.3p -1.090178e-05 109.3125p -1.1451629999999999e-05 109.32499999999999p -1.1993370000000001e-05 109.33749999999999p -1.2526e-05 109.35000000000001p -1.304847e-05
+ 109.36250000000001p -1.355972e-05 109.375p -1.4058690000000001e-05 109.3875p -1.454429e-05 109.40000000000001p -1.5015459999999999e-05 109.41249999999999p -1.547113e-05 109.425p -1.5910240000000002e-05 109.4375p -1.633178e-05 109.44999999999999p -1.673474e-05 109.46249999999999p -1.7118150000000001e-05 109.47500000000001p -1.7481109999999998e-05 109.48750000000001p -1.782273e-05 109.5p -1.814219e-05 109.5125p -1.8438720000000002e-05 109.52500000000001p -1.8711630000000001e-05 109.53749999999999p -1.8960280000000001e-05 109.55p -1.9184100000000002e-05 109.5625p -1.9382589999999999e-05 109.57499999999999p -1.955532e-05
+ 109.58749999999999p -1.9701949999999999e-05 109.60000000000001p -1.9822200000000001e-05 109.61250000000001p -1.9915870000000001e-05 109.625p -1.9982840000000001e-05 109.6375p -2.0023069999999999e-05 109.65000000000001p -2.0036579999999999e-05 109.66249999999999p -2.002347e-05 109.675p -1.9983910000000001e-05 109.6875p -1.991813e-05 109.7p -1.982644e-05 109.71249999999999p -1.970919e-05 109.72499999999999p -1.9566810000000001e-05 109.73750000000001p -1.9399770000000001e-05 109.75p -1.920858e-05 109.7625p -1.899383e-05 109.77500000000001p -1.875612e-05 109.78749999999999p -1.849609e-05 109.8p -1.8214429999999998e-05
+ 109.8125p -1.791184e-05 109.825p -1.7589050000000001e-05 109.83749999999999p -1.724681e-05 109.84999999999999p -1.688589e-05 109.86250000000001p -1.650705e-05 109.875p -1.6111080000000001e-05 109.8875p -1.5698770000000001e-05 109.90000000000001p -1.52709e-05 109.91249999999999p -1.4828239999999999e-05 109.925p -1.437158e-05 109.9375p -1.390166e-05 109.95p -1.341925e-05 109.96249999999999p -1.2925070000000001e-05 109.97499999999999p -1.241984e-05 109.9875p -1.1904259999999999e-05 110p -1.137901e-05 110.0125p -1.084473e-05 110.02500000000001p -1.030207e-05
+ 110.03749999999999p -9.7516369999999995e-06 110.05p -9.1940119999999999e-06 110.0625p -8.6297589999999994e-06 110.075p -8.0594189999999998e-06 110.08749999999999p -7.4835079999999998e-06 110.09999999999999p -6.9025200000000001e-06 110.1125p -6.3169310000000003e-06 110.125p -5.727193e-06 110.1375p -5.1337420000000004e-06 110.15000000000001p -4.5369980000000003e-06 110.16250000000001p -3.9373630000000002e-06 110.175p -3.3352299999999998e-06 110.1875p -2.7309770000000002e-06 110.2p -2.124977e-06 110.21249999999999p -1.5175929999999999e-06 110.22499999999999p -9.0918749999999999e-07 110.2375p -3.0011759999999999e-07 110.25p 3.0925689999999998e-07
+ 110.2625p 9.1857419999999999e-07 110.27500000000001p 1.5274669999999999e-06 110.28750000000001p 2.1355609999999999e-06 110.3p 2.7424729999999999e-06 110.3125p 3.3478060000000001e-06 110.325p 3.9511540000000004e-06 110.33749999999999p 4.5520919999999998e-06 110.34999999999999p 5.1501809999999999e-06 110.3625p 5.7449639999999999e-06 110.375p 6.3359669999999997e-06 110.3875p 6.9226929999999998e-06 110.40000000000001p 7.5046290000000003e-06 110.41250000000001p 8.0812419999999997e-06 110.425p 8.6519760000000005e-06 110.4375p 9.2162589999999997e-06 110.45p 9.7734980000000001e-06 110.46249999999999p 1.032308e-05 110.47499999999999p 1.086439e-05
+ 110.4875p 1.139677e-05 110.5p 1.1919560000000001e-05 110.5125p 1.243211e-05 110.52500000000001p 1.2933740000000001e-05 110.53750000000001p 1.3423739999999999e-05 110.55p 1.390144e-05 110.5625p 1.436613e-05 110.575p 1.481713e-05 110.58749999999999p 1.5253720000000001e-05 110.59999999999999p 1.5675240000000001e-05 110.6125p 1.6080979999999999e-05 110.625p 1.6470279999999999e-05 110.6375p 1.6842479999999999e-05 110.65000000000001p 1.7196940000000001e-05 110.66250000000001p 1.753301e-05 110.675p 1.78501e-05 110.6875p 1.814762e-05 110.7p 1.8425010000000001e-05
+ 110.71249999999999p 1.8681719999999999e-05 110.72499999999999p 1.8917270000000001e-05 110.7375p 1.9131160000000001e-05 110.75p 1.9322969999999999e-05 110.7625p 1.949226e-05 110.77500000000001p 1.9638680000000001e-05 110.78750000000001p 1.976188e-05 110.8p 1.986155e-05 110.8125p 1.9937439999999999e-05 110.825p 1.9989309999999999e-05 110.83750000000001p 2.0016990000000001e-05 110.84999999999999p 2.002032e-05 110.8625p 1.99992e-05 110.875p 1.9953559999999999e-05 110.8875p 1.9883379999999999e-05 110.90000000000001p 1.978866e-05 110.91250000000001p 1.9669480000000001e-05 110.925p 1.952592e-05
+ 110.9375p 1.9358129999999999e-05 110.95p 1.9166279999999998e-05 110.96250000000001p 1.895058e-05 110.97499999999999p 1.8711309999999999e-05 110.9875p 1.8448749999999998e-05 111p 1.8163239999999999e-05 111.01249999999999p 1.7855150000000001e-05 111.02500000000001p 1.752491e-05 111.03750000000001p 1.717295e-05 111.05p 1.679978e-05 111.0625p 1.6405909999999999e-05 111.075p 1.5991899999999998e-05 111.08750000000001p 1.5558339999999999e-05 111.09999999999999p 1.5105880000000001e-05 111.1125p 1.4635160000000001e-05 111.125p 1.4146889999999999e-05 111.13749999999999p 1.364179e-05 111.15000000000001p 1.3120620000000001e-05
+ 111.16250000000001p 1.258415e-05 111.17500000000001p 1.2033209999999999e-05 111.1875p 1.1468629999999999e-05 111.2p 1.0891260000000001e-05 111.21250000000001p 1.0302000000000001e-05 111.22499999999999p 9.7017370000000002e-06 111.2375p 9.091404e-06 111.25p 8.4719340000000007e-06 111.26249999999999p 7.8442780000000003e-06 111.27499999999999p 7.2093970000000001e-06 111.28750000000001p 6.5682610000000003e-06 111.30000000000001p 5.9218480000000003e-06 111.3125p 5.2711369999999998e-06 111.325p 4.6171100000000001e-06 111.33750000000001p 3.960746e-06 111.34999999999999p 3.303018e-06 111.3625p 2.6448949999999999e-06 111.375p 1.9873329999999999e-06
+ 111.38749999999999p 1.3312770000000001e-06 111.39999999999999p 6.7765559999999997e-07 111.41250000000001p 2.738039e-08 111.42500000000001p -6.1865760000000004e-07 111.4375p -1.2595899999999999e-06 111.45p -1.8945729999999999e-06 111.46250000000001p -2.5227890000000001e-06 111.47499999999999p -3.1434490000000001e-06 111.4875p -3.7557969999999998e-06 111.5p -4.3591030000000002e-06 111.51249999999999p -4.9526769999999996e-06 111.52499999999999p -5.5358569999999997e-06 111.53749999999999p -6.1080190000000001e-06 111.55000000000001p -6.6685760000000002e-06 111.5625p -7.2169740000000002e-06 111.575p -7.7526990000000001e-06 111.58750000000001p -8.2752699999999998e-06 111.59999999999999p -8.7842469999999999e-06
+ 111.6125p -9.2792219999999994e-06 111.625p -9.7598260000000004e-06 111.6375p -1.0225720000000001e-05 111.64999999999999p -1.0676609999999999e-05 111.66249999999999p -1.1112230000000001e-05 111.67500000000001p -1.1532340000000001e-05 111.6875p -1.1936730000000001e-05 111.7p -1.232524e-05 111.71250000000001p -1.269772e-05 111.72499999999999p -1.305404e-05 111.7375p -1.339411e-05 111.75p -1.3717869999999999e-05 111.7625p -1.4025249999999999e-05 111.77499999999999p -1.4316230000000001e-05 111.78749999999999p -1.4590799999999999e-05 111.8p -1.484896e-05 111.8125p -1.509071e-05 111.825p -1.5316100000000001e-05
+ 111.83750000000001p -1.5525140000000001e-05 111.84999999999999p -1.5717900000000001e-05 111.8625p -1.5894409999999999e-05 111.875p -1.605474e-05 111.8875p -1.619893e-05 111.89999999999999p -1.6327040000000001e-05 111.91249999999999p -1.6439139999999999e-05 111.925p -1.6535269999999999e-05 111.9375p -1.661549e-05 111.95p -1.6679839999999999e-05 111.96250000000001p -1.6728369999999999e-05 111.97500000000001p -1.6761109999999998e-05 111.9875p -1.677808e-05 112p -1.6779319999999998e-05 112.0125p -1.6764839999999999e-05 112.02499999999999p -1.673464e-05 112.03749999999999p -1.668873e-05 112.05p -1.6627109999999999e-05
+ 112.0625p -1.6549759999999999e-05 112.075p -1.6456669999999999e-05 112.08750000000001p -1.6347820000000001e-05 112.10000000000001p -1.6223200000000001e-05 112.1125p -1.6082769999999999e-05 112.125p -1.5926529999999999e-05 112.1375p -1.575445e-05 112.14999999999999p -1.5566519999999999e-05 112.16249999999999p -1.5362750000000001e-05 112.175p -1.5143129999999999e-05 112.1875p -1.4907669999999999e-05 112.2p -1.4656420000000001e-05 112.21250000000001p -1.438942e-05 112.22500000000001p -1.410673e-05 112.2375p -1.380845e-05 112.25p -1.349468e-05 112.2625p -1.316558e-05 112.27499999999999p -1.28213e-05
+ 112.28749999999999p -1.2462059999999999e-05 112.3p -1.208807e-05 112.3125p -1.1699629999999999e-05 112.325p -1.129702e-05 112.33750000000001p -1.08806e-05 112.35000000000001p -1.045075e-05 112.3625p -1.000791e-05 112.375p -9.5525259999999999e-06 112.3875p -9.0851200000000002e-06 112.39999999999999p -8.6062390000000007e-06 112.41249999999999p -8.1164739999999998e-06 112.425p -7.6164550000000001e-06 112.4375p -7.1068530000000003e-06 112.45p -6.5883750000000003e-06 112.46250000000001p -6.0617629999999998e-06 112.47500000000001p -5.5277950000000003e-06 112.4875p -4.9872770000000001e-06 112.5p -4.4410460000000003e-06
+ 112.5125p -3.8899620000000002e-06 112.52499999999999p -3.3349079999999998e-06 112.53749999999999p -2.7767839999999998e-06 112.55p -2.2165049999999998e-06 112.5625p -1.655e-06 112.575p -1.0931989999999999e-06 112.58750000000001p -5.3203879999999998e-07 112.60000000000001p 2.7546439999999999e-08 112.6125p 5.8462830000000004e-07 112.625p 1.1382880000000001e-06 112.6375p 1.6876200000000001e-06 112.64999999999999p 2.2317370000000001e-06 112.66249999999999p 2.769773e-06 112.675p 3.3008860000000001e-06 112.6875p 3.8242630000000004e-06 112.7p 4.3391230000000001e-06 112.71250000000001p 4.8447179999999996e-06 112.72500000000001p 5.3403380000000001e-06
+ 112.7375p 5.825311e-06 112.75p 6.2990070000000002e-06 112.7625p 6.7608380000000003e-06 112.77500000000001p 7.2102610000000002e-06 112.78749999999999p 7.6467760000000004e-06 112.8p 8.0699299999999992e-06 112.8125p 8.4793140000000002e-06 112.82499999999999p 8.874566e-06 112.83750000000001p 9.2553659999999998e-06 112.85000000000001p 9.6214400000000002e-06 112.8625p 9.9725559999999997e-06 112.875p 1.0308519999999999e-05 112.8875p 1.0629190000000001e-05 112.90000000000001p 1.0934439999999999e-05 112.91249999999999p 1.12242e-05 112.925p 1.1498410000000001e-05 112.9375p 1.1757069999999999e-05 112.94999999999999p 1.200017e-05
+ 112.96250000000001p 1.2227760000000001e-05 112.97500000000001p 1.243989e-05 112.9875p 1.2636630000000001e-05 113p 1.2818060000000001e-05 113.0125p 1.2984280000000001e-05 113.02500000000001p 1.313541e-05 113.03749999999999p 1.327155e-05 113.05p 1.339282e-05 113.0625p 1.349933e-05 113.07499999999999p 1.3591190000000001e-05 113.08749999999999p 1.366851e-05 113.10000000000001p 1.373139e-05 113.11250000000001p 1.377992e-05 113.125p 1.3814179999999999e-05 113.1375p 1.3834229999999999e-05 113.15000000000001p 1.384013e-05 113.16249999999999p 1.383192e-05 113.175p 1.3809629999999999e-05
+ 113.1875p 1.3773279999999999e-05 113.19999999999999p 1.372285e-05 113.21249999999999p 1.365834e-05 113.22500000000001p 1.357973e-05 113.23750000000001p 1.348698e-05 113.25p 1.3380050000000001e-05 113.2625p 1.3258899999999999e-05 113.27500000000001p 1.312347e-05 113.28749999999999p 1.2973720000000001e-05 113.3p 1.28096e-05 113.3125p 1.263107e-05 113.32499999999999p 1.24381e-05 113.33749999999999p 1.223068e-05 113.35000000000001p 1.2008799999999999e-05 113.36250000000001p 1.17725e-05 113.375p 1.152182e-05 113.3875p 1.125684e-05 113.40000000000001p 1.097768e-05
+ 113.41249999999999p 1.0684479999999999e-05 113.425p 1.0377439999999999e-05 113.4375p 1.005678e-05 113.45p 9.7228049999999998e-06 113.46249999999999p 9.3758299999999996e-06 113.47499999999999p 9.0162449999999999e-06 113.48750000000001p 8.6444869999999994e-06 113.5p 8.2610510000000005e-06 113.5125p 7.8664869999999994e-06 113.52500000000001p 7.4614009999999996e-06 113.53749999999999p 7.0464570000000001e-06 113.55p 6.622374e-06 113.5625p 6.1899260000000001e-06 113.575p 5.7499380000000004e-06 113.58749999999999p 5.3032889999999996e-06 113.59999999999999p 4.8509009999999998e-06 113.61250000000001p 4.3937430000000001e-06 113.625p 3.9328209999999998e-06
+ 113.6375p 3.4691789999999998e-06 113.65000000000001p 3.0038879999999998e-06 113.66249999999999p 2.5380469999999999e-06 113.675p 2.072774e-06 113.6875p 1.609199e-06 113.7p 1.148459e-06 113.71249999999999p 6.9169520000000004e-07 113.72499999999999p 2.4004039999999999e-07 113.7375p -2.0538319999999999e-07 113.75p -6.4347150000000002e-07 113.7625p -1.0731449999999999e-06 113.77500000000001p -1.493356e-06 113.78750000000001p -1.903091e-06 113.8p -2.3013809999999998e-06 113.8125p -2.687305e-06 113.825p -3.0599929999999999e-06 113.83749999999999p -3.4186350000000001e-06 113.84999999999999p -3.7624810000000001e-06
+ 113.8625p -4.0908480000000003e-06 113.875p -4.4031219999999996e-06 113.8875p -4.6987600000000004e-06 113.90000000000001p -4.9772929999999998e-06 113.91250000000001p -5.2383299999999999e-06 113.925p -5.4815559999999998e-06 113.9375p -5.7067339999999996e-06 113.95p -5.9137050000000002e-06 113.96249999999999p -6.1023869999999997e-06 113.97499999999999p -6.2727780000000001e-06 113.9875p -6.4249479999999997e-06 114p -6.5590420000000001e-06 114.0125p -6.6752790000000003e-06 114.02500000000001p -6.7739429999999998e-06 114.03750000000001p -6.8553859999999997e-06 114.05p -6.9200239999999996e-06 114.0625p -6.9683279999999998e-06 114.075p -7.0008269999999996e-06
+ 114.08749999999999p -7.0180990000000004e-06 114.09999999999999p -7.0207679999999997e-06 114.1125p -7.0094990000000002e-06 114.125p -6.9849949999999997e-06 114.1375p -6.9479879999999999e-06 114.15000000000001p -6.8992400000000002e-06 114.16250000000001p -6.8395289999999996e-06 114.175p -6.7696560000000002e-06 114.1875p -6.690427e-06 114.2p -6.6026579999999996e-06 114.21249999999999p -6.5071650000000002e-06 114.22499999999999p -6.4047590000000004e-06 114.2375p -6.296246e-06 114.25p -6.1824140000000003e-06 114.2625p -6.0640379999999997e-06 114.27500000000001p -5.9418679999999998e-06 114.28750000000001p -5.8166289999999997e-06 114.3p -5.6890180000000002e-06
+ 114.3125p -5.5596960000000002e-06 114.325p -5.4292880000000004e-06 114.33749999999999p -5.298379e-06 114.34999999999999p -5.1675129999999998e-06 114.3625p -5.0371870000000001e-06 114.375p -4.9078510000000002e-06 114.3875p -4.7799039999999999e-06 114.40000000000001p -4.6536970000000001e-06 114.41250000000001p -4.5295249999999996e-06 114.425p -4.4076330000000002e-06 114.4375p -4.2882090000000003e-06 114.45p -4.1713869999999998e-06 114.46249999999999p -4.0572470000000001e-06 114.47499999999999p -3.9458140000000004e-06 114.4875p -3.8370599999999998e-06 114.5p -3.730903e-06 114.5125p -3.62721e-06 114.52500000000001p -3.5257980000000001e-06
+ 114.53750000000001p -3.4264360000000001e-06 114.55p -3.328847e-06 114.5625p -3.2327099999999998e-06 114.575p -3.1376650000000001e-06 114.58750000000001p -3.0433129999999999e-06 114.59999999999999p -2.949221e-06 114.6125p -2.8549270000000001e-06 114.625p -2.7599419999999999e-06 114.6375p -2.6637539999999998e-06 114.65000000000001p -2.5658340000000002e-06 114.66250000000001p -2.4656409999999998e-06 114.675p -2.362621e-06 114.6875p -2.2562219999999999e-06 114.7p -2.1458869999999999e-06 114.71250000000001p -2.031072e-06 114.72499999999999p -1.9112379999999998e-06 114.7375p -1.785866e-06 114.75p -1.6544570000000001e-06
+ 114.76249999999999p -1.516539e-06 114.77500000000001p -1.371672e-06 114.78750000000001p -1.219449e-06 114.8p -1.059507e-06 114.8125p -8.9152419999999997e-07 114.825p -7.1522939999999997e-07 114.83750000000001p -5.304032e-07 114.84999999999999p -3.3688160000000002e-07 114.8625p -1.345591e-07 114.875p 7.6608930000000005e-08 114.88749999999999p 2.9660390000000001e-07 114.90000000000001p 5.2534289999999995e-07 114.91250000000001p 7.626772e-07 114.92500000000001p 1.0083919999999999e-06 114.9375p 1.2622050000000001e-06 114.95p 1.5237699999999999e-06 114.96250000000001p 1.792675e-06 114.97499999999999p 2.0684439999999999e-06
+ 114.9875p 2.35054e-06 115p 2.6383659999999999e-06 115.01249999999999p 2.9312719999999999e-06 115.02499999999999p 3.228551e-06 115.03750000000001p 3.5294520000000002e-06 115.05000000000001p 3.8331749999999999e-06 115.0625p 4.1388820000000002e-06 115.075p 4.4456999999999996e-06 115.08750000000001p 4.7527240000000001e-06 115.09999999999999p 5.0590269999999999e-06 115.1125p 5.3636599999999997e-06 115.125p 5.6656600000000004e-06 115.13749999999999p 5.9640559999999998e-06 115.14999999999999p 6.257876e-06 115.16250000000001p 6.5461489999999998e-06 115.17500000000001p 6.827913e-06 115.1875p 7.1022189999999998e-06 115.2p 7.3681370000000002e-06
+ 115.21250000000001p 7.6247619999999996e-06 115.22499999999999p 7.871217e-06 115.2375p 8.1066570000000005e-06 115.25p 8.3302780000000003e-06 115.26249999999999p 8.5413120000000002e-06 115.27499999999999p 8.7390390000000005e-06 115.28749999999999p 8.9227869999999998e-06 115.30000000000001p 9.0919309999999999e-06 115.3125p 9.2459030000000006e-06 115.325p 9.3841860000000008e-06 115.33750000000001p 9.5063219999999993e-06 115.34999999999999p 9.6119069999999994e-06 115.3625p 9.7005979999999994e-06 115.375p 9.7721079999999994e-06 115.3875p 9.8262099999999999e-06 115.39999999999999p 9.8627320000000005e-06 115.41249999999999p 9.8815619999999998e-06 115.42500000000001p 9.8826420000000008e-06
+ 115.4375p 9.8659669999999998e-06 115.45p 9.8315879999999997e-06 115.46250000000001p 9.7796050000000007e-06 115.47499999999999p 9.7101670000000004e-06 115.4875p 9.6234679999999994e-06 115.5p 9.5197479999999993e-06 115.5125p 9.399286e-06 115.52499999999999p 9.2623999999999996e-06 115.53749999999999p 9.1094460000000004e-06 115.55p 8.9408079999999994e-06 115.5625p 8.7569030000000007e-06 115.575p 8.558173e-06 115.58750000000001p 8.3450860000000008e-06 115.59999999999999p 8.1181279999999993e-06 115.6125p 7.8778049999999997e-06 115.625p 7.6246370000000002e-06 115.6375p 7.3591590000000001e-06 115.64999999999999p 7.0819139999999999e-06
+ 115.66249999999999p 6.7934540000000003e-06 115.675p 6.494336e-06 115.6875p 6.1851219999999996e-06 115.7p 5.8663750000000002e-06 115.71250000000001p 5.5386569999999999e-06 115.72500000000001p 5.2025310000000004e-06 115.7375p 4.858556e-06 115.75p 4.5072879999999997e-06 115.7625p 4.1492760000000004e-06 115.77499999999999p 3.7850670000000001e-06 115.78749999999999p 3.4151990000000001e-06 115.8p 3.0402039999999998e-06 115.8125p 2.660609e-06 115.825p 2.276933e-06 115.83750000000001p 1.8896869999999999e-06 115.85000000000001p 1.499377e-06 115.8625p 1.106502e-06 115.875p 7.1155369999999996e-07
+ 115.8875p 3.150196e-07 115.89999999999999p -8.2618620000000005e-08 115.91249999999999p -4.8088400000000001e-07 115.925p -8.7930380000000001e-07 115.9375p -1.2774090000000001e-06 115.95p -1.6747320000000001e-06 115.96250000000001p -2.0708109999999998e-06 115.97500000000001p -2.4651820000000001e-06 115.9875p -2.857386e-06 116p -3.246963e-06 116.0125p -3.633454e-06 116.02499999999999p -4.0164009999999996e-06 116.03749999999999p -4.3953460000000001e-06 116.05p -4.76983e-06 116.0625p -5.1393949999999999e-06 116.075p -5.5035830000000003e-06 116.08750000000001p -5.8619380000000004e-06 116.10000000000001p -6.214003e-06
+ 116.1125p -6.5593229999999996e-06 116.125p -6.8974430000000004e-06 116.1375p -7.2279139999999998e-06 116.14999999999999p -7.5502869999999998e-06 116.16249999999999p -7.8641199999999995e-06 116.175p -8.1689730000000004e-06 116.1875p -8.4644139999999998e-06 116.2p -8.7500170000000008e-06 116.21250000000001p -9.0253669999999997e-06 116.22500000000001p -9.2900540000000002e-06 116.2375p -9.5436820000000006e-06 116.25p -9.7858670000000003e-06 116.2625p -1.001624e-05 116.27499999999999p -1.023443e-05 116.28749999999999p -1.044012e-05 116.3p -1.063296e-05 116.3125p -1.081266e-05 116.325p -1.097893e-05
+ 116.33750000000001p -1.1131510000000001e-05 116.35000000000001p -1.127014e-05 116.3625p -1.1394599999999999e-05 116.375p -1.1504709999999999e-05 116.3875p -1.1600269999999999e-05 116.39999999999999p -1.1681150000000001e-05 116.41249999999999p -1.1747210000000001e-05 116.42499999999998p -1.1798359999999999e-05 116.43749999999999p -1.183453e-05 116.45p -1.185567e-05 116.46250000000001p -1.1861759999999999e-05 116.47500000000001p -1.185281e-05 116.48750000000001p -1.182886e-05 116.50000000000001p -1.178996e-05 116.51249999999999p -1.173621e-05 116.52499999999999p -1.166772e-05 116.53749999999999p -1.1584620000000001e-05 116.55p -1.1487080000000001e-05
+ 116.5625p -1.1375299999999999e-05 116.575p -1.1249469999999999e-05 116.58750000000001p -1.1109839999999999e-05 116.59999999999999p -1.0956669999999999e-05 116.6125p -1.079022e-05 116.625p -1.06108e-05 116.6375p -1.0418729999999999e-05 116.65000000000001p -1.021433e-05 116.66250000000001p -9.9979619999999992e-06 116.67499999999998p -9.7699870000000008e-06 116.68749999999999p -9.5307849999999992e-06 116.69999999999999p -9.2807489999999998e-06 116.71250000000001p -9.0202849999999996e-06 116.72500000000001p -8.7498080000000007e-06 116.73750000000001p -8.4697419999999995e-06 116.75000000000001p -8.1805219999999992e-06 116.76249999999999p -7.8825859999999997e-06 116.77499999999999p -7.5763830000000002e-06
+ 116.78749999999999p -7.2623629999999997e-06 116.8p -6.940982e-06 116.8125p -6.6126970000000004e-06 116.825p -6.2779700000000003e-06 116.83750000000001p -5.9372609999999999e-06 116.84999999999999p -5.5910320000000004e-06 116.8625p -5.2397440000000004e-06 116.875p -4.8838580000000001e-06 116.8875p -4.5238300000000002e-06 116.90000000000001p -4.160117e-06 116.91250000000001p -3.7931710000000002e-06 116.92500000000001p -3.4234410000000002e-06 116.93749999999999p -3.0513720000000002e-06 116.94999999999999p -2.6774040000000001e-06 116.96249999999999p -2.3019750000000001e-06 116.97500000000001p -1.9255149999999998e-06 116.98750000000001p -1.548451e-06 117.00000000000001p -1.171205e-06
+ 117.01249999999999p -7.9419240000000002e-07 117.02499999999999p -4.1782439999999999e-07 117.03749999999999p -4.2506620000000003e-08 117.05p 3.3136039999999999e-07 117.0625p 7.0338139999999999e-07 117.075p 1.0731660000000001e-06 117.08750000000001p 1.44033e-06 117.09999999999999p 1.8044930000000001e-06 117.1125p 2.1652789999999999e-06 117.125p 2.522318e-06 117.1375p 2.8752450000000002e-06 117.15000000000001p 3.2236980000000001e-06 117.16250000000001p 3.5673210000000001e-06 117.17500000000001p 3.9057609999999999e-06 117.18749999999999p 4.2386719999999998e-06 117.19999999999999p 4.5657089999999998e-06 117.21249999999999p 4.8865340000000002e-06 117.22499999999999p 5.2008140000000002e-06
+ 117.23750000000001p 5.5082180000000001e-06 117.25000000000001p 5.8084210000000001e-06 117.26250000000002p 6.1011050000000003e-06 117.27499999999999p 6.3859540000000004e-06 117.28749999999999p 6.6626590000000001e-06 117.3p 6.9309159999999996e-06 117.3125p 7.1904279999999997e-06 117.325p 7.4409030000000001e-06 117.33750000000001p 7.6820560000000002e-06 117.34999999999999p 7.9136100000000006e-06 117.3625p 8.1352949999999995e-06 117.375p 8.3468480000000008e-06 117.3875p 8.5480160000000006e-06 117.40000000000001p 8.7385540000000005e-06 117.41250000000001p 8.9182269999999993e-06 117.42500000000001p 9.0868099999999998e-06 117.43749999999999p 9.2440880000000007e-06 117.44999999999999p 9.3898579999999998e-06
+ 117.46249999999999p 9.5239280000000003e-06 117.47499999999999p 9.6461179999999999e-06 117.4875p 9.7562639999999999e-06 117.50000000000001p 9.8542100000000003e-06 117.51250000000002p 9.9398180000000002e-06 117.52499999999999p 1.0012959999999999e-05 117.53749999999999p 1.007354e-05 117.55p 1.012144e-05 117.5625p 1.01566e-05 117.575p 1.017895e-05 117.58750000000001p 1.0188450000000001e-05 117.60000000000001p 1.0185060000000001e-05 117.6125p 1.016878e-05 117.625p 1.013962e-05 117.6375p 1.0097590000000001e-05 117.65000000000001p 1.0042740000000001e-05 117.66250000000001p 9.9751259999999999e-06 117.67500000000001p 9.8948340000000002e-06
+ 117.68749999999999p 9.8019569999999994e-06 117.69999999999999p 9.6966120000000008e-06 117.71249999999999p 9.5789319999999999e-06 117.72499999999999p 9.4490700000000003e-06 117.7375p 9.3071960000000003e-06 117.75p 9.1534990000000003e-06 117.76250000000002p 8.9881859999999998e-06 117.77499999999999p 8.8114780000000001e-06 117.78749999999999p 8.6236180000000008e-06 117.8p 8.424863e-06 117.8125p 8.2154870000000006e-06 117.825p 7.9957780000000004e-06 117.83750000000001p 7.7660430000000008e-06 117.85000000000001p 7.5266000000000001e-06 117.86249999999998p 7.2777840000000004e-06 117.875p 7.019941e-06 117.8875p 6.7534319999999996e-06 117.90000000000001p 6.4786290000000003e-06
+ 117.91250000000001p 6.1959149999999996e-06 117.92500000000001p 5.9056839999999996e-06 117.93750000000001p 5.6083390000000002e-06 117.94999999999999p 5.3042949999999998e-06 117.96249999999999p 4.9939709999999998e-06 117.97499999999999p 4.677795e-06 117.9875p 4.3562029999999998e-06 118p 4.0296329999999998e-06 118.0125p 3.6985319999999999e-06 118.02499999999999p 3.3633480000000001e-06 118.03749999999999p 3.024532e-06 118.05p 2.6825379999999999e-06 118.0625p 2.3378220000000001e-06 118.075p 1.9908379999999998e-06 118.08750000000001p 1.642043e-06 118.10000000000001p 1.29189e-06 118.11249999999998p 9.4083289999999997e-07 118.12499999999999p 5.8932050000000005e-07
+ 118.1375p 2.3779990000000001e-07 118.15000000000001p -1.13286e-07 118.16250000000001p -4.6349859999999999e-07 118.17500000000001p -8.1240479999999999e-07 118.18750000000001p -1.1595770000000001e-06 118.19999999999999p -1.504592e-06 118.21249999999999p -1.847037e-06 118.22499999999999p -2.186503e-06 118.2375p -2.5225899999999999e-06 118.25p -2.8549040000000001e-06 118.2625p -3.1830610000000001e-06 118.27500000000002p -3.5066859999999999e-06 118.28749999999999p -3.8254109999999999e-06 118.3p -4.1388769999999999e-06 118.3125p -4.446735e-06 118.325p -4.7486450000000003e-06 118.33750000000001p -5.044278e-06 118.35000000000001p -5.3333119999999997e-06
+ 118.36249999999998p -5.615437e-06 118.37499999999999p -5.8903509999999997e-06 118.38749999999999p -6.1577649999999998e-06 118.40000000000001p -6.4173959999999996e-06 118.41250000000001p -6.6689730000000003e-06 118.42500000000001p -6.912237e-06 118.43750000000001p -7.1469369999999997e-06 118.44999999999999p -7.372832e-06 118.46249999999999p -7.5896909999999999e-06 118.47499999999999p -7.7972959999999998e-06 118.4875p -7.9954369999999993e-06 118.5p -8.1839139999999997e-06 118.5125p -8.3625380000000006e-06 118.52500000000001p -8.5311310000000002e-06 118.53749999999999p -8.6895250000000005e-06 118.55p -8.8375609999999999e-06 118.5625p -8.9750940000000001e-06 118.575p -9.1019849999999992e-06
+ 118.58750000000001p -9.2181090000000003e-06 118.60000000000001p -9.3233519999999999e-06 118.61249999999998p -9.4176070000000002e-06 118.62499999999999p -9.5007830000000007e-06 118.63749999999999p -9.572796e-06 118.65000000000001p -9.6335750000000003e-06 118.66250000000001p -9.6830599999999994e-06 118.67500000000001p -9.7212019999999998e-06 118.68750000000001p -9.7479640000000004e-06 118.69999999999999p -9.7633220000000004e-06 118.71249999999999p -9.7672610000000005e-06 118.72499999999999p -9.7597810000000007e-06 118.7375p -9.7408910000000006e-06 118.75p -9.7106169999999997e-06 118.7625p -9.6689929999999993e-06 118.77500000000001p -9.6160680000000001e-06 118.78749999999999p -9.5519049999999995e-06 118.8p -9.4765770000000005e-06
+ 118.8125p -9.3901739999999992e-06 118.825p -9.2927959999999992e-06 118.83750000000001p -9.1845580000000002e-06 118.85000000000001p -9.0655899999999994e-06 118.86250000000001p -8.9360330000000008e-06 118.87499999999999p -8.7960449999999999e-06 118.88749999999999p -8.6457939999999997e-06 118.89999999999999p -8.4854649999999996e-06 118.91250000000001p -8.3152570000000005e-06 118.92500000000001p -8.1353789999999993e-06 118.93750000000001p -7.9460589999999995e-06 118.94999999999999p -7.7475339999999996e-06 118.96249999999999p -7.5400580000000001e-06 118.97499999999999p -7.323895e-06 118.9875p -7.099325e-06 119p -6.8666389999999996e-06 119.0125p -6.6261400000000002e-06 119.02500000000001p -6.3781440000000003e-06
+ 119.03749999999999p -6.1229789999999997e-06 119.05p -5.8609829999999996e-06 119.0625p -5.5925040000000004e-06 119.075p -5.317902e-06 119.08750000000001p -5.0375450000000002e-06 119.10000000000001p -4.7518099999999998e-06 119.11250000000001p -4.4610829999999997e-06 119.12499999999999p -4.1657550000000002e-06 119.13749999999999p -3.866227e-06 119.14999999999999p -3.5629039999999999e-06 119.16249999999999p -3.2561949999999999e-06 119.17500000000001p -2.9465160000000001e-06 119.18750000000001p -2.6342839999999999e-06 119.20000000000002p -2.3199200000000001e-06 119.21249999999999p -2.003845e-06 119.22499999999999p -1.686483e-06 119.2375p -1.368258e-06 119.25p -1.04959e-06
+ 119.2625p -7.3090119999999997e-07 119.27500000000001p -4.1260879999999998e-07 119.28749999999999p -9.5127420000000004e-08 119.3p 2.2113239999999999e-07 119.3125p 5.3576519999999999e-07 119.325p 8.483709e-07 119.33750000000001p 1.1585560000000001e-06 119.35000000000001p 1.4659339999999999e-06 119.36250000000001p 1.7701250000000001e-06 119.37499999999999p 2.0707579999999998e-06 119.38749999999999p 2.367471e-06 119.39999999999999p 2.65991e-06 119.41249999999999p 2.9477320000000002e-06 119.425p 3.2306009999999999e-06 119.43750000000001p 3.5081949999999998e-06 119.45000000000002p 3.780199e-06 119.46249999999999p 4.0463100000000004e-06 119.47499999999999p 4.3062350000000003e-06
+ 119.4875p 4.559694e-06 119.5p 4.8064149999999996e-06 119.5125p 5.0461379999999996e-06 119.52500000000001p 5.2786149999999999e-06 119.53750000000001p 5.5036070000000001e-06 119.55p 5.720887e-06 119.5625p 5.930237e-06 119.575p 6.131452e-06 119.58750000000001p 6.3243359999999999e-06 119.60000000000001p 6.5087019999999997e-06 119.61250000000001p 6.6843739999999996e-06 119.62499999999999p 6.851187e-06 119.63749999999999p 7.0089839999999997e-06 119.64999999999999p 7.157618e-06 119.66249999999999p 7.2969509999999999e-06 119.675p 7.4268559999999996e-06 119.6875p 7.5472109999999996e-06 119.70000000000002p 7.6579080000000002e-06
+ 119.71249999999999p 7.7588460000000002e-06 119.72499999999999p 7.8499310000000007e-06 119.7375p 7.9310799999999996e-06 119.75p 8.0022200000000008e-06 119.7625p 8.0632859999999996e-06 119.77500000000001p 8.1142210000000001e-06 119.78750000000001p 8.1549810000000004e-06 119.79999999999998p 8.1855279999999997e-06 119.8125p 8.2058369999999998e-06 119.825p 8.2158929999999996e-06 119.83750000000001p 8.2156899999999993e-06 119.85000000000001p 8.2052349999999997e-06 119.86250000000001p 8.1845460000000002e-06 119.87500000000001p 8.1536540000000004e-06 119.88749999999999p 8.1126010000000003e-06 119.89999999999999p 8.0614429999999997e-06 119.91249999999999p 8.0002490000000008e-06 119.925p 7.9291029999999999e-06
+ 119.9375p 7.8481030000000002e-06 119.95p 7.7573630000000001e-06 119.96249999999999p 7.6570100000000004e-06 119.97499999999999p 7.5471899999999996e-06 119.9875p 7.4280629999999997e-06 120p 7.299807e-06 120.0125p 7.1626179999999999e-06 120.02500000000001p 7.0167049999999996e-06 120.03750000000001p 6.8622990000000001e-06 120.04999999999998p 6.6996469999999996e-06 120.06249999999999p 6.5290109999999998e-06 120.075p 6.350675e-06 120.08750000000001p 6.164935e-06 120.10000000000001p 5.9721090000000004e-06 120.11250000000001p 5.7725259999999997e-06 120.12500000000001p 5.5665360000000001e-06 120.13749999999999p 5.3545010000000004e-06 120.14999999999999p 5.1367990000000003e-06
+ 120.16249999999999p 4.9138229999999999e-06 120.175p 4.6859749999999996e-06 120.1875p 4.4536729999999997e-06 120.2p 4.217345e-06 120.21250000000001p 3.9774259999999997e-06 120.22499999999999p 3.734362e-06 120.2375p 3.488604e-06 120.25p 3.240611e-06 120.2625p 2.9908420000000001e-06 120.27500000000001p 2.7397619999999998e-06 120.28750000000001p 2.4878339999999998e-06 120.29999999999998p 2.235523e-06 120.31249999999999p 1.9832879999999998e-06 120.32499999999999p 1.7315859999999999e-06 120.33750000000001p 1.480868e-06 120.35000000000001p 1.231576e-06 120.36250000000001p 9.8414420000000006e-07 120.37500000000001p 7.3899550000000002e-07
+ 120.38749999999999p 4.9654049999999999e-07 120.39999999999999p 2.5717589999999998e-07 120.41249999999999p 2.1283400000000001e-08 120.425p -2.107721e-07 120.4375p -4.3864319999999998e-07 120.45p -6.6200150000000001e-07 120.46250000000001p -8.8053860000000003e-07 120.47499999999999p -1.093967e-06 120.4875p -1.3020199999999999e-06 120.5p -1.504454e-06 120.5125p -1.7010479999999999e-06 120.52500000000001p -1.8916039999999999e-06 120.53750000000001p -2.0759470000000001e-06 120.55000000000001p -2.2539269999999998e-06 120.56249999999999p -2.4254169999999999e-06 120.57499999999999p -2.5903119999999999e-06 120.58749999999999p -2.74853e-06 120.60000000000001p -2.9000160000000002e-06
+ 120.61250000000001p -3.0447310000000001e-06 120.62500000000001p -3.182661e-06 120.63749999999999p -3.3138130000000001e-06 120.64999999999999p -3.4382130000000001e-06 120.66249999999999p -3.5559039999999998e-06 120.675p -3.6669509999999999e-06 120.6875p -3.771432e-06 120.7p -3.8694410000000002e-06 120.71250000000001p -3.9610870000000003e-06 120.72499999999999p -4.0464909999999997e-06 120.7375p -4.1257860000000004e-06 120.75p -4.1991129999999999e-06 120.7625p -4.2666220000000001e-06 120.77500000000001p -4.328471e-06 120.78750000000001p -4.3848209999999999e-06 120.80000000000001p -4.435839e-06 120.81249999999999p -4.4816919999999996e-06 120.82499999999999p -4.522548e-06
+ 120.83749999999999p -4.5585749999999998e-06 120.85000000000001p -4.5899389999999999e-06 120.86250000000001p -4.6168000000000004e-06 120.87500000000001p -4.639315e-06 120.88749999999999p -4.657635e-06 120.89999999999999p -4.6719000000000001e-06 120.91249999999999p -4.6822449999999996e-06 120.925p -4.6887950000000004e-06 120.9375p -4.6916619999999997e-06 120.95p -4.6909469999999997e-06 120.96250000000001p -4.6867420000000003e-06 120.97499999999999p -4.6791209999999997e-06 120.9875p -4.6681490000000001e-06 121p -4.6538740000000002e-06 121.0125p -4.6363330000000003e-06 121.02500000000001p -4.6155439999999996e-06 121.03750000000001p -4.5915159999999996e-06 121.05000000000001p -4.5642409999999999e-06
+ 121.06249999999999p -4.5336969999999996e-06 121.07499999999999p -4.4998499999999998e-06 121.08749999999999p -4.4626500000000004e-06 121.09999999999999p -4.4220360000000003e-06 121.11250000000001p -4.3779379999999998e-06 121.12500000000001p -4.3302690000000001e-06 121.13750000000002p -4.2789389999999998e-06 121.14999999999999p -4.223842e-06 121.16249999999999p -4.1648700000000002e-06 121.175p -4.1019060000000002e-06 121.1875p -4.0348269999999996e-06 121.2p -3.9635089999999999e-06 121.21250000000001p -3.8878219999999996e-06 121.22499999999999p -3.80764e-06 121.2375p -3.7228350000000001e-06 121.25p -3.6332810000000001e-06 121.2625p -3.5388599999999999e-06 121.27500000000001p -3.4394550000000001e-06
+ 121.28750000000001p -3.3349620000000001e-06 121.30000000000001p -3.225283e-06 121.31249999999999p -3.1103320000000001e-06 121.32499999999999p -2.9900359999999999e-06 121.33749999999999p -2.864336e-06 121.34999999999999p -2.7331909999999999e-06 121.3625p -2.5965730000000002e-06 121.37500000000001p -2.454477e-06 121.38750000000002p -2.3069150000000001e-06 121.39999999999999p -2.153922e-06 121.41249999999999p -1.995554e-06 121.425p -1.8318899999999999e-06 121.4375p -1.6630330000000001e-06 121.45p -1.4891090000000001e-06 121.46250000000001p -1.310271e-06 121.47500000000001p -1.126695e-06 121.4875p -9.3858209999999997e-07 121.5p -7.4615890000000004e-07
+ 121.5125p -5.4967599999999998e-07 121.52500000000001p -3.4940850000000001e-07 121.53750000000001p -1.4565459999999999e-07 121.55000000000001p 6.1264389999999997e-08 121.56249999999999p 2.710058e-07 121.57499999999999p 4.8320620000000003e-07 121.58749999999999p 6.9748270000000002e-07 121.59999999999999p 9.1343450000000001e-07 121.6125p 1.130645e-06 121.625p 1.348681e-06 121.63750000000002p 1.567099e-06 121.64999999999999p 1.785442e-06 121.66249999999999p 2.0032449999999999e-06 121.675p 2.2200349999999998e-06 121.6875p 2.4353350000000001e-06 121.7p 2.648664e-06 121.71250000000001p 2.859541e-06 121.72500000000001p 3.0674839999999998e-06
+ 121.73749999999998p 3.272015e-06 121.75p 3.4726640000000001e-06 121.7625p 3.668965e-06 121.77500000000001p 3.8604609999999997e-06 121.78750000000001p 4.0467090000000002e-06 121.80000000000001p 4.2272769999999997e-06 121.81250000000001p 4.401747e-06 121.82499999999999p 4.5697179999999997e-06 121.83749999999999p 4.7308079999999999e-06 121.84999999999999p 4.8846510000000001e-06 121.8625p 5.0309049999999999e-06 121.875p 5.1692460000000004e-06 121.8875p 5.2993740000000002e-06 121.89999999999999p 5.421013e-06 121.91249999999999p 5.5339100000000004e-06 121.925p 5.6378350000000004e-06 121.9375p 5.7325849999999998e-06 121.95p 5.8179800000000003e-06
+ 121.96250000000001p 5.8938680000000004e-06 121.97500000000001p 5.9601190000000002e-06 121.98749999999998p 6.0166299999999997e-06 121.99999999999999p 6.0633220000000002e-06 122.0125p 6.1001390000000003e-06 122.02500000000001p 6.1270519999999997e-06 122.03750000000001p 6.1440519999999997e-06 122.05000000000001p 6.1511539999999997e-06 122.06250000000001p 6.1483930000000003e-06 122.07499999999999p 6.1358289999999999e-06 122.08749999999999p 6.1135360000000001e-06 122.09999999999999p 6.0816130000000001e-06 122.1125p 6.040171e-06 122.125p 5.9893439999999999e-06 122.1375p 5.9292760000000003e-06 122.15000000000001p 5.8601309999999998e-06 122.16249999999999p 5.782082e-06 122.175p 5.6953189999999998e-06
+ 122.1875p 5.6000389999999998e-06 122.2p 5.4964539999999998e-06 122.21250000000001p 5.3847819999999996e-06 122.22500000000001p 5.2652510000000004e-06 122.23749999999998p 5.1380980000000004e-06 122.24999999999999p 5.0035630000000003e-06 122.26249999999999p 4.8618970000000001e-06 122.27500000000001p 4.7133509999999998e-06 122.28750000000001p 4.5581840000000002e-06 122.30000000000001p 4.3966579999999999e-06 122.31250000000001p 4.2290380000000003e-06 122.32499999999999p 4.0555910000000001e-06 122.33749999999999p 3.8765869999999997e-06 122.34999999999999p 3.6922980000000002e-06 122.3625p 3.5029989999999999e-06 122.375p 3.3089639999999999e-06 122.3875p 3.1104700000000001e-06 122.40000000000001p 2.9077929999999999e-06
+ 122.41249999999999p 2.701214e-06 122.425p 2.4910099999999998e-06 122.4375p 2.2774629999999998e-06 122.45p 2.060854e-06 122.46250000000001p 1.841466e-06 122.47500000000001p 1.6195820000000001e-06 122.48750000000001p 1.3954879999999999e-06 122.49999999999999p 1.169471e-06 122.51249999999999p 9.4181959999999998e-07 122.52499999999999p 7.1282290000000004e-07 122.53750000000001p 4.8277329999999998e-07 122.55000000000001p 2.519646e-07 122.56250000000001p 2.0692739999999999e-08 122.57499999999999p -2.1074420000000001e-07 122.58749999999999p -4.420462e-07 122.59999999999999p -6.7291109999999998e-07 122.6125p -9.0303469999999996e-07 122.625p -1.132111e-06
+ 122.6375p -1.3598319999999999e-06 122.65000000000001p -1.585889e-06 122.66249999999999p -1.8099700000000001e-06 122.675p -2.0317649999999999e-06 122.6875p -2.2509610000000001e-06 122.7p -2.467245e-06 122.71250000000001p -2.680307e-06 122.72500000000001p -2.8898339999999999e-06 122.73750000000001p -3.0955170000000001e-06 122.74999999999999p -3.2970489999999998e-06 122.76249999999999p -3.494124e-06 122.77499999999999p -3.686441e-06 122.78749999999999p -3.873704e-06 122.80000000000001p -4.0556190000000001e-06 122.81250000000001p -4.2319010000000003e-06 122.82500000000002p -4.4022690000000004e-06 122.83749999999999p -4.5664519999999998e-06 122.84999999999999p -4.7241850000000002e-06
+ 122.8625p -4.8752119999999998e-06 122.875p -5.0192899999999997e-06 122.8875p -5.156183e-06 122.90000000000001p -5.2856690000000003e-06 122.91249999999999p -5.4075369999999999e-06 122.925p -5.5215889999999997e-06 122.9375p -5.627642e-06 122.95p -5.7255270000000002e-06 122.96250000000001p -5.8150880000000001e-06 122.97500000000001p -5.8961869999999998e-06 122.98750000000001p -5.9687019999999998e-06 122.99999999999999p -6.0325250000000003e-06 123.01249999999999p -6.0875669999999997e-06 123.02499999999999p -6.1337570000000003e-06 123.03749999999999p -6.1710379999999996e-06 123.05p -6.199374e-06 123.06250000000001p -6.218745e-06 123.07500000000002p -6.2291490000000001e-06
+ 123.08749999999999p -6.2306010000000004e-06 123.09999999999999p -6.2231349999999997e-06 123.1125p -6.2068020000000001e-06 123.125p -6.1816689999999998e-06 123.1375p -6.1478209999999998e-06 123.15000000000001p -6.1053590000000004e-06 123.16250000000001p -6.0543989999999998e-06 123.175p -5.9950740000000001e-06 123.1875p -5.9275319999999996e-06 123.2p -5.8519340000000003e-06 123.21250000000001p -5.7684560000000004e-06 123.22500000000001p -5.6772849999999996e-06 123.23750000000001p -5.5786240000000001e-06 123.24999999999999p -5.4726839999999997e-06 123.26249999999999p -5.3596880000000002e-06 123.27499999999999p -5.2398689999999998e-06 123.28749999999999p -5.1134699999999998e-06 123.3p -4.9807410000000001e-06
+ 123.31250000000001p -4.8419399999999996e-06 123.32500000000002p -4.6973319999999999e-06 123.33749999999999p -4.5471879999999999e-06 123.34999999999999p -4.3917839999999996e-06 123.3625p -4.2313980000000002e-06 123.375p -4.0663149999999997e-06 123.3875p -3.8968200000000002e-06 123.40000000000001p -3.7232000000000002e-06 123.41250000000001p -3.5457460000000002e-06 123.42499999999998p -3.3647460000000002e-06 123.4375p -3.1804890000000002e-06 123.45p -2.9932629999999998e-06 123.46250000000001p -2.8033560000000002e-06 123.47500000000001p -2.611051e-06 123.48750000000001p -2.4166319999999999e-06 123.49999999999999p -2.2203780000000002e-06 123.51249999999999p -2.022563e-06 123.52499999999999p -1.823461e-06
+ 123.53749999999999p -1.623339e-06 123.55p -1.4224590000000001e-06 123.5625p -1.2210809999999999e-06 123.57500000000002p -1.019458e-06 123.58749999999999p -8.1783859999999997e-07 123.59999999999999p -6.1646459999999996e-07 123.6125p -4.1557390000000002e-07 123.625p -2.1539830000000001e-07 123.6375p -1.6164179999999999e-08 123.65000000000001p 1.8190799999999999e-07 123.66250000000001p 3.7860319999999998e-07 123.67499999999998p 5.7371189999999998e-07 123.6875p 7.6703039999999998e-07 123.7p 9.5835990000000002e-07 123.71250000000001p 1.147508e-06 123.72500000000001p 1.3342850000000001e-06 123.73750000000001p 1.51851e-06 123.75000000000001p 1.7000039999999999e-06
+ 123.76249999999999p 1.878595e-06 123.77499999999999p 2.0541130000000001e-06 123.78749999999999p 2.2263959999999999e-06 123.8p 2.3952829999999999e-06 123.8125p 2.5606199999999998e-06 123.825p 2.7222540000000002e-06 123.83749999999999p 2.880041e-06 123.84999999999999p 3.033835e-06 123.8625p 3.1834969999999998e-06 123.875p 3.3288919999999998e-06 123.8875p 3.4698869999999999e-06 123.90000000000001p 3.6063539999999999e-06 123.91250000000001p 3.7381670000000002e-06 123.92499999999998p 3.8652050000000002e-06 123.93749999999999p 3.9873489999999998e-06 123.95p 4.1044839999999998e-06 123.96250000000001p 4.216499e-06 123.97500000000001p 4.3232859999999998e-06
+ 123.98750000000001p 4.4247399999999996e-06 124.00000000000001p 4.5207620000000002e-06 124.01249999999999p 4.611253e-06 124.02499999999999p 4.696122e-06 124.03749999999999p 4.7752789999999999e-06 124.05p 4.8486389999999996e-06 124.0625p 4.9161219999999996e-06 124.075p 4.9776530000000004e-06 124.08750000000001p 5.0331589999999999e-06 124.09999999999999p 5.0825759999999996e-06 124.1125p 5.1258409999999998e-06 124.125p 5.1628979999999997e-06 124.1375p 5.1936980000000003e-06 124.15000000000001p 5.2181970000000004e-06 124.16250000000001p 5.2363540000000004e-06 124.17499999999998p 5.2481380000000004e-06 124.18749999999999p 5.2535240000000004e-06 124.19999999999999p 5.2524909999999996e-06
+ 124.21250000000001p 5.2450270000000003e-06 124.22500000000001p 5.2311260000000001e-06 124.23750000000001p 5.2107900000000003e-06 124.25000000000001p 5.1840270000000004e-06 124.26249999999999p 5.1508550000000003e-06 124.27499999999999p 5.1112969999999998e-06 124.28749999999999p 5.0653849999999996e-06 124.3p 5.0131590000000001e-06 124.3125p 4.9546659999999997e-06 124.325p 4.889962e-06 124.33750000000001p 4.8191119999999996e-06 124.34999999999999p 4.7421870000000004e-06 124.3625p 4.6592670000000002e-06 124.375p 4.570441e-06 124.3875p 4.4758049999999999e-06 124.40000000000001p 4.375465e-06 124.41250000000001p 4.2695320000000004e-06 124.42500000000001p 4.1581269999999997e-06
+ 124.43749999999999p 4.041379e-06 124.44999999999999p 3.9194229999999997e-06 124.46249999999999p 3.792404e-06 124.47500000000001p 3.6604729999999998e-06 124.48750000000001p 3.5237880000000001e-06 124.50000000000001p 3.382515e-06 124.51249999999999p 3.2368239999999999e-06 124.52499999999999p 3.0868959999999999e-06 124.53749999999999p 2.9329150000000001e-06 124.55p 2.775072e-06 124.5625p 2.6135629999999999e-06 124.575p 2.4485919999999999e-06 124.58750000000001p 2.2803649999999999e-06 124.59999999999999p 2.1090940000000001e-06 124.6125p 1.934996e-06 124.625p 1.758292e-06 124.6375p 1.579207e-06 124.65000000000001p 1.397968e-06
+ 124.66250000000001p 1.214808e-06 124.67500000000001p 1.0299610000000001e-06 124.68749999999999p 8.4366170000000005e-07 124.69999999999999p 6.5615049999999997e-07 124.71249999999999p 4.676673e-07 124.72499999999999p 2.7845390000000002e-07 124.73750000000001p 8.8752979999999994e-08 124.75000000000001p -1.01192e-07 124.76250000000002p -2.9113739999999999e-07 124.77499999999999p -4.8083970000000003e-07 124.78749999999999p -6.7005580000000002e-07 124.8p -8.5854320000000002e-07 124.8125p -1.046061e-06 124.825p -1.232369e-06 124.83750000000001p -1.4172299999999999e-06 124.84999999999999p -1.6004069999999999e-06 124.8625p -1.781669e-06 124.875p -1.9607830000000001e-06
+ 124.8875p -2.1375229999999999e-06 124.90000000000001p -2.3116649999999999e-06 124.91250000000001p -2.4829890000000001e-06 124.92500000000001p -2.651279e-06 124.93749999999999p -2.8163219999999998e-06 124.94999999999999p -2.977911e-06 124.96249999999999p -3.1358449999999999e-06 124.97499999999999p -3.2899259999999999e-06 124.9875p -3.4399610000000001e-06 125.00000000000001p -3.5857659999999999e-06 125.01250000000002p -3.7271580000000002e-06 125.02499999999999p -3.8639649999999999e-06 125.03749999999999p -3.9960170000000002e-06 125.05p -4.1231530000000004e-06 125.0625p -4.2452189999999999e-06 125.075p -4.3620669999999999e-06 125.08750000000001p -4.4735539999999998e-06 125.10000000000001p -4.5795489999999998e-06
+ 125.1125p -4.6799239999999997e-06 125.125p -4.774561e-06 125.1375p -4.8633480000000001e-06 125.15000000000001p -4.9461820000000001e-06 125.16250000000001p -5.0229669999999997e-06 125.17500000000001p -5.0936160000000003e-06 125.18749999999999p -5.1580499999999997e-06 125.19999999999999p -5.2161970000000003e-06 125.21249999999999p -5.2679939999999996e-06 125.22499999999999p -5.3133859999999999e-06 125.2375p -5.3523270000000001e-06 125.25p -5.3847780000000003e-06 125.26250000000002p -5.4107100000000004e-06 125.27499999999999p -5.4301010000000001e-06 125.28749999999999p -5.4429379999999998e-06 125.3p -5.4492170000000001e-06 125.3125p -5.4489410000000001e-06 125.325p -5.4421220000000001e-06
+ 125.33750000000001p -5.4287799999999999e-06 125.35000000000001p -5.4089440000000004e-06 125.36249999999998p -5.3826519999999997e-06 125.375p -5.3499460000000002e-06 125.3875p -5.3108809999999999e-06 125.40000000000001p -5.2655169999999996e-06 125.41250000000001p -5.2139229999999997e-06 125.42500000000001p -5.1561749999999998e-06 125.43750000000001p -5.0923569999999996e-06 125.44999999999999p -5.0225599999999997e-06 125.46249999999999p -4.9468839999999996e-06 125.47499999999999p -4.8654330000000003e-06 125.4875p -4.7783219999999998e-06 125.5p -4.6856700000000003e-06 125.5125p -4.5876029999999998e-06 125.52499999999999p -4.4842549999999998e-06 125.53749999999999p -4.375766e-06 125.55p -4.2622800000000001e-06
+ 125.5625p -4.1439500000000004e-06 125.575p -4.0209330000000002e-06 125.58750000000001p -3.8933919999999996e-06 125.60000000000001p -3.761495e-06 125.61249999999998p -3.6254149999999998e-06 125.62499999999999p -3.4853319999999999e-06 125.6375p -3.3414260000000002e-06 125.65000000000001p -3.1938869999999999e-06 125.66250000000001p -3.042905e-06 125.67500000000001p -2.8886740000000001e-06 125.68750000000001p -2.7313960000000001e-06 125.69999999999999p -2.5712699999999999e-06 125.71249999999999p -2.4085030000000002e-06 125.72499999999999p -2.2433030000000001e-06 125.7375p -2.0758800000000002e-06 125.75p -1.9064479999999999e-06 125.7625p -1.73522e-06 125.77500000000002p -1.5624150000000001e-06
+ 125.78749999999999p -1.38825e-06 125.8p -1.212943e-06 125.8125p -1.036716e-06 125.825p -8.5978920000000001e-07 125.83750000000001p -6.8238290000000004e-07 125.85000000000001p -5.0471849999999999e-07 125.86249999999998p -3.2701680000000001e-07 125.87499999999999p -1.4949789999999999e-07 125.88749999999999p 2.7618710000000001e-08 125.90000000000001p 2.0411479999999999e-07 125.91250000000001p 3.7977319999999998e-07 125.92500000000001p 5.5437880000000001e-07 125.93750000000001p 7.2771810000000005e-07 125.94999999999999p 8.9957969999999998e-07 125.96249999999999p 1.0697549999999999e-06 125.97499999999999p 1.238037e-06 125.9875p 1.404223e-06 126p 1.568113e-06
+ 126.0125p 1.72951e-06 126.02500000000001p 1.8882199999999999e-06 126.03749999999999p 2.0440549999999999e-06 126.05p 2.196829e-06 126.0625p 2.3463619999999999e-06 126.075p 2.4924769999999999e-06 126.08750000000001p 2.6350019999999998e-06 126.10000000000001p 2.7737709999999999e-06 126.11249999999998p 2.9086220000000002e-06 126.12499999999999p 3.0393989999999998e-06 126.13749999999999p 3.165951e-06 126.15000000000001p 3.288134e-06 126.16250000000001p 3.4058079999999999e-06 126.17500000000001p 3.5188399999999999e-06 126.18750000000001p 3.6271040000000001e-06 126.19999999999999p 3.73048e-06 126.21249999999999p 3.8288529999999996e-06 126.22499999999999p 3.9221159999999997e-06
+ 126.2375p 4.0101690000000004e-06 126.25p 4.0929199999999999e-06 126.2625p 4.1702819999999996e-06 126.27500000000001p 4.242176e-06 126.28749999999999p 4.3085310000000001e-06 126.3p 4.3692819999999998e-06 126.3125p 4.4243750000000003e-06 126.325p 4.4737589999999998e-06 126.33750000000001p 4.5173940000000004e-06 126.35000000000001p 4.5552470000000003e-06 126.36250000000001p 4.5872930000000001e-06 126.37499999999999p 4.6135150000000002e-06 126.38749999999999p 4.6339020000000003e-06 126.39999999999999p 4.6484560000000001e-06 126.41250000000001p 4.6571809999999998e-06 126.42500000000001p 4.6600929999999997e-06 126.43750000000001p 4.6572150000000003e-06 126.44999999999999p 4.6485779999999997e-06
+ 126.46249999999999p 4.6342200000000002e-06 126.47499999999999p 4.6141889999999997e-06 126.4875p 4.5885390000000002e-06 126.5p 4.5573329999999998e-06 126.5125p 4.5206399999999998e-06 126.52500000000001p 4.4785380000000002e-06 126.53749999999999p 4.4311120000000001e-06 126.55p 4.3784530000000003e-06 126.5625p 4.3206620000000002e-06 126.575p 4.2578430000000003e-06 126.58750000000001p 4.1901099999999998e-06 126.60000000000001p 4.1175820000000001e-06 126.61250000000001p 4.0403829999999996e-06 126.62499999999999p 3.9586450000000003e-06 126.63749999999999p 3.8725039999999999e-06 126.64999999999999p 3.782103e-06 126.66249999999999p 3.6875880000000002e-06 126.67500000000001p 3.589112e-06
+ 126.68750000000001p 3.4868300000000002e-06 126.70000000000002p 3.380903e-06 126.71249999999999p 3.2714959999999998e-06 126.72499999999999p 3.1587739999999999e-06 126.7375p 3.04291e-06 126.75p 2.9240759999999999e-06 126.7625p 2.8024469999999999e-06 126.77500000000001p 2.6782009999999999e-06 126.78749999999999p 2.5515169999999999e-06 126.8p 2.4225749999999998e-06 126.8125p 2.291555e-06 126.825p 2.158639e-06 126.83750000000001p 2.0240079999999998e-06 126.85000000000001p 1.8878439999999999e-06 126.86250000000001p 1.7503269999999999e-06 126.87499999999999p 1.6116369999999999e-06 126.88749999999999p 1.471952e-06 126.89999999999999p 1.33145e-06
+ 126.91249999999999p 1.190304e-06 126.925p 1.0486889999999999e-06 126.93750000000001p 9.0677410000000001e-07 126.95000000000002p 7.6472830000000002e-07 126.96249999999999p 6.2271659999999996e-07 126.97499999999999p 4.8090120000000004e-07 126.9875p 3.3944129999999998e-07 127p 1.9849249999999999e-07 127.0125p 5.8207179999999998e-08 127.02500000000001p -8.1265930000000005e-08 127.03750000000001p -2.1978179999999999e-07 127.05p -3.5719900000000002e-07 127.0625p -4.9337990000000005e-07 127.075p -6.2819079999999995e-07 127.08750000000001p -7.6150169999999996e-07 127.10000000000001p -8.9318639999999998e-07 127.11250000000001p -1.023122e-06 127.12499999999999p -1.1511910000000001e-06
+ 127.13749999999999p -1.277276e-06 127.14999999999999p -1.401267e-06 127.16249999999999p -1.5230559999999999e-06 127.175p -1.6425360000000001e-06 127.1875p -1.7596080000000001e-06 127.20000000000002p -1.874171e-06 127.21249999999999p -1.9861310000000001e-06 127.22499999999999p -2.0953940000000001e-06 127.2375p -2.2018700000000001e-06 127.25p -2.3054699999999998e-06 127.2625p -2.40611e-06 127.27500000000001p -2.5037050000000002e-06 127.28750000000001p -2.5981749999999999e-06 127.29999999999998p -2.6894390000000001e-06 127.3125p -2.77742e-06 127.325p -2.8620400000000001e-06 127.33750000000001p -2.9432259999999999e-06 127.35000000000001p -3.0209039999999999e-06
+ 127.36250000000001p -3.0950020000000001e-06 127.37500000000001p -3.1654479999999999e-06 127.38749999999999p -3.232173e-06 127.39999999999999p -3.2951079999999998e-06 127.41249999999999p -3.3541849999999998e-06 127.425p -3.4093379999999999e-06 127.4375p -3.4605020000000002e-06 127.45p -3.507612e-06 127.46249999999999p -3.5506060000000001e-06 127.47499999999999p -3.5894229999999999e-06 127.4875p -3.6240010000000002e-06 127.5p -3.6542839999999999e-06 127.5125p -3.6802150000000001e-06 127.52500000000001p -3.7017390000000001e-06 127.53750000000001p -3.718804e-06 127.54999999999998p -3.731361e-06 127.56249999999999p -3.7393619999999999e-06 127.575p -3.7427650000000001e-06
+ 127.58750000000001p -3.741528e-06 127.60000000000001p -3.7356139999999998e-06 127.61250000000001p -3.7249920000000001e-06 127.62500000000001p -3.7096309999999998e-06 127.63749999999999p -3.689509e-06 127.64999999999999p -3.664607e-06 127.66249999999999p -3.63491e-06 127.675p -3.6004120000000002e-06 127.6875p -3.5611099999999999e-06 127.7p -3.5170099999999998e-06 127.71250000000001p -3.4681229999999999e-06 127.72499999999999p -3.4144669999999998e-06 127.7375p -3.35607e-06 127.75p -3.2929639999999999e-06 127.7625p -3.2251919999999998e-06 127.77500000000001p -3.1528039999999998e-06 127.78750000000001p -3.075859e-06 127.79999999999998p -2.9944250000000001e-06
+ 127.81249999999999p -2.9085779999999998e-06 127.82499999999999p -2.8184040000000001e-06 127.83750000000001p -2.7239969999999998e-06 127.85000000000001p -2.6254619999999999e-06 127.86250000000001p -2.5229110000000001e-06 127.87500000000001p -2.4164689999999999e-06 127.88749999999999p -2.3062660000000002e-06 127.89999999999999p -2.1924439999999999e-06 127.91249999999999p -2.075152e-06 127.925p -1.954551e-06 127.9375p -1.8308060000000001e-06 127.95p -1.704095e-06 127.96250000000001p -1.574601e-06 127.97499999999999p -1.442516e-06 127.9875p -1.308039e-06 128p -1.1713750000000001e-06 128.01249999999999p -1.0327380000000001e-06 128.02500000000001p -8.9234429999999999e-07
+ 128.03750000000002p -7.5041859999999997e-07 128.05000000000001p -6.07189e-07 128.0625p -4.6288809999999997e-07 128.07499999999999p -3.1775229999999998e-07 128.08750000000001p -1.7202079999999999e-07 128.09999999999999p -2.5935139999999999e-08 128.11250000000001p 1.202613e-07 128.125p 2.6632410000000002e-07 128.13749999999999p 4.120086e-07 128.15000000000001p 5.5707029999999997e-07 128.16249999999999p 7.0126590000000004e-07 128.17500000000001p 8.4435360000000005e-07 128.1875p 9.8609369999999999e-07 128.20000000000002p 1.12625e-06 128.21250000000001p 1.264589e-06 128.22499999999999p 1.4008819999999999e-06 128.23749999999998p 1.534905e-06 128.25p 1.6664390000000001e-06
+ 128.26249999999999p 1.795271e-06 128.27500000000001p 1.921195e-06 128.28749999999999p 2.0440100000000001e-06 128.30000000000001p 2.1635230000000001e-06 128.3125p 2.2795500000000001e-06 128.32499999999999p 2.3919130000000001e-06 128.33750000000001p 2.5004429999999999e-06 128.34999999999999p 2.6049799999999999e-06 128.36250000000001p 2.7053709999999998e-06 128.375p 2.8014750000000001e-06 128.38750000000002p 2.893157e-06 128.39999999999998p 2.9802939999999999e-06 128.41249999999999p 3.0627689999999999e-06 128.42500000000001p 3.1404780000000001e-06 128.4375p 3.2133229999999998e-06 128.45000000000002p 3.2812189999999999e-06 128.46250000000001p 3.3440859999999999e-06 128.47499999999999p 3.4018580000000001e-06
+ 128.48749999999998p 3.4544739999999998e-06 128.5p 3.5018850000000001e-06 128.51249999999999p 3.5440490000000002e-06 128.52500000000001p 3.5809319999999999e-06 128.53749999999999p 3.612512e-06 128.55000000000001p 3.6387730000000001e-06 128.5625p 3.6597049999999998e-06 128.57499999999999p 3.6753100000000001e-06 128.58750000000001p 3.6855959999999998e-06 128.59999999999999p 3.6905760000000001e-06 128.61250000000001p 3.6902740000000002e-06 128.625p 3.6847189999999999e-06 128.63750000000002p 3.6739469999999999e-06 128.64999999999998p 3.6580010000000002e-06 128.66249999999999p 3.6369280000000002e-06 128.67500000000001p 3.610785e-06 128.6875p 3.579632e-06 128.70000000000002p 3.5435349999999999e-06
+ 128.71250000000001p 3.5025660000000001e-06 128.72499999999999p 3.456803e-06 128.73749999999998p 3.4063290000000001e-06 128.75p 3.3512300000000002e-06 128.76249999999999p 3.2916e-06 128.77500000000001p 3.227537e-06 128.78749999999999p 3.159141e-06 128.80000000000001p 3.086521e-06 128.8125p 3.0097869999999998e-06 128.82499999999999p 2.9290569999999999e-06 128.83750000000001p 2.8444499999999999e-06 128.84999999999999p 2.7560910000000001e-06 128.86250000000001p 2.6641099999999999e-06 128.875p 2.5686400000000001e-06 128.88750000000002p 2.4698200000000002e-06 128.89999999999998p 2.3677919999999998e-06 128.91249999999999p 2.2627029999999998e-06 128.92499999999998p 2.1547030000000002e-06
+ 128.9375p 2.0439480000000001e-06 128.95000000000002p 1.9305960000000001e-06 128.96250000000001p 1.8148110000000001e-06 128.97500000000002p 1.69676e-06 128.98749999999998p 1.576613e-06 129p 1.454547e-06 129.01249999999999p 1.330738e-06 129.02500000000001p 1.2053680000000001e-06 129.03749999999999p 1.078624e-06 129.05000000000001p 9.5069240000000002e-07 129.0625p 8.2176539999999997e-07 129.07499999999999p 6.9203640000000001e-07 129.08750000000001p 5.6170189999999996e-07 129.09999999999999p 4.3095999999999999e-07 129.11250000000001p 3.0001120000000001e-07 129.125p 1.6905690000000001e-07 129.13750000000002p 3.8300110000000001e-08 129.14999999999998p -9.2055659999999998e-08
+ 129.16249999999999p -2.2180650000000001e-07 129.17499999999998p -3.5074840000000001e-07 129.1875p -4.7867799999999999e-07 129.20000000000002p -6.0539290000000003e-07 129.21250000000001p -7.3069200000000004e-07 129.22500000000002p -8.54376e-07 129.23749999999998p -9.7624810000000007e-07 129.25p -1.0961139999999999e-06 129.26249999999999p -1.2137839999999999e-06 129.27500000000001p -1.3290699999999999e-06 129.28749999999999p -1.44179e-06 129.30000000000001p -1.5517670000000001e-06 129.3125p -1.658827e-06 129.32499999999999p -1.762805e-06 129.33750000000001p -1.8635400000000001e-06 129.34999999999999p -1.960878e-06 129.36250000000001p -2.0546720000000001e-06 129.375p -2.1447840000000002e-06
+ 129.38750000000002p -2.231082e-06 129.39999999999998p -2.3134429999999999e-06 129.41249999999999p -2.3917529999999999e-06 129.42499999999998p -2.4659049999999999e-06 129.4375p -2.535804e-06 129.44999999999999p -2.601362e-06 129.46250000000001p -2.6625010000000002e-06 129.47500000000002p -2.7191529999999999e-06 129.48749999999998p -2.771259e-06 129.5p -2.8187729999999999e-06 129.51249999999999p -2.8616540000000001e-06 129.52500000000001p -2.8998740000000001e-06 129.53749999999999p -2.9334149999999999e-06 129.55000000000001p -2.9622670000000001e-06 129.5625p -2.9864319999999999e-06 129.57499999999999p -3.005918e-06 129.58750000000001p -3.020747e-06 129.59999999999999p -3.0309469999999999e-06
+ 129.61250000000001p -3.0365550000000001e-06 129.625p -3.0376170000000002e-06 129.63750000000002p -3.034189e-06 129.65000000000001p -3.026333e-06 129.66249999999999p -3.014119e-06 129.67499999999998p -2.9976240000000001e-06 129.6875p -2.9769330000000001e-06 129.69999999999999p -2.9521359999999998e-06 129.71250000000001p -2.9233290000000002e-06 129.72500000000002p -2.8906159999999999e-06 129.73749999999998p -2.854104e-06 129.75p -2.8139030000000002e-06 129.76249999999999p -2.7701310000000002e-06 129.77500000000001p -2.7229070000000002e-06 129.78749999999999p -2.6723549999999998e-06 129.80000000000001p -2.618599e-06 129.8125p -2.5617680000000002e-06 129.82499999999999p -2.5019920000000001e-06
+ 129.83750000000001p -2.4394030000000002e-06 129.84999999999999p -2.3741319999999999e-06 129.86250000000001p -2.3063120000000002e-06 129.875p -2.2360779999999999e-06 129.88750000000002p -2.1635609999999999e-06 129.90000000000001p -2.0888950000000001e-06 129.91249999999999p -2.0122099999999998e-06 129.92499999999998p -1.933637e-06 129.9375p -1.8533060000000001e-06 129.94999999999999p -1.771343e-06 129.96250000000001p -1.6878730000000001e-06 129.97500000000002p -1.6030200000000001e-06 129.98750000000001p -1.5169029999999999e-06 130p -1.4296419999999999e-06 130.01249999999999p -1.3413519999999999e-06 130.02500000000001p -1.252145e-06 130.03749999999999p -1.1621310000000001e-06 130.05000000000001p -1.071416e-06
+ 130.0625p -9.8010549999999999e-07 130.07499999999999p -8.8829959999999996e-07 130.08750000000001p -7.9609630000000001e-07 130.09999999999999p -7.0359090000000005e-07 130.11250000000001p -6.1087550000000001e-07 130.125p -5.1803960000000003e-07 130.13750000000002p -4.2516999999999999e-07 130.15000000000001p -3.3235100000000001e-07 130.16249999999999p -2.396643e-07 130.17499999999998p -1.471895e-07 130.1875p -5.5003849999999999e-08 130.19999999999999p 3.6817220000000002e-08 130.21250000000001p 1.2820020000000001e-07 130.22499999999999p 2.1907310000000001e-07 130.23750000000001p 3.0936550000000001e-07 130.25p 3.990083e-07 130.26249999999999p 4.8793339999999995e-07 130.27500000000001p 5.7607369999999997e-07
+ 130.28749999999999p 6.6336269999999998e-07 130.30000000000001p 7.4973460000000004e-07 130.3125p 8.3512410000000003e-07 130.32500000000002p 9.1946590000000002e-07 130.33749999999998p 1.002695e-06 130.34999999999999p 1.084747e-06 130.36250000000001p 1.1655549999999999e-06 130.375p 1.245055e-06 130.38750000000002p 1.323181e-06 130.40000000000001p 1.3998670000000001e-06 130.41249999999999p 1.475045e-06 130.42499999999998p 1.548649e-06 130.4375p 1.6206110000000001e-06 130.44999999999999p 1.690862e-06 130.46250000000001p 1.7593330000000001e-06 130.47499999999999p 1.825956e-06 130.48750000000001p 1.8906599999999999e-06 130.5p 1.9533750000000002e-06
+ 130.51249999999999p 2.0140300000000001e-06 130.52500000000001p 2.0725539999999999e-06 130.53749999999999p 2.1288770000000001e-06 130.55000000000001p 2.182927e-06 130.5625p 2.2346339999999998e-06 130.57500000000002p 2.2839280000000002e-06 130.58749999999998p 2.3307380000000002e-06 130.59999999999999p 2.374996e-06 130.61250000000001p 2.4166319999999999e-06 130.625p 2.4555809999999999e-06 130.63750000000002p 2.491777e-06 130.65000000000001p 2.525154e-06 130.66250000000002p 2.5556519999999999e-06 130.67499999999998p 2.5832090000000001e-06 130.6875p 2.6077679999999998e-06 130.69999999999999p 2.6292729999999999e-06 130.71250000000001p 2.6476709999999999e-06 130.72499999999999p 2.6629130000000001e-06
+ 130.73750000000001p 2.6749520000000002e-06 130.75p 2.683745e-06 130.76249999999999p 2.689253e-06 130.77500000000001p 2.6914409999999998e-06 130.78749999999999p 2.6902760000000001e-06 130.80000000000001p 2.685732e-06 130.8125p 2.677786e-06 130.82500000000002p 2.6664209999999999e-06 130.83749999999998p 2.6516230000000002e-06 130.84999999999999p 2.6333849999999999e-06 130.86249999999998p 2.611702e-06 130.875p 2.5865780000000002e-06 130.88750000000002p 2.5580189999999998e-06 130.90000000000001p 2.5260390000000001e-06 130.91250000000002p 2.490657e-06 130.92499999999998p 2.4518949999999998e-06 130.9375p 2.4097829999999999e-06 130.94999999999999p 2.3643570000000001e-06
+ 130.96250000000001p 2.315657e-06 130.97499999999999p 2.2637290000000002e-06 130.98750000000001p 2.208625e-06 131p 2.1504019999999998e-06 131.01249999999999p 2.0891219999999998e-06 131.02500000000001p 2.0248530000000001e-06 131.03749999999999p 1.9576690000000001e-06 131.05000000000001p 1.887648e-06 131.0625p 1.8148720000000001e-06 131.07500000000002p 1.73943e-06 131.08749999999998p 1.6614159999999999e-06 131.09999999999999p 1.580925e-06 131.11249999999998p 1.4980600000000001e-06 131.125p 1.412927e-06 131.13750000000002p 1.325635e-06 131.15000000000001p 1.2362990000000001e-06 131.16250000000002p 1.145035e-06 131.17499999999998p 1.0519649999999999e-06
+ 131.1875p 9.572124e-07 131.19999999999999p 8.6090349999999998e-07 131.21250000000001p 7.6316809999999996e-07 131.22499999999999p 6.6413800000000001e-07 131.23750000000001p 5.6394740000000001e-07 131.25p 4.6273239999999999e-07 131.26249999999999p 3.60631e-07 131.27500000000001p 2.577823e-07 131.28749999999999p 1.5432709999999999e-07 131.30000000000001p 5.0406899999999997e-08 131.3125p -5.3835880000000001e-08 131.32500000000002p -1.5825840000000001e-07 131.33749999999998p -2.627174e-07 131.34999999999999p -3.6706969999999999e-07 131.36249999999998p -4.7117219999999999e-07 131.375p -5.7488239999999999e-07 131.38749999999999p -6.7805820000000001e-07 131.40000000000001p -7.8055850000000001e-07
+ 131.41250000000002p -8.8224330000000005e-07 131.42499999999998p -9.8297379999999999e-07 131.4375p -1.082613e-06 131.44999999999999p -1.1810250000000001e-06 131.46250000000001p -1.2780760000000001e-06 131.47499999999999p -1.373635e-06 131.48750000000001p -1.467572e-06 131.5p -1.5597620000000001e-06 131.51249999999999p -1.6500779999999999e-06 131.52500000000001p -1.738401e-06 131.53749999999999p -1.824612e-06 131.55000000000001p -1.9085949999999999e-06 131.5625p -1.990239e-06 131.57500000000002p -2.0694349999999999e-06 131.58750000000001p -2.1460770000000001e-06 131.59999999999999p -2.220066e-06 131.61249999999998p -2.291302e-06 131.625p -2.3596939999999999e-06
+ 131.63749999999999p -2.42515e-06 131.65000000000001p -2.4875860000000002e-06 131.66250000000002p -2.5469210000000001e-06 131.67499999999998p -2.6030770000000001e-06 131.6875p -2.6559829999999998e-06 131.69999999999999p -2.7055709999999998e-06 131.71250000000001p -2.7517770000000001e-06 131.72499999999999p -2.7945429999999998e-06 131.73750000000001p -2.8338150000000001e-06 131.75p -2.8695440000000002e-06 131.76249999999999p -2.9016860000000001e-06 131.77500000000001p -2.9302010000000002e-06 131.78749999999999p -2.9550550000000001e-06 131.80000000000001p -2.9762180000000001e-06 131.8125p -2.9936660000000001e-06 131.82500000000002p -3.0073789999999998e-06 131.83750000000001p -3.017343e-06 131.84999999999999p -3.0235470000000002e-06
+ 131.86249999999998p -3.025988e-06 131.875p -3.0246659999999999e-06 131.88749999999999p -3.0195850000000001e-06 131.90000000000001p -3.0107569999999999e-06 131.91249999999999p -2.9981959999999998e-06 131.92500000000001p -2.981922e-06 131.9375p -2.9619610000000002e-06 131.94999999999999p -2.9383420000000002e-06 131.96250000000001p -2.9111e-06 131.97499999999999p -2.8802730000000001e-06 131.98750000000001p -2.8459059999999999e-06 132p -2.8080469999999999e-06 132.01249999999999p -2.7667480000000002e-06 132.02499999999998p -2.7220680000000001e-06 132.03749999999999p -2.6740679999999999e-06 132.05000000000001p -2.622812e-06 132.0625p -2.5683730000000002e-06 132.07500000000002p -2.5108219999999999e-06
+ 132.08750000000001p -2.4502389999999999e-06 132.09999999999999p -2.3867040000000001e-06 132.11249999999998p -2.3203040000000002e-06 132.125p -2.251127e-06 132.13749999999999p -2.1792650000000001e-06 132.15000000000001p -2.1048140000000001e-06 132.16249999999999p -2.0278739999999998e-06 132.17500000000001p -1.9485449999999998e-06 132.1875p -1.8669329999999999e-06 132.19999999999999p -1.7831450000000001e-06 132.21250000000001p -1.697291e-06 132.22499999999999p -1.609483e-06 132.23750000000001p -1.519838e-06 132.25p -1.42847e-06 132.26250000000002p -1.3355e-06 132.27499999999998p -1.2410479999999999e-06 132.28749999999999p -1.145237e-06 132.30000000000001p -1.0481899999999999e-06
+ 132.3125p -9.5003229999999997e-07 132.32500000000002p -8.5089059999999997e-07 132.33750000000001p -7.5089190000000003e-07 132.34999999999999p -6.5016459999999995e-07 132.36249999999998p -5.4883739999999998e-07 132.375p -4.4703940000000001e-07 132.38749999999999p -3.4490039999999999e-07 132.40000000000001p -2.4255000000000001e-07 132.41249999999999p -1.4011789999999999e-07 132.42500000000001p -3.7733709999999999e-08 132.4375p 6.4473480000000005e-08 132.44999999999999p 1.6637500000000001e-07 132.46250000000001p 2.6784279999999999e-07 132.47499999999999p 3.6874979999999998e-07 132.48750000000001p 4.689699e-07 132.5p 5.6837790000000002e-07 132.51250000000002p 6.6685030000000005e-07 132.52499999999998p 7.6426480000000004e-07
+ 132.53749999999999p 8.6050069999999995e-07 132.55000000000001p 9.554392000000001e-07 132.5625p 1.0489630000000001e-06 132.57500000000002p 1.1409580000000001e-06 132.58750000000001p 1.2313110000000001e-06 132.60000000000002p 1.3199109999999999e-06 132.61249999999998p 1.4066499999999999e-06 132.625p 1.491423e-06 132.63749999999999p 1.574128e-06 132.65000000000001p 1.6546640000000001e-06 132.66249999999999p 1.7329340000000001e-06 132.67500000000001p 1.8088449999999999e-06 132.6875p 1.8823059999999999e-06 132.69999999999999p 1.9532289999999999e-06 132.71250000000001p 2.0215309999999998e-06 132.72499999999999p 2.0871299999999999e-06 132.73750000000001p 2.1499500000000001e-06 132.75p 2.2099170000000001e-06
+ 132.76250000000002p 2.266961e-06 132.77499999999998p 2.321018e-06 132.78749999999999p 2.372025e-06 132.79999999999998p 2.4199229999999999e-06 132.8125p 2.46466e-06 132.82500000000002p 2.5061859999999999e-06 132.83750000000001p 2.5444539999999999e-06 132.85000000000002p 2.5794240000000001e-06 132.86249999999998p 2.6110589999999998e-06 132.875p 2.6393240000000001e-06 132.88749999999999p 2.6641929999999999e-06 132.90000000000001p 2.6856409999999998e-06 132.91249999999999p 2.7036479999999999e-06 132.92500000000001p 2.718198e-06 132.9375p 2.7292820000000002e-06 132.94999999999999p 2.736891e-06 132.96250000000001p 2.7410250000000002e-06 132.97499999999999p 2.7416850000000002e-06
+ 132.98750000000001p 2.738878e-06 133p 2.7326159999999999e-06 133.01250000000002p 2.7229129999999999e-06 133.02499999999998p 2.70979e-06 133.03749999999999p 2.6932700000000001e-06 133.04999999999998p 2.673382e-06 133.0625p 2.650159e-06 133.07500000000002p 2.6236359999999999e-06 133.08750000000001p 2.5938559999999999e-06 133.10000000000002p 2.5608620000000001e-06 133.11249999999998p 2.5247050000000001e-06 133.125p 2.4854349999999999e-06 133.13749999999999p 2.443111e-06 133.15000000000001p 2.3977919999999999e-06 133.16249999999999p 2.349542e-06 133.17500000000001p 2.298429e-06 133.1875p 2.2445229999999999e-06 133.19999999999999p 2.1878999999999998e-06
+ 133.21250000000001p 2.128636e-06 133.22499999999999p 2.066813e-06 133.23750000000001p 2.0025139999999998e-06 133.25p 1.935826e-06 133.26250000000002p 1.8668380000000001e-06 133.27500000000001p 1.7956419999999999e-06 133.28749999999999p 1.7223330000000001e-06 133.29999999999998p 1.6470089999999999e-06 133.3125p 1.569768e-06 133.32499999999999p 1.4907120000000001e-06 133.33750000000001p 1.409946e-06 133.35000000000002p 1.3275730000000001e-06 133.36249999999998p 1.2437019999999999e-06 133.375p 1.1584410000000001e-06 133.38749999999999p 1.0719000000000001e-06 133.40000000000001p 9.841917e-07 133.41249999999999p 8.9542840000000004e-07 133.42500000000001p 8.0572410000000004e-07
+ 133.4375p 7.1519349999999998e-07 133.44999999999999p 6.2395220000000001e-07 133.46250000000001p 5.3211640000000005e-07 133.47499999999999p 4.3980289999999999e-07 133.48750000000001p 3.471288e-07 133.5p 2.542113e-07 133.51250000000002p 1.6116779999999999e-07 133.52500000000001p 6.8115720000000003e-08 133.53749999999999p -2.4827850000000001e-08 133.54999999999998p -1.175461e-07 133.5625p -2.099226e-07 133.57499999999999p -3.0184159999999999e-07 133.58750000000001p -3.9318799999999999e-07 133.60000000000002p -4.8384769999999995e-07 133.61249999999998p -5.7370719999999997e-07 133.625p -6.6265459999999998e-07 133.63749999999999p -7.5057889999999997e-07 133.65000000000001p -8.3737040000000001e-07
+ 133.66249999999999p -9.2292109999999998e-07 133.67500000000001p -1.0071249999999999e-06 133.6875p -1.0898759999999999e-06 133.69999999999999p -1.171072e-06 133.71250000000001p -1.2506120000000001e-06 133.72499999999999p -1.328397e-06 133.73750000000001p -1.40433e-06 133.75p -1.4783169999999999e-06 133.76250000000002p -1.5502659999999999e-06 133.77500000000001p -1.620087e-06 133.78749999999999p -1.6876919999999999e-06 133.79999999999998p -1.752999e-06 133.8125p -1.8159259999999999e-06 133.82499999999999p -1.876394e-06 133.83750000000001p -1.9343280000000002e-06 133.84999999999999p -1.989655e-06 133.86250000000001p -2.0423080000000001e-06 133.875p -2.0922189999999999e-06
+ 133.88749999999999p -2.1393279999999999e-06 133.90000000000001p -2.1835750000000001e-06 133.91249999999999p -2.2249059999999998e-06 133.92500000000001p -2.26327e-06 133.9375p -2.298618e-06 133.94999999999999p -2.3309079999999998e-06 133.96249999999998p -2.3600989999999998e-06 133.97499999999999p -2.386157e-06 133.98750000000001p -2.4090499999999998e-06 134p -2.4287499999999998e-06 134.01250000000002p -2.4452349999999998e-06 134.02500000000001p -2.4584850000000001e-06 134.03749999999999p -2.468487e-06 134.04999999999998p -2.4752309999999998e-06 134.0625p -2.4787099999999999e-06 134.07499999999999p -2.4789250000000002e-06 134.08750000000001p -2.4758769999999999e-06 134.09999999999999p -2.4695759999999998e-06
+ 134.11250000000001p -2.460033e-06 134.125p -2.4472660000000002e-06 134.13749999999999p -2.431295e-06 134.15000000000001p -2.4121479999999998e-06 134.16249999999999p -2.3898540000000002e-06 134.17500000000001p -2.3644479999999998e-06 134.1875p -2.335971e-06 134.20000000000002p -2.3044649999999998e-06 134.21249999999998p -2.2699789999999999e-06 134.22499999999999p -2.2325639999999999e-06 134.23750000000001p -2.1922789999999998e-06 134.25p -2.1491840000000001e-06 134.26250000000002p -2.103343e-06 134.27500000000001p -2.0548249999999998e-06 134.28749999999999p -2.0037040000000001e-06 134.29999999999998p -1.950055e-06 134.3125p -1.8939580000000001e-06 134.32499999999999p -1.835497e-06
+ 134.33750000000001p -1.7747590000000001e-06 134.34999999999999p -1.711835e-06 134.36250000000001p -1.6468160000000001e-06 134.375p -1.5797990000000001e-06 134.38749999999999p -1.510884e-06 134.40000000000001p -1.440171e-06 134.41249999999999p -1.3677649999999999e-06 134.42500000000001p -1.2937720000000001e-06 134.4375p -1.218299e-06 134.45000000000002p -1.1414560000000001e-06 134.46249999999998p -1.0633569999999999e-06 134.47499999999999p -9.8411229999999997e-07 134.48749999999998p -9.0383820000000001e-07 134.5p -8.2264979999999999e-07 134.51250000000002p -7.4066360000000005e-07 134.52500000000001p -6.5799680000000003e-07 134.53750000000002p -5.7476720000000001e-07 134.54999999999998p -4.9109259999999999e-07
+ 134.5625p -4.0709140000000002e-07 134.57499999999999p -3.2288160000000002e-07 134.58750000000001p -2.3858109999999998e-07 134.59999999999999p -1.543071e-07 134.61250000000001p -7.0176620000000005e-08 134.625p 1.369452e-08 134.63749999999999p 9.7191330000000006e-08 134.65000000000001p 1.8020000000000001e-07 134.66249999999999p 2.626079e-07 134.67500000000001p 3.4430420000000002e-07 134.6875p 4.251793e-07 134.70000000000002p 5.0512580000000004e-07 134.71249999999998p 5.8403789999999999e-07 134.72499999999999p 6.6181199999999997e-07 134.73749999999998p 7.3834669999999998e-07 134.75p 8.1354300000000005e-07 134.76250000000002p 8.8730420000000005e-07 134.77500000000001p 9.595361999999999e-07
+ 134.78750000000002p 1.0301479999999999e-06 134.79999999999998p 1.0990500000000001e-06 134.8125p 1.166157e-06 134.82499999999999p 1.231387e-06 134.83750000000001p 1.294659e-06 134.84999999999999p 1.3558959999999999e-06 134.86250000000001p 1.4150260000000001e-06 134.875p 1.4719789999999999e-06 134.88749999999999p 1.526686e-06 134.90000000000001p 1.5790850000000001e-06 134.91249999999999p 1.629116e-06 134.92500000000001p 1.6767219999999999e-06 134.9375p 1.7218509999999999e-06 134.95000000000002p 1.7644519999999999e-06 134.96249999999998p 1.8044790000000001e-06 134.97499999999999p 1.8418920000000001e-06 134.98749999999998p 1.8766500000000001e-06 135p 1.9087200000000002e-06
+ 135.01250000000002p 1.938071e-06 135.02500000000001p 1.9646740000000001e-06 135.03750000000002p 1.9885070000000001e-06 135.04999999999998p 2.0095500000000001e-06 135.0625p 2.0277870000000002e-06 135.07499999999999p 2.0432059999999999e-06 135.08750000000001p 2.0557990000000001e-06 135.09999999999999p 2.065562e-06 135.11250000000001p 2.0724939999999999e-06 135.125p 2.0765980000000001e-06 135.13749999999999p 2.077882e-06 135.15000000000001p 2.0763579999999998e-06 135.16249999999999p 2.0720400000000001e-06 135.17500000000001p 2.0649459999999999e-06 135.1875p 2.0551009999999998e-06 135.20000000000002p 2.0425290000000001e-06 135.21250000000001p 2.0272630000000001e-06 135.22499999999999p 2.0093349999999999e-06
+ 135.23749999999998p 1.9887839999999999e-06 135.25p 1.9656509999999998e-06 135.26249999999999p 1.9399810000000002e-06 135.27500000000001p 1.9118239999999999e-06 135.28750000000002p 1.8812310000000001e-06 135.29999999999998p 1.8482590000000001e-06 135.3125p 1.812967e-06 135.32499999999999p 1.775418e-06 135.33750000000001p 1.735677e-06 135.34999999999999p 1.6938129999999999e-06 135.36250000000001p 1.649899e-06 135.375p 1.6040100000000001e-06 135.38749999999999p 1.5562240000000001e-06 135.40000000000001p 1.5066220000000001e-06 135.41249999999999p 1.4552869999999999e-06 135.42500000000001p 1.402304e-06 135.4375p 1.347762e-06 135.45000000000002p 1.291751e-06
+ 135.46250000000001p 1.2343640000000001e-06 135.47499999999999p 1.1756940000000001e-06 135.48749999999998p 1.1158369999999999e-06 135.5p 1.054891e-06 135.51249999999999p 9.9295309999999998e-07 135.52500000000001p 9.3012389999999998e-07 135.53750000000002p 8.6650340000000004e-07 135.55000000000001p 8.021929e-07 135.5625p 7.3729399999999996e-07 135.57499999999999p 6.719085e-07 135.58750000000001p 6.0613830000000003e-07 135.59999999999999p 5.4008529999999996e-07 135.61250000000001p 4.7385070000000002e-07 135.625p 4.075354e-07 135.63749999999999p 3.412394e-07 135.65000000000001p 2.7506179999999999e-07 135.66249999999999p 2.091002e-07 135.67500000000001p 1.4345100000000001e-07
+ 135.6875p 7.8209079999999995e-08 135.70000000000002p 1.3467259999999999e-08 135.71250000000001p -5.0683499999999999e-08 135.72499999999999p -1.141544e-07 135.73749999999998p -1.768591e-07 135.75p -2.3871370000000003e-07 135.76249999999999p -2.9963689999999998e-07 135.77500000000001p -3.5955029999999999e-07 135.78749999999999p -4.1837839999999998e-07 135.80000000000001p -4.7604880000000002e-07 135.8125p -5.324923e-07 135.82499999999999p -5.8764289999999997e-07 135.83750000000001p -6.41438e-07 135.84999999999999p -6.9381830000000003e-07 135.86250000000001p -7.4472819999999995e-07 135.875p -7.9411559999999999e-07 135.88750000000002p -8.4193170000000005e-07 135.89999999999998p -8.8813170000000002e-07
+ 135.91249999999999p -9.32674e-07 135.92500000000001p -9.7552080000000009e-07 135.9375p -1.0166379999999999e-06 135.95000000000002p -1.055995e-06 135.96250000000001p -1.0935640000000001e-06 135.97499999999999p -1.1293210000000001e-06 135.98749999999998p -1.163247e-06 136p -1.195323e-06 136.01249999999999p -1.2255360000000001e-06 136.02500000000001p -1.2538759999999999e-06 136.03749999999999p -1.2803339999999999e-06 136.05000000000001p -1.3049049999999999e-06 136.0625p -1.3275870000000001e-06 136.07499999999999p -1.348381e-06 136.08750000000001p -1.36729e-06 136.09999999999999p -1.3843180000000001e-06 136.11250000000001p -1.3994750000000001e-06 136.125p -1.412768e-06
+ 136.13750000000002p -1.4242109999999999e-06 136.14999999999998p -1.433816e-06 136.16249999999999p -1.4415990000000001e-06 136.17500000000001p -1.4475760000000001e-06 136.1875p -1.4517649999999999e-06 136.20000000000002p -1.454186e-06 136.21250000000001p -1.454859e-06 136.22499999999999p -1.4538059999999999e-06 136.23749999999998p -1.451048e-06 136.25p -1.4466090000000001e-06 136.26249999999999p -1.4405119999999999e-06 136.27500000000001p -1.432782e-06 136.28749999999999p -1.4234420000000001e-06 136.30000000000001p -1.4125189999999999e-06 136.3125p -1.4000369999999999e-06 136.32499999999999p -1.3860219999999999e-06 136.33750000000001p -1.370499e-06 136.34999999999999p -1.3534940000000001e-06
+ 136.36250000000001p -1.335033e-06 136.375p -1.31514e-06 136.38750000000002p -1.2938429999999999e-06 136.39999999999998p -1.2711659999999999e-06 136.41249999999999p -1.247135e-06 136.42499999999998p -1.2217760000000001e-06 136.4375p -1.195115e-06 136.45000000000002p -1.167177e-06 136.46250000000001p -1.137987e-06 136.47500000000002p -1.1075730000000001e-06 136.48749999999998p -1.0759590000000001e-06 136.5p -1.0431729999999999e-06 136.51249999999999p -1.0092400000000001e-06 136.52500000000001p -9.741882000000001e-07 136.53749999999999p -9.3804400000000001e-07 136.55000000000001p -9.0083579999999997e-07 136.5625p -8.6259189999999995e-07 136.57499999999999p -8.2334160000000005e-07
+ 136.58750000000001p -7.8311479999999997e-07 136.59999999999999p -7.4194249999999995e-07 136.61250000000001p -6.998562e-07 136.625p -6.5688909999999997e-07 136.63750000000002p -6.1307490000000001e-07 136.64999999999998p -5.6844909999999995e-07 136.66249999999999p -5.2304799999999996e-07 136.67499999999998p -4.7690960000000003e-07 136.6875p -4.300732e-07 136.70000000000002p -3.8257979999999999e-07 136.71250000000001p -3.3447190000000001e-07 136.72500000000002p -2.8579350000000001e-07 136.73749999999998p -2.365904e-07 136.75p -1.8691020000000001e-07 136.76249999999999p -1.3680200000000001e-07 136.77500000000001p -8.6317040000000004e-08 136.78749999999999p -3.550793e-08 136.80000000000001p 1.5570720000000001e-08
+ 136.8125p 6.6862630000000002e-08 136.82499999999999p 1.1830979999999999e-07 136.83750000000001p 1.698524e-07 136.84999999999999p 2.2142929999999999e-07 136.86250000000001p 2.729773e-07 136.875p 3.2443219999999999e-07 136.88750000000002p 3.7572809999999998e-07 136.89999999999998p 4.267977e-07 136.91249999999999p 4.7757269999999995e-07 136.92499999999998p 5.2798350000000004e-07 136.9375p 5.7795949999999995e-07 136.94999999999999p 6.2742949999999999e-07 136.96250000000001p 6.7632120000000002e-07 136.97500000000002p 7.2456209999999997e-07 136.98749999999998p 7.7207909999999998e-07 137p 8.1879890000000003e-07 137.01249999999999p 8.64648e-07 137.02500000000001p 9.095532e-07
+ 137.03749999999999p 9.5344150000000003e-07 137.05000000000001p 9.962403999999999e-07 137.0625p 1.0378780000000001e-06 137.07499999999999p 1.0782830000000001e-06 137.08750000000001p 1.1173859999999999e-06 137.09999999999999p 1.155118e-06 137.11250000000001p 1.1914120000000001e-06 137.125p 1.226201e-06 137.13750000000002p 1.259423e-06 137.15000000000001p 1.291014e-06 137.16249999999999p 1.3209149999999999e-06 137.17499999999998p 1.3490680000000001e-06 137.1875p 1.3754190000000001e-06 137.19999999999999p 1.3999149999999999e-06 137.21250000000001p 1.4225060000000001e-06 137.22500000000002p 1.443145e-06 137.23749999999998p 1.461789e-06 137.25p 1.478397e-06
+ 137.26249999999999p 1.492932e-06 137.27500000000001p 1.50536e-06 137.28749999999999p 1.5156520000000001e-06 137.30000000000001p 1.523779e-06 137.3125p 1.5297200000000001e-06 137.32499999999999p 1.533455e-06 137.33750000000001p 1.5349680000000001e-06 137.34999999999999p 1.5342479999999999e-06 137.36250000000001p 1.5312869999999999e-06 137.375p 1.526081e-06 137.38750000000002p 1.5186289999999999e-06 137.40000000000001p 1.508937e-06 137.41249999999999p 1.4970100000000001e-06 137.42499999999998p 1.482862e-06 137.4375p 1.466507e-06 137.44999999999999p 1.447965e-06 137.46250000000001p 1.427259e-06 137.47500000000002p 1.404414e-06
+ 137.48750000000001p 1.3794620000000001e-06 137.5p 1.3524359999999999e-06 137.51249999999999p 1.323374e-06 137.52500000000001p 1.2923150000000001e-06 137.53749999999999p 1.2593050000000001e-06 137.55000000000001p 1.224389e-06 137.5625p 1.1876179999999999e-06 137.57499999999999p 1.1490459999999999e-06 137.58749999999998p 1.108728e-06 137.59999999999999p 1.0667220000000001e-06 137.61250000000001p 1.023091e-06 137.625p 9.7789829999999996e-07 137.63750000000002p 9.3120950000000002e-07 137.65000000000001p 8.8309330000000001e-07 137.66249999999999p 8.336203e-07 137.67499999999998p 7.8286299999999999e-07 137.6875p 7.3089570000000003e-07 137.69999999999999p 6.7779449999999995e-07
+ 137.71250000000001p 6.2363700000000001e-07 137.72499999999999p 5.6850230000000002e-07 137.73750000000001p 5.1247080000000003e-07 137.75p 4.556241e-07 137.76249999999999p 3.9804479999999998e-07 137.77500000000001p 3.398164e-07 137.78749999999999p 2.8102330000000002e-07 137.80000000000001p 2.2175059999999999e-07 137.8125p 1.6208359999999999e-07 137.82500000000002p 1.021084e-07 137.83749999999998p 4.1911169999999998e-08 137.84999999999999p -1.8421659999999999e-08 137.86250000000001p -7.8803689999999996e-08 137.875p -1.391486e-07 137.88750000000002p -1.9937010000000001e-07 137.90000000000001p -2.593825e-07 137.91249999999999p -3.1910040000000001e-07 137.92499999999998p -3.7843879999999998e-07
+ 137.9375p -4.3731360000000003e-07 137.94999999999999p -4.9564140000000001e-07 137.96250000000001p -5.5333949999999999e-07 137.97499999999999p -6.1032639999999995e-07 137.98750000000001p -6.665216e-07 138p -7.2184580000000003e-07 138.01249999999999p -7.7622100000000003e-07 138.02500000000001p -8.2957060000000004e-07 138.03749999999999p -8.8181949999999998e-07 138.05000000000001p -9.3289429999999997e-07 138.0625p -9.8272299999999993e-07 138.07500000000002p -1.0312359999999999e-06 138.08749999999998p -1.078364e-06 138.09999999999999p -1.1240430000000001e-06 138.11250000000001p -1.1682070000000001e-06 138.125p -1.210795e-06 138.13750000000002p -1.251747e-06 138.15000000000001p -1.291006e-06
+ 138.16250000000002p -1.3285160000000001e-06 138.17499999999998p -1.3642260000000001e-06 138.1875p -1.398086e-06 138.19999999999999p -1.4300479999999999e-06 138.21250000000001p -1.460068e-06 138.22499999999999p -1.4881030000000001e-06 138.23750000000001p -1.5141160000000001e-06 138.25p -1.538071e-06 138.26249999999999p -1.5599329999999999e-06 138.27500000000001p -1.579673e-06 138.28749999999999p -1.597265e-06 138.30000000000001p -1.612684e-06 138.3125p -1.625909e-06 138.32500000000002p -1.636924e-06 138.33749999999998p -1.6457129999999999e-06 138.34999999999999p -1.652266e-06 138.36249999999998p -1.6565740000000001e-06 138.375p -1.658634e-06
+ 138.38750000000002p -1.658443e-06 138.40000000000001p -1.656004e-06 138.41250000000002p -1.651323e-06 138.42499999999998p -1.6444070000000001e-06 138.4375p -1.635268e-06 138.44999999999999p -1.623922e-06 138.46250000000001p -1.6103859999999999e-06 138.47499999999999p -1.5946820000000001e-06 138.48750000000001p -1.576835e-06 138.5p -1.5568719999999999e-06 138.51249999999999p -1.5348239999999999e-06 138.52500000000001p -1.510725e-06 138.53749999999999p -1.484611e-06 138.55000000000001p -1.4565219999999999e-06 138.5625p -1.4265e-06 138.57500000000002p -1.3945900000000001e-06 138.58749999999998p -1.360841e-06 138.59999999999999p -1.3253010000000001e-06
+ 138.61249999999998p -1.288025e-06 138.625p -1.249068e-06 138.63750000000002p -1.208486e-06 138.65000000000001p -1.16634e-06 138.66250000000002p -1.122691e-06 138.67499999999998p -1.077604e-06 138.6875p -1.0311439999999999e-06 138.69999999999999p -9.8337769999999998e-07 138.71250000000001p -9.3437549999999996e-07 138.72499999999999p -8.8420759999999998e-07 138.73750000000001p -8.32946e-07 138.75p -7.8066429999999998e-07 138.76249999999999p -7.2743710000000002e-07 138.77500000000001p -6.7333989999999997e-07 138.78749999999999p -6.1844949999999997e-07 138.80000000000001p -5.6284320000000004e-07 138.8125p -5.0659920000000001e-07 138.82500000000002p -4.4979629999999999e-07
+ 138.83749999999998p -3.925135e-07 138.84999999999999p -3.3483040000000001e-07 138.86249999999998p -2.7682670000000002e-07 138.875p -2.185822e-07 138.88749999999999p -1.6017669999999999e-07 138.90000000000001p -1.016899e-07 138.91250000000002p -4.3200990000000001e-08 138.92499999999998p 1.5210850000000002e-08 138.9375p 7.3467149999999994e-08 138.94999999999999p 1.3148999999999999e-07 138.96250000000001p 1.89202e-07 138.97499999999999p 2.465269e-07 138.98750000000001p 3.0338909999999998e-07 139p 3.5971409999999998e-07 139.01249999999999p 4.1542829999999998e-07 139.02500000000001p 4.7045960000000002e-07 139.03749999999999p 5.24737e-07 139.05000000000001p 5.7819089999999995e-07
+ 139.0625p 6.3075309999999998e-07 139.07500000000002p 6.82357e-07 139.08750000000001p 7.3293760000000003e-07 139.09999999999999p 7.8243159999999998e-07 139.11249999999998p 8.3077740000000002e-07 139.125p 8.7791530000000001e-07 139.13749999999999p 9.2378730000000004e-07 139.15000000000001p 9.6833759999999992e-07 139.16250000000002p 1.0115120000000001e-06 139.17499999999998p 1.0532590000000001e-06 139.1875p 1.0935289999999999e-06 139.19999999999999p 1.1322750000000001e-06 139.21250000000001p 1.1694500000000001e-06 139.22499999999999p 1.205011e-06 139.23750000000001p 1.238919e-06 139.25p 1.2711330000000001e-06 139.26249999999999p 1.3016190000000001e-06 139.27500000000001p 1.3303429999999999e-06
+ 139.28749999999999p 1.357272e-06 139.30000000000001p 1.3823779999999999e-06 139.3125p 1.4056350000000001e-06 139.32500000000002p 1.4270179999999999e-06 139.33750000000001p 1.446507e-06 139.34999999999999p 1.464081e-06 139.36249999999998p 1.479724e-06 139.375p 1.493423e-06 139.38749999999999p 1.5051650000000001e-06 139.40000000000001p 1.514942e-06 139.41249999999999p 1.5227470000000001e-06 139.42500000000001p 1.528576e-06 139.4375p 1.5324280000000001e-06 139.44999999999999p 1.534304e-06 139.46250000000001p 1.534206e-06 139.47499999999999p 1.532141e-06 139.48750000000001p 1.5281180000000001e-06 139.5p 1.522146e-06
+ 139.51249999999999p 1.5142400000000001e-06 139.52499999999998p 1.5044139999999999e-06 139.53749999999999p 1.492686e-06 139.55000000000001p 1.479077e-06 139.5625p 1.4636090000000001e-06 139.57500000000002p 1.446307e-06 139.58750000000001p 1.427196e-06 139.59999999999999p 1.406308e-06 139.61249999999998p 1.383671e-06 139.625p 1.359321e-06 139.63749999999999p 1.333291e-06 139.65000000000001p 1.30562e-06 139.66249999999999p 1.276346e-06 139.67500000000001p 1.24551e-06 139.6875p 1.2131549999999999e-06 139.69999999999999p 1.179326e-06 139.71250000000001p 1.144069e-06 139.72499999999999p 1.107431e-06
+ 139.73750000000001p 1.0694629999999999e-06 139.75p 1.0302150000000001e-06 139.76250000000002p 9.8973970000000004e-07 139.77499999999998p 9.4809100000000004e-07 139.78749999999999p 9.0532399999999996e-07 139.80000000000001p 8.61495e-07 139.8125p 8.1666159999999999e-07 139.82500000000002p 7.708824e-07 139.83750000000001p 7.2421709999999997e-07 139.84999999999999p 6.7672619999999998e-07 139.86249999999998p 6.2847129999999997e-07 139.875p 5.795145e-07 139.88749999999999p 5.2991889999999995e-07 139.90000000000001p 4.7974799999999999e-07 139.91249999999999p 4.2906600000000001e-07 139.92500000000001p 3.7793749999999999e-07 139.9375p 3.2642760000000002e-07 139.94999999999999p 2.7460150000000003e-07
+ 139.96250000000001p 2.225249e-07 139.97499999999999p 1.7026339999999999e-07 139.98750000000001p 1.178828e-07 140p 6.5448960000000006e-08 140.01250000000002p 1.302743e-08 140.02499999999998p -3.9316260000000003e-08 140.03749999999999p -9.1516870000000003e-08 140.05000000000001p -1.4350950000000001e-07 140.0625p -1.9522970000000001e-07 140.07500000000002p -2.466135e-07 140.08750000000001p -2.975975e-07 140.10000000000002p -3.481189e-07 140.11249999999998p -3.9811579999999998e-07 140.125p -4.4752680000000002e-07 140.13749999999999p -4.9629180000000002e-07 140.15000000000001p -5.4435129999999998e-07 140.16249999999999p -5.9164710000000005e-07 140.17500000000001p -6.3812179999999996e-07
+ 140.1875p -6.8371939999999998e-07 140.19999999999999p -7.2838510000000004e-07 140.21250000000001p -7.720653e-07 140.22499999999999p -8.1470789999999997e-07 140.23750000000001p -8.562623e-07 140.25p -8.9667899999999998e-07 140.26250000000002p -9.3591049999999998e-07 140.27499999999998p -9.739107999999999e-07 140.28749999999999p -1.010635e-06 140.29999999999998p -1.0460410000000001e-06 140.3125p -1.0800879999999999e-06 140.32500000000002p -1.1127369999999999e-06 140.33750000000001p -1.143949e-06 140.35000000000002p -1.1736910000000001e-06 140.36249999999998p -1.201928e-06 140.375p -1.22863e-06 140.38749999999999p -1.2537660000000001e-06 140.40000000000001p -1.2773090000000001e-06
+ 140.41249999999999p -1.2992349999999999e-06 140.42500000000001p -1.3195199999999999e-06 140.4375p -1.3381430000000001e-06 140.44999999999999p -1.355085e-06 140.46250000000001p -1.370329e-06 140.47499999999999p -1.383862e-06 140.48750000000001p -1.3956700000000001e-06 140.5p -1.4057440000000001e-06 140.51250000000002p -1.4140750000000001e-06 140.52499999999998p -1.4206589999999999e-06 140.53749999999999p -1.4254909999999999e-06 140.54999999999998p -1.428571e-06 140.5625p -1.4299000000000001e-06 140.57500000000002p -1.4294799999999999e-06 140.58750000000001p -1.4273179999999999e-06 140.60000000000002p -1.423422e-06 140.61249999999998p -1.4178e-06 140.625p -1.410465e-06
+ 140.63749999999999p -1.4014320000000001e-06 140.65000000000001p -1.3907160000000001e-06 140.66249999999999p -1.3783349999999999e-06 140.67500000000001p -1.3643119999999999e-06 140.6875p -1.348666e-06 140.69999999999999p -1.3314249999999999e-06 140.71250000000001p -1.3126120000000001e-06 140.72499999999999p -1.292258e-06 140.73750000000001p -1.2703919999999999e-06 140.75p -1.2470469999999999e-06 140.76250000000002p -1.222255e-06 140.77500000000001p -1.196053e-06 140.78749999999999p -1.1684779999999999e-06 140.79999999999998p -1.139568e-06 140.8125p -1.109365e-06 140.82499999999999p -1.0779099999999999e-06 140.83750000000001p -1.045246e-06 140.85000000000002p -1.0114190000000001e-06
+ 140.86249999999998p -9.7647500000000004e-07 140.875p -9.4046060000000005e-07 140.88749999999999p -9.0342490000000001e-07 140.90000000000001p -8.6541770000000005e-07 140.91249999999999p -8.264898e-07 140.92500000000001p -7.8669320000000003e-07 140.9375p -7.4608059999999997e-07 140.94999999999999p -7.0470570000000003e-07 140.96250000000001p -6.6262300000000002e-07 140.97499999999999p -6.198876e-07 140.98750000000001p -5.7655540000000001e-07 141p -5.3268279999999997e-07 141.01250000000002p -4.8832659999999998e-07 141.02500000000001p -4.435442e-07 141.03749999999999p -3.9839320000000002e-07 141.04999999999998p -3.529316e-07 141.0625p -3.072175e-07 141.07499999999999p -2.6130910000000002e-07
+ 141.08750000000001p -2.1526459999999999e-07 141.10000000000002p -1.691423e-07 141.11250000000001p -1.230004e-07 141.125p -7.689674e-08 141.13749999999999p -3.0889019999999999e-08 141.15000000000001p 1.496542e-08 141.16249999999999p 6.0609659999999996e-08 141.17500000000001p 1.059873e-07 141.1875p 1.5104230000000001e-07 141.19999999999999p 1.9571970000000001e-07 141.21250000000001p 2.399646e-07 141.22499999999999p 2.8372349999999999e-07 141.23750000000001p 3.2694329999999999e-07 141.25p 3.69572e-07 141.26250000000002p 4.1155860000000002e-07 141.27500000000001p 4.5285290000000002e-07 141.28749999999999p 4.9340619999999995e-07 141.29999999999998p 5.3317049999999996e-07
+ 141.3125p 5.7209940000000004e-07 141.32499999999999p 6.1014759999999997e-07 141.33750000000001p 6.4727110000000002e-07 141.34999999999999p 6.8342739999999996e-07 141.36250000000001p 7.1857540000000001e-07 141.375p 7.5267560000000001e-07 141.38749999999999p 7.8568969999999996e-07 141.40000000000001p 8.1758139999999999e-07 141.41249999999999p 8.4831589999999997e-07 141.42500000000001p 8.7785979999999996e-07 141.4375p 9.0618180000000005e-07 141.44999999999999p 9.3325219999999996e-07 141.46249999999998p 9.5904299999999997e-07 141.47499999999999p 9.8352810000000006e-07 141.48750000000001p 1.006683e-06 141.5p 1.028486e-06 141.51250000000002p 1.048916e-06 141.52500000000001p 1.067954e-06
+ 141.53749999999999p 1.085584e-06 141.54999999999998p 1.1017909999999999e-06 141.5625p 1.116562e-06 141.57499999999999p 1.129886e-06 141.58750000000001p 1.141755e-06 141.59999999999999p 1.1521609999999999e-06 141.61250000000001p 1.1611e-06 141.625p 1.1685689999999999e-06 141.63749999999999p 1.1745660000000001e-06 141.65000000000001p 1.1790920000000001e-06 141.66249999999999p 1.182151e-06 141.67500000000001p 1.183746e-06 141.6875p 1.183884e-06 141.70000000000002p 1.1825750000000001e-06 141.71249999999998p 1.179828e-06 141.72499999999999p 1.1756550000000001e-06 141.73750000000001p 1.17007e-06 141.75p 1.163088e-06
+ 141.76250000000002p 1.1547280000000001e-06 141.77500000000001p 1.145007e-06 141.78749999999999p 1.1339470000000001e-06 141.79999999999998p 1.12157e-06 141.8125p 1.107899e-06 141.82499999999999p 1.0929599999999999e-06 141.83750000000001p 1.076778e-06 141.84999999999999p 1.0593829999999999e-06 141.86250000000001p 1.0408019999999999e-06 141.875p 1.021068e-06 141.88749999999999p 1.0002110000000001e-06 141.90000000000001p 9.7826379999999999e-07 141.91249999999999p 9.552613e-07 141.92500000000001p 9.3123799999999996e-07 141.9375p 9.062298e-07 141.95000000000002p 8.8027360000000002e-07 141.96249999999998p 8.5340700000000004e-07 141.97499999999999p 8.2566840000000003e-07
+ 141.98749999999998p 7.9709699999999998e-07 142p 7.6773250000000002e-07 142.01250000000002p 7.3761529999999995e-07 142.02500000000001p 7.0678630000000002e-07 142.03750000000002p 6.7528690000000004e-07 142.04999999999998p 6.4315870000000005e-07 142.0625p 6.1044379999999997e-07 142.07499999999999p 5.7718459999999999e-07 142.08750000000001p 5.434238e-07 142.09999999999999p 5.0920400000000004e-07 142.11250000000001p 4.7456809999999998e-07 142.125p 4.3955900000000003e-07 142.13749999999999p 4.0421980000000002e-07 142.15000000000001p 3.685933e-07 142.16249999999999p 3.3272230000000001e-07 142.17500000000001p 2.9664949999999999e-07 142.1875p 2.6041749999999998e-07 142.20000000000002p 2.2406850000000001e-07
+ 142.21249999999998p 1.8764470000000001e-07 142.22499999999999p 1.5118769999999999e-07 142.23749999999998p 1.147391e-07 142.25p 7.8339859999999994e-08 142.26250000000002p 4.2030730000000001e-08 142.27500000000001p 5.8519850000000002e-09 142.28750000000002p -3.0156540000000002e-08 142.29999999999998p -6.5955459999999998e-08 142.3125p -1.015059e-07 142.32499999999999p -1.3676950000000001e-07 142.33750000000001p -1.7170850000000001e-07 142.34999999999999p -2.0628539999999999e-07 142.36250000000001p -2.404637e-07 142.375p -2.7420720000000003e-07 142.38749999999999p -3.0748019999999998e-07 142.40000000000001p -3.4024799999999999e-07 142.41249999999999p -3.7247619999999999e-07 142.42500000000001p -4.0413110000000003e-07
+ 142.4375p -4.3517959999999999e-07 142.45000000000002p -4.6558950000000001e-07 142.46249999999998p -4.9532889999999996e-07 142.47499999999999p -5.2436679999999996e-07 142.48749999999998p -5.5267300000000001e-07 142.5p -5.8021759999999997e-07 142.51250000000002p -6.0697179999999995e-07 142.52500000000001p -6.3290719999999998e-07 142.53750000000002p -6.579965e-07 142.54999999999998p -6.822129e-07 142.5625p -7.0553020000000003e-07 142.57499999999999p -7.2792340000000002e-07 142.58750000000001p -7.493679e-07 142.59999999999999p -7.6983999999999996e-07 142.61250000000001p -7.8931700000000005e-07 142.625p -8.0777689999999998e-07 142.63749999999999p -8.2519850000000002e-07 142.65000000000001p -8.4156150000000001e-07
+ 142.66249999999999p -8.5684669999999999e-07 142.67500000000001p -8.7103550000000003e-07 142.6875p -8.8411060000000005e-07 142.70000000000002p -8.9605550000000003e-07 142.71250000000001p -9.0685469999999995e-07 142.72499999999999p -9.1649379999999999e-07 142.73749999999998p -9.2495940000000004e-07 142.75p -9.3223929999999999e-07 142.76249999999999p -9.3832249999999996e-07 142.77500000000001p -9.43199e-07 142.78750000000002p -9.4686009999999999e-07 142.79999999999998p -9.4929839999999998e-07 142.8125p -9.5050759999999998e-07 142.82499999999999p -9.50483e-07 142.83750000000001p -9.4922089999999996e-07 142.84999999999999p -9.4671940000000004e-07 142.86250000000001p -9.4297770000000001e-07 142.875p -9.3799660000000001e-07
+ 142.88749999999999p -9.3177829999999997e-07 142.90000000000001p -9.2432669999999996e-07 142.91249999999999p -9.1564710000000004e-07 142.92500000000001p -9.0574649999999998e-07 142.9375p -8.9463340000000001e-07 142.95000000000002p -8.8231799999999997e-07 142.96250000000001p -8.6881220000000005e-07 142.97499999999999p -8.5412949999999997e-07 142.98749999999998p -8.3828519999999998e-07 143p -8.2129619999999996e-07 143.01249999999999p -8.0318130000000003e-07 143.02500000000001p -7.8396080000000003e-07 143.03750000000002p -7.6365699999999997e-07 143.05000000000001p -7.4229369999999999e-07 143.0625p -7.1989649999999999e-07 143.07499999999999p -6.964929e-07 143.08750000000001p -6.7211189999999996e-07 143.09999999999999p -6.4678419999999996e-07
+ 143.11250000000001p -6.2054229999999995e-07 143.125p -5.9342020000000001e-07 143.13749999999999p -5.654537e-07 143.15000000000001p -5.3667990000000002e-07 143.16249999999999p -5.0713770000000005e-07 143.17500000000001p -4.7686740000000005e-07 143.1875p -4.4591050000000001e-07 143.20000000000002p -4.1431029999999999e-07 143.21250000000001p -3.8211109999999999e-07 143.22499999999999p -3.493586e-07 143.23749999999998p -3.1609950000000002e-07 143.25p -2.8238179999999998e-07 143.26249999999999p -2.4825449999999998e-07 143.27500000000001p -2.137675e-07 143.28749999999999p -1.789716e-07 143.30000000000001p -1.4391819999999999e-07 143.3125p -1.086598e-07 143.32499999999999p -7.324895e-08
+ 143.33750000000001p -3.773913e-08 143.34999999999999p -2.1839909999999999e-09 143.36250000000001p 3.3362450000000002e-08 143.375p 6.884602e-08 143.38750000000002p 1.042124e-07 143.39999999999998p 1.3940739999999999e-07 143.41249999999999p 1.7437690000000001e-07 143.42500000000001p 2.0906690000000001e-07 143.4375p 2.434239e-07 143.45000000000002p 2.7739480000000002e-07 143.46250000000001p 3.1092690000000002e-07 143.47499999999999p 3.439684e-07 143.48749999999998p 3.7646799999999998e-07 143.5p 4.083754e-07 143.51249999999999p 4.396412e-07 143.52500000000001p 4.7021700000000001e-07 143.53749999999999p 5.0005550000000003e-07 143.55000000000001p 5.2911089999999999e-07
+ 143.5625p 5.5733820000000002e-07 143.57499999999999p 5.8469429999999996e-07 143.58750000000001p 6.1113729999999995e-07 143.59999999999999p 6.3662679999999999e-07 143.61250000000001p 6.6112409999999998e-07 143.625p 6.845923e-07 143.63750000000002p 7.0699610000000001e-07 143.64999999999998p 7.2830189999999999e-07 143.66249999999999p 7.4847809999999998e-07 143.67500000000001p 7.6749520000000002e-07 143.6875p 7.8532519999999996e-07 143.70000000000002p 8.0194239999999996e-07 143.71250000000001p 8.1732319999999998e-07 143.72500000000002p 8.3144569999999996e-07 143.73749999999998p 8.4429049999999996e-07 143.75p 8.5583999999999997e-07 143.76249999999999p 8.6607889999999996e-07 143.77500000000001p 8.7499389999999999e-07
+ 143.78749999999999p 8.8257400000000005e-07 143.80000000000001p 8.8881029999999995e-07 143.8125p 8.9369609999999995e-07 143.82499999999999p 8.972266e-07 143.83750000000001p 8.9939950000000001e-07 143.84999999999999p 9.0021449999999995e-07 143.86250000000001p 8.9967340000000001e-07 143.875p 8.9777999999999998e-07 143.88750000000002p 8.9454039999999998e-07 143.89999999999998p 8.8996269999999996e-07 143.91249999999999p 8.8405680000000003e-07 143.92499999999998p 8.7683509999999997e-07 143.9375p 8.6831139999999997e-07 143.95000000000002p 8.5850190000000003e-07 143.96250000000001p 8.4742449999999997e-07 143.97500000000002p 8.3509900000000003e-07 143.98749999999998p 8.2154700000000002e-07 144p 8.067919e-07
+ 144.01249999999999p 7.9085879999999996e-07 144.02500000000001p 7.7377470000000003e-07 144.03749999999999p 7.5556790000000004e-07 144.05000000000001p 7.3626859999999997e-07 144.0625p 7.1590839999999998e-07 144.07499999999999p 6.9452030000000003e-07 144.08750000000001p 6.7213900000000001e-07 144.09999999999999p 6.4880029999999996e-07 144.11250000000001p 6.2454160000000004e-07 144.125p 5.9940129999999998e-07 144.13750000000002p 5.7341910000000003e-07 144.14999999999998p 5.4663600000000003e-07 144.16249999999999p 5.1909390000000004e-07 144.17499999999998p 4.9083590000000002e-07 144.1875p 4.619058e-07 144.20000000000002p 4.3234849999999999e-07 144.21250000000001p 4.0220980000000002e-07 144.22500000000002p 3.71536e-07
+ 144.23749999999998p 3.403744e-07 144.25p 3.0877269999999998e-07 144.26249999999999p 2.7677919999999998e-07 144.27500000000001p 2.4444290000000002e-07 144.28749999999999p 2.1181299999999999e-07 144.30000000000001p 1.7893900000000001e-07 144.3125p 1.45871e-07 144.32499999999999p 1.12659e-07 144.33750000000001p 7.935318e-08 144.34999999999999p 4.6003909999999997e-08 144.36250000000001p 1.266145e-08 144.375p -2.0624039999999999e-08 144.38750000000002p -5.3802560000000001e-08 144.39999999999998p -8.682434e-08 144.41249999999999p -1.1963990000000001e-07 144.42499999999998p -1.5220039999999999e-07 144.4375p -1.84457e-07 144.44999999999999p -2.163619e-07
+ 144.46250000000001p -2.4786759999999998e-07 144.47500000000002p -2.789276e-07 144.48749999999998p -3.0949580000000002e-07 144.5p -3.3952730000000002e-07 144.51249999999999p -3.6897800000000001e-07 144.52500000000001p -3.9780480000000002e-07 144.53749999999999p -4.2596560000000002e-07 144.55000000000001p -4.5341960000000002e-07 144.5625p -4.8012710000000001e-07 144.57499999999999p -5.0604960000000004e-07 144.58750000000001p -5.3115010000000003e-07 144.59999999999999p -5.5539300000000003e-07 144.61250000000001p -5.7874409999999995e-07 144.625p -6.0117060000000003e-07 144.63750000000002p -6.2264149999999996e-07 144.65000000000001p -6.4312729999999996e-07 144.66249999999999p -6.6260009999999996e-07 144.67499999999998p -6.8103400000000001e-07
+ 144.6875p -6.9840440000000003e-07 144.69999999999999p -7.1468900000000003e-07 144.71250000000001p -7.2986700000000003e-07 144.72500000000002p -7.4391949999999999e-07 144.73749999999998p -7.5682960000000001e-07 144.75p -7.6858219999999995e-07 144.76249999999999p -7.7916420000000004e-07 144.77500000000001p -7.8856450000000003e-07 144.78749999999999p -7.9677370000000004e-07 144.80000000000001p -8.0378470000000002e-07 144.8125p -8.0959209999999998e-07 144.82499999999999p -8.1419249999999998e-07 144.83750000000001p -8.175847e-07 144.84999999999999p -8.1976899999999996e-07 144.86250000000001p -8.2074810000000003e-07 144.875p -8.2052619999999998e-07 144.88750000000002p -8.1910969999999995e-07 144.90000000000001p -8.1650660000000005e-07
+ 144.91249999999999p -8.1272679999999998e-07 144.92499999999998p -8.0778220000000004e-07 144.9375p -8.0168630000000005e-07 144.94999999999999p -7.9445410000000002e-07 144.96250000000001p -7.8610259999999999e-07 144.97500000000002p -7.7665030000000004e-07 144.98750000000001p -7.6611730000000003e-07 145p -7.5452499999999999e-07 145.01249999999999p -7.4189659999999999e-07 145.02500000000001p -7.2825650000000005e-07 145.03749999999999p -7.1363039999999999e-07 145.05000000000001p -6.9804539999999997e-07 145.0625p -6.8152979999999995e-07 145.07499999999999p -6.6411299999999996e-07 145.08749999999998p -6.4582560000000003e-07 145.09999999999999p -6.266989e-07 145.11250000000001p -6.067656e-07 145.125p -5.8605889999999998e-07
+ 145.13750000000002p -5.64613e-07 145.15000000000001p -5.4246289999999999e-07 145.16249999999999p -5.1964400000000002e-07 145.17499999999998p -4.9619259999999995e-07 145.1875p -4.721453e-07 145.19999999999999p -4.4753939999999999e-07 145.21250000000001p -4.2241240000000001e-07 145.22499999999999p -3.9680219999999999e-07 145.23750000000001p -3.7074689999999999e-07 145.25p -3.4428499999999999e-07 145.26249999999999p -3.1745500000000001e-07 145.27500000000001p -2.9029539999999999e-07 145.28749999999999p -2.6284489999999998e-07 145.30000000000001p -2.3514209999999999e-07 145.3125p -2.0722530000000001e-07 145.32500000000002p -1.7913310000000001e-07 145.33749999999998p -1.5090340000000001e-07 145.34999999999999p -1.225743e-07
+ 145.36250000000001p -9.418332e-08 145.375p -6.576772e-08 145.38750000000002p -3.7364399999999998e-08 145.40000000000001p -9.0098320000000003e-09 145.41249999999999p 1.9259989999999999e-08 145.42499999999998p 4.7409550000000001e-08 145.4375p 7.5403869999999996e-08 145.44999999999999p 1.0320849999999999e-07 145.46250000000001p 1.3078980000000001e-07 145.47499999999999p 1.5811430000000001e-07 145.48750000000001p 1.8514959999999999e-07 145.5p 2.1186380000000001e-07 145.51249999999999p 2.3822579999999999e-07 145.52500000000001p 2.6420489999999998e-07 145.53749999999999p 2.8977160000000001e-07 145.55000000000001p 3.1489679999999998e-07 145.5625p 3.3955230000000002e-07 145.57500000000002p 3.6371070000000002e-07
+ 145.58749999999998p 3.8734529999999998e-07 145.59999999999999p 4.1043019999999999e-07 145.61250000000001p 4.3294050000000002e-07 145.625p 4.5485199999999998e-07 145.63750000000002p 4.7614119999999999e-07 145.65000000000001p 4.9678569999999996e-07 145.66250000000002p 5.167637e-07 145.67499999999998p 5.360546e-07 145.6875p 5.5463829999999997e-07 145.69999999999999p 5.7249560000000005e-07 145.71250000000001p 5.8960849999999996e-07 145.72499999999999p 6.0595959999999999e-07 145.73750000000001p 6.2153229999999996e-07 145.75p 6.3631120000000002e-07 145.76249999999999p 6.5028149999999996e-07 145.77500000000001p 6.634294e-07 145.78749999999999p 6.7574200000000004e-07 145.80000000000001p 6.8720729999999997e-07
+ 145.8125p 6.9781419999999996e-07 145.82500000000002p 7.0755240000000003e-07 145.83749999999998p 7.1641279999999999e-07 145.84999999999999p 7.2438679999999998e-07 145.86249999999998p 7.3146700000000005e-07 145.875p 7.3764679999999998e-07 145.88750000000002p 7.4292059999999999e-07 145.90000000000001p 7.4728369999999998e-07 145.91250000000002p 7.5073230000000003e-07 145.92499999999998p 7.532635e-07 145.9375p 7.5487539999999998e-07 145.94999999999999p 7.5556690000000001e-07 145.96250000000001p 7.5533810000000003e-07 145.97499999999999p 7.5418970000000003e-07 145.98750000000001p 7.5212369999999996e-07 146p 7.4914279999999999e-07 146.01249999999999p 7.4525069999999998e-07 146.02500000000001p 7.4045210000000004e-07
+ 146.03749999999999p 7.3475260000000005e-07 146.05000000000001p 7.2815869999999997e-07 146.0625p 7.2067810000000001e-07 146.07500000000002p 7.1231900000000004e-07 146.08749999999998p 7.0309099999999995e-07 146.09999999999999p 6.9300440000000005e-07 146.11249999999998p 6.8207050000000003e-07 146.125p 6.7030139999999996e-07 146.13750000000002p 6.5771050000000004e-07 146.15000000000001p 6.443117e-07 146.16250000000002p 6.3012009999999997e-07 146.17499999999998p 6.1515149999999999e-07 146.1875p 5.9942289999999999e-07 146.19999999999999p 5.8295180000000003e-07 146.21250000000001p 5.6575689999999998e-07 146.22499999999999p 5.4785760000000001e-07 146.23750000000001p 5.2927430000000001e-07 146.25p 5.1002800000000002e-07
+ 146.26249999999999p 4.9014070000000002e-07 146.27500000000001p 4.6963509999999998e-07 146.28749999999999p 4.485348e-07 146.30000000000001p 4.268641e-07 146.3125p 4.0464800000000001e-07 146.32500000000002p 3.8191229999999999e-07 146.33749999999998p 3.5868319999999999e-07 146.34999999999999p 3.349881e-07 146.36249999999998p 3.1085450000000003e-07 146.375p 2.8631080000000002e-07 146.38749999999999p 2.613858e-07 146.40000000000001p 2.3610910000000001e-07 146.41250000000002p 2.105106e-07 146.42499999999998p 1.846206e-07 146.4375p 1.5847010000000001e-07 146.44999999999999p 1.320902e-07 146.46250000000001p 1.055128e-07 146.47499999999999p 7.8769590000000005e-08
+ 146.48750000000001p 5.1892949999999997e-08 146.5p 2.4915350000000001e-08 146.51249999999999p -2.1305120000000001e-09 146.52500000000001p -2.921177e-08 146.53749999999999p -5.6295419999999997e-08 146.55000000000001p -8.3348380000000002e-08 146.5625p -1.103376e-07 146.57500000000002p -1.3722980000000001e-07 146.58750000000001p -1.639921e-07 146.59999999999999p -1.9059140000000001e-07 146.61249999999998p -2.1699499999999999e-07 146.625p -2.4317010000000002e-07 146.63749999999999p -2.6908430000000001e-07 146.65000000000001p -2.947055e-07 146.66250000000002p -3.2000169999999998e-07 146.67499999999998p -3.449416e-07 146.6875p -3.6949390000000002e-07 146.69999999999999p -3.936281e-07
+ 146.71250000000001p -4.1731389999999998e-07 146.72499999999999p -4.405217e-07 146.73750000000001p -4.6322240000000001e-07 146.75p -4.8538750000000002e-07 146.76249999999999p -5.0698919999999997e-07 146.77500000000001p -5.2800040000000004e-07 146.78749999999999p -5.4839449999999997e-07 146.80000000000001p -5.6814600000000001e-07 146.8125p -5.8722990000000001e-07 146.82500000000002p -6.0562220000000003e-07 146.83750000000001p -6.232997e-07 146.84999999999999p -6.4024010000000001e-07 146.86249999999998p -6.5642200000000005e-07 146.875p -6.7182509999999996e-07 146.88749999999999p -6.8642990000000005e-07 146.90000000000001p -7.0021790000000001e-07 146.91249999999999p -7.1317190000000004e-07 146.92500000000001p -7.2527530000000004e-07
+ 146.9375p -7.3651310000000004e-07 146.94999999999999p -7.4687100000000004e-07 146.96250000000001p -7.5633610000000005e-07 146.97499999999999p -7.6489640000000004e-07 146.98750000000001p -7.7254110000000003e-07 147p -7.7926079999999999e-07 147.01249999999999p -7.8504700000000003e-07 147.02499999999998p -7.8989249999999995e-07 147.03749999999999p -7.9379139999999996e-07 147.05000000000001p -7.9673870000000002e-07 147.0625p -7.9873099999999998e-07 147.07500000000002p -7.9976590000000002e-07 147.08750000000001p -7.9984220000000003e-07 147.09999999999999p -7.9895999999999995e-07 147.11249999999998p -7.9712060000000004e-07 147.125p -7.9432640000000001e-07 147.13749999999999p -7.9058130000000003e-07 147.15000000000001p -7.8589010000000005e-07
+ 147.16249999999999p -7.80259e-07 147.17500000000001p -7.7369519999999995e-07 147.1875p -7.6620720000000004e-07 147.19999999999999p -7.5780480000000002e-07 147.21250000000001p -7.4849860000000002e-07 147.22499999999999p -7.3830069999999999e-07 147.23750000000001p -7.2722400000000003e-07 147.25p -7.1528269999999998e-07 147.26250000000002p -7.0249220000000003e-07 147.27499999999998p -6.8886849999999996e-07 147.28749999999999p -6.7442919999999999e-07 147.30000000000001p -6.5919240000000004e-07 147.3125p -6.431776e-07 147.32500000000002p -6.2640499999999998e-07 147.33750000000001p -6.0889580000000002e-07 147.34999999999999p -5.9067219999999997e-07 147.36249999999998p -5.7175709999999999e-07 147.375p -5.5217439999999997e-07
+ 147.38749999999999p -5.3194869999999999e-07 147.40000000000001p -5.1110539999999997e-07 147.41249999999999p -4.8967080000000001e-07 147.42500000000001p -4.6767159999999999e-07 147.4375p -4.4513540000000002e-07 147.44999999999999p -4.220905e-07 147.46250000000001p -3.9856549999999998e-07 147.47499999999999p -3.7458989999999998e-07 147.48750000000001p -3.5019349999999998e-07 147.5p -3.2540669999999999e-07 147.51250000000002p -3.0026029999999999e-07 147.52499999999998p -2.7478539999999998e-07 147.53749999999999p -2.4901370000000001e-07 147.54999999999998p -2.2297709999999999e-07 147.5625p -1.9670769999999999e-07 147.57500000000002p -1.7023799999999999e-07 147.58750000000001p -1.4360059999999999e-07 147.60000000000002p -1.168284e-07
+ 147.61249999999998p -8.9954159999999997e-08 147.625p -6.3010959999999995e-08 147.63749999999999p -3.603181e-08 147.65000000000001p -9.0497379999999992e-09 147.66249999999999p 1.790227e-08 147.67500000000001p 4.479131e-08 147.6875p 7.158462e-08 147.69999999999999p 9.8249609999999998e-08 147.71250000000001p 1.2475389999999999e-07 147.72499999999999p 1.5106519999999999e-07 147.73750000000001p 1.771519e-07 147.75p 2.0298229999999999e-07 147.76250000000002p 2.285252e-07 147.77499999999998p 2.5375000000000001e-07 147.78749999999999p 2.7862619999999998e-07 147.79999999999998p 3.0312399999999998e-07 147.8125p 3.2721399999999998e-07 147.82500000000002p 3.5086759999999999e-07
+ 147.83750000000001p 3.7405629999999997e-07 147.85000000000002p 3.967528e-07 147.86249999999998p 4.1892990000000001e-07 147.875p 4.4056140000000002e-07 147.88749999999999p 4.6162179999999999e-07 147.90000000000001p 4.8208609999999999e-07 147.91249999999999p 5.0193050000000001e-07 147.92500000000001p 5.211315e-07 147.9375p 5.3966679999999995e-07 147.94999999999999p 5.5751479999999996e-07 147.96250000000001p 5.7465469999999998e-07 147.97499999999999p 5.9106669999999995e-07 147.98750000000001p 6.0673199999999998e-07 148p 6.2163249999999995e-07 148.01250000000002p 6.3575140000000001e-07 148.02499999999998p 6.4907250000000004e-07 148.03749999999999p 6.6158090000000001e-07 148.04999999999998p 6.7326260000000004e-07
+ 148.0625p 6.8410449999999996e-07 148.07500000000002p 6.9409489999999998e-07 148.08750000000001p 7.0322280000000001e-07 148.10000000000002p 7.1147839999999998e-07 148.11249999999998p 7.1885310000000003e-07 148.125p 7.2533919999999997e-07 148.13749999999999p 7.3093009999999999e-07 148.15000000000001p 7.3562050000000003e-07 148.16249999999999p 7.3940600000000002e-07 148.17500000000001p 7.4228350000000004e-07 148.1875p 7.4425089999999999e-07 148.19999999999999p 7.4530710000000001e-07 148.21250000000001p 7.4545240000000002e-07 148.22499999999999p 7.4468789999999999e-07 148.23750000000001p 7.4301620000000002e-07 148.25p 7.4044049999999999e-07 148.26250000000002p 7.3696569999999998e-07 148.27500000000001p 7.3259719999999999e-07
+ 148.28749999999999p 7.2734189999999996e-07 148.29999999999998p 7.2120760000000001e-07 148.3125p 7.1420329999999998e-07 148.32499999999999p 7.0633889999999999e-07 148.33750000000001p 6.9762540000000002e-07 148.35000000000002p 6.8807499999999997e-07 148.36249999999998p 6.7770060000000005e-07 148.375p 6.6651630000000004e-07 148.38749999999999p 6.5453719999999999e-07 148.40000000000001p 6.4177930000000002e-07 148.41249999999999p 6.2825959999999997e-07 148.42500000000001p 6.1399599999999996e-07 148.4375p 5.9900719999999997e-07 148.44999999999999p 5.8331289999999998e-07 148.46250000000001p 5.6693369999999998e-07 148.47499999999999p 5.4989090000000004e-07 148.48750000000001p 5.3220670000000002e-07 148.5p 5.1390399999999997e-07
+ 148.51250000000002p 4.9500649999999999e-07 148.52500000000001p 4.7553869999999998e-07 148.53749999999999p 4.5552570000000002e-07 148.54999999999998p 4.3499330000000001e-07 148.5625p 4.1396780000000001e-07 148.57499999999999p 3.924764e-07 148.58750000000001p 3.7054659999999999e-07 148.60000000000002p 3.4820660000000002e-07 148.61250000000001p 3.2548490000000001e-07 148.625p 3.0241070000000002e-07 148.63749999999999p 2.7901359999999999e-07 148.65000000000001p 2.5532349999999998e-07 148.66249999999999p 2.3137059999999999e-07 148.67500000000001p 2.0718559999999999e-07 148.6875p 1.8279950000000001e-07 148.69999999999999p 1.5824339999999999e-07 148.71250000000001p 1.3354860000000001e-07 148.72499999999999p 1.087468e-07
+ 148.73750000000001p 8.3869529999999998e-08 148.75p 5.8948710000000001e-08 148.76250000000002p 3.4016119999999997e-08 148.77500000000001p 9.1036390000000007e-09 148.78749999999999p -1.5756920000000001e-08 148.79999999999998p -4.053378e-08 148.8125p -6.5195280000000006e-08 148.82499999999999p -8.9709899999999995e-08 148.83750000000001p -1.140463e-07 148.84999999999999p -1.381734e-07 148.86250000000001p -1.6206030000000001e-07 148.875p -1.8567660000000001e-07 148.88749999999999p -2.08992e-07 148.90000000000001p -2.3197670000000001e-07 148.91249999999999p -2.5460140000000001e-07 148.92500000000001p -2.768371e-07 148.9375p -2.9865549999999998e-07 148.94999999999999p -3.2002879999999998e-07
+ 148.96249999999998p -3.4092950000000001e-07 148.97499999999999p -3.6133119999999998e-07 148.98750000000001p -3.8120790000000002e-07 149p -4.005341e-07 149.01250000000002p -4.1928539999999998e-07 149.02500000000001p -4.3743810000000002e-07 149.03749999999999p -4.5496899999999998e-07 149.04999999999998p -4.7185609999999998e-07 149.0625p -4.8807799999999996e-07 149.07499999999999p -5.0361439999999997e-07 149.08750000000001p -5.1844590000000004e-07 149.09999999999999p -5.3255380000000001e-07 149.11250000000001p -5.459208e-07 149.125p -5.5853039999999998e-07 149.13749999999999p -5.7036700000000001e-07 149.15000000000001p -5.8141640000000004e-07 149.16249999999999p -5.9166510000000002e-07 149.17500000000001p -6.0110110000000002e-07
+ 149.1875p -6.0971319999999999e-07 149.20000000000002p -6.1749169999999998e-07 149.21249999999998p -6.2442759999999996e-07 149.22499999999999p -6.3051360000000004e-07 149.23750000000001p -6.3574309999999997e-07 149.25p -6.4011110000000005e-07 149.26250000000002p -6.4361359999999996e-07 149.27500000000001p -6.4624789999999996e-07 149.28749999999999p -6.4801239999999996e-07 149.29999999999998p -6.4890709999999997e-07 149.3125p -6.4893269999999998e-07 149.32499999999999p -6.4809149999999996e-07 149.33750000000001p -6.4638700000000003e-07 149.34999999999999p -6.4382380000000002e-07 149.36250000000001p -6.4040779999999996e-07 149.375p -6.3614620000000002e-07 149.38749999999999p -6.3104719999999998e-07 149.40000000000001p -6.251203e-07
+ 149.41249999999999p -6.1837629999999998e-07 149.42500000000001p -6.108269e-07 149.4375p -6.024851e-07 149.45000000000002p -5.9336510000000004e-07 149.46249999999998p -5.8348200000000004e-07 149.47499999999999p -5.7285219999999998e-07 149.48749999999998p -5.6149290000000002e-07 149.5p -5.4942260000000001e-07 149.51250000000002p -5.3666040000000001e-07 149.52500000000001p -5.2322689999999999e-07 149.53750000000002p -5.0914309999999999e-07 149.54999999999998p -4.9443130000000002e-07 149.5625p -4.7911429999999999e-07 149.57499999999999p -4.6321609999999998e-07 149.58750000000001p -4.4676109999999998e-07 149.59999999999999p -4.2977480000000001e-07 149.61250000000001p -4.1228300000000001e-07 149.625p -3.943126e-07
+ 149.63749999999999p -3.758908e-07 149.65000000000001p -3.5704550000000002e-07 149.66249999999999p -3.37805e-07 149.67500000000001p -3.1819820000000001e-07 149.6875p -2.9825439999999999e-07 149.70000000000002p -2.7800329999999998e-07 149.71249999999998p -2.5747489999999998e-07 149.72499999999999p -2.3669950000000001e-07 149.73749999999998p -2.157075e-07 149.75p -1.9452989999999999e-07 149.76250000000002p -1.7319729999999999e-07 149.77500000000001p -1.517408e-07 149.78750000000002p -1.301914e-07 149.79999999999998p -1.0858e-07 149.8125p -8.6937729999999994e-08 149.82499999999999p -6.5295329999999996e-08 149.83750000000001p -4.3683529999999998e-08 149.84999999999999p -2.2132859999999999e-08
+ 149.86250000000001p -6.7358540000000003e-10 149.875p 2.0664279999999999e-08 149.88749999999999p 4.1851060000000001e-08 149.90000000000001p 6.2857460000000006e-08 149.91249999999999p 8.3654570000000006e-08 149.92500000000001p 1.04214e-07 149.9375p 1.2450769999999999e-07 149.95000000000002p 1.4450829999999999e-07 149.96249999999998p 1.6418910000000001e-07 149.97499999999999p 1.835236e-07 149.98749999999998p 2.024864e-07 150p 2.210525e-07 150.01249999999999p 2.3919779999999998e-07 150.02500000000001p 2.5689869999999997e-07 150.03750000000002p 2.741325e-07 150.04999999999998p 2.9087740000000001e-07 150.0625p 3.0711240000000003e-07 150.07499999999999p 3.2281709999999999e-07
+ 150.08750000000001p 3.3797219999999999e-07 150.09999999999999p 3.5255940000000002e-07 150.11250000000001p 3.6656119999999998e-07 150.125p 3.799609e-07 150.13749999999999p 3.9274299999999999e-07 150.15000000000001p 4.0489280000000001e-07 150.16249999999999p 4.1639669999999999e-07 150.17500000000001p 4.272421e-07 150.1875p 4.3741749999999999e-07 150.20000000000002p 4.4691220000000001e-07 150.21250000000001p 4.5571679999999999e-07 150.22499999999999p 4.6382269999999998e-07 150.23749999999998p 4.7122250000000002e-07 150.25p 4.7790999999999997e-07 150.26249999999999p 4.8387989999999997e-07 150.27500000000001p 4.8912780000000005e-07 150.28750000000002p 4.9365070000000003e-07 150.29999999999998p 4.9744660000000005e-07
+ 150.3125p 5.0051440000000005e-07 150.32499999999999p 5.0285410000000003e-07 150.33750000000001p 5.0446689999999999e-07 150.34999999999999p 5.0535499999999999e-07 150.36250000000001p 5.0552150000000003e-07 150.375p 5.0497079999999999e-07 150.38749999999999p 5.0370800000000005e-07 150.40000000000001p 5.0173950000000003e-07 150.41249999999999p 4.9907260000000004e-07 150.42500000000001p 4.9571549999999998e-07 150.4375p 4.916775e-07 150.45000000000002p 4.8696870000000002e-07 150.46250000000001p 4.816003e-07 150.47499999999999p 4.7558420000000002e-07 150.48749999999998p 4.689334e-07 150.5p 4.6166169999999999e-07 150.51249999999999p 4.5378370000000001e-07 150.52500000000001p 4.453148e-07
+ 150.53750000000002p 4.3627119999999999e-07 150.55000000000001p 4.266699e-07 150.5625p 4.1652869999999998e-07 150.57499999999999p 4.0586579999999998e-07 150.58750000000001p 3.9470050000000002e-07 150.59999999999999p 3.830524e-07 150.61250000000001p 3.7094179999999998e-07 150.625p 3.5838969999999999e-07 150.63749999999999p 3.4541740000000002e-07 150.65000000000001p 3.3204689999999999e-07 150.66249999999999p 3.183005e-07 150.67500000000001p 3.0420100000000001e-07 150.6875p 2.8977150000000002e-07 150.70000000000002p 2.7503570000000003e-07 150.71250000000001p 2.6001730000000002e-07 150.72499999999999p 2.4474029999999998e-07 150.73749999999998p 2.292292e-07 150.75p 2.1350830000000001e-07
+ 150.76249999999999p 1.9760220000000001e-07 150.77500000000001p 1.8153580000000001e-07 150.78749999999999p 1.6533369999999999e-07 150.80000000000001p 1.4902069999999999e-07 150.8125p 1.3262160000000001e-07 150.82499999999999p 1.16161e-07 150.83750000000001p 9.9663530000000001e-08 150.84999999999999p 8.3153620000000003e-08 150.86250000000001p 6.6655480000000004e-08 150.875p 5.019311e-08 150.88750000000002p 3.3790239999999997e-08 150.89999999999998p 1.747031e-08 150.91249999999999p 1.2563810000000001e-09 150.92500000000001p -1.482883e-08 150.9375p -3.0763029999999999e-08 150.95000000000002p -4.6524369999999999e-08 150.96250000000001p -6.2091499999999997e-08 150.97499999999999p -7.7443549999999997e-08
+ 150.98749999999998p -9.2560209999999997e-08 151p -1.074217e-07 151.01249999999999p -1.2200899999999999e-07 151.02500000000001p -1.3630339999999999e-07 151.03749999999999p -1.5028709999999999e-07 151.05000000000001p -1.6394290000000001e-07 151.0625p -1.7725419999999999e-07 151.07499999999999p -1.9020509999999999e-07 151.08750000000001p -2.0278069999999999e-07 151.09999999999999p -2.1496639999999999e-07 151.11250000000001p -2.2674870000000001e-07 151.125p -2.3811470000000001e-07 151.13750000000002p -2.4905220000000001e-07 151.14999999999998p -2.5955000000000002e-07 151.16249999999999p -2.6959740000000002e-07 151.17500000000001p -2.7918469999999999e-07 151.1875p -2.8830289999999999e-07 151.20000000000002p -2.9694390000000002e-07
+ 151.21250000000001p -3.0510009999999999e-07 151.22500000000002p -3.1276489999999999e-07 151.23749999999998p -3.199325e-07 151.25p -3.2659779999999999e-07 151.26249999999999p -3.3275649999999998e-07 151.27500000000001p -3.384049e-07 151.28749999999999p -3.435402e-07 151.30000000000001p -3.4816039999999998e-07 151.3125p -3.5226400000000001e-07 151.32499999999999p -3.5585029999999998e-07 151.33750000000001p -3.5891939999999998e-07 151.34999999999999p -3.6147189999999998e-07 151.36250000000001p -3.6350920000000001e-07 151.375p -3.650331e-07 151.38750000000002p -3.6604639999999999e-07 151.39999999999998p -3.665521e-07 151.41249999999999p -3.6655400000000001e-07 151.42499999999998p -3.6605659999999999e-07
+ 151.4375p -3.6506449999999998e-07 151.45000000000002p -3.6358329999999998e-07 151.46250000000001p -3.6161880000000002e-07 151.47500000000002p -3.5917740000000001e-07 151.48749999999998p -3.56266e-07 151.5p -3.528918e-07 151.51249999999999p -3.4906249999999999e-07 151.52500000000001p -3.4478619999999999e-07 151.53749999999999p -3.400714e-07 151.55000000000001p -3.3492700000000002e-07 151.5625p -3.2936220000000002e-07 151.57499999999999p -3.233865e-07 151.58750000000001p -3.1700980000000002e-07 151.59999999999999p -3.102421e-07 151.61250000000001p -3.03094e-07 151.625p -2.9557609999999999e-07 151.63750000000002p -2.8769930000000002e-07 151.64999999999998p -2.7947489999999999e-07
+ 151.66249999999999p -2.7091420000000002e-07 151.67499999999998p -2.620289e-07 151.6875p -2.5283080000000001e-07 151.70000000000002p -2.4333180000000001e-07 151.71250000000001p -2.3354429999999999e-07 151.72500000000002p -2.234805e-07 151.73749999999998p -2.13153e-07 151.75p -2.0257450000000001e-07 151.76249999999999p -1.917578e-07 151.77500000000001p -1.807158e-07 151.78749999999999p -1.694618e-07 151.80000000000001p -1.5800880000000001e-07 151.8125p -1.463704e-07 151.82499999999999p -1.345598e-07 151.83750000000001p -1.225909e-07 151.84999999999999p -1.104772e-07 151.86250000000001p -9.8232500000000003e-08 151.875p -8.5870770000000001e-08
+ 151.88750000000002p -7.3405979999999996e-08 151.89999999999998p -6.0852229999999995e-08 151.91249999999999p -4.8223670000000003e-08 151.92499999999998p -3.5534570000000002e-08 151.9375p -2.2799250000000001e-08 151.94999999999999p -1.003211e-08 151.96250000000001p 2.7523729999999998e-09 151.97500000000002p 1.553967e-08 151.98749999999998p 2.831521e-08 152p 4.1064359999999999e-08 152.01249999999999p 5.3772449999999998e-08 152.02500000000001p 6.642477e-08 152.03749999999999p 7.9006610000000002e-08 152.05000000000001p 9.150322e-08 152.0625p 1.0389990000000001e-07 152.07499999999999p 1.161818e-07 152.08750000000001p 1.2833429999999999e-07 152.09999999999999p 1.4034260000000001e-07
+ 152.11250000000001p 1.521922e-07 152.125p 1.6386839999999999e-07 152.13750000000002p 1.753567e-07 152.15000000000001p 1.8664270000000001e-07 152.16249999999999p 1.977119e-07 152.17499999999998p 2.085503e-07 152.1875p 2.191436e-07 152.19999999999999p 2.2947789999999999e-07 152.21250000000001p 2.3953960000000002e-07 152.22500000000002p 2.4931489999999999e-07 152.23749999999998p 2.5879050000000002e-07 152.25p 2.6795319999999998e-07 152.26249999999999p 2.7679020000000002e-07 152.27500000000001p 2.8528890000000002e-07 152.28749999999999p 2.934368e-07 152.30000000000001p 3.012219e-07 152.3125p 3.0863269999999998e-07 152.32499999999999p 3.1565759999999998e-07
+ 152.33750000000001p 3.2228580000000002e-07 152.34999999999999p 3.2850660000000002e-07 152.36250000000001p 3.3431010000000003e-07 152.375p 3.3968630000000002e-07 152.38750000000002p 3.4462620000000002e-07 152.40000000000001p 3.4912089999999997e-07 152.41249999999999p 3.531623e-07 152.42499999999998p 3.5674260000000001e-07 152.4375p 3.598545e-07 152.44999999999999p 3.6249159999999999e-07 152.46250000000001p 3.6464779999999999e-07 152.47500000000002p 3.6631759999999999e-07 152.48750000000001p 3.674963e-07 152.5p 3.6817959999999998e-07 152.51249999999999p 3.6836409999999999e-07 152.52500000000001p 3.6804689999999999e-07 152.53749999999999p 3.6722570000000001e-07 152.55000000000001p 3.6589909999999998e-07
+ 152.5625p 3.6406629999999998e-07 152.57499999999999p 3.6172710000000001e-07 152.58749999999998p 3.5888209999999999e-07 152.59999999999999p 3.555328e-07 152.61250000000001p 3.5168100000000001e-07 152.625p 3.4732960000000001e-07 152.63750000000002p 3.4248220000000002e-07 152.65000000000001p 3.3714280000000001e-07 152.66249999999999p 3.3131659999999998e-07 152.67499999999998p 3.2500919999999998e-07 152.6875p 3.1822709999999997e-07 152.69999999999999p 3.109773e-07 152.71250000000001p 3.032678e-07 152.72499999999999p 2.9510710000000002e-07 152.73750000000001p 2.8650459999999999e-07 152.75p 2.774701e-07 152.76249999999999p 2.6801430000000001e-07 152.77500000000001p 2.5814860000000002e-07
+ 152.78749999999999p 2.4788480000000001e-07 152.80000000000001p 2.372356e-07 152.8125p 2.2621410000000001e-07 152.82500000000002p 2.1483430000000001e-07 152.83749999999998p 2.0311039999999999e-07 152.84999999999999p 1.910575e-07 152.86250000000001p 1.78691e-07 152.875p 1.6602700000000001e-07 152.88750000000002p 1.530819e-07 152.90000000000001p 1.3987269999999999e-07 152.91249999999999p 1.2641689999999999e-07 152.92499999999998p 1.127322e-07 152.9375p 9.8837030000000003e-08 152.94999999999999p 8.4749840000000003e-08 152.96250000000001p 7.0489610000000006e-08 152.97499999999999p 5.607559e-08 152.98750000000001p 4.1527300000000002e-08 153p 2.6864529999999998e-08
+ 153.01249999999999p 1.2107270000000001e-08 153.02500000000001p -2.724276e-09 153.03749999999999p -1.760976e-08 153.05000000000001p -3.2528700000000003e-08 153.0625p -4.746051e-08 153.07500000000002p -6.2384530000000001e-08 153.08749999999998p -7.728008e-08 153.09999999999999p -9.2126460000000002e-08 153.11250000000001p -1.06903e-07 153.125p -1.2158910000000001e-07 153.13750000000002p -1.3616409999999999e-07 153.15000000000001p -1.5060780000000001e-07 153.16250000000002p -1.6489979999999999e-07 153.17499999999998p -1.7901990000000001e-07 153.1875p -1.9294840000000001e-07 153.19999999999999p -2.0666560000000001e-07 153.21250000000001p -2.2015209999999999e-07 153.22499999999999p -2.333887e-07
+ 153.23750000000001p -2.4635669999999998e-07 153.25p -2.5903769999999999e-07 153.26249999999999p -2.714136e-07 153.27500000000001p -2.8346669999999998e-07 153.28749999999999p -2.9517989999999998e-07 153.30000000000001p -3.0653630000000002e-07 153.3125p -3.1751959999999998e-07 153.32500000000002p -3.28114e-07 153.33749999999998p -3.3830429999999999e-07 153.34999999999999p -3.480756e-07 153.36249999999998p -3.5741389999999998e-07 153.375p -3.6630539999999999e-07 153.38750000000002p -3.7473729999999998e-07 153.40000000000001p -3.8269720000000001e-07 153.41250000000002p -3.9017330000000001e-07 153.42499999999998p -3.971545e-07 153.4375p -4.0363049999999998e-07 153.44999999999999p -4.0959159999999998e-07
+ 153.46250000000001p -4.1502880000000002e-07 153.47499999999999p -4.199337e-07 153.48750000000001p -4.2429889999999999e-07 153.5p -4.2811749999999998e-07 153.51249999999999p -4.3138339999999999e-07 153.52500000000001p -4.340913e-07 153.53749999999999p -4.3623669999999999e-07 153.55000000000001p -4.378157e-07 153.5625p -4.388255e-07 153.57500000000002p -4.392638e-07 153.58749999999998p -4.3912910000000001e-07 153.59999999999999p -4.3842080000000002e-07 153.61249999999998p -4.3713899999999998e-07 153.625p -4.3528480000000001e-07 153.63750000000002p -4.3285979999999999e-07 153.65000000000001p -4.2986649999999998e-07 153.66250000000002p -4.2630829999999998e-07 153.67499999999998p -4.221893e-07
+ 153.6875p -4.1751420000000003e-07 153.69999999999999p -4.1228869999999999e-07 153.71250000000001p -4.0651920000000003e-07 153.72499999999999p -4.002128e-07 153.73750000000001p -3.9337749999999998e-07 153.75p -3.8602179999999998e-07 153.76249999999999p -3.7815500000000001e-07 153.77500000000001p -3.6978729999999998e-07 153.78749999999999p -3.6092929999999999e-07 153.80000000000001p -3.5159240000000001e-07 153.8125p -3.4178879999999998e-07 153.82500000000002p -3.3153110000000002e-07 153.83750000000001p -3.208327e-07 153.84999999999999p -3.0970760000000001e-07 153.86249999999998p -2.9817020000000001e-07 153.875p -2.8623580000000001e-07 153.88749999999999p -2.739201e-07 153.90000000000001p -2.6123909999999999e-07
+ 153.91250000000002p -2.482096e-07 153.92499999999998p -2.348488e-07 153.9375p -2.211743e-07 153.94999999999999p -2.072041e-07 153.96250000000001p -1.9295690000000001e-07 153.97499999999999p -1.7845129999999999e-07 153.98750000000001p -1.637067e-07 154p -1.4874250000000001e-07 154.01249999999999p -1.3357860000000001e-07 154.02500000000001p -1.1823510000000001e-07 154.03749999999999p -1.027323e-07 154.05000000000001p -8.7090750000000002e-08 154.0625p -7.1331230000000006e-08 154.07500000000002p -5.5474599999999997e-08 154.08750000000001p -3.9541890000000002e-08 154.09999999999999p -2.3554200000000001e-08 154.11249999999998p -7.5327190000000001e-09 154.125p 8.5013560000000005e-09
+ 154.13749999999999p 2.4526800000000001e-08 154.15000000000001p 4.0522439999999998e-08 154.16250000000002p 5.6467119999999997e-08 154.17499999999998p 7.23398e-08 154.1875p 8.8119539999999997e-08 154.19999999999999p 1.037855e-07 154.21250000000001p 1.1931719999999999e-07 154.22499999999999p 1.3469409999999999e-07 154.23750000000001p 1.4989600000000001e-07 154.25p 1.64903e-07 154.26249999999999p 1.7969539999999999e-07 154.27500000000001p 1.9425399999999999e-07 154.28749999999999p 2.0855970000000001e-07 154.30000000000001p 2.225939e-07 154.3125p 2.3633830000000001e-07 154.32500000000002p 2.4977510000000002e-07 154.33750000000001p 2.6288690000000002e-07 154.34999999999999p 2.756569e-07
+ 154.36249999999998p 2.8806850000000002e-07 154.375p 3.0010590000000001e-07 154.38749999999999p 3.1175350000000001e-07 154.40000000000001p 3.2299670000000001e-07 154.41249999999999p 3.3382109999999997e-07 154.42500000000001p 3.4421290000000002e-07 154.4375p 3.541592e-07 154.44999999999999p 3.636473e-07 154.46250000000001p 3.7266559999999999e-07 154.47499999999999p 3.8120289999999998e-07 154.48750000000001p 3.8924849999999998e-07 154.5p 3.967927e-07 154.51249999999999p 4.0382630000000001e-07 154.52499999999998p 4.1034099999999998e-07 154.53749999999999p 4.163289e-07 154.55000000000001p 4.2178309999999998e-07 154.5625p 4.2669729999999998e-07 154.57500000000002p 4.3106590000000001e-07
+ 154.58750000000001p 4.3488419999999998e-07 154.59999999999999p 4.3814799999999999e-07 154.61249999999998p 4.4085420000000002e-07 154.625p 4.4300009999999998e-07 154.63749999999999p 4.4458389999999999e-07 154.65000000000001p 4.4560470000000002e-07 154.66249999999999p 4.4606200000000001e-07 154.67500000000001p 4.4595629999999998e-07 154.6875p 4.4528890000000002e-07 154.69999999999999p 4.4406169999999999e-07 154.71250000000001p 4.4227740000000001e-07 154.72499999999999p 4.399394e-07 154.73750000000001p 4.3705179999999998e-07 154.75p 4.3361949999999997e-07 154.76250000000002p 4.2964809999999998e-07 154.77499999999998p 4.2514379999999997e-07 154.78749999999999p 4.201137e-07 154.80000000000001p 4.1456519999999999e-07
+ 154.8125p 4.0850679999999998e-07 154.82500000000002p 4.0194730000000002e-07 154.83750000000001p 3.9489639999999999e-07 154.84999999999999p 3.8736419999999998e-07 154.86249999999998p 3.7936160000000001e-07 154.875p 3.7090000000000002e-07 154.88749999999999p 3.6199129999999998e-07 154.90000000000001p 3.5264800000000002e-07 154.91249999999999p 3.4288320000000002e-07 154.92500000000001p 3.3271049999999998e-07 154.9375p 3.2214390000000001e-07 154.94999999999999p 3.1119799999999998e-07 154.96250000000001p 2.9988769999999999e-07 154.97499999999999p 2.8822849999999999e-07 154.98750000000001p 2.7623609999999998e-07 155p 2.6392689999999999e-07 155.01250000000002p 2.513173e-07 155.02499999999998p 2.3842430000000002e-07
+ 155.03749999999999p 2.2526509999999999e-07 155.04999999999998p 2.118572e-07 155.0625p 1.982184e-07 155.07500000000002p 1.843667e-07 155.08750000000001p 1.7032030000000001e-07 155.10000000000002p 1.5609779999999999e-07 155.11249999999998p 1.417176e-07 155.125p 1.2719850000000001e-07 155.13749999999999p 1.125593e-07 155.15000000000001p 9.7819060000000003e-08 155.16249999999999p 8.2996699999999996e-08 155.17500000000001p 6.8111259999999997e-08 155.1875p 5.3181789999999999e-08 155.19999999999999p 3.8227350000000001e-08 155.21250000000001p 2.326691e-08 155.22499999999999p 8.3194289999999994e-09 155.23750000000001p -6.5962550000000002e-09 155.25p -2.1461400000000001e-08
+ 155.26250000000002p -3.625742e-08 155.27499999999998p -5.0965860000000003e-08 155.28749999999999p -6.5568480000000003e-08 155.29999999999998p -8.0047220000000006e-08 155.3125p -9.4384280000000003e-08 155.32500000000002p -1.085621e-07 155.33750000000001p -1.2256340000000001e-07 155.35000000000002p -1.3637109999999999e-07 155.36249999999998p -1.4996859999999999e-07 155.375p -1.633397e-07 155.38749999999999p -1.764682e-07 155.40000000000001p -1.893386e-07 155.41249999999999p -2.0193570000000001e-07 155.42500000000001p -2.1424469999999999e-07 155.4375p -2.2625130000000001e-07 155.44999999999999p -2.3794149999999999e-07 155.46250000000001p -2.493019e-07 155.47499999999999p -2.6031970000000001e-07
+ 155.48750000000001p -2.709822e-07 155.5p -2.8127750000000003e-07 155.51250000000002p -2.9119429999999998e-07 155.52499999999998p -3.0072159999999999e-07 155.53749999999999p -3.098491e-07 155.54999999999998p -3.18567e-07 155.5625p -3.2686600000000001e-07 155.57500000000002p -3.3473760000000002e-07 155.58750000000001p -3.4217359999999998e-07 155.60000000000002p -3.4916669999999999e-07 155.61249999999998p -3.5570990000000001e-07 155.625p -3.6179699999999999e-07 155.63749999999999p -3.6742230000000002e-07 155.65000000000001p -3.7258080000000001e-07 155.66249999999999p -3.7726820000000002e-07 155.67500000000001p -3.814806e-07 155.6875p -3.8521479999999999e-07 155.69999999999999p -3.8846830000000001e-07
+ 155.71250000000001p -3.912393e-07 155.72499999999999p -3.9352640000000002e-07 155.73750000000001p -3.9532890000000001e-07 155.75p -3.9664679999999998e-07 155.76250000000002p -3.9748069999999998e-07 155.77500000000001p -3.9783179999999997e-07 155.78749999999999p -3.9770179999999999e-07 155.79999999999998p -3.9709309999999999e-07 155.8125p -3.960088e-07 155.82499999999999p -3.944525e-07 155.83750000000001p -3.9242820000000001e-07 155.85000000000002p -3.899408e-07 155.86249999999998p -3.8699549999999999e-07 155.875p -3.8359829999999999e-07 155.88749999999999p -3.797554e-07 155.90000000000001p -3.7547390000000003e-07 155.91249999999999p -3.7076119999999998e-07 155.92500000000001p -3.6562530000000002e-07
+ 155.9375p -3.6007459999999998e-07 155.94999999999999p -3.5411819999999998e-07 155.96250000000001p -3.4776529999999999e-07 155.97499999999999p -3.4102589999999998e-07 155.98750000000001p -3.3391029999999998e-07 156p -3.2642929999999999e-07 156.01250000000002p -3.1859390000000001e-07 156.02500000000001p -3.1041570000000002e-07 156.03749999999999p -3.0190659999999998e-07 156.04999999999998p -2.9307890000000001e-07 156.0625p -2.8394510000000001e-07 156.07499999999999p -2.7451819999999998e-07 156.08750000000001p -2.648114e-07 156.10000000000002p -2.548383e-07 156.11250000000001p -2.4461249999999998e-07 156.125p -2.3414799999999999e-07 156.13749999999999p -2.2345929999999999e-07 156.15000000000001p -2.125606e-07
+ 156.16249999999999p -2.0146659999999999e-07 156.17500000000001p -1.9019210000000001e-07 156.1875p -1.787521e-07 156.19999999999999p -1.671616e-07 156.21250000000001p -1.554359e-07 156.22499999999999p -1.435901e-07 156.23750000000001p -1.316397e-07 156.25p -1.1960000000000001e-07 156.26250000000002p -1.074864e-07 156.27500000000001p -9.5314260000000006e-08 156.28749999999999p -8.3099079999999994e-08 156.29999999999998p -7.0856189999999997e-08 156.3125p -5.8600890000000001e-08 156.32499999999999p -4.634844e-08 156.33750000000001p -3.4113959999999997e-08 156.34999999999999p -2.1912499999999999e-08 156.36250000000001p -9.7589600000000004e-09 156.375p 2.3319039999999998e-09
+ 156.38749999999999p 1.4345499999999999e-08 156.40000000000001p 2.6267430000000001e-08 156.41249999999999p 3.8083499999999998e-08 156.42500000000001p 4.9779720000000003e-08 156.4375p 6.1342349999999993e-08 156.45000000000002p 7.2757900000000003e-08 156.46249999999998p 8.4013159999999997e-08 156.47499999999999p 9.5095179999999997e-08 156.48750000000001p 1.059913e-07 156.5p 1.166893e-07 156.51250000000002p 1.2717709999999999e-07 156.52500000000001p 1.3744320000000001e-07 156.53749999999999p 1.4747610000000001e-07 156.54999999999998p 1.5726490000000001e-07 156.5625p 1.6679930000000001e-07 156.57499999999999p 1.7606889999999999e-07 156.58750000000001p 1.8506409999999999e-07 156.59999999999999p 1.9377549999999999e-07
+ 156.61250000000001p 2.0219429999999999e-07 156.625p 2.1031189999999999e-07 156.63749999999999p 2.181203e-07 156.65000000000001p 2.256119e-07 156.66249999999999p 2.3277969999999999e-07 156.67500000000001p 2.396169e-07 156.6875p 2.4611729999999998e-07 156.70000000000002p 2.5227529999999998e-07 156.71249999999998p 2.5808539999999999e-07 156.72499999999999p 2.6354310000000001e-07 156.73750000000001p 2.6864390000000001e-07 156.75p 2.7338409999999997e-07 156.76250000000002p 2.777603e-07 156.77500000000001p 2.8176969999999998e-07 156.78749999999999p 2.8541000000000001e-07 156.79999999999998p 2.8867920000000002e-07 156.8125p 2.9157600000000002e-07 156.82499999999999p 2.9409950000000001e-07
+ 156.83750000000001p 2.9624919999999998e-07 156.84999999999999p 2.9802530000000003e-07 156.86250000000001p 2.9942810000000002e-07 156.875p 3.0045869999999997e-07 156.88749999999999p 3.011185e-07 156.90000000000001p 3.0140939999999999e-07 156.91249999999999p 3.0133379999999998e-07 156.92500000000001p 3.0089450000000001e-07 156.9375p 3.000945e-07 156.95000000000002p 2.9893770000000002e-07 156.96249999999998p 2.9742789999999999e-07 156.97499999999999p 2.9556980000000001e-07 156.98749999999998p 2.9336809999999998e-07 157p 2.9082800000000002e-07 157.01250000000002p 2.879552e-07 157.02500000000001p 2.8475569999999998e-07 157.03750000000002p 2.8123560000000002e-07 157.04999999999998p 2.774018e-07
+ 157.0625p 2.7326120000000001e-07 157.07499999999999p 2.6882110000000001e-07 157.08750000000001p 2.640891e-07 157.09999999999999p 2.5907310000000003e-07 157.11250000000001p 2.537812e-07 157.125p 2.4822189999999999e-07 157.13749999999999p 2.4240380000000002e-07 157.15000000000001p 2.3633589999999999e-07 157.16249999999999p 2.300273e-07 157.17500000000001p 2.234873e-07 157.1875p 2.1672549999999999e-07 157.20000000000002p 2.0975159999999999e-07 157.21249999999998p 2.0257539999999999e-07 157.22499999999999p 1.9520700000000001e-07 157.23749999999998p 1.876566e-07 157.25p 1.799344e-07 157.26250000000002p 1.7205089999999999e-07 157.27500000000001p 1.6401660000000001e-07
+ 157.28750000000002p 1.55842e-07 157.29999999999998p 1.4753789999999999e-07 157.3125p 1.3911489999999999e-07 157.32499999999999p 1.3058379999999999e-07 157.33750000000001p 1.219555e-07 157.34999999999999p 1.132408e-07 157.36250000000001p 1.044505e-07 157.375p 9.5595470000000001e-08 157.38749999999999p 8.6686530000000003e-08 157.40000000000001p 7.7734509999999997e-08 157.41249999999999p 6.8750190000000005e-08 157.42500000000001p 5.9744309999999995e-08 157.4375p 5.0727549999999998e-08 157.45000000000002p 4.1710540000000001e-08 157.46249999999998p 3.2703820000000002e-08 157.47499999999999p 2.3717879999999999e-08 157.48749999999998p 1.476309e-08 157.5p 5.8497289999999999e-09
+ 157.51249999999999p -3.0120160000000001e-09 157.52500000000001p -1.1812090000000001e-08 157.53750000000002p -2.0540550000000001e-08 157.54999999999998p -2.9187590000000001e-08 157.5625p -3.7743540000000003e-08 157.57499999999999p -4.6198870000000001e-08 157.58750000000001p -5.4544210000000003e-08 157.59999999999999p -6.2770340000000001e-08 157.61250000000001p -7.0868210000000004e-08 157.625p -7.8828940000000005e-08 157.63749999999999p -8.6643829999999997e-08 157.65000000000001p -9.4304349999999994e-08 157.66249999999999p -1.018022e-07 157.67500000000001p -1.0912919999999999e-07 157.6875p -1.162774e-07 157.70000000000002p -1.2323919999999999e-07 157.71250000000001p -1.3000689999999999e-07 157.72499999999999p -1.3657340000000001e-07
+ 157.73749999999998p -1.4293139999999999e-07 157.75p -1.490743e-07 157.76249999999999p -1.549953e-07 157.77500000000001p -1.606882e-07 157.78750000000002p -1.6614670000000001e-07 157.79999999999998p -1.71365e-07 157.8125p -1.7633750000000001e-07 157.82499999999999p -1.810588e-07 157.83750000000001p -1.855238e-07 157.84999999999999p -1.8972780000000001e-07 157.86250000000001p -1.936661e-07 157.875p -1.973345e-07 157.88749999999999p -2.00729e-07 157.90000000000001p -2.0384600000000001e-07 157.91249999999999p -2.06682e-07 157.92500000000001p -2.0923400000000001e-07 157.9375p -2.1149930000000001e-07 157.95000000000002p -2.134753e-07
+ 157.96250000000001p -2.1515990000000001e-07 157.97499999999999p -2.1655129999999999e-07 157.98749999999998p -2.1764810000000001e-07 158p -2.18449e-07 158.01249999999999p -2.1895329999999999e-07 158.02500000000001p -2.1916040000000001e-07 158.03750000000002p -2.1907040000000001e-07 158.05000000000001p -2.186833e-07 158.0625p -2.1799969999999999e-07 158.07499999999999p -2.1702069999999999e-07 158.08750000000001p -2.157474e-07 158.09999999999999p -2.1418160000000001e-07 158.11250000000001p -2.123252e-07 158.125p -2.1018080000000001e-07 158.13749999999999p -2.077509e-07 158.15000000000001p -2.050388e-07 158.16249999999999p -2.0204789999999999e-07 158.17500000000001p -1.987822e-07
+ 158.1875p -1.9524579999999999e-07 158.20000000000002p -1.914434e-07 158.21250000000001p -1.8738e-07 158.22499999999999p -1.8306079999999999e-07 158.23749999999998p -1.784917e-07 158.25p -1.7367860000000001e-07 158.26249999999999p -1.6862810000000001e-07 158.27500000000001p -1.633468e-07 158.28749999999999p -1.578419e-07 158.30000000000001p -1.521209e-07 158.3125p -1.461915e-07 158.32499999999999p -1.4006190000000001e-07 158.33750000000001p -1.3374060000000001e-07 158.34999999999999p -1.272362e-07 158.36250000000001p -1.205578e-07 158.375p -1.137148e-07 158.38750000000002p -1.067168e-07 158.39999999999998p -9.9573669999999996e-08
+ 158.41249999999999p -9.2295539999999994e-08 158.42500000000001p -8.4892799999999994e-08 158.4375p -7.7376070000000007e-08 158.45000000000002p -6.9756170000000001e-08 158.46250000000001p -6.2044130000000005e-08 158.47499999999999p -5.4251139999999999e-08 158.48749999999998p -4.6388599999999998e-08 158.5p -3.846803e-08 158.51249999999999p -3.0501080000000002e-08 158.52500000000001p -2.2499549999999998e-08 158.53749999999999p -1.447529e-08 158.55000000000001p -6.4402650000000002e-09 158.5625p 1.5935030000000001e-09 158.57499999999999p 9.6139589999999994e-09 158.58750000000001p 1.7609019999999999e-08 158.59999999999999p 2.5566610000000001e-08 158.61250000000001p 3.3474650000000001e-08 158.625p 4.1321120000000002e-08
+ 158.63750000000002p 4.9094040000000002e-08 158.64999999999998p 5.6781519999999998e-08 158.66249999999999p 6.4371760000000005e-08 158.67500000000001p 7.1853080000000001e-08 158.6875p 7.9213940000000004e-08 158.70000000000002p 8.6442950000000006e-08 158.71250000000001p 9.3528899999999998e-08 158.72500000000002p 1.004608e-07 158.73749999999998p 1.072278e-07 158.75p 1.138194e-07 158.76249999999999p 1.2022530000000001e-07 158.77500000000001p 1.2643549999999999e-07 158.78749999999999p 1.3244010000000001e-07 158.80000000000001p 1.382299e-07 158.8125p 1.4379550000000001e-07 158.82499999999999p 1.4912840000000001e-07 158.83750000000001p 1.5422010000000001e-07 158.84999999999999p 1.5906239999999999e-07
+ 158.86250000000001p 1.6364789999999999e-07 158.875p 1.679692e-07 158.88750000000002p 1.720194e-07 158.89999999999998p 1.757922e-07 158.91249999999999p 1.7928149999999999e-07 158.92499999999998p 1.8248179999999999e-07 158.9375p 1.8538810000000001e-07 158.95000000000002p 1.8799559999999999e-07 158.96250000000001p 1.9030030000000001e-07 158.97500000000002p 1.9229850000000001e-07 158.98749999999998p 1.9398690000000001e-07 159p 1.95363e-07 159.01249999999999p 1.9642440000000001e-07 159.02500000000001p 1.971695e-07 159.03749999999999p 1.9759710000000001e-07 159.05000000000001p 1.977065e-07 159.0625p 1.974975e-07 159.07499999999999p 1.9697050000000001e-07
+ 159.08750000000001p 1.961262e-07 159.09999999999999p 1.9496590000000001e-07 159.11250000000001p 1.934916e-07 159.125p 1.917055e-07 159.13750000000002p 1.8961040000000001e-07 159.14999999999998p 1.8720969999999999e-07 159.16249999999999p 1.8450709999999999e-07 159.17499999999998p 1.8150689999999999e-07 159.1875p 1.782138e-07 159.20000000000002p 1.74633e-07 159.21250000000001p 1.707702e-07 159.22500000000002p 1.666314e-07 159.23749999999998p 1.622231e-07 159.25p 1.5755230000000001e-07 159.26249999999999p 1.5262630000000001e-07 159.27500000000001p 1.474529e-07 159.28749999999999p 1.4204010000000001e-07 159.30000000000001p 1.3639650000000001e-07
+ 159.3125p 1.305309e-07 159.32499999999999p 1.2445259999999999e-07 159.33750000000001p 1.181709e-07 159.34999999999999p 1.116958e-07 159.36250000000001p 1.050374e-07 159.375p 9.8206140000000004e-08 159.38750000000002p 9.1212590000000006e-08 159.39999999999998p 8.4067710000000002e-08 159.41249999999999p 7.6782649999999994e-08 159.42499999999998p 6.9368759999999994e-08 159.4375p 6.1837589999999996e-08 159.44999999999999p 5.4200850000000002e-08 159.46250000000001p 4.6470430000000003e-08 159.47500000000002p 3.8658339999999997e-08 159.48749999999998p 3.0776709999999998e-08 159.5p 2.2837779999999998e-08 159.51249999999999p 1.485386e-08 159.52500000000001p 6.8373270000000003e-09
+ 159.53749999999999p -1.199404e-09 159.55000000000001p -9.2438920000000002e-09 159.5625p -1.7283690000000002e-08 159.57499999999999p -2.530638e-08 159.58750000000001p -3.3299559999999999e-08 159.59999999999999p -4.1250890000000001e-08 159.61250000000001p -4.9148120000000003e-08 159.625p -5.6979060000000003e-08 159.63750000000002p -6.4731650000000001e-08 159.65000000000001p -7.2393970000000003e-08 159.66249999999999p -7.9954230000000003e-08 159.67499999999998p -8.7400810000000002e-08 159.6875p -9.4722289999999999e-08 159.69999999999999p -1.019074e-07 159.71250000000001p -1.089452e-07 159.72500000000002p -1.158248e-07 159.73749999999998p -1.225358e-07 159.75p -1.2906790000000001e-07
+ 159.76249999999999p -1.3541110000000001e-07 159.77500000000001p -1.4155579999999999e-07 159.78749999999999p -1.474925e-07 159.80000000000001p -1.532124e-07 159.8125p -1.587066e-07 159.82499999999999p -1.6396679999999999e-07 159.83750000000001p -1.6898520000000001e-07 159.84999999999999p -1.7375400000000001e-07 159.86250000000001p -1.782662e-07 159.875p -1.825149e-07 159.88750000000002p -1.8649379999999999e-07 159.90000000000001p -1.901969e-07 159.91249999999999p -1.9361870000000001e-07 159.92499999999998p -1.967542e-07 159.9375p -1.995985e-07 159.94999999999999p -2.0214769999999999e-07 159.96250000000001p -2.04398e-07 159.97499999999999p -2.0634599999999999e-07
+ 159.98750000000001p -2.0798909999999999e-07 160p -2.0932479999999999e-07 160.01249999999999p -2.103514e-07 160.02500000000001p -2.1106739999999999e-07 160.03749999999999p -2.11472e-07 160.05000000000001p -2.1156479999999999e-07 160.0625p -2.1134569999999999e-07 160.07499999999999p -2.108153e-07 160.08749999999998p -2.099746e-07 160.09999999999999p -2.0882510000000001e-07 160.11250000000001p -2.0736870000000001e-07 160.125p -2.0560790000000001e-07 160.13750000000002p -2.0354529999999999e-07 160.15000000000001p -2.011845e-07 160.16249999999999p -1.9852899999999999e-07 160.17499999999998p -1.955831e-07 160.1875p -1.9235139999999999e-07 160.19999999999999p -1.888388e-07
+ 160.21250000000001p -1.8505089999999999e-07 160.22499999999999p -1.8099340000000001e-07 160.23750000000001p -1.7667259999999999e-07 160.25p -1.7209500000000001e-07 160.26249999999999p -1.6726770000000001e-07 160.27500000000001p -1.621978e-07 160.28749999999999p -1.5689309999999999e-07 160.30000000000001p -1.5136149999999999e-07 160.3125p -1.456112e-07 160.32500000000002p -1.3965100000000001e-07 160.33749999999998p -1.334895e-07 160.34999999999999p -1.2713600000000001e-07 160.36250000000001p -1.205997e-07 160.375p -1.138904e-07 160.38750000000002p -1.070177e-07 160.40000000000001p -9.9991809999999999e-08 160.41249999999999p -9.2822830000000002e-08 160.42499999999998p -8.5521150000000003e-08
+ 160.4375p -7.8097300000000004e-08 160.44999999999999p -7.0561940000000001e-08 160.46250000000001p -6.2925840000000006e-08 160.47499999999999p -5.5199879999999999e-08 160.48750000000001p -4.7395020000000002e-08 160.5p -3.9522279999999998e-08 160.51249999999999p -3.159274e-08 160.52500000000001p -2.3617509999999999e-08 160.53749999999999p -1.560771e-08 160.55000000000001p -7.5744560000000003e-09 160.5625p 4.7114029999999998e-10 160.57500000000002p 8.5180090000000001e-09 160.58749999999998p 1.655513e-08 160.59999999999999p 2.4571539999999999e-08 160.61250000000001p 3.2556359999999999e-08 160.625p 4.049882e-08 160.63750000000002p 4.8388229999999997e-08 160.65000000000001p 5.6214060000000002e-08
+ 160.66250000000002p 6.3965880000000007e-08 160.67499999999998p 7.1633449999999995e-08 160.6875p 7.9206669999999997e-08 160.69999999999999p 8.6675619999999999e-08 160.71250000000001p 9.4030580000000002e-08 160.72499999999999p 1.01262e-07 160.73750000000001p 1.083607e-07 160.75p 1.1531739999999999e-07 160.76249999999999p 1.2212329999999999e-07 160.77500000000001p 1.2876989999999999e-07 160.78749999999999p 1.3524880000000001e-07 160.80000000000001p 1.415519e-07 160.8125p 1.476713e-07 160.82500000000002p 1.535996e-07 160.83749999999998p 1.5932959999999999e-07 160.84999999999999p 1.6485409999999999e-07 160.86249999999998p 1.7016669999999999e-07 160.875p 1.752609e-07
+ 160.88750000000002p 1.8013070000000001e-07 160.90000000000001p 1.847704e-07 160.91250000000002p 1.891747e-07 160.92499999999998p 1.933384e-07 160.9375p 1.9725679999999999e-07 160.94999999999999p 2.0092549999999999e-07 160.96250000000001p 2.043405e-07 160.97499999999999p 2.07498e-07 160.98750000000001p 2.103946e-07 161p 2.130273e-07 161.01249999999999p 2.153934e-07 161.02500000000001p 2.174906e-07 161.03749999999999p 2.193167e-07 161.05000000000001p 2.208702e-07 161.0625p 2.2214970000000001e-07 161.07500000000002p 2.2315410000000001e-07 161.08749999999998p 2.2388299999999999e-07 161.09999999999999p 2.2433579999999999e-07
+ 161.11249999999998p 2.2451269999999999e-07 161.125p 2.2441410000000001e-07 161.13750000000002p 2.240405e-07 161.15000000000001p 2.233929e-07 161.16250000000002p 2.2247289999999999e-07 161.17499999999998p 2.2128189999999999e-07 161.1875p 2.198219e-07 161.19999999999999p 2.180953e-07 161.21250000000001p 2.161045e-07 161.22499999999999p 2.1385260000000001e-07 161.23750000000001p 2.1134259999999999e-07 161.25p 2.08578e-07 161.26249999999999p 2.055627e-07 161.27500000000001p 2.0230060000000001e-07 161.28749999999999p 1.9879609999999999e-07 161.30000000000001p 1.9505369999999999e-07 161.3125p 1.910782e-07 161.32500000000002p 1.8687489999999999e-07
+ 161.33750000000001p 1.824489e-07 161.34999999999999p 1.77806e-07 161.36249999999998p 1.7295179999999999e-07 161.375p 1.6789249999999999e-07 161.38749999999999p 1.626343e-07 161.40000000000001p 1.5718370000000001e-07 161.41250000000002p 1.515474e-07 161.42499999999998p 1.4573209999999999e-07 161.4375p 1.397451e-07 161.44999999999999p 1.3359339999999999e-07 161.46250000000001p 1.272846e-07 161.47499999999999p 1.2082609999999999e-07 161.48750000000001p 1.142257e-07 161.5p 1.074913e-07 161.51249999999999p 1.006308e-07 161.52500000000001p 9.3652330000000003e-08 161.53749999999999p 8.6564200000000004e-08 161.55000000000001p 7.9374719999999998e-08
+ 161.5625p 7.2092330000000001e-08 161.57500000000002p 6.4725559999999999e-08 161.58750000000001p 5.7283039999999997e-08 161.59999999999999p 4.977344e-08 161.61249999999998p 4.22055e-08 161.625p 3.4588039999999998e-08 161.63749999999999p 2.6929879999999998e-08 161.65000000000001p 1.92399e-08 161.66250000000002p 1.152699e-08 161.67499999999998p 3.8000570000000001e-09 161.6875p -3.9319870000000001e-09 161.69999999999999p -1.166024e-08 161.71250000000001p -1.937581e-08 161.72499999999999p -2.7069829999999999e-08 161.73750000000001p -3.4733490000000001e-08 161.75p -4.2357989999999998e-08 161.76249999999999p -4.9934620000000001e-08 161.77500000000001p -5.7454699999999998e-08
+ 161.78749999999999p -6.4909639999999995e-08 161.80000000000001p -7.2290949999999999e-08 161.8125p -7.9590199999999998e-08 161.82500000000002p -8.6799079999999994e-08 161.83750000000001p -9.3909389999999996e-08 161.84999999999999p -1.009131e-07 161.86249999999998p -1.0780209999999999e-07 161.875p -1.145687e-07 161.88749999999999p -1.2120530000000001e-07 161.90000000000001p -1.277042e-07 161.91249999999999p -1.3405820000000001e-07 161.92500000000001p -1.4026000000000001e-07 161.9375p -1.4630270000000001e-07 161.94999999999999p -1.5217949999999999e-07 161.96250000000001p -1.5788370000000001e-07 161.97499999999999p -1.6340890000000001e-07 161.98750000000001p -1.6874890000000001e-07 162p -1.738978e-07
+ 162.01249999999999p -1.7884969999999999e-07 162.02499999999998p -1.8359909999999999e-07 162.03749999999999p -1.8814080000000001e-07 162.05000000000001p -1.9246960000000001e-07 162.0625p -1.9658079999999999e-07 162.07500000000002p -2.004699e-07 162.08750000000001p -2.0413240000000001e-07 162.09999999999999p -2.0756450000000001e-07 162.11249999999998p -2.1076229999999999e-07 162.125p -2.1372240000000001e-07 162.13749999999999p -2.1644139999999999e-07 162.15000000000001p -2.189167e-07 162.16249999999999p -2.2114529999999999e-07 162.17500000000001p -2.231251e-07 162.1875p -2.2485400000000001e-07 162.19999999999999p -2.2633010000000001e-07 162.21250000000001p -2.27552e-07 162.22499999999999p -2.285185e-07
+ 162.23750000000001p -2.2922869999999999e-07 162.25p -2.29682e-07 162.26250000000002p -2.298782e-07 162.27499999999998p -2.2981720000000001e-07 162.28749999999999p -2.2949930000000001e-07 162.30000000000001p -2.289252e-07 162.3125p -2.280958e-07 162.32500000000002p -2.2701209999999999e-07 162.33750000000001p -2.256758e-07 162.34999999999999p -2.2408859999999999e-07 162.36249999999998p -2.222526e-07 162.375p -2.201702e-07 162.38749999999999p -2.1784390000000001e-07 162.40000000000001p -2.1527679999999999e-07 162.41249999999999p -2.1247190000000001e-07 162.42500000000001p -2.094329e-07 162.4375p -2.0616340000000001e-07 162.44999999999999p -2.0266739999999999e-07
+ 162.46250000000001p -1.989492e-07 162.47499999999999p -1.950134e-07 162.48750000000001p -1.9086470000000001e-07 162.5p -1.8650810000000001e-07 162.51250000000002p -1.819488e-07 162.52499999999998p -1.7719240000000001e-07 162.53749999999999p -1.722445e-07 162.54999999999998p -1.6711110000000001e-07 162.5625p -1.6179830000000001e-07 162.57500000000002p -1.5631230000000001e-07 162.58750000000001p -1.5065979999999999e-07 162.60000000000002p -1.448473e-07 162.61249999999998p -1.3888189999999999e-07 162.625p -1.327706e-07 162.63749999999999p -1.2652039999999999e-07 162.65000000000001p -1.201389e-07 162.66249999999999p -1.136335e-07 162.67500000000001p -1.070119e-07
+ 162.6875p -1.002818e-07 162.69999999999999p -9.3450999999999994e-08 162.71250000000001p -8.6527599999999997e-08 162.72499999999999p -7.9519619999999998e-08 162.73750000000001p -7.243523e-08 162.75p -6.5282669999999997e-08 162.76250000000002p -5.8070229999999997e-08 162.77499999999998p -5.0806269999999999e-08 162.78749999999999p -4.3499189999999999e-08 162.79999999999998p -3.6157450000000002e-08 162.8125p -2.8789490000000001e-08 162.82500000000002p -2.140382e-08 162.83750000000001p -1.4008909999999999e-08 162.85000000000002p -6.6132629999999997e-09 162.86249999999998p 7.7465590000000003e-10 162.875p 8.1463930000000002e-09 162.88749999999999p 1.5493529999999999e-08 162.90000000000001p 2.2807689999999999e-08
+ 162.91249999999999p 3.0080549999999999e-08 162.92500000000001p 3.7303840000000003e-08 162.9375p 4.4469380000000001e-08 162.94999999999999p 5.1569060000000003e-08 162.96250000000001p 5.8594850000000001e-08 162.97499999999999p 6.5538840000000004e-08 162.98750000000001p 7.2393209999999999e-08 163p 7.9150259999999994e-08 163.01250000000002p 8.5802430000000001e-08 163.02499999999998p 9.2342269999999994e-08 163.03749999999999p 9.8762489999999999e-08 163.04999999999998p 1.05056e-07 163.0625p 1.1121570000000001e-07 163.07500000000002p 1.1723480000000001e-07 163.08750000000001p 1.2310669999999999e-07 163.10000000000002p 1.2882499999999999e-07 163.11249999999998p 1.343833e-07 163.125p 1.3977550000000001e-07
+ 163.13749999999999p 1.4499589999999999e-07 163.15000000000001p 1.5003859999999999e-07 163.16249999999999p 1.5489829999999999e-07 163.17500000000001p 1.5956969999999999e-07 163.1875p 1.640479e-07 163.19999999999999p 1.683279e-07 163.21250000000001p 1.7240540000000001e-07 163.22499999999999p 1.7627589999999999e-07 163.23750000000001p 1.7993549999999999e-07 163.25p 1.833802e-07 163.26250000000002p 1.866067e-07 163.27500000000001p 1.896115e-07 163.28749999999999p 1.9239169999999999e-07 163.29999999999998p 1.9494449999999999e-07 163.3125p 1.9726740000000001e-07 163.32499999999999p 1.993581e-07 163.33750000000001p 2.0121469999999999e-07 163.35000000000002p 2.0283560000000001e-07
+ 163.36249999999998p 2.0421929999999999e-07 163.375p 2.0536470000000001e-07 163.38749999999999p 2.0627089999999999e-07 163.40000000000001p 2.0693750000000001e-07 163.41249999999999p 2.07364e-07 163.42500000000001p 2.0755049999999999e-07 163.4375p 2.0749739999999999e-07 163.44999999999999p 2.0720500000000001e-07 163.46250000000001p 2.0667429999999999e-07 163.47499999999999p 2.0590640000000001e-07 163.48750000000001p 2.0490269999999999e-07 163.5p 2.0366480000000001e-07 163.51250000000002p 2.0219469999999999e-07 163.52500000000001p 2.004946e-07 163.53749999999999p 1.9856700000000001e-07 163.54999999999998p 1.9641460000000001e-07 163.5625p 1.940405e-07 163.57499999999999p 1.914478e-07
+ 163.58750000000001p 1.886403e-07 163.60000000000002p 1.8562150000000001e-07 163.61250000000001p 1.8239570000000001e-07 163.625p 1.789669e-07 163.63749999999999p 1.7533989999999999e-07 163.65000000000001p 1.715192e-07 163.66249999999999p 1.675099e-07 163.67500000000001p 1.6331719999999999e-07 163.6875p 1.5894639999999999e-07 163.69999999999999p 1.5440330000000001e-07 163.71250000000001p 1.4969369999999999e-07 163.72499999999999p 1.4482350000000001e-07 163.73750000000001p 1.3979910000000001e-07 163.75p 1.3462679999999999e-07 163.76250000000002p 1.2931310000000001e-07 163.77500000000001p 1.2386490000000001e-07 163.78749999999999p 1.182891e-07 163.79999999999998p 1.125927e-07
+ 163.8125p 1.06783e-07 163.82499999999999p 1.008672e-07 163.83750000000001p 9.4852919999999997e-08 163.84999999999999p 8.8747670000000002e-08 163.86250000000001p 8.255917e-08 163.875p 7.6295229999999996e-08 163.88749999999999p 6.996374e-08 163.90000000000001p 6.3572670000000004e-08 163.91249999999999p 5.7130060000000002e-08 163.92500000000001p 5.0644030000000003e-08 163.9375p 4.4122729999999997e-08 163.95000000000002p 3.7574359999999998e-08 163.96249999999998p 3.1007139999999999e-08 163.97499999999999p 2.4429329999999999e-08 163.98750000000001p 1.7849190000000001e-08 164p 1.127497e-08 164.01250000000002p 4.7149259999999999e-09 164.02500000000001p -1.8227200000000001e-09
+ 164.03749999999999p -8.3297719999999993e-09 164.04999999999998p -1.479808e-08 164.0625p -2.1219559999999999e-08 164.07499999999999p -2.7586160000000001e-08 164.08750000000001p -3.3889940000000002e-08 164.09999999999999p -4.0123020000000001e-08 164.11250000000001p -4.6277639999999997e-08 164.125p -5.2346129999999999e-08 164.13749999999999p -5.8320939999999997e-08 164.15000000000001p -6.4194640000000004e-08 164.16249999999999p -6.9959969999999996e-08 164.17500000000001p -7.5609790000000006e-08 164.1875p -8.1137120000000006e-08 164.20000000000002p -8.6535150000000002e-08 164.21249999999998p -9.1797269999999998e-08 164.22499999999999p -9.691702e-08 164.23750000000001p -1.018882e-07 164.25p -1.067047e-07
+ 164.26250000000002p -1.113607e-07 164.27500000000001p -1.1585070000000001e-07 164.28749999999999p -1.2016920000000001e-07 164.29999999999998p -1.2431119999999999e-07 164.3125p -1.282717e-07 164.32499999999999p -1.3204610000000001e-07 164.33750000000001p -1.356301e-07 164.34999999999999p -1.390195e-07 164.36250000000001p -1.4221049999999999e-07 164.375p -1.4519960000000001e-07 164.38749999999999p -1.479835e-07 164.40000000000001p -1.5055910000000001e-07 164.41249999999999p -1.52924e-07 164.42500000000001p -1.5507549999999999e-07 164.4375p -1.570117e-07 164.45000000000002p -1.5873080000000001e-07 164.46249999999998p -1.602313e-07 164.47499999999999p -1.6151209999999999e-07
+ 164.48749999999998p -1.6257230000000001e-07 164.5p -1.6341130000000001e-07 164.51250000000002p -1.6402899999999999e-07 164.52500000000001p -1.6442550000000001e-07 164.53750000000002p -1.6460100000000001e-07 164.54999999999998p -1.645565e-07 164.5625p -1.6429279999999999e-07 164.57499999999999p -1.6381140000000001e-07 164.58750000000001p -1.6311399999999999e-07 164.59999999999999p -1.6220229999999999e-07 164.61250000000001p -1.610788e-07 164.625p -1.5974600000000001e-07 164.63749999999999p -1.5820670000000001e-07 164.65000000000001p -1.5646410000000001e-07 164.66249999999999p -1.5452159999999999e-07 164.67500000000001p -1.523829e-07 164.6875p -1.50052e-07 164.70000000000002p -1.4753320000000001e-07
+ 164.71249999999998p -1.4483100000000001e-07 164.72499999999999p -1.4195009999999999e-07 164.73749999999998p -1.3889549999999999e-07 164.75p -1.356726e-07 164.76250000000002p -1.322867e-07 164.77500000000001p -1.2874349999999999e-07 164.78750000000002p -1.25049e-07 164.79999999999998p -1.2120930000000001e-07 164.8125p -1.172306e-07 164.82499999999999p -1.131195e-07 164.83750000000001p -1.088825e-07 164.84999999999999p -1.045266e-07 164.86250000000001p -1.000585e-07 164.875p -9.5485450000000002e-08 164.88749999999999p -9.0814640000000001e-08 164.90000000000001p -8.6053379999999998e-08 164.91249999999999p -8.1209100000000002e-08 164.92500000000001p -7.6289319999999999e-08
+ 164.9375p -7.1301640000000003e-08 164.95000000000002p -6.6253719999999996e-08 164.96249999999998p -6.1153280000000002e-08 164.97499999999999p -5.600806e-08 164.98749999999998p -5.082587e-08 165p -4.5614489999999998e-08 165.01249999999999p -4.038174e-08 165.02500000000001p -3.5135430000000001e-08 165.03750000000002p -2.988332e-08 165.04999999999998p -2.4633170000000001e-08 165.0625p -1.9392690000000001e-08 165.07499999999999p -1.416952e-08 165.08750000000001p -8.9712539999999996e-09 165.09999999999999p -3.8053900000000002e-09 165.11250000000001p 1.320654e-09 165.125p 6.3995649999999997e-09 165.13749999999999p 1.142414e-08 165.15000000000001p 1.6387299999999999e-08
+ 165.16249999999999p 2.128209e-08 165.17500000000001p 2.6101720000000001e-08 165.1875p 3.0839529999999999e-08 165.20000000000002p 3.5489040000000001e-08 165.21250000000001p 4.0043910000000002e-08 165.22499999999999p 4.4498030000000002e-08 165.23749999999998p 4.8845430000000003e-08 165.25p 5.3080379999999998e-08 165.26249999999999p 5.7197320000000002e-08 165.27500000000001p 6.1190919999999996e-08 165.28750000000002p 6.5056060000000003e-08 165.29999999999998p 6.8787869999999999e-08 165.3125p 7.2381690000000006e-08 165.32499999999999p 7.5833099999999994e-08 165.33750000000001p 7.9137930000000001e-08 165.34999999999999p 8.2292259999999997e-08 165.36250000000001p 8.5292419999999995e-08 165.375p 8.8135000000000001e-08
+ 165.38749999999999p 9.0816849999999997e-08 165.40000000000001p 9.3335090000000004e-08 165.41249999999999p 9.568712e-08 165.42500000000001p 9.7870570000000005e-08 165.4375p 9.9883379999999997e-08 165.45000000000002p 1.0172379999999999e-07 165.46250000000001p 1.033902e-07 165.47499999999999p 1.0488140000000001e-07 165.48749999999998p 1.0619649999999999e-07 165.5p 1.073347e-07 165.51249999999999p 1.082956e-07 165.52500000000001p 1.090791e-07 165.53750000000002p 1.096854e-07 165.55000000000001p 1.1011480000000001e-07 165.5625p 1.1036789999999999e-07 165.57499999999999p 1.104459e-07 165.58750000000001p 1.103497e-07 165.59999999999999p 1.10081e-07
+ 165.61250000000001p 1.096415e-07 165.625p 1.090331e-07 165.63749999999999p 1.08258e-07 165.65000000000001p 1.0731870000000001e-07 165.66249999999999p 1.0621800000000001e-07 165.67500000000001p 1.049587e-07 165.6875p 1.03544e-07 165.70000000000002p 1.019773e-07 165.71250000000001p 1.002623e-07 165.72499999999999p 9.8402619999999996e-08 165.73749999999998p 9.6402369999999997e-08 165.75p 9.4265719999999995e-08 165.76249999999999p 9.1997060000000006e-08 165.77500000000001p 8.9600929999999994e-08 165.78749999999999p 8.7082049999999995e-08 165.80000000000001p 8.4445309999999999e-08 165.8125p 8.1695730000000006e-08 165.82499999999999p 7.8838489999999998e-08
+ 165.83750000000001p 7.5878899999999995e-08 165.84999999999999p 7.2822369999999994e-08 165.86250000000001p 6.9674470000000003e-08 165.875p 6.6440820000000001e-08 165.88750000000002p 6.3127170000000001e-08 165.89999999999998p 5.9739350000000002e-08 165.91249999999999p 5.6283250000000002e-08 165.92500000000001p 5.2764850000000001e-08 165.9375p 4.919017e-08 165.95000000000002p 4.5565269999999998e-08 165.96250000000001p 4.1896259999999997e-08 165.97499999999999p 3.8189249999999999e-08 165.98749999999998p 3.4450409999999999e-08 166p 3.0685869999999999e-08 166.01249999999999p 2.6901770000000001e-08 166.02500000000001p 2.310426e-08 166.03749999999999p 1.9299430000000001e-08 166.05000000000001p 1.5493350000000001e-08
+ 166.0625p 1.1692060000000001e-08 166.07499999999999p 7.9015330000000002e-09 166.08750000000001p 4.1276790000000001e-09 166.09999999999999p 3.7634650000000002e-10 166.11250000000001p -3.3467009999999999e-09 166.125p -7.035787e-09 166.13750000000002p -1.068533e-08 166.14999999999998p -1.4289859999999999e-08 166.16249999999999p -1.7844000000000001e-08 166.17500000000001p -2.134252e-08 166.1875p -2.4780300000000001e-08 166.20000000000002p -2.8152359999999999e-08 166.21250000000001p -3.145386e-08 166.22500000000002p -3.4680109999999999e-08 166.23749999999998p -3.782657e-08 166.25p -4.0888870000000001e-08 166.26249999999999p -4.3862780000000003e-08 166.27500000000001p -4.6744280000000001e-08
+ 166.28749999999999p -4.952948e-08 166.30000000000001p -5.2214719999999998e-08 166.3125p -5.4796470000000001e-08 166.32499999999999p -5.7271430000000002e-08 166.33750000000001p -5.963648e-08 166.34999999999999p -6.188867e-08 166.36250000000001p -6.4025280000000002e-08 166.375p -6.6043759999999995e-08 166.38750000000002p -6.7941790000000006e-08 166.39999999999998p -6.9717220000000005e-08 166.41249999999999p -7.1368120000000006e-08 166.42499999999998p -7.2892770000000002e-08 166.4375p -7.4289640000000003e-08 166.45000000000002p -7.5557400000000001e-08 166.46250000000001p -7.6694950000000003e-08 166.47500000000002p -7.7701369999999994e-08 166.48749999999998p -7.8575939999999996e-08 166.5p -7.9318149999999997e-08
+ 166.51249999999999p -7.992769e-08 166.52500000000001p -8.0404450000000001e-08 166.53749999999999p -8.0748489999999994e-08 166.55000000000001p -8.0960099999999997e-08 166.5625p -8.1039720000000006e-08 166.57499999999999p -8.0988009999999994e-08 166.58750000000001p -8.0805800000000005e-08 166.59999999999999p -8.0494080000000005e-08 166.61250000000001p -8.0054060000000003e-08 166.625p -7.9487070000000005e-08 166.63750000000002p -7.8794640000000003e-08 166.64999999999998p -7.797846e-08 166.66249999999999p -7.7040369999999999e-08 166.67499999999998p -7.5982370000000004e-08 166.6875p -7.4806599999999994e-08 166.70000000000002p -7.3515350000000006e-08 166.71250000000001p -7.2111059999999996e-08 166.72500000000002p -7.0596280000000002e-08
+ 166.73749999999998p -6.8973700000000003e-08 166.75p -6.7246149999999994e-08 166.76249999999999p -6.5416539999999995e-08 166.77500000000001p -6.3487930000000003e-08 166.78749999999999p -6.1463469999999997e-08 166.80000000000001p -5.9346409999999999e-08 166.8125p -5.71401e-08 166.82499999999999p -5.484797e-08 166.83750000000001p -5.2473560000000003e-08 166.84999999999999p -5.0020469999999998e-08 166.86250000000001p -4.7492369999999998e-08 166.875p -4.4893019999999997e-08 166.88750000000002p -4.2226209999999998e-08 166.89999999999998p -3.949584e-08 166.91249999999999p -3.67058e-08 166.92499999999998p -3.3860090000000002e-08 166.9375p -3.0962700000000001e-08 166.94999999999999p -2.801769e-08
+ 166.96250000000001p -2.502915e-08 166.97500000000002p -2.2001180000000001e-08 166.98749999999998p -1.8937930000000001e-08 167p -1.5843539999999998e-08 167.01249999999999p -1.2722190000000001e-08 167.02500000000001p -9.5780569999999998e-09 167.03749999999999p -6.4153209999999996e-09 167.05000000000001p -3.2381689999999999e-09 167.0625p -5.0783400000000003e-11 167.07499999999999p 3.14266e-09 167.08750000000001p 6.3379970000000001e-09 167.09999999999999p 9.5310779999999995e-09 167.11250000000001p 1.271777e-08 167.125p 1.589398e-08 167.13750000000002p 1.90556e-08 167.15000000000001p 2.2198600000000001e-08 167.16249999999999p 2.531896e-08 167.17499999999998p 2.8412680000000002e-08
+ 167.1875p 3.1475839999999999e-08 167.19999999999999p 3.4504540000000003e-08 167.21250000000001p 3.7494909999999997e-08 167.22500000000002p 4.0443170000000001e-08 167.23749999999998p 4.3345560000000002e-08 167.25p 4.619839e-08 167.26249999999999p 4.8998030000000003e-08 167.27500000000001p 5.1740900000000001e-08 167.28749999999999p 5.4423510000000001e-08 167.30000000000001p 5.7042410000000001e-08 167.3125p 5.9594240000000001e-08 167.32499999999999p 6.2075700000000003e-08 167.33750000000001p 6.4483590000000005e-08 167.34999999999999p 6.6814759999999996e-08 167.36250000000001p 6.9066160000000003e-08 167.375p 7.1234819999999998e-08 167.38750000000002p 7.331787e-08 167.40000000000001p 7.5312499999999994e-08
+ 167.41249999999999p 7.7216029999999998e-08 167.42499999999998p 7.9025860000000004e-08 167.4375p 8.073948e-08 167.44999999999999p 8.2354480000000005e-08 167.46250000000001p 8.3868590000000003e-08 167.47499999999999p 8.5279599999999998e-08 167.48750000000001p 8.6585430000000002e-08 167.5p 8.7784110000000002e-08 167.51249999999999p 8.8873789999999998e-08 167.52500000000001p 8.9852719999999994e-08 167.53749999999999p 9.071929e-08 167.55000000000001p 9.1472e-08 167.5625p 9.2109459999999996e-08 167.57499999999999p 9.2630430000000001e-08 167.58749999999998p 9.3033790000000004e-08 167.59999999999999p 9.3318530000000006e-08 167.61250000000001p 9.3483799999999994e-08 167.625p 9.3528859999999998e-08
+ 167.63750000000002p 9.3453130000000005e-08 167.65000000000001p 9.3256140000000003e-08 167.66249999999999p 9.2937580000000007e-08 167.67499999999998p 9.2497269999999998e-08 167.6875p 9.1935159999999994e-08 167.69999999999999p 9.1251370000000006e-08 167.71250000000001p 9.0446150000000003e-08 167.72499999999999p 8.9519879999999998e-08 167.73750000000001p 8.8473110000000003e-08 167.75p 8.7306519999999995e-08 167.76249999999999p 8.6020950000000004e-08 167.77500000000001p 8.4617360000000005e-08 167.78749999999999p 8.3096890000000004e-08 167.80000000000001p 8.1460800000000006e-08 167.8125p 7.9710529999999994e-08 167.82500000000002p 7.7847619999999995e-08 167.83749999999998p 7.5873799999999997e-08 167.84999999999999p 7.3790920000000003e-08
+ 167.86250000000001p 7.1600970000000004e-08 167.875p 6.9306110000000001e-08 167.88750000000002p 6.6908609999999995e-08 167.90000000000001p 6.4410909999999998e-08 167.91249999999999p 6.1815559999999995e-08 167.92499999999998p 5.9125259999999999e-08 167.9375p 5.6342850000000002e-08 167.94999999999999p 5.3471290000000003e-08 167.96250000000001p 5.0513669999999999e-08 167.97499999999999p 4.7473209999999998e-08 167.98750000000001p 4.435325e-08 168p 4.1157259999999999e-08 168.01249999999999p 3.7888819999999998e-08 168.02500000000001p 3.4551600000000002e-08 168.03749999999999p 3.1149419999999998e-08 168.05000000000001p 2.7686169999999998e-08 168.0625p 2.4165860000000001e-08 168.07500000000002p 2.059258e-08
+ 168.08749999999998p 1.6970539999999999e-08 168.09999999999999p 1.3304e-08 168.11250000000001p 9.597317e-09 168.125p 5.8549350000000001e-09 168.13750000000002p 2.081355e-09 168.15000000000001p -1.7188539999999999e-09 168.16250000000002p -5.5410599999999999e-09 168.17499999999998p -9.3805810000000002e-09 168.1875p -1.3232680000000001e-08 168.19999999999999p -1.7092590000000001e-08 168.21250000000001p -2.0955499999999999e-08 168.22499999999999p -2.4816559999999999e-08 168.23750000000001p -2.867091e-08 168.25p -3.251368e-08 168.26249999999999p -3.633996e-08 168.27500000000001p -4.0144869999999998e-08 168.28749999999999p -4.3923500000000003e-08 168.30000000000001p -4.7670979999999997e-08
+ 168.3125p -5.1382430000000001e-08 168.32500000000002p -5.505301e-08 168.33749999999998p -5.8677899999999999e-08 168.34999999999999p -6.2252309999999993e-08 168.36249999999998p -6.5771490000000004e-08 168.375p -6.9230770000000006e-08 168.38750000000002p -7.2625489999999994e-08 168.40000000000001p -7.5951089999999999e-08 168.41250000000002p -7.9203049999999994e-08 168.42499999999998p -8.2376940000000004e-08 168.4375p -8.546841e-08 168.44999999999999p -8.8473180000000005e-08 168.46250000000001p -9.1387090000000005e-08 168.47499999999999p -9.4206059999999996e-08 168.48750000000001p -9.6926120000000002e-08 168.5p -9.9543409999999998e-08 168.51249999999999p -1.0205420000000001e-07 168.52500000000001p -1.0445479999999999e-07
+ 168.53749999999999p -1.067419e-07 168.55000000000001p -1.089119e-07 168.5625p -1.109618e-07 168.57500000000002p -1.128883e-07 168.58749999999998p -1.1468859999999999e-07 168.59999999999999p -1.1636e-07 168.61249999999998p -1.178996e-07 168.625p -1.1930520000000001e-07 168.63750000000002p -1.205744e-07 168.65000000000001p -1.2170510000000001e-07 168.66250000000002p -1.226953e-07 168.67499999999998p -1.235431e-07 168.6875p -1.2424710000000001e-07 168.69999999999999p -1.2480570000000001e-07 168.71250000000001p -1.2521779999999999e-07 168.72499999999999p -1.254822e-07 168.73750000000001p -1.2559800000000001e-07 168.75p -1.255646e-07
+ 168.76249999999999p -1.2538149999999999e-07 168.77500000000001p -1.2504839999999999e-07 168.78749999999999p -1.245651e-07 168.80000000000001p -1.239317e-07 168.8125p -1.231485e-07 168.82500000000002p -1.2221599999999999e-07 168.83750000000001p -1.211347e-07 168.84999999999999p -1.1990559999999999e-07 168.86249999999998p -1.185297e-07 168.875p -1.170082e-07 168.88749999999999p -1.1534259999999999e-07 168.90000000000001p -1.135344e-07 168.91250000000002p -1.115855e-07 168.92499999999998p -1.0949779999999999e-07 168.9375p -1.072735e-07 168.94999999999999p -1.04915e-07 168.96250000000001p -1.0242479999999999e-07 168.97499999999999p -9.9805600000000005e-08
+ 168.98750000000001p -9.7060269999999997e-08 169p -9.4191880000000002e-08 169.01249999999999p -9.1203619999999999e-08 169.02500000000001p -8.8098880000000002e-08 169.03749999999999p -8.4881200000000002e-08 169.05000000000001p -8.1554249999999997e-08 169.0625p -7.8121880000000004e-08 169.07500000000002p -7.4588059999999999e-08 169.08750000000001p -7.0956920000000006e-08 169.09999999999999p -6.7232709999999997e-08 169.11249999999998p -6.3419799999999997e-08 169.125p -5.952272e-08 169.13749999999999p -5.5546079999999999e-08 169.15000000000001p -5.149461e-08 169.16250000000002p -4.7373169999999998e-08 169.17500000000001p -4.3186690000000002e-08 169.1875p -3.8940200000000001e-08 169.19999999999999p -3.4638839999999999e-08
+ 169.21250000000001p -3.0287789999999999e-08 169.22499999999999p -2.589234e-08 169.23750000000001p -2.1457820000000001e-08 169.25p -1.698965e-08 169.26249999999999p -1.249326e-08 169.27500000000001p -7.9741729999999997e-09 169.28749999999999p -3.4379139999999998e-09 169.30000000000001p 1.109946e-09 169.3125p 5.6638139999999997e-09 169.32500000000002p 1.021808e-08 169.33750000000001p 1.4767129999999999e-08 169.34999999999999p 1.9305339999999999e-08 169.36249999999998p 2.3827100000000001e-08 169.375p 2.8326809999999998e-08 169.38749999999999p 3.2798900000000003e-08 169.40000000000001p 3.7237809999999998e-08 169.41249999999999p 4.1638019999999998e-08 169.42500000000001p 4.599408e-08
+ 169.4375p 5.030056e-08 169.44999999999999p 5.4552100000000003e-08 169.46250000000001p 5.87434e-08 169.47499999999999p 6.2869240000000002e-08 169.48750000000001p 6.6924480000000005e-08 169.5p 7.0904049999999994e-08 169.51249999999999p 7.4802999999999998e-08 169.52499999999998p 7.8616459999999995e-08 169.53749999999999p 8.2339679999999999e-08 169.55000000000001p 8.5968000000000006e-08 169.5625p 8.9496910000000002e-08 169.57500000000002p 9.2922000000000003e-08 169.58750000000001p 9.6239010000000002e-08 169.59999999999999p 9.9443809999999999e-08 169.61249999999998p 1.025324e-07 169.625p 1.05501e-07 169.63749999999999p 1.083458e-07 169.65000000000001p 1.110634e-07
+ 169.66249999999999p 1.136504e-07 169.67500000000001p 1.161036e-07 169.6875p 1.1841990000000001e-07 169.69999999999999p 1.2059660000000001e-07 169.71250000000001p 1.2263089999999999e-07 169.72499999999999p 1.2452049999999999e-07 169.73750000000001p 1.262629e-07 169.75p 1.278561e-07 169.76250000000002p 1.2929820000000001e-07 169.77499999999998p 1.3058749999999999e-07 169.78749999999999p 1.3172239999999999e-07 169.80000000000001p 1.327016e-07 169.8125p 1.3352409999999999e-07 169.82500000000002p 1.3418889999999999e-07 169.83750000000001p 1.3469530000000001e-07 169.84999999999999p 1.3504279999999999e-07 169.86249999999998p 1.3523109999999999e-07 169.875p 1.3526019999999999e-07
+ 169.88749999999999p 1.3513010000000001e-07 169.90000000000001p 1.3484119999999999e-07 169.91249999999999p 1.3439400000000001e-07 169.92500000000001p 1.3378930000000001e-07 169.9375p 1.330279e-07 169.94999999999999p 1.3211100000000001e-07 169.96250000000001p 1.3103999999999999e-07 169.97499999999999p 1.298164e-07 169.98750000000001p 1.2844189999999999e-07)
I_IBIAS 0 IBIAS pwl(0p 0 1p 40u 2p 40u 170p 40u)
.tran 0.0125p 170p
.print P(BJs|XBQ) V(BJs|XBQ) I(BJs|XBQ)
.print P(BJL1|XBQ) V(BJL1|XBQ) I(BJL1|XBQ)
.print P(BJL2|XBQ) V(BJL2|XBQ) I(BJL2|XBQ)
.print I(I_REPLAY) I(I_IBIAS) V(IN) V(OUT) I(R_LOAD)
.print I(Lin|XBQ) I(L0|XBQ) I(L1|XBQ) I(L2|XBQ) I(RB|XBQ) I(RJ1|XBQ) I(RJ2|XBQ)
.end
