* UNVALIDATED DESIGN-REVIEW DRAFT: CARRY5 11x13, two post-write1 reads, 8 SFQ clocks.
* Source: user-supplied D3/D4 trial deck with original CARRY5 data path preserved.
* Place this directory under test/exploration/bvm-4x4-diagonal-array-v1-20261009/.
* Only examine after a static JoSIM preflight; do not overwrite prior immutable runs.
* BVM 4x4 diagonal collection; physical seven-stage T1/CBU chain.
* Cell WL/BL are physically shared buses; SE is cell-local.
.include ../../../../circuits/models/jjmit.cir
.include ../../../../circuits/bvm/bvm_cell_0923.cir
.include ../../../../circuits/qb/BQ_0928.cir
.include ../../../../circuits/sJTL_0923.cir
.include ../../../../circuits/CB/CB_0928.cir
.include library_josim/dcsfq2.cir
.include library_josim/jtl2.cir
.include stimulus.inc

.include sources/t1_cell_tunable.cir

* No THmitll_MERGE instances in this deck; Carry uses CB_0928 directly.
.include ../../../../circuits/standard/DFF.cir
.include sources/d0_jtl_tunable.cir

XBVM_R1C1 WL_R1 BL_C1 SE_R1C1 SL_R1C1 BVM
XBQ_R1C1 SL_R1C1 MERGE_D3_L1 BQ
XBVM_R1C2 WL_R1 BL_C2 SE_R1C2 SL_R1C2 BVM
XBQ_R1C2 SL_R1C2 MERGE_D2_L1 BQ
XBVM_R1C3 WL_R1 BL_C3 SE_R1C3 SL_R1C3 BVM
XBQ_R1C3 SL_R1C3 MERGE_D1_L1 BQ
XBVM_R1C4 WL_R1 BL_C4 SE_R1C4 SL_R1C4 BVM
XBQ_R1C4 SL_R1C4 MERGE_D0_L1 BQ
XBVM_R2C1 WL_R2 BL_C1 SE_R2C1 SL_R2C1 BVM
XBQ_R2C1 SL_R2C1 MERGE_D4_L1 BQ
XBVM_R2C2 WL_R2 BL_C2 SE_R2C2 SL_R2C2 BVM
XBQ_R2C2 SL_R2C2 MERGE_D3_L2 BQ
XBVM_R2C3 WL_R2 BL_C3 SE_R2C3 SL_R2C3 BVM
XBQ_R2C3 SL_R2C3 MERGE_D2_L2 BQ
XBVM_R2C4 WL_R2 BL_C4 SE_R2C4 SL_R2C4 BVM
XBQ_R2C4 SL_R2C4 MERGE_D1_L2 BQ
XBVM_R3C1 WL_R3 BL_C1 SE_R3C1 SL_R3C1 BVM
XBQ_R3C1 SL_R3C1 MERGE_D5_L1 BQ
XBVM_R3C2 WL_R3 BL_C2 SE_R3C2 SL_R3C2 BVM
XBQ_R3C2 SL_R3C2 MERGE_D4_L2 BQ
XBVM_R3C3 WL_R3 BL_C3 SE_R3C3 SL_R3C3 BVM
XBQ_R3C3 SL_R3C3 MERGE_D3_L3 BQ
XBVM_R3C4 WL_R3 BL_C4 SE_R3C4 SL_R3C4 BVM
XBQ_R3C4 SL_R3C4 MERGE_D2_L3 BQ
XBVM_R4C1 WL_R4 BL_C1 SE_R4C1 SL_R4C1 BVM
XBQ_R4C1 SL_R4C1 MERGE_D6_L1 BQ
XBVM_R4C2 WL_R4 BL_C2 SE_R4C2 SL_R4C2 BVM
XBQ_R4C2 SL_R4C2 MERGE_D5_L2 BQ
XBVM_R4C3 WL_R4 BL_C3 SE_R4C3 SL_R4C3 BVM
XBQ_R4C3 SL_R4C3 MERGE_D4_L3 BQ
XBVM_R4C4 WL_R4 BL_C4 SE_R4C4 SL_R4C4 BVM
XBQ_R4C4 SL_R4C4 MERGE_D3_L4 BQ
XSJTL_D0_L1 MERGE_D0_L1 SJTL_OUT_D0_L1 sJTL
XCB_D0_L1 SJTL_OUT_D0_L1 DOUT_D0 CB
XSJTL_D1_L1 MERGE_D1_L1 SJTL_OUT_D1_L1 sJTL
XCB_D1_L1 SJTL_OUT_D1_L1 MERGE_D1_L2 CB
XSJTL_D1_L2 MERGE_D1_L2 SJTL_OUT_D1_L2 sJTL
XCB_D1_L2 SJTL_OUT_D1_L2 DOUT_D1 CB
XSJTL_D2_L1 MERGE_D2_L1 SJTL_OUT_D2_L1 sJTL
XCB_D2_L1 SJTL_OUT_D2_L1 MERGE_D2_L2 CB
XSJTL_D2_L2_S1 MERGE_D2_L2 SJTL_MID_D2_L2_S1 sJTL
XSJTL_D2_L2_S2 SJTL_MID_D2_L2_S1 SJTL_OUT_D2_L2 sJTL
XCB_D2_L2 SJTL_OUT_D2_L2 MERGE_D2_L3 CB
XSJTL_D2_L3 MERGE_D2_L3 SJTL_OUT_D2_L3 sJTL
XCB_D2_L3 SJTL_OUT_D2_L3 DOUT_D2 CB
XSJTL_D3_L1 MERGE_D3_L1 SJTL_OUT_D3_L1 sJTL
XCB_D3_L1 SJTL_OUT_D3_L1 MERGE_D3_L2 CB
XSJTL_D3_L2_S1 MERGE_D3_L2 SJTL_MID_D3_L2_S1 sJTL
XSJTL_D3_L2_S2 SJTL_MID_D3_L2_S1 SJTL_OUT_D3_L2 sJTL
XCB_D3_L2 SJTL_OUT_D3_L2 MERGE_D3_L3 CB
XSJTL_D3_L3_S1 MERGE_D3_L3 SJTL_MID_D3_L3_S1 sJTL
XSJTL_D3_L3_S2 SJTL_MID_D3_L3_S1 SJTL_OUT_D3_L3 sJTL
XCB_D3_L3 SJTL_OUT_D3_L3 MERGE_D3_L4 CB
XSJTL_D3_L4 MERGE_D3_L4 SJTL_OUT_D3_L4 sJTL
XCB_D3_L4 SJTL_OUT_D3_L4 DOUT_D3 CB
XSJTL_D4_L1 MERGE_D4_L1 SJTL_OUT_D4_L1 sJTL
XCB_D4_L1 SJTL_OUT_D4_L1 MERGE_D4_L2 CB
XSJTL_D4_L2_S1 MERGE_D4_L2 SJTL_MID_D4_L2_S1 sJTL
XSJTL_D4_L2_S2 SJTL_MID_D4_L2_S1 SJTL_OUT_D4_L2 sJTL
XCB_D4_L2 SJTL_OUT_D4_L2 MERGE_D4_L3 CB
XSJTL_D4_L3 MERGE_D4_L3 SJTL_OUT_D4_L3 sJTL
XCB_D4_L3 SJTL_OUT_D4_L3 DOUT_D4 CB
XSJTL_D5_L1 MERGE_D5_L1 SJTL_OUT_D5_L1 sJTL
XCB_D5_L1 SJTL_OUT_D5_L1 MERGE_D5_L2 CB
XSJTL_D5_L2 MERGE_D5_L2 SJTL_OUT_D5_L2 sJTL
XCB_D5_L2 SJTL_OUT_D5_L2 DOUT_D5 CB
XSJTL_D6_L1 MERGE_D6_L1 SJTL_OUT_D6_L1 sJTL
XCB_D6_L1 SJTL_OUT_D6_L1 DOUT_D6 CB

* Physical ripple chain: D0-JTL -> T1_D0; Dk + C(k-1) -> CBU_Dk -> T1_Dk.
V_BIAS1_D0 N_BIAS1_D0 0 DC 1.8m
V_BIAS2_D0 N_BIAS2_D0 0 DC 1.8m
V_BIAS3_D0 N_BIAS3_D0 0 DC 1.8m
R_S_D0 S_D0 0 12
V_TRIG_CLK_D0 CLK_RAW_D0 0 PWL(0p 0 210p 0 211p 1.2m 213p 1.2m 214p 0 410p 0 411p 1.2m 413p 1.2m 414p 0 550p 0)
R_TRIG_CLK_D0 CLK_RAW_D0 CLK_D0_IN1 2
XDCSFQ_D0 CLK_D0_IN1 CLK_D0_IN2 dcsfq2
XJTL_IN_D0 CLK_D0_IN2 CLK_D0 jtl2
XT1_D0 T1_I_D0 CLK_D0 S_D0 C_D0 N_BIAS1_D0 N_BIAS2_D0 N_BIAS3_D0 T1
V_BIAS1_D1 N_BIAS1_D1 0 DC 1.8m
V_BIAS2_D1 N_BIAS2_D1 0 DC 1.8m
V_BIAS3_D1 N_BIAS3_D1 0 DC 1.8m
R_S_D1 S_D1 0 12
V_TRIG_CLK_D1 CLK_RAW_D1 0 PWL(0p 0 210p 0 211p 1.2m 213p 1.2m 214p 0 410p 0 411p 1.2m 413p 1.2m 414p 0 550p 0)
R_TRIG_CLK_D1 CLK_RAW_D1 CLK_D1_IN1 2
XDCSFQ_D1 CLK_D1_IN1 CLK_D1_IN2 dcsfq2
XJTL_IN_D1 CLK_D1_IN2 CLK_D1 jtl2
XT1_D1 T1_I_D1 CLK_D1 S_D1 C_D1 N_BIAS1_D1 N_BIAS2_D1 N_BIAS3_D1 T1
V_BIAS1_D2 N_BIAS1_D2 0 DC 1.8m
V_BIAS2_D2 N_BIAS2_D2 0 DC 1.8m
V_BIAS3_D2 N_BIAS3_D2 0 DC 1.8m
R_S_D2 S_D2 0 12
V_TRIG_CLK_D2 CLK_RAW_D2 0 PWL(0p 0 210p 0 211p 1.2m 213p 1.2m 214p 0 410p 0 411p 1.2m 413p 1.2m 414p 0 550p 0)
R_TRIG_CLK_D2 CLK_RAW_D2 CLK_D2_IN1 2
XDCSFQ_D2 CLK_D2_IN1 CLK_D2_IN2 dcsfq2
XJTL_IN_D2 CLK_D2_IN2 CLK_D2 jtl2
XT1_D2 T1_I_D2 CLK_D2 S_D2 C_D2 N_BIAS1_D2 N_BIAS2_D2 N_BIAS3_D2 T1
V_BIAS1_D3 N_BIAS1_D3 0 DC 1.8m
V_BIAS2_D3 N_BIAS2_D3 0 DC 1.8m
V_BIAS3_D3 N_BIAS3_D3 0 DC 1.8m
R_S_D3 S_D3 0 12
V_TRIG_CLK_D3 CLK_RAW_D3 0 PWL(0p 0 210p 0 211p 1.2m 213p 1.2m 214p 0 410p 0 411p 1.2m 413p 1.2m 414p 0 550p 0)
R_TRIG_CLK_D3 CLK_RAW_D3 CLK_D3_IN1 2
XDCSFQ_D3 CLK_D3_IN1 CLK_D3_IN2 dcsfq2
XJTL_IN_D3 CLK_D3_IN2 CLK_D3 jtl2
XT1_D3 T1_I_D3 CLK_D3 S_D3 C_D3 N_BIAS1_D3 N_BIAS2_D3 N_BIAS3_D3 T1
V_BIAS1_D4 N_BIAS1_D4 0 DC 1.8m
V_BIAS2_D4 N_BIAS2_D4 0 DC 1.8m
V_BIAS3_D4 N_BIAS3_D4 0 DC 1.8m
R_S_D4 S_D4 0 12
V_TRIG_CLK_D4 CLK_RAW_D4 0 PWL(0p 0 210p 0 211p 1.2m 213p 1.2m 214p 0 410p 0 411p 1.2m 413p 1.2m 414p 0 550p 0)
R_TRIG_CLK_D4 CLK_RAW_D4 CLK_D4_IN1 2
XDCSFQ_D4 CLK_D4_IN1 CLK_D4_IN2 dcsfq2
XJTL_IN_D4 CLK_D4_IN2 CLK_D4 jtl2
XT1_D4 T1_I_D4 CLK_D4 S_D4 C_D4 N_BIAS1_D4 N_BIAS2_D4 N_BIAS3_D4 T1
V_BIAS1_D5 N_BIAS1_D5 0 DC 1.8m
V_BIAS2_D5 N_BIAS2_D5 0 DC 1.8m
V_BIAS3_D5 N_BIAS3_D5 0 DC 1.8m
R_S_D5 S_D5 0 12
V_TRIG_CLK_D5 CLK_RAW_D5 0 PWL(0p 0 210p 0 211p 1.2m 213p 1.2m 214p 0 410p 0 411p 1.2m 413p 1.2m 414p 0 550p 0)
R_TRIG_CLK_D5 CLK_RAW_D5 CLK_D5_IN1 2
XDCSFQ_D5 CLK_D5_IN1 CLK_D5_IN2 dcsfq2
XJTL_IN_D5 CLK_D5_IN2 CLK_D5 jtl2
XT1_D5 T1_I_D5 CLK_D5 S_D5 C_D5 N_BIAS1_D5 N_BIAS2_D5 N_BIAS3_D5 T1
V_BIAS1_D6 N_BIAS1_D6 0 DC 1.8m
V_BIAS2_D6 N_BIAS2_D6 0 DC 1.8m
V_BIAS3_D6 N_BIAS3_D6 0 DC 1.8m
R_S_D6 S_D6 0 12
V_TRIG_CLK_D6 CLK_RAW_D6 0 PWL(0p 0 210p 0 211p 1.2m 213p 1.2m 214p 0 410p 0 411p 1.2m 413p 1.2m 414p 0 550p 0)
R_TRIG_CLK_D6 CLK_RAW_D6 CLK_D6_IN1 2
XDCSFQ_D6 CLK_D6_IN1 CLK_D6_IN2 dcsfq2
XJTL_IN_D6 CLK_D6_IN2 CLK_D6 jtl2
XT1_D6 T1_I_D6 CLK_D6 S_D6 C_D6 N_BIAS1_D6 N_BIAS2_D6 N_BIAS3_D6 T1

* D0 physical entrance JTL; every stage has series 0-V branch-current sensors.
V_D0_JTL_IN_1 DOUT_D0 D0_JTL_IN_1 0
XJTL_D0_1 D0_JTL_IN_1 D0_JTL_OUT_1 D0_JTL
V_T1_LINK_D0 D0_JTL_OUT_1 T1_I_D0 0

* Selected Carry branches: configured canonical sJTL chain -> CB_0928 -> JOIN; array DOUT joins directly.
V_CBU_A_D1 DOUT_D1 CBU_JOIN_D1 0
V_CARRY_IN_D1 C_D0 CARRY_SJTL_IN_D1 0
XSJTL_CARRY_D1 CARRY_SJTL_IN_D1 CARRY_SJTL_OUT_D1 sJTL
V_CARRY_SJTL_OUT_D1 CARRY_SJTL_OUT_D1 CARRY_CB_IN_D1 0
XCB_CARRY_D1 CARRY_CB_IN_D1 CARRY_CB_OUT_D1 CB
V_CBU_B_D1 CARRY_CB_OUT_D1 CBU_JOIN_D1 0
V_T1_LINK_D1 CBU_JOIN_D1 T1_I_D1 0
V_CBU_A_D2 DOUT_D2 CBU_JOIN_D2 0
V_CARRY_IN_D2 C_D1 CARRY_SJTL_IN_D2 0
XSJTL_CARRY_D2 CARRY_SJTL_IN_D2 CARRY_SJTL_OUT_D2 sJTL
V_CARRY_SJTL_OUT_D2 CARRY_SJTL_OUT_D2 CARRY_CB_IN_D2 0
XCB_CARRY_D2 CARRY_CB_IN_D2 CARRY_CB_OUT_D2 CB
V_CBU_B_D2 CARRY_CB_OUT_D2 CBU_JOIN_D2 0
V_T1_LINK_D2 CBU_JOIN_D2 T1_I_D2 0
V_CBU_A_D3 DOUT_D3 CBU_JOIN_D3 0
V_CARRY_IN_D3 C_D2 CARRY_SJTL_IN_D3 0
XSJTL_CARRY_D3 CARRY_SJTL_IN_D3 CARRY_SJTL_MID_D3_S1 sJTL
V_CARRY_SJTL_LINK_D3_S1 CARRY_SJTL_MID_D3_S1 CARRY_SJTL_IN_D3_S2 0
XSJTL_CARRY_D3_S2 CARRY_SJTL_IN_D3_S2 CARRY_SJTL_MID_D3_S2 sJTL
V_CARRY_SJTL_LINK_D3_S2 CARRY_SJTL_MID_D3_S2 CARRY_SJTL_IN_D3_S3 0
XSJTL_CARRY_D3_S3 CARRY_SJTL_IN_D3_S3 CARRY_SJTL_MID_D3_S3 sJTL
V_CARRY_SJTL_LINK_D3_S3 CARRY_SJTL_MID_D3_S3 CARRY_SJTL_IN_D3_S4 0
XSJTL_CARRY_D3_S4 CARRY_SJTL_IN_D3_S4 CARRY_SJTL_MID_D3_S4 sJTL
V_CARRY_SJTL_LINK_D3_S4 CARRY_SJTL_MID_D3_S4 CARRY_SJTL_IN_D3_S5 0
XSJTL_CARRY_D3_S5 CARRY_SJTL_IN_D3_S5 CARRY_SJTL_OUT_D3 sJTL
V_CARRY_SJTL_OUT_D3 CARRY_SJTL_OUT_D3 CARRY_CB_IN_D3 0
XCB_CARRY_D3 CARRY_CB_IN_D3 CARRY_CB_OUT_D3 CB
V_CBU_B_D3 CARRY_CB_OUT_D3 CBU_JOIN_D3 0
V_T1_LINK_D3 CBU_JOIN_D3 T1_I_D3 0
V_CBU_A_D4 DOUT_D4 CBU_JOIN_D4 0
V_CARRY_IN_D4 C_D3 CARRY_SJTL_IN_D4 0
XSJTL_CARRY_D4 CARRY_SJTL_IN_D4 CARRY_SJTL_OUT_D4 sJTL
V_CARRY_SJTL_OUT_D4 CARRY_SJTL_OUT_D4 CARRY_CB_IN_D4 0
XCB_CARRY_D4 CARRY_CB_IN_D4 CARRY_CB_OUT_D4 CB
V_CBU_B_D4 CARRY_CB_OUT_D4 CBU_JOIN_D4 0
V_T1_LINK_D4 CBU_JOIN_D4 T1_I_D4 0
V_CBU_A_D5 DOUT_D5 CBU_JOIN_D5 0
V_CARRY_IN_D5 C_D4 CARRY_SJTL_IN_D5 0
XSJTL_CARRY_D5 CARRY_SJTL_IN_D5 CARRY_SJTL_OUT_D5 sJTL
V_CARRY_SJTL_OUT_D5 CARRY_SJTL_OUT_D5 CARRY_CB_IN_D5 0
XCB_CARRY_D5 CARRY_CB_IN_D5 CARRY_CB_OUT_D5 CB
V_CBU_B_D5 CARRY_CB_OUT_D5 CBU_JOIN_D5 0
V_T1_LINK_D5 CBU_JOIN_D5 T1_I_D5 0
V_CBU_A_D6 DOUT_D6 CBU_JOIN_D6 0
V_CARRY_IN_D6 C_D5 CARRY_SJTL_IN_D6 0
XSJTL_CARRY_D6 CARRY_SJTL_IN_D6 CARRY_SJTL_OUT_D6 sJTL
V_CARRY_SJTL_OUT_D6 CARRY_SJTL_OUT_D6 CARRY_CB_IN_D6 0
XCB_CARRY_D6 CARRY_CB_IN_D6 CARRY_CB_OUT_D6 CB
V_CBU_B_D6 CARRY_CB_OUT_D6 CBU_JOIN_D6 0
V_T1_LINK_D6 CBU_JOIN_D6 T1_I_D6 0

* C0-C5 directly drive the next CBU; C6 directly drives the DFF data input.
V_DFF_DATA C_D6 DFF_IN 0
R_DFF_OUT DFF_O 0 12
XDFF DFF_IN CLK_DFF DFF_O THmitll_DFF
V_TRIG_CLK_DFF CLK_RAW_DFF 0 PWL(0p 0 210p 0 211p 1.2m 213p 1.2m 214p 0 410p 0 411p 1.2m 413p 1.2m 414p 0 550p 0)
R_TRIG_CLK_DFF CLK_RAW_DFF CLK_DFF_IN1 2
XDCSFQ_DFF CLK_DFF_IN1 CLK_DFF_IN2 dcsfq2
XJTL_IN_DFF CLK_DFF_IN2 CLK_DFF jtl2

* Registered probes; P is raw radians.
* .print V(DOUT_D0)
* .print P(BJ1|XCB_D0_L1)
* .print V(BJ1|XCB_D0_L1)
* .print P(BJ2|XCB_D0_L1)
* .print V(BJ2|XCB_D0_L1)

*.print V(T1_I_D0)
.print V(S_D0)
*.print V(C_D0)
*.print V(T1_I_D1)
.print V(S_D1)
*.print V(C_D1)
*.print V(T1_I_D2)
.print V(S_D2)
*.print V(C_D2)
*.print V(T1_I_D3)
.print V(S_D3)
*.print V(C_D3)
*.print V(T1_I_D4)
.print V(S_D4)
*.print V(C_D4)
*.print V(T1_I_D5)
.print V(S_D5)
*.print V(C_D5)
*.print V(T1_I_D6)
.print V(S_D6)
*.print V(C_D6)
*.print V(T1_I_D7)
*.print V(S_D7)
*.print V(C_D7)
*.print V(DFF_IN)
*.print V(CLK_DFF)
.print V(DFF_O)

* 实际SFQ时钟到达
.print V(CLK_D0)
.print V(CLK_D1)
.print V(CLK_D2)
.print V(CLK_D3)
.print V(CLK_D4)
.print V(CLK_D5)
.print V(CLK_D6)
.print V(CLK_DFF)

* D3时钟链的内部JJ
.print P(B03|XDCSFQ_D3)
.print V(B03|XDCSFQ_D3)
.print P(B02|XJTL_IN_D3)
.print V(B02|XJTL_IN_D3)

* D3 T1输入、Carry与时钟JJ
.print V(T1_I_D3)
.print V(C_D3)
.print P(B_J2|XT1_D3)
.print V(B_J2|XT1_D3)

* DFF数据输入
.print V(DFF_IN)

* BVM代表交叉点的状态观测
.print P(B_JS1|XBVM_R1C1)
.print V(B_JS1|XBVM_R1C1)

* ============================================
* V3: BVM STORAGE STATE PROBES
* ============================================

* Selected cell: R1C1
* S-Loop currents
.print I(L_M1|XBVM_R1C1)
.print I(L_M2|XBVM_R1C1)
.print I(L_M3|XBVM_R1C1)

* JJ phases
.print P(B_JM1|XBVM_R1C1)
.print P(B_JM2|XBVM_R1C1)
.print P(B_JS2|XBVM_R1C1)

* Unselected cell on active WL: R1C3
* S-Loop currents
.print I(L_M1|XBVM_R1C3)
.print I(L_M2|XBVM_R1C3)
.print I(L_M3|XBVM_R1C3)

* JJ phases
.print P(B_JM1|XBVM_R1C3)
.print P(B_JM2|XBVM_R1C3)
.print P(B_JS2|XBVM_R1C3)
.tran 0.01p 550p
.end
