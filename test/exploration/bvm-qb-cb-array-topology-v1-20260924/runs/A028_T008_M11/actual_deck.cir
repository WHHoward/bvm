* Generated top-level deck; component parameters live only in source snapshots.
* BVM array -> QB/CB/sJTL topology fixture
* Shared frozen junction model; needed by BVM and identical to component-local cards.
.model jjmit jj(rtype=1, vg=2.8mV, cap=0.07pF, r0=160, rN=16, icrit=0.1mA)

.include snapshot/sources/bvm_tunable.cir
.include snapshot/sources/BQ_tunable.cir
.include snapshot/sources/CB_tunable.cir
.include snapshot/sources/sJTL_tunable.cir
.include stimulus.inc

XBVM1 WL1 BL1 SE1 BVM1_SL BVM
XBQ1 BVM1_SL MERGE1 BQ
XSJTL1_01 MERGE1 L1_01 sJTL
XPOSTCB1 L1_01 MERGE2 CB
XBVM2 WL2 BL2 SE2 BVM2_SL BVM
XBQ2 BVM2_SL MERGE2 BQ
XPOSTCB2 MERGE2 FINAL_OUT CB

R_TERM FINAL_OUT 0 2
.print I(I_WL1)
.print I(I_BL1)
.print I(I_SE1)
.print P(B_JM1|XBVM1)
.print V(B_JM1|XBVM1)
.print P(B_JM2|XBVM1)
.print V(B_JM2|XBVM1)
.print P(B_JS1|XBVM1)
.print V(B_JS1|XBVM1)
.print P(B_JS2|XBVM1)
.print V(B_JS2|XBVM1)
.print I(L_M1|XBVM1)
.print I(L_M2|XBVM1)
.print I(L_M3|XBVM1)
.print I(L_PM|XBVM1)
.print I(L_SL|XBVM1)
.print V(BVM1_SL)
.print P(BJ1|XBQ1)
.print V(BJ1|XBQ1)
.print P(BJ2|XBQ1)
.print V(BJ2|XBQ1)
.print P(BJ3|XBQ1)
.print V(BJ3|XBQ1)
.print I(LIN|XBQ1)
.print I(L1|XBQ1)
.print I(L2|XBQ1)
.print I(L3|XBQ1)
.print V(MERGE1)
.print I(I_WL2)
.print I(I_BL2)
.print I(I_SE2)
.print P(B_JM1|XBVM2)
.print V(B_JM1|XBVM2)
.print P(B_JM2|XBVM2)
.print V(B_JM2|XBVM2)
.print P(B_JS1|XBVM2)
.print V(B_JS1|XBVM2)
.print P(B_JS2|XBVM2)
.print V(B_JS2|XBVM2)
.print I(L_M1|XBVM2)
.print I(L_M2|XBVM2)
.print I(L_M3|XBVM2)
.print I(L_PM|XBVM2)
.print I(L_SL|XBVM2)
.print V(BVM2_SL)
.print P(BJ1|XBQ2)
.print V(BJ1|XBQ2)
.print P(BJ2|XBQ2)
.print V(BJ2|XBQ2)
.print P(BJ3|XBQ2)
.print V(BJ3|XBQ2)
.print I(LIN|XBQ2)
.print I(L1|XBQ2)
.print I(L2|XBQ2)
.print I(L3|XBQ2)
.print V(MERGE2)
.print P(BJ1|XPOSTCB1)
.print V(BJ1|XPOSTCB1)
.print P(BJ2|XPOSTCB1)
.print V(BJ2|XPOSTCB1)
.print I(L1|XPOSTCB1)
.print I(L4|XPOSTCB1)
.print V(L1_01)
.print P(BJ1|XSJTL1_01)
.print V(BJ1|XSJTL1_01)
.print I(L1|XSJTL1_01)
.print I(L2|XSJTL1_01)
.print P(BJ1|XPOSTCB2)
.print V(BJ1|XPOSTCB2)
.print P(BJ2|XPOSTCB2)
.print V(BJ2|XPOSTCB2)
.print I(L1|XPOSTCB2)
.print I(L4|XPOSTCB2)
.print V(FINAL_OUT)
.print I(R_TERM)
.tran 0.01p 200p
.end
