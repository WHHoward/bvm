* CLK-only: Direct R_trig drive, V_TRIG tuned for T1 input impedance
.include ../../../circuits/t1/t1_cell.cir

XT1 0 CLK S C N_BIAS1 N_BIAS2 N_BIAS3 T1
.include ../../../circuits/models/jjmit.cir
V_BIAS1 N_BIAS1 0 DC 1.67m
V_BIAS2 N_BIAS2 0 DC 1.67m
I_BIAS3 N_BIAS3 0 DC 35U
R_S S 0 12.0
R_C C 0 12.0

* T1 CLK input Z≈3.6Ω. With R_TRIG=5Ω: V(CLK)=V_TRIG×3.6/(5+3.6)=V_TRIG×0.42
* Need V(CLK)≈0.5mV → V_TRIG≈1.2mV (< V_gap=2.8mV ✓)
V_TRIG CLK_RAW 0 pulse(0 1.2m 20p 1p 1p 2p 50p)
R_TRIG CLK_RAW CLK 5

.tran 0.2p 220p 0 0.4p 0 DST
.print V(CLK) V(S) V(C)
.print P(B_J2|XT1) P(B_J9|XT1)
.end
