* REGISTERED QBIN linear shunt conductance ladder; point=r25; mask=0111
* This candidate changes exactly one line relative to the open baseline.
* P(...) is raw phase in radians; phase turns are display/navigation only.
.include ../../../../../../circuits/models/jjmit.cir
.include ../../../../../../circuits/qb/bq_parameterized_v1.cir
.include ../../../../bvm-population-scaling-rj2p12-l1p14-l2p20-ib260-rj32-bjs400-v1-20260910/inputs/bvm_jm2_connected.cir
.include ../../../../bvm-population-scaling-rj2p12-l1p14-l2p20-ib260-rj32-bjs400-v1-20260910/inputs/jtl2.cir

XBVM1 WL1 BL1 SE1 COMMON_SL BVM
XBVM2 WL2 BL2 SE2 COMMON_SL BVM
XBVM3 WL3 BL3 SE3 COMMON_SL BVM
XBVM4 WL4 BL4 SE4 COMMON_SL BVM

B_JSL1 COMMON_SL JSL_NODE1 jjmit area=5.0
B_JSL2 JSL_NODE1 JSL_NODE2 jjmit area=5.0
B_JSL3 JSL_NODE2 JSL_NODE3 jjmit area=5.0
B_JSL4 JSL_NODE3 JSL_NODE4 jjmit area=5.0
B_JSL5 JSL_NODE4 JSL_NODE5 jjmit area=5.0
B_JSL6 JSL_NODE5 JSL_NODE6 jjmit area=5.0
B_JSL7 JSL_NODE6 JSL_NODE7 jjmit area=5.0
B_JSL8 JSL_NODE7 QBIN jjmit area=5.0

* Positive shunt direction is QBIN -> ground.
R_QBIN_SHUNT QBIN 0 25

XBQ QBIN QBOUT BQ
XJTL1_1 QBOUT JTL1_OUT jtl
XJTL1_2 JTL1_OUT JTL2_OUT jtl
XJTL1_3 JTL2_OUT JTL3_OUT jtl
XJTL1_4 JTL3_OUT JTL4_OUT jtl
XJTL1_5 JTL4_OUT JTL5_OUT jtl
XJTL1_6 JTL5_OUT JTL6_OUT jtl
R_TERM JTL6_OUT 0 10

I_WL1 0 WL1 pwl(0p 0 50p 0 51p -100u 60p -100u 61p 0 70p 0 71p +100u 80p +100u 81p 0 90p 0 91p +100u 100p +100u 101p 0 110p 0 111p 0 120p 0 121p 0 200p 0)
I_BL1 0 BL1 pwl(0p 0 50p 0 51p -100u 60p -100u 61p 0 70p 0 81p 0 90p 0 91p +100u 100p +100u 101p 0 110p 0 121p 0 200p 0)
I_SE1 0 SE1 pwl(0p 0 70p 0 81p 0 90p 0 101p 0 110p 0 111p 0 120p 0 121p 0 200p 0)
I_WL2 0 WL2 pwl(0p 0 50p 0 51p -100u 60p -100u 61p 0 70p 0 71p +100u 80p +100u 81p 0 90p 0 91p +100u 100p +100u 101p 0 110p 0 111p +100u 120p +100u 121p 0 200p 0)
I_BL2 0 BL2 pwl(0p 0 50p 0 51p -100u 60p -100u 61p 0 70p 0 81p 0 90p 0 91p +100u 100p +100u 101p 0 110p 0 121p 0 200p 0)
I_SE2 0 SE2 pwl(0p 0 70p 0 81p 0 90p 0 101p 0 110p 0 111p +100u 120p +100u 121p 0 200p 0)
I_WL3 0 WL3 pwl(0p 0 50p 0 51p -100u 60p -100u 61p 0 70p 0 71p +100u 80p +100u 81p 0 90p 0 91p +100u 100p +100u 101p 0 110p 0 111p +100u 120p +100u 121p 0 200p 0)
I_BL3 0 BL3 pwl(0p 0 50p 0 51p -100u 60p -100u 61p 0 70p 0 81p 0 90p 0 91p +100u 100p +100u 101p 0 110p 0 121p 0 200p 0)
I_SE3 0 SE3 pwl(0p 0 70p 0 81p 0 90p 0 101p 0 110p 0 111p +100u 120p +100u 121p 0 200p 0)
I_WL4 0 WL4 pwl(0p 0 50p 0 51p -100u 60p -100u 61p 0 70p 0 71p +100u 80p +100u 81p 0 90p 0 91p +100u 100p +100u 101p 0 110p 0 111p +100u 120p +100u 121p 0 200p 0)
I_BL4 0 BL4 pwl(0p 0 50p 0 51p -100u 60p -100u 61p 0 70p 0 81p 0 90p 0 91p +100u 100p +100u 101p 0 110p 0 121p 0 200p 0)
I_SE4 0 SE4 pwl(0p 0 70p 0 81p 0 90p 0 101p 0 110p 0 111p +100u 120p +100u 121p 0 200p 0)

.tran 0.1p 200p

.print I(I_WL1) I(I_BL1) I(I_SE1)
.print P(B_JM1|XBVM1) V(B_JM1|XBVM1) I(B_JM1|XBVM1)
.print P(B_JM2|XBVM1) V(B_JM2|XBVM1) I(B_JM2|XBVM1)
.print P(B_JS1|XBVM1) V(B_JS1|XBVM1) I(B_JS1|XBVM1)
.print P(B_JS2|XBVM1) V(B_JS2|XBVM1) I(B_JS2|XBVM1)
.print I(L_M1|XBVM1) V(L_M1|XBVM1)
.print I(L_M2|XBVM1) V(L_M2|XBVM1)
.print I(L_M3|XBVM1) V(L_M3|XBVM1)
.print I(L_S1|XBVM1) V(L_S1|XBVM1)
.print I(L_S2|XBVM1) V(L_S2|XBVM1)
.print I(L_S3|XBVM1) V(L_S3|XBVM1)
.print I(L_PSL|XBVM1) V(L_PSL|XBVM1)
.print I(L_SL|XBVM1) V(L_SL|XBVM1)
.print I(I_WL2) I(I_BL2) I(I_SE2)
.print P(B_JM1|XBVM2) V(B_JM1|XBVM2) I(B_JM1|XBVM2)
.print P(B_JM2|XBVM2) V(B_JM2|XBVM2) I(B_JM2|XBVM2)
.print P(B_JS1|XBVM2) V(B_JS1|XBVM2) I(B_JS1|XBVM2)
.print P(B_JS2|XBVM2) V(B_JS2|XBVM2) I(B_JS2|XBVM2)
.print I(L_M1|XBVM2) V(L_M1|XBVM2)
.print I(L_M2|XBVM2) V(L_M2|XBVM2)
.print I(L_M3|XBVM2) V(L_M3|XBVM2)
.print I(L_S1|XBVM2) V(L_S1|XBVM2)
.print I(L_S2|XBVM2) V(L_S2|XBVM2)
.print I(L_S3|XBVM2) V(L_S3|XBVM2)
.print I(L_PSL|XBVM2) V(L_PSL|XBVM2)
.print I(L_SL|XBVM2) V(L_SL|XBVM2)
.print I(I_WL3) I(I_BL3) I(I_SE3)
.print P(B_JM1|XBVM3) V(B_JM1|XBVM3) I(B_JM1|XBVM3)
.print P(B_JM2|XBVM3) V(B_JM2|XBVM3) I(B_JM2|XBVM3)
.print P(B_JS1|XBVM3) V(B_JS1|XBVM3) I(B_JS1|XBVM3)
.print P(B_JS2|XBVM3) V(B_JS2|XBVM3) I(B_JS2|XBVM3)
.print I(L_M1|XBVM3) V(L_M1|XBVM3)
.print I(L_M2|XBVM3) V(L_M2|XBVM3)
.print I(L_M3|XBVM3) V(L_M3|XBVM3)
.print I(L_S1|XBVM3) V(L_S1|XBVM3)
.print I(L_S2|XBVM3) V(L_S2|XBVM3)
.print I(L_S3|XBVM3) V(L_S3|XBVM3)
.print I(L_PSL|XBVM3) V(L_PSL|XBVM3)
.print I(L_SL|XBVM3) V(L_SL|XBVM3)
.print I(I_WL4) I(I_BL4) I(I_SE4)
.print P(B_JM1|XBVM4) V(B_JM1|XBVM4) I(B_JM1|XBVM4)
.print P(B_JM2|XBVM4) V(B_JM2|XBVM4) I(B_JM2|XBVM4)
.print P(B_JS1|XBVM4) V(B_JS1|XBVM4) I(B_JS1|XBVM4)
.print P(B_JS2|XBVM4) V(B_JS2|XBVM4) I(B_JS2|XBVM4)
.print I(L_M1|XBVM4) V(L_M1|XBVM4)
.print I(L_M2|XBVM4) V(L_M2|XBVM4)
.print I(L_M3|XBVM4) V(L_M3|XBVM4)
.print I(L_S1|XBVM4) V(L_S1|XBVM4)
.print I(L_S2|XBVM4) V(L_S2|XBVM4)
.print I(L_S3|XBVM4) V(L_S3|XBVM4)
.print I(L_PSL|XBVM4) V(L_PSL|XBVM4)
.print I(L_SL|XBVM4) V(L_SL|XBVM4)
.print V(COMMON_SL)
.print P(B_JSL1) V(B_JSL1) I(B_JSL1)
.print P(B_JSL2) V(B_JSL2) I(B_JSL2)
.print P(B_JSL3) V(B_JSL3) I(B_JSL3)
.print P(B_JSL4) V(B_JSL4) I(B_JSL4)
.print P(B_JSL5) V(B_JSL5) I(B_JSL5)
.print P(B_JSL6) V(B_JSL6) I(B_JSL6)
.print P(B_JSL7) V(B_JSL7) I(B_JSL7)
.print P(B_JSL8) V(B_JSL8) I(B_JSL8)
.print V(QBIN)
.print I(R_QBIN_SHUNT) V(R_QBIN_SHUNT)
.print I(LIN|XBQ) V(LIN|XBQ)
.print I(L1|XBQ) V(L1|XBQ)
.print I(L2|XBQ) V(L2|XBQ)
.print I(L3|XBQ) V(L3|XBQ)
.print I(RJ1|XBQ) V(RJ1|XBQ)
.print I(RJ2|XBQ) V(RJ2|XBQ)
.print P(BJS|XBQ) V(BJS|XBQ) I(BJS|XBQ)
.print P(BJ1|XBQ) V(BJ1|XBQ) I(BJ1|XBQ)
.print P(BJ2|XBQ) V(BJ2|XBQ) I(BJ2|XBQ)
.print V(QBOUT)
.print P(B01|XJTL1_1) V(B01|XJTL1_1) I(B01|XJTL1_1) P(B02|XJTL1_1) V(B02|XJTL1_1) I(B02|XJTL1_1)
.print V(JTL1_OUT)
.print P(B01|XJTL1_2) V(B01|XJTL1_2) I(B01|XJTL1_2) P(B02|XJTL1_2) V(B02|XJTL1_2) I(B02|XJTL1_2)
.print V(JTL2_OUT)
.print P(B01|XJTL1_3) V(B01|XJTL1_3) I(B01|XJTL1_3) P(B02|XJTL1_3) V(B02|XJTL1_3) I(B02|XJTL1_3)
.print V(JTL3_OUT)
.print P(B01|XJTL1_4) V(B01|XJTL1_4) I(B01|XJTL1_4) P(B02|XJTL1_4) V(B02|XJTL1_4) I(B02|XJTL1_4)
.print V(JTL4_OUT)
.print P(B01|XJTL1_5) V(B01|XJTL1_5) I(B01|XJTL1_5) P(B02|XJTL1_5) V(B02|XJTL1_5) I(B02|XJTL1_5)
.print V(JTL5_OUT)
.print P(B01|XJTL1_6) V(B01|XJTL1_6) I(B01|XJTL1_6) P(B02|XJTL1_6) V(B02|XJTL1_6) I(B02|XJTL1_6)
.print V(JTL6_OUT)
.print I(R_TERM)
.end
