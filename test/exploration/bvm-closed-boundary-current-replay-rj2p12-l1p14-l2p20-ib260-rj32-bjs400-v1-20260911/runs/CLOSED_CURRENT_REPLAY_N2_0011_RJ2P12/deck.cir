* GENERATED STAGE A CLOSED-BOUNDARY CURRENT REPLAY DECK
* source_class=CURRENT_BJS400_POPULATION_CLOSED_LOOP_RAW
* source_snapshot=test/exploration/bvm-closed-boundary-current-replay-rj2p12-l1p14-l2p20-ib260-rj32-bjs400-v1-20260911/data/CLOSED_LOOP_N2_I_BJSL8_source.csv
* source_signal=I(B_JSL8); sample_count=1999
* transformation_registry=[]; exact stored pairs; no sign change
* orientation=I_REPLAY 0 QBIN; positive current injects QBIN

.param L1_VALUE=1.4p
.param IB_VALUE=260u
.param RJ1_VALUE=32
.param RJ2_VALUE=12
.include ../../inputs/jjmit.cir
.include ../../inputs/BQ_parameterized_bjs400_rj2.cir
.include ../../inputs/jtl2.cir

XBQ1 QBIN QBOUT BQ
XJTL1_1 QBOUT JTL1_OUT jtl
XJTL1_2 JTL1_OUT JTL2_OUT jtl
XJTL1_3 JTL2_OUT JTL3_OUT jtl
XJTL1_4 JTL3_OUT JTL4_OUT jtl
XJTL1_5 JTL4_OUT JTL5_OUT jtl
XJTL1_6 JTL5_OUT JTL6_OUT jtl
R_TERM JTL6_OUT 0 10

I_REPLAY 0 QBIN pwl(0p 0.000000e+00 0.1p -4.333377e-07 0.2p -1.811854e-06 0.3p -4.436265e-06 0.4p -8.272457e-06 0.5p -1.297042e-05 0.6p -1.797827e-05 0.7p -2.270009e-05 0.8p -2.664993e-05 0.9p -2.956489e-05 1p -3.145527e-05 1.1p -3.215445e-05 1.2p -3.159087e-05 1.3p -2.996163e-05 1.4p -2.773335e-05 1.5p -2.552389e-05 1.6p -2.393554e-05 1.7p -2.340060e-05
+ 1.8p -2.408165e-05 1.9p -2.584635e-05 2p -2.831481e-05 2.1p -3.096048e-05 2.2p -3.323555e-05 2.3p -3.469001e-05 2.4p -3.505866e-05 2.5p -3.430047e-05 2.6p -3.258659e-05 2.7p -3.024491e-05 2.8p -2.767713e-05 2.9p -2.526878e-05 3p -2.331192e-05 3.1p -2.195588e-05 3.2p -2.119374e-05 3.3p -2.088395e-05 3.4p -2.079879e-05 3.5p -2.068631e-05
+ 3.6p -2.033070e-05 3.7p -1.959820e-05 3.8p -1.845990e-05 3.9p -1.698939e-05 4p -1.533853e-05 4.1p -1.369937e-05 4.2p -1.226209e-05 4.3p -1.117835e-05 4.4p -1.053702e-05 4.5p -1.035557e-05 4.6p -1.058649e-05 4.7p -1.113509e-05 4.8p -1.188316e-05 4.9p -1.271256e-05 5p -1.352423e-05 5.1p -1.424928e-05 5.2p -1.485163e-05 5.3p -1.532341e-05
+ 5.4p -1.567539e-05 5.5p -1.592592e-05 5.6p -1.609094e-05 5.7p -1.617751e-05 5.8p -1.618155e-05 5.9p -1.608984e-05 6p -1.588497e-05 6.1p -1.555171e-05 6.2p -1.508296e-05 6.3p -1.448377e-05 6.4p -1.377266e-05 6.5p -1.298004e-05 6.6p -1.214428e-05 6.7p -1.130641e-05 6.8p -1.050460e-05 6.9p -9.769611e-06 7p -9.121858e-06 7.1p -8.570540e-06
+ 7.2p -8.114648e-06 7.3p -7.745392e-06 7.4p -7.449341e-06 7.5p -7.211546e-06 7.6p -7.018064e-06 7.7p -6.857512e-06 7.8p -6.721590e-06 7.9p -6.604734e-06 8p -6.503245e-06 8.1p -6.414276e-06 8.2p -6.335021e-06 8.3p -6.262336e-06 8.4p -6.192834e-06 8.5p -6.123376e-06 8.6p -6.051752e-06 8.7p -5.977298e-06 8.8p -5.901252e-06 8.9p -5.826695e-06
+ 9p -5.758053e-06 9.1p -5.700240e-06 9.2p -5.657615e-06 9.3p -5.632952e-06 9.4p -5.626634e-06 9.5p -5.636231e-06 9.6p -5.656526e-06 9.7p -5.680005e-06 9.8p -5.697688e-06 9.9p -5.700190e-06 10p -5.678812e-06 10.1p -5.626519e-06 10.2p -5.538668e-06 10.3p -5.413416e-06 10.4p -5.251790e-06 10.5p -5.057459e-06 10.6p -4.836272e-06 10.7p -4.595667e-06
+ 10.8p -4.344021e-06 10.9p -4.090038e-06 11p -3.842188e-06 11.1p -3.608263e-06 11.2p -3.395007e-06 11.3p -3.207845e-06 11.4p -3.050667e-06 11.5p -2.925690e-06 11.6p -2.833364e-06 11.7p -2.772367e-06 11.8p -2.739677e-06 11.9p -2.730762e-06 12p -2.739873e-06 12.1p -2.760451e-06 12.2p -2.785620e-06 12.3p -2.808720e-06 12.4p -2.823839e-06 12.5p -2.826284e-06
+ 12.6p -2.812933e-06 12.7p -2.782439e-06 12.8p -2.735261e-06 12.9p -2.673509e-06 13p -2.600647e-06 13.1p -2.521070e-06 13.2p -2.439609e-06 13.3p -2.361034e-06 13.4p -2.289577e-06 13.5p -2.228551e-06 13.6p -2.180068e-06 13.7p -2.144892e-06 13.8p -2.122423e-06 13.9p -2.110807e-06 14p -2.107142e-06 14.1p -2.107777e-06 14.2p -2.108649e-06 14.3p -2.105653e-06
+ 14.4p -2.094995e-06 14.5p -2.073517e-06 14.6p -2.038957e-06 14.7p -1.990142e-06 14.9p -1.850988e-06 15p -1.764154e-06 15.1p -1.669809e-06 15.2p -1.571849e-06 15.3p -1.474539e-06 15.4p -1.382178e-06 15.5p -1.298766e-06 15.6p -1.227691e-06 15.7p -1.171472e-06 15.8p -1.131564e-06 15.9p -1.108258e-06 16p -1.100668e-06 16.1p -1.106818e-06 16.2p -1.123809e-06
+ 16.3p -1.148063e-06 16.4p -1.175617e-06 16.5p -1.202442e-06 16.6p -1.224759e-06 16.7p -1.239337e-06 16.8p -1.243726e-06 16.9p -1.236430e-06 17p -1.216993e-06 17.1p -1.185998e-06 17.2p -1.144980e-06 17.3p -1.096260e-06 17.4p -1.042726e-06 17.5p -9.875706e-07 17.6p -9.340091e-07 17.7p -8.850138e-07 17.8p -8.430707e-07 17.9p -8.099877e-07 18p -7.867642e-07
+ 18.1p -7.735323e-07 18.2p -7.695707e-07 18.3p -7.733892e-07 18.4p -7.828752e-07 18.5p -7.954870e-07 18.6p -8.084794e-07 18.7p -8.191406e-07 18.8p -8.250225e-07 18.9p -8.241433e-07 19p -8.151486e-07 19.1p -7.974165e-07 19.2p -7.710998e-07 19.3p -7.371025e-07 19.4p -6.969940e-07 19.5p -6.528690e-07 19.6p -6.071664e-07 19.7p -5.624622e-07 19.8p -5.212552e-07
+ 19.9p -4.857622e-07 20p -4.577403e-07 20.1p -4.383506e-07 20.2p -4.280716e-07 20.3p -4.266716e-07 20.4p -4.332376e-07 20.5p -4.462606e-07 20.6p -4.637670e-07 20.7p -4.834857e-07 20.8p -5.030359e-07 20.9p -5.201214e-07 21p -5.327137e-07 21.1p -5.392094e-07 21.2p -5.385507e-07 21.3p -5.302978e-07 21.4p -5.146496e-07 21.5p -4.924114e-07 21.6p -4.649132e-07
+ 21.7p -4.338875e-07 21.8p -4.013164e-07 21.9p -3.692623e-07 22p -3.396965e-07 22.1p -3.143395e-07 22.2p -2.945259e-07 22.3p -2.811046e-07 22.4p -2.743818e-07 22.5p -2.741085e-07 22.6p -2.795157e-07 22.7p -2.893900e-07 22.8p -3.021849e-07 22.9p -3.161560e-07 23p -3.295107e-07 23.1p -3.405577e-07 23.2p -3.478457e-07 23.3p -3.502792e-07 23.4p -3.472023e-07
+ 23.5p -3.384443e-07 23.6p -3.243245e-07 23.7p -3.056161e-07 23.8p -2.834726e-07 23.9p -2.593247e-07 24p -2.347564e-07 24.1p -2.113702e-07 24.2p -1.906541e-07 24.3p -1.738610e-07 24.4p -1.619091e-07 24.5p -1.553128e-07 24.6p -1.541474e-07 24.7p -1.580511e-07 24.8p -1.662628e-07 24.9p -1.776915e-07 25p -1.910115e-07 25.1p -2.047758e-07 25.2p -2.175357e-07
+ 25.3p -2.279603e-07 25.4p -2.349419e-07 25.5p -2.376825e-07 25.6p -2.357529e-07 25.7p -2.291195e-07 25.8p -2.181387e-07 25.9p -2.035195e-07 26p -1.862573e-07 26.1p -1.675457e-07 26.2p -1.486744e-07 26.3p -1.309212e-07 26.4p -1.154471e-07 26.5p -1.032039e-07 26.6p -9.486101e-08 26.7p -9.075650e-08 26.8p -9.087708e-08 26.9p -9.486692e-08 27p -1.020645e-07
+ 27.1p -1.115637e-07 27.2p -1.222936e-07 27.3p -1.331102e-07 27.4p -1.428920e-07 27.5p -1.506324e-07 27.6p -1.555198e-07 27.7p -1.570006e-07 27.8p -1.548196e-07 27.9p -1.490345e-07 28p -1.400049e-07 28.1p -1.283557e-07 28.2p -1.149204e-07 28.3p -1.006672e-07 28.4p -8.661663e-08 28.5p -7.375591e-08 28.6p -6.295811e-08 28.7p -5.491245e-08 28.8p -5.007120e-08
+ 28.9p -4.861720e-08 29p -5.045418e-08 29.1p -5.522029e-08 29.2p -6.232310e-08 29.3p -7.099287e-08 29.4p -8.034930e-08 29.5p -8.947603e-08 29.6p -9.749659e-08 29.7p -1.036456e-07 29.8p -1.073294e-07 29.9p -1.081712e-07 30p -1.060378e-07 30.1p -1.010453e-07 30.2p -9.354417e-08 30.3p -8.408596e-08 30.4p -7.337329e-08 30.5p -6.219898e-08 30.6p -5.137894e-08
+ 30.7p -4.168458e-08 30.8p -3.378032e-08 30.9p -2.817134e-08 31p -2.516541e-08 31.1p -2.485186e-08 31.2p -2.709884e-08 31.3p -3.156890e-08 31.4p -3.775100e-08 31.5p -4.500620e-08 31.6p -5.262285e-08 31.7p -5.987664e-08 31.8p -6.609045e-08 31.9p -7.068905e-08 32p -7.324435e-08 32.1p -7.350756e-08 32.2p -7.142590e-08 32.3p -6.714283e-08 32.4p -6.098209e-08
+ 32.5p -5.341717e-08 32.6p -4.502912e-08 32.7p -3.645638e-08 32.8p -2.834086e-08 32.9p -2.127503e-08 33p -1.575405e-08 33.1p -1.213705e-08 33.2p -1.062032e-08 33.3p -1.122451e-08 33.4p -1.379658e-08 33.5p -1.802584e-08 33.6p -2.347282e-08 33.7p -2.960794e-08 33.8p -3.585692e-08 33.9p -4.164891e-08 34p -4.646331e-08 34.1p -4.987163e-08 34.2p -5.157074e-08
+ 34.3p -5.140531e-08 34.4p -4.937748e-08 34.5p -4.564345e-08 34.6p -4.049740e-08 34.7p -3.434441e-08 34.8p -2.766483e-08 34.9p -2.097315e-08 35p -1.477499e-08 35.1p -9.525703e-09 35.2p -5.593960e-09 35.3p -3.233303e-09 35.4p -2.563696e-09 35.5p -3.564477e-09 35.6p -6.078993e-09 35.7p -9.830320e-09 35.8p -1.444652e-08 35.9p -1.949320e-08 36p -2.451049e-08
+ 36.1p -2.905141e-08 36.2p -3.271833e-08 36.3p -3.519463e-08 36.4p -3.626907e-08 36.5p -3.585091e-08 36.6p -3.397490e-08 36.7p -3.079574e-08 36.8p -2.657279e-08 36.9p -2.164652e-08 37p -1.640874e-08 37.1p -1.126927e-08 37.2p -6.621767e-09 37.3p -2.811692e-09 37.4p -1.088510e-10 37.5p 1.313214e-09 37.6p 1.389498e-09 37.7p 1.666187e-10 37.8p -2.203345e-09
+ 37.9p -5.477555e-09 38p -9.344270e-09 38.1p -1.344992e-08 38.2p -1.742908e-08 38.3p -2.093473e-08 38.4p -2.366649e-08 38.5p -2.539434e-08 38.6p -2.597611e-08 38.7p -2.536732e-08 38.8p -2.362286e-08 38.9p -2.089039e-08 39p -1.739619e-08 39.1p -1.342497e-08 39.2p -9.295134e-09 39.3p -5.331914e-09 39.4p -1.840416e-09 39.5p 9.190546e-10 39.6p 2.751489e-09
+ 39.7p 3.541862e-09 39.8p 3.262930e-09 39.9p 1.975656e-09 40p -1.776378e-10 40.1p -2.986655e-09 40.2p -6.191832e-09 40.3p -9.506701e-09 40.4p -1.264201e-08 40.5p -1.532957e-08 40.6p -1.734389e-08 40.7p -1.851984e-08 40.8p -1.876498e-08 40.9p -1.806567e-08 41p -1.648654e-08 41.1p -1.416356e-08 41.2p -1.129134e-08 41.3p -8.105885e-09 41.4p -4.864335e-09
+ 41.5p -1.823332e-09 41.6p 7.820815e-10 41.7p 2.757352e-09 41.8p 3.963584e-09 41.9p 4.327805e-09 42p 3.847605e-09 42.1p 2.589865e-09 42.2p 6.838298e-10 42.3p -1.690818e-09 42.4p -4.319772e-09 42.5p -6.972441e-09 42.6p -9.421249e-09 42.7p -1.146028e-08 42.8p -1.292178e-08 42.9p -1.368914e-08 43p -1.370544e-08 43.1p -1.297688e-08 43.2p -1.157095e-08
+ 43.3p -9.609606e-09 43.4p -7.258105e-09 43.5p -4.710480e-09 43.6p -2.172990e-09 43.7p 1.531087e-10 43.8p 2.088009e-09 43.9p 3.487699e-09 44p 4.255050e-09 44.1p 4.346831e-09 44.2p 3.776128e-09 44.3p 2.610095e-09 44.4p 9.633014e-10 44.5p -1.012683e-09 44.6p -3.142521e-09 44.7p -5.242028e-09 44.8p -7.133502e-09 44.9p -8.660207e-09 45p -9.698824e-09
+ 45.1p -1.016890e-08 45.2p -1.003857e-08 45.3p -9.326145e-09 45.4p -8.097576e-09 45.5p -6.460003e-09 45.6p -4.552076e-09 45.7p -2.531882e-09 45.8p -5.635181e-10 45.9p 1.196539e-09 46p 2.612158e-09 46.1p 3.578329e-09 46.2p 4.029157e-09 46.3p 3.942466e-09 46.4p 3.340711e-09 46.5p 2.288199e-09 46.6p 8.849218e-10 46.7p -7.424124e-10 46.8p -2.451367e-09
+ 46.9p -4.095828e-09 47p -5.538103e-09 47.1p -6.660085e-09 47.2p -7.372566e-09 47.3p -7.621981e-09 47.4p -7.394078e-09 47.5p -6.714274e-09 47.6p -5.644736e-09 47.7p -4.278505e-09 47.8p -2.731186e-09 47.9p -1.130965e-09 48p 3.922036e-10 48.1p 1.717338e-09 48.2p 2.742196e-09 48.3p 3.391307e-09 48.4p 3.621626e-09 48.5p 3.425407e-09 48.6p 2.830113e-09
+ 48.7p 1.895426e-09 48.8p 7.076741e-10 48.9p -6.278207e-10 49p -1.995798e-09 49.1p -3.280747e-09 49.2p -4.376412e-09 49.3p -5.194345e-09 49.4p -5.670811e-09 49.5p -5.771523e-09 49.6p -5.493851e-09 49.7p -4.866385e-09 49.8p -3.945936e-09 49.9p -2.812276e-09 50p -1.561099e-09 50.1p -2.759833e-06 50.2p -5.020334e-06 50.3p -6.798047e-06 50.4p -8.176786e-06
+ 50.5p -9.268105e-06 50.6p -1.017825e-05 50.7p -1.098506e-05 50.8p -1.172778e-05 50.9p -1.241009e-05 51p -1.301361e-05 51.1p -1.075700e-05 51.2p -8.888524e-06 51.3p -7.407413e-06 51.4p -6.269239e-06 51.5p -5.421157e-06 51.6p -4.824400e-06 51.7p -4.466097e-06 51.8p -4.360609e-06 51.9p -4.541466e-06 52p -5.046270e-06 52.1p -5.898071e-06 52.2p -7.087468e-06
+ 52.3p -8.559770e-06 52.4p -1.021079e-05 52.5p -1.189318e-05 52.6p -1.343288e-05 52.7p -1.465288e-05 52.8p -1.539982e-05 52.9p -1.556840e-05 53p -1.511872e-05 53.1p -1.408369e-05 53.2p -1.256499e-05 53.3p -1.071862e-05 53.4p -8.732531e-06 53.5p -6.800614e-06 53.6p -5.097667e-06 53.7p -3.759883e-06 53.8p -2.873949e-06 53.9p -2.475843e-06 54p -2.558015e-06
+ 54.1p -3.081755e-06 54.2p -3.990547e-06 54.3p -5.220549e-06 54.4p -6.705714e-06 54.5p -8.377188e-06 54.6p -1.015859e-05 54.7p -1.196019e-05 54.8p -1.367554e-05 54.9p -1.518367e-05 55p -1.635870e-05 55.1p -1.708634e-05 55.2p -1.728419e-05 55.3p -1.691990e-05 55.4p -1.602166e-05 55.5p -1.467742e-05 55.6p -1.302275e-05 55.7p -1.122038e-05 55.8p -9.436062e-06
+ 55.9p -7.816298e-06 56p -6.471974e-06 56.1p -5.470855e-06 56.2p -4.839206e-06 56.3p -4.570707e-06 56.4p -4.639076e-06 56.5p -5.010127e-06 56.6p -5.649553e-06 56.7p -6.524396e-06 56.8p -7.598392e-06 56.9p -8.823604e-06 57p -1.013213e-05 57.1p -1.143186e-05 57.2p -1.260906e-05 57.3p -1.353873e-05 57.4p -1.410103e-05 57.5p -1.420068e-05 57.6p -1.378479e-05
+ 57.7p -1.285507e-05 57.8p -1.147138e-05 57.9p -9.745423e-06 58p -7.825770e-06 58.1p -5.877042e-06 58.2p -4.057603e-06 58.3p -2.500130e-06 58.4p -1.298603e-06 58.5p -5.034778e-07 58.6p -1.247335e-07 58.7p -1.405513e-07 58.8p -5.083072e-07 58.9p -1.174445e-06 59p -2.080734e-06 59.1p -3.166025e-06 59.2p -4.364391e-06 59.3p -5.601848e-06 59.4p -6.794389e-06
+ 59.5p -7.849575e-06 59.6p -8.672727e-06 59.7p -9.177201e-06 59.8p -9.296840e-06 59.9p -8.997810e-06 60p -8.286959e-06 60.1p -4.454882e-06 60.2p -8.454687e-07 60.3p 2.445273e-06 60.4p 5.381214e-06 60.5p 7.959931e-06 60.6p 1.019019e-05 60.7p 1.207277e-05 60.8p 1.358783e-05 60.9p 1.469224e-05 61p 1.532828e-05 61.1p 1.268327e-05 61.2p 9.991839e-06
+ 61.3p 7.273133e-06 61.4p 4.552268e-06 61.5p 1.903559e-06 61.6p -5.331514e-07 61.7p -2.562291e-06 61.8p -3.964205e-06 61.9p -4.539869e-06 62p -4.157503e-06 62.1p -2.790113e-06 62.2p -5.351794e-07 62.3p 2.388676e-06 62.4p 5.668430e-06 62.5p 8.941968e-06 62.6p 1.185252e-05 62.7p 1.410041e-05 62.8p 1.548104e-05 62.9p 1.590238e-05 63p 1.538087e-05
+ 63.1p 1.402080e-05 63.2p 1.198555e-05 63.3p 9.469695e-06 63.4p 6.677750e-06 63.5p 3.811559e-06 63.6p 1.064086e-06 63.7p -1.384301e-06 63.8p -3.370735e-06 63.9p -4.757763e-06 64p -5.443977e-06 64.1p -5.375502e-06 64.2p -4.555776e-06 64.3p -3.050987e-06 64.4p -9.889215e-07 64.5p 1.450199e-06 64.6p 4.050907e-06 64.7p 6.585795e-06 64.8p 8.841128e-06
+ 64.9p 1.063982e-05 65p 1.185727e-05 65.1p 1.242752e-05 65.2p 1.234005e-05 65.3p 1.163026e-05 65.4p 1.036796e-05 65.5p 8.648094e-06 65.6p 6.585400e-06 65.7p 4.312634e-06 65.8p 1.979470e-06 65.9p -2.511682e-07 66p -2.211704e-06 66.1p -3.743752e-06 66.2p -4.715415e-06 66.3p -5.038786e-06 66.4p -4.683996e-06 66.5p -3.686702e-06 66.6p -2.147061e-06
+ 66.7p -2.197706e-07 66.8p 1.903625e-06 66.9p 4.017484e-06 67p 5.926116e-06 67.1p 7.465069e-06 67.2p 8.516243e-06 67.3p 9.014978e-06 67.4p 8.949205e-06 67.5p 8.352607e-06 67.6p 7.294704e-06 67.7p 5.870733e-06 67.8p 4.193220e-06 67.9p 2.385645e-06 68p 5.773580e-07 68.1p -1.101689e-06 68.2p -2.527653e-06 68.3p -3.591352e-06 68.4p -4.208034e-06
+ 68.5p -4.326888e-06 68.6p -3.938400e-06 68.7p -3.077798e-06 68.8p -1.823386e-06 68.9p -2.894850e-07 69p 1.385286e-06 69.1p 3.052686e-06 69.2p 4.570195e-06 69.3p 5.814653e-06 69.4p 6.692332e-06 69.5p 7.144522e-06 69.6p 7.148811e-06 69.7p 6.717076e-06 69.8p 5.891585e-06 69.9p 4.740361e-06 70p 3.352402e-06 70.1p 7.494541e-06 70.2p 1.068249e-05
+ 70.3p 1.311254e-05 70.4p 1.510720e-05 70.5p 1.701756e-05 70.6p 1.914467e-05 70.7p 2.168410e-05 70.8p 2.470055e-05 70.9p 2.813502e-05 71p 3.183965e-05 71.1p 2.996846e-05 71.2p 2.895451e-05 71.3p 2.861145e-05 71.4p 2.869509e-05 71.5p 2.898049e-05 71.6p 2.929978e-05 71.7p 2.955043e-05 71.8p 2.968274e-05 71.9p 2.967625e-05 72p 2.951502e-05
+ 72.1p 2.916955e-05 72.2p 2.858916e-05 72.3p 2.770546e-05 72.4p 2.644430e-05 72.5p 2.474189e-05 72.6p 2.256081e-05 72.7p 1.990181e-05 72.8p 1.680936e-05 72.9p 1.337016e-05 73p 9.705717e-06 73.1p 5.960742e-06 73.2p 2.289906e-06 73.3p -1.155130e-06 73.4p -4.236856e-06 73.5p -6.840571e-06 73.6p -8.880552e-06 73.7p -1.030405e-05 73.8p -1.109343e-05
+ 73.9p -1.126643e-05 74p -1.087428e-05 74.1p -9.997300e-06 74.2p -8.737589e-06 74.3p -7.209334e-06 74.4p -5.527461e-06 74.5p -3.796051e-06 74.6p -2.098004e-06 74.7p -4.873063e-07 74.8p 1.015084e-06 74.9p 2.421133e-06 75p 3.771171e-06 75.1p 5.125041e-06 75.2p 6.549707e-06 75.3p 8.104710e-06 75.4p 9.827615e-06 75.5p 1.172203e-05 75.6p 1.375074e-05
+ 75.7p 1.583577e-05 75.8p 1.786591e-05 75.9p 1.971074e-05 76p 2.123880e-05 76.1p 2.233658e-05 76.2p 2.292519e-05 76.3p 2.297182e-05 76.4p 2.249443e-05 76.5p 2.155940e-05 76.6p 2.027301e-05 76.7p 1.876848e-05 76.8p 1.719051e-05 76.9p 1.567927e-05 77p 1.435541e-05 77.1p 1.330747e-05 77.2p 1.258285e-05 77.3p 1.218362e-05 77.4p 1.206795e-05
+ 77.5p 1.215785e-05 77.6p 1.235246e-05 77.7p 1.254516e-05 77.8p 1.264181e-05 77.9p 1.257658e-05 78p 1.232277e-05 78.1p 1.189642e-05 78.2p 1.135256e-05 78.3p 1.077497e-05 78.4p 1.026167e-05 78.5p 9.908649e-06 78.6p 9.794707e-06 78.7p 9.969429e-06 78.8p 1.044603e-05 78.9p 1.119971e-05 79p 1.217145e-05 79.1p 1.327621e-05 79.2p 1.441413e-05
+ 79.3p 1.548266e-05 79.4p 1.638783e-05 79.5p 1.705302e-05 79.6p 1.742432e-05 79.7p 1.747221e-05 79.8p 1.719003e-05 79.9p 1.659033e-05 80p 1.570023e-05 80.1p 8.895204e-06 80.2p 2.802840e-06 80.3p -2.640773e-06 80.4p -7.639930e-06 80.5p -1.243439e-05 80.6p -1.720493e-05 80.7p -2.200113e-05 80.8p -2.671085e-05 80.9p -3.108596e-05 81p -3.482529e-05
+ 81.1p -3.203284e-05 81.2p -2.925529e-05 81.3p -2.660134e-05 81.4p -2.425644e-05 81.5p -2.245558e-05 81.6p -2.139501e-05 81.7p -2.113933e-05 81.8p -2.156892e-05 81.9p -2.239090e-05 82p -2.321121e-05 82.1p -2.364408e-05 82.2p -2.342354e-05 82.3p -2.248123e-05 82.4p -2.096489e-05 82.5p -1.919063e-05 82.6p -1.754343e-05 82.7p -1.635757e-05 82.8p -1.581586e-05
+ 82.9p -1.589833e-05 83p -1.639366e-05 83.1p -1.696512e-05 83.2p -1.724740e-05 83.3p -1.694472e-05 83.4p -1.590394e-05 83.5p -1.414747e-05 83.6p -1.186275e-05 83.7p -9.356492e-06 83.8p -6.988682e-06 83.9p -5.102928e-06 84p -3.967635e-06 84.1p -3.737286e-06 84.2p -4.437491e-06 84.3p -5.972462e-06 84.4p -8.150081e-06 84.5p -1.071771e-05 84.6p -1.340120e-05
+ 84.7p -1.594029e-05 84.8p -1.811512e-05 84.9p -1.976168e-05 85p -2.077648e-05 85.1p -2.111289e-05 85.2p -2.077260e-05 85.3p -1.979528e-05 85.4p -1.824901e-05 85.5p -1.622277e-05 85.6p -1.382139e-05 85.7p -1.116304e-05 85.8p -8.378144e-06 85.9p -5.608971e-06 86p -3.007790e-06 86.1p -7.316704e-07 86.2p 1.067939e-06 86.3p 2.260993e-06 86.4p 2.757671e-06
+ 86.5p 2.525585e-06 86.6p 1.599906e-06 86.7p 8.252392e-08 86.8p -1.870277e-06 86.9p -4.068414e-06 87p -6.311307e-06 87.1p -8.408439e-06 87.2p -1.019407e-05 87.3p -1.153637e-05 87.4p -1.234383e-05 87.5p -1.257203e-05 87.6p -1.223129e-05 87.7p -1.139233e-05 87.8p -1.018399e-05 87.9p -8.778232e-06 88p -7.361887e-06 88.1p -6.100556e-06 88.2p -5.104744e-06
+ 88.3p -4.409089e-06 88.4p -3.972143e-06 88.5p -3.697858e-06 88.6p -3.472994e-06 88.7p -3.209347e-06 88.8p -2.877560e-06 88.9p -2.521100e-06 89p -2.244666e-06 89.1p -2.179365e-06 89.2p -2.435165e-06 89.3p -3.056170e-06 89.4p -3.993856e-06 89.5p -5.107484e-06 89.6p -6.191692e-06 89.7p -7.022514e-06 89.8p -7.408069e-06 89.9p -7.230061e-06 90p -6.466528e-06
+ 90.1p -2.433114e-06 90.2p 1.458941e-06 90.3p 5.022013e-06 90.4p 8.122833e-06 90.5p 1.067344e-05 90.6p 1.262361e-05 90.7p 1.395386e-05 90.8p 1.467078e-05 90.9p 1.480510e-05 91p 1.441214e-05 91.1p 1.081348e-05 91.2p 7.375103e-06 91.3p 4.218765e-06 91.4p 1.423361e-06 91.5p -9.405768e-07 91.6p -2.790169e-06 91.7p -4.024697e-06 91.8p -4.535927e-06
+ 91.9p -4.230898e-06 92p -3.060255e-06 92.1p -1.043709e-06 92.2p 1.715028e-06 92.3p 5.028482e-06 92.4p 8.641459e-06 92.5p 1.225950e-05 92.6p 1.558381e-05 92.7p 1.834602e-05 92.8p 2.033711e-05 92.9p 2.142669e-05 93p 2.157094e-05 93.1p 2.081003e-05 93.2p 1.925731e-05 93.3p 1.708335e-05 93.4p 1.449675e-05 93.5p 1.172222e-05 93.6p 8.977461e-06
+ 93.7p 6.452913e-06 93.8p 4.299331e-06 93.9p 2.626479e-06 94p 1.511511e-06 94.1p 1.011143e-06 94.2p 1.169671e-06 94.3p 2.016689e-06 94.4p 3.553491e-06 94.5p 5.733314e-06 94.6p 8.444740e-06 94.7p 1.150725e-05 94.8p 1.468326e-05 94.9p 1.770443e-05 95p 2.030496e-05 95.1p 2.225366e-05 95.2p 2.337955e-05 95.3p 2.359038e-05 95.4p 2.288605e-05
+ 95.5p 2.136784e-05 95.6p 1.923943e-05 95.7p 1.679227e-05 95.8p 1.436954e-05 95.9p 1.231053e-05 96p 1.088634e-05 96.1p 1.024388e-05 96.2p 1.037465e-05 96.3p 1.111817e-05 96.4p 1.220056e-05 96.5p 1.329888e-05 96.6p 1.411584e-05 96.7p 1.444682e-05 96.8p 1.422377e-05 96.9p 1.352576e-05 97p 1.255379e-05 97.1p 1.157568e-05 97.2p 1.085413e-05
+ 97.3p 1.057559e-05 97.4p 1.079803e-05 97.5p 1.143115e-05 97.6p 1.225396e-05 97.7p 1.296519e-05 97.8p 1.325315e-05 97.9p 1.286797e-05 98p 1.167925e-05 98.1p 9.707110e-06 98.2p 7.121381e-06 98.3p 4.210962e-06 98.4p 1.331464e-06 98.5p -1.157196e-06 98.6p -2.950491e-06 98.7p -3.845135e-06 98.8p -3.763574e-06 98.9p -2.754489e-06 99p -9.717196e-07
+ 99.1p 1.361809e-06 99.2p 3.996198e-06 99.3p 6.693495e-06 99.4p 9.256098e-06 99.5p 1.154060e-05 99.6p 1.345710e-05 99.7p 1.495743e-05 99.8p 1.601815e-05 99.9p 1.662471e-05 100p 1.676161e-05 100.1p 1.365170e-05 100.2p 1.053618e-05 100.3p 7.395833e-06 100.4p 4.166774e-06 100.5p 7.923723e-07 100.6p -2.736268e-06 100.7p -6.354349e-06 100.8p -9.915758e-06
+ 100.9p -1.320533e-05 101p -1.596978e-05 101.1p -1.520363e-05 101.2p -1.397822e-05 101.3p -1.220147e-05 101.4p -9.852815e-06 101.5p -7.027051e-06 101.6p -3.938088e-06 101.7p -8.878056e-07 101.8p 1.788010e-06 101.9p 3.780155e-06 102p 4.857876e-06 102.1p 4.903101e-06 102.2p 3.924788e-06 102.3p 2.055508e-06 102.4p -4.667462e-07 102.5p -3.329477e-06 102.6p -6.187382e-06
+ 102.7p -8.710732e-06 102.8p -1.063283e-05 102.9p -1.178662e-05 103p -1.212142e-05 103.1p -1.169559e-05 103.2p -1.064747e-05 103.3p -9.153762e-06 103.4p -7.387881e-06 103.5p -5.490409e-06 103.6p -3.558856e-06 103.7p -1.656734e-06 103.8p 1.648478e-07 103.9p 1.843651e-06 104p 3.290928e-06 104.1p 4.390324e-06 104.2p 5.011695e-06 104.3p 5.035768e-06 104.4p 4.382784e-06
+ 104.5p 3.037831e-06 104.6p 1.066734e-06 104.7p -1.381399e-06 104.8p -4.086276e-06 104.9p -6.781704e-06 105p -9.190065e-06 105.1p -1.106002e-05 105.2p -1.220068e-05 105.3p -1.250604e-05 105.4p -1.196567e-05 105.5p -1.066028e-05 105.6p -8.744365e-06 105.7p -6.420089e-06 105.8p -3.908274e-06 105.9p -1.421859e-06 106p 8.540469e-07 106.1p 2.773679e-06 106.2p 4.234114e-06
+ 106.3p 5.172976e-06 106.4p 5.563349e-06 106.5p 5.408719e-06 106.6p 4.739638e-06 106.7p 3.612434e-06 106.8p 2.108963e-06 106.9p 3.357538e-07 107p -1.579062e-06 107.1p -3.491989e-06 107.2p -5.253640e-06 107.3p -6.720634e-06 107.4p -7.768627e-06 107.5p -8.304885e-06 107.6p -8.278823e-06 107.7p -7.688994e-06 107.8p -6.585290e-06 107.9p -5.065481e-06 108p -3.266052e-06
+ 108.1p -1.348250e-06 108.2p 5.187692e-07 108.3p 2.175188e-06 108.4p 3.485764e-06 108.5p 4.351327e-06 108.6p 4.715820e-06 108.7p 4.569012e-06 108.8p 3.945392e-06 108.9p 2.919636e-06 109p 1.598818e-06 109.1p 1.115059e-07 109.2p -1.405562e-06 109.3p -2.821751e-06 109.4p -4.025556e-06 109.5p -4.934086e-06 109.6p -5.497417e-06 109.7p -5.697563e-06 109.8p -5.543339e-06
+ 109.9p -5.063438e-06 110p -4.300289e-06 110.1p -4.754735e-07 110.2p 3.050398e-06 110.3p 6.246250e-06 110.4p 9.136834e-06 110.5p 1.176002e-05 110.6p 1.413700e-05 110.7p 1.625703e-05 110.8p 1.807924e-05 110.9p 1.955089e-05 111p 2.063787e-05 111.1p 1.852811e-05 111.2p 1.661634e-05 111.3p 1.503869e-05 111.4p 1.392428e-05 111.5p 1.339638e-05 111.6p 1.355478e-05
+ 111.7p 1.445373e-05 111.8p 1.608625e-05 111.9p 1.838165e-05 112p 2.121764e-05 112.1p 2.444395e-05 112.2p 2.791064e-05 112.3p 3.149342e-05 112.4p 3.510862e-05 112.5p 3.871262e-05 112.6p 4.228309e-05 112.7p 4.578189e-05 112.8p 4.910393e-05 112.9p 5.202371e-05 113p 5.416328e-05 113.1p 5.501548e-05 113.2p 5.404874e-05 113.3p 5.088192e-05 113.4p 4.546628e-05
+ 113.5p 3.818902e-05 113.6p 2.984254e-05 113.7p 2.146497e-05 113.8p 1.411023e-05 113.9p 8.624125e-06 114p 5.488870e-06 114.1p 4.766038e-06 114.2p 6.133444e-06 114.3p 8.986547e-06 114.4p 1.256708e-05 114.5p 1.609155e-05 114.6p 1.886825e-05 114.7p 2.039522e-05 114.8p 2.042421e-05 114.9p 1.897892e-05 115p 1.633196e-05 115.1p 1.295661e-05 115.2p 9.466145e-06
+ 115.3p 6.542243e-06 115.4p 4.847699e-06 115.5p 4.920356e-06 115.6p 7.050927e-06 115.7p 1.114969e-05 115.8p 1.661388e-05 115.9p 2.224408e-05 116p 2.632803e-05 116.1p 2.702190e-05 116.2p 2.298448e-05 116.3p 1.396902e-05 116.4p 1.042500e-06 116.5p -1.367428e-05 116.6p -2.760022e-05 116.7p -3.836546e-05 116.8p -4.433752e-05 116.9p -4.487918e-05 117p -4.032506e-05
+ 117.1p -3.174856e-05 117.2p -2.063262e-05 117.3p -8.550098e-06 117.4p 3.081306e-06 117.5p 1.315026e-05 117.6p 2.091632e-05 117.7p 2.600566e-05 117.8p 2.835897e-05 117.9p 2.815149e-05 118p 2.570896e-05 118.1p 2.145277e-05 118.2p 1.590472e-05 118.3p 9.746366e-06 118.4p 3.877584e-06 118.5p -5.995242e-07 118.6p -2.514611e-06 118.7p -8.708527e-07 118.8p 4.854013e-06
+ 118.9p 1.441710e-05 119p 2.663491e-05 119.1p 3.947593e-05 119.2p 5.053073e-05 119.3p 5.774381e-05 119.4p 6.006391e-05 119.5p 5.770150e-05 119.6p 5.192997e-05 119.7p 4.459017e-05 119.8p 3.753143e-05 119.9p 3.217461e-05 120p 2.928751e-05 120.1p 2.614119e-05 120.2p 2.561047e-05 120.3p 2.691305e-05 120.4p 2.908828e-05 120.5p 3.120469e-05 120.6p 3.250598e-05
+ 120.7p 3.250136e-05 120.8p 3.100161e-05 120.9p 2.809445e-05 121p 2.405857e-05 121.1p 2.207116e-05 121.2p 1.912659e-05 121.3p 1.544066e-05 121.4p 1.118810e-05 121.5p 6.530025e-06 121.6p 1.666078e-06 121.7p -3.138054e-06 121.8p -7.572515e-06 121.9p -1.134686e-05 122p -1.426631e-05 122.1p -1.628775e-05 122.2p -1.753286e-05 122.3p -1.825122e-05 122.4p -1.874144e-05
+ 122.5p -1.924930e-05 122.6p -1.986999e-05 122.7p -2.048839e-05 122.8p -2.079231e-05 122.9p -2.037600e-05 123p -1.890999e-05 123.1p -1.630937e-05 123.2p -1.282340e-05 123.3p -9.006199e-06 123.4p -5.585438e-06 123.5p -3.285523e-06 123.6p -2.668283e-06 123.7p -4.032455e-06 123.8p -7.381694e-06 123.9p -1.244588e-05 124p -1.873290e-05 124.1p -2.559638e-05 124.2p -3.231737e-05
+ 124.3p -3.820079e-05 124.4p -4.267845e-05 124.5p -4.539846e-05 124.6p -4.627701e-05 124.7p -4.549625e-05 124.8p -4.344832e-05 124.9p -4.064173e-05 125p -3.759696e-05 125.1p -3.475914e-05 125.2p -3.244758e-05 125.3p -3.084798e-05 125.4p -3.003860e-05 125.5p -3.003293e-05 125.6p -3.081967e-05 125.7p -3.238678e-05 125.8p -3.472509e-05 125.9p -3.781502e-05 126p -4.160613e-05
+ 126.1p -4.600106e-05 126.2p -5.085338e-05 126.3p -5.598309e-05 126.4p -6.120507e-05 126.5p -6.635845e-05 126.6p -7.132206e-05 126.7p -7.600595e-05 126.8p -8.031913e-05 126.9p -8.412584e-05 127p -8.721166e-05 127.1p -8.928001e-05 127.2p -8.999109e-05 127.3p -8.903881e-05 127.4p -8.624588e-05 127.5p -8.164847e-05 127.6p -7.554332e-05 127.7p -6.848110e-05 127.8p -6.120478e-05
+ 127.9p -5.454542e-05 128p -4.929613e-05 128.1p -4.608768e-05 128.2p -4.528776e-05 128.3p -4.694099e-05 128.4p -5.076054e-05 128.5p -5.617307e-05 128.6p -6.240910e-05 128.7p -6.862105e-05 128.8p -7.400610e-05 128.9p -7.791032e-05 129p -7.989700e-05 129.1p -7.977148e-05 129.2p -7.756569e-05 129.3p -7.349439e-05 129.4p -6.789917e-05 129.5p -6.119575e-05 129.6p -5.383467e-05
+ 129.7p -4.627772e-05 129.8p -3.898515e-05 129.9p -3.240448e-05 130p -2.695261e-05 130.1p -2.298755e-05 130.2p -2.077231e-05 130.3p -2.043844e-05 130.4p -2.195880e-05 130.5p -2.513726e-05 130.6p -2.961964e-05 130.7p -3.492570e-05 130.8p -4.049791e-05 130.9p -4.576058e-05 131p -5.018118e-05 131.1p -5.332575e-05 131.2p -5.490111e-05 131.3p -5.477858e-05 131.4p -5.299682e-05
+ 131.5p -4.974468e-05 131.6p -4.532825e-05 131.7p -4.012848e-05 131.8p -3.455666e-05 131.9p -2.901415e-05 132p -2.386090e-05 132.1p -1.939443e-05 132.2p -1.583852e-05 132.3p -1.333939e-05 132.4p -1.196651e-05 132.5p -1.171577e-05 132.6p -1.251387e-05 132.7p -1.422408e-05 132.8p -1.665406e-05 132.9p -1.956698e-05 133p -2.269618e-05 133.1p -2.576336e-05 133.2p -2.849885e-05
+ 133.3p -3.066212e-05 133.4p -3.206056e-05 133.5p -3.256436e-05 133.6p -3.211612e-05 133.7p -3.073456e-05 133.8p -2.851192e-05 133.9p -2.560562e-05 134p -2.222473e-05 134.1p -1.861257e-05 134.2p -1.502649e-05 134.3p -1.171670e-05 134.4p -8.905904e-06 134.5p -6.771505e-06 134.6p -5.431868e-06 134.7p -4.937766e-06 134.8p -5.269580e-06 134.9p -6.340548e-06 135p -8.005993e-06
+ 135.1p -1.007807e-05 135.2p -1.234481e-05 135.3p -1.459154e-05 135.4p -1.662171e-05 135.5p -1.827421e-05 135.6p -1.943440e-05 135.7p -2.003776e-05 135.8p -2.006639e-05 135.9p -1.954088e-05 136p -1.851057e-05 136.1p -1.704539e-05 136.2p -1.523119e-05 136.3p -1.316849e-05 136.4p -1.097282e-05 136.5p -8.773876e-06 136.6p -6.711140e-06 136.7p -4.924729e-06 136.8p -3.542363e-06
+ 136.9p -2.664636e-06 137p -2.351540e-06 137.1p -2.612924e-06 137.2p -3.404741e-06 137.3p -4.631825e-06 137.4p -6.156964e-06 137.5p -7.815247e-06 137.6p -9.432002e-06 137.7p -1.084213e-05 137.8p -1.190821e-05 137.9p -1.253473e-05 138p -1.267631e-05 138.1p -1.233874e-05 138.2p -1.157311e-05 138.3p -1.046465e-05 138.4p -9.118897e-06 138.5p -7.648039e-06 138.6p -6.159766e-06
+ 138.7p -4.749974e-06 138.8p -3.499314e-06 138.9p -2.472590e-06 139p -1.719454e-06 139.1p -1.274890e-06 139.2p -1.158561e-06 139.3p -1.372863e-06 139.4p -1.900317e-06 139.5p -2.701408e-06 139.6p -3.714109e-06 139.7p -4.856067e-06 139.8p -6.029859e-06 139.9p -7.131070e-06 140p -8.058283e-06 140.1p -8.723582e-06 140.2p -9.062016e-06 140.3p -9.038572e-06 140.4p -8.651643e-06
+ 140.5p -7.932562e-06 140.6p -6.941414e-06 140.7p -5.759934e-06 140.8p -4.482621e-06 140.9p -3.207363e-06 141p -2.026717e-06 141.1p -1.020685e-06 141.2p -2.514492e-07 141.3p 2.398421e-07 141.4p 4.343994e-07 141.5p 3.355141e-07 141.6p -3.302493e-08 141.7p -6.295703e-07 141.8p -1.398110e-06 141.9p -2.272431e-06 142p -3.180737e-06 142.1p -4.050505e-06 142.2p -4.813302e-06
+ 142.3p -5.409364e-06 142.4p -5.791706e-06 142.5p -5.929584e-06 142.6p -5.811071e-06 142.7p -5.444486e-06 142.8p -4.858345e-06 142.9p -4.099571e-06 143p -3.229865e-06 143.1p -2.320404e-06 143.2p -1.445341e-06 143.3p -6.748483e-07 143.4p -6.853266e-08 143.5p 3.300123e-07 143.6p 4.969407e-07 143.7p 4.298676e-07 143.8p 1.474815e-07 143.9p -3.128411e-07 144p -8.991687e-07
+ 144.1p -1.550506e-06 144.2p -2.203088e-06 144.3p -2.796771e-06 144.4p -3.280717e-06 144.5p -3.617630e-06 144.6p -3.786024e-06 144.7p -3.780388e-06 144.8p -3.609508e-06 144.9p -3.293580e-06 145p -2.860882e-06 145.1p -2.344716e-06 145.2p -1.781049e-06 145.3p -1.206921e-06 145.4p -6.593472e-07 145.5p -1.742770e-07 145.6p 2.148440e-07 145.7p 4.791237e-07 145.8p 5.968254e-07
+ 145.9p 5.561538e-07 146p 3.576652e-07 146.1p 1.569254e-08 146.2p -4.417025e-07 146.3p -9.745033e-07 146.4p -1.534180e-06 146.5p -2.068436e-06 146.6p -2.526651e-06 146.7p -2.865281e-06 146.8p -3.052463e-06 146.9p -3.071206e-06 147p -2.920775e-06 147.1p -2.616182e-06 147.2p -2.185956e-06 147.3p -1.668631e-06 147.4p -1.108501e-06 147.5p -5.512426e-07 147.6p -3.989107e-08
+ 147.7p 3.884587e-07 147.8p 7.050497e-07 147.9p 8.909336e-07 148p 9.375998e-07 148.1p 8.469001e-07 148.2p 6.304039e-07 148.3p 3.082891e-07 148.4p -9.216944e-08 148.5p -5.384777e-07 148.6p -9.951301e-07 148.7p -1.426085e-06 148.8p -1.797393e-06 148.9p -2.079815e-06 149p -2.251200e-06 149.1p -2.298393e-06 149.2p -2.218429e-06 149.3p -2.018853e-06 149.4p -1.717068e-06
+ 149.5p -1.338743e-06 149.6p -9.154511e-07 149.7p -4.817536e-07 149.8p -7.208052e-08 149.9p 2.822920e-07 150p 5.558562e-07 150.1p 7.308480e-07 150.2p 7.984291e-07 150.3p 7.590086e-07 150.4p 6.217208e-07 150.5p 4.031538e-07 150.6p 1.254928e-07 150.7p -1.856992e-07 150.8p -5.038109e-07 150.9p -8.033698e-07 151p -1.061880e-06 151.1p -1.261181e-06 151.2p -1.388301e-06
+ 151.3p -1.435859e-06 151.4p -1.402132e-06 151.5p -1.290915e-06 151.6p -1.111220e-06 151.7p -8.768493e-07 151.8p -6.057477e-07 151.9p -3.190491e-07 152p -3.973781e-08 152.1p 2.090776e-07 152.2p 4.061724e-07 152.3p 5.342907e-07 152.4p 5.820342e-07 152.5p 5.452678e-07 152.6p 4.278075e-07 152.7p 2.412450e-07 152.8p 3.893854e-09 152.9p -2.610400e-07 153p -5.278458e-07
+ 153.1p -7.709646e-07 153.2p -9.675912e-07 153.3p -1.099910e-06 153.4p -1.156712e-06 153.5p -1.134224e-06 153.6p -1.036106e-06 153.7p -8.726778e-07 153.8p -6.595295e-07 153.9p -4.157482e-07 154p -1.619998e-07 154.1p 8.131149e-08 154.2p 2.956359e-07 154.3p 4.655250e-07 154.4p 5.795019e-07 154.5p 6.305735e-07 154.6p 6.164347e-07 154.7p 5.394139e-07 154.8p 4.061981e-07
+ 154.9p 2.273542e-07 155p 1.664783e-08 155.1p -2.098425e-07 155.2p -4.348043e-07 155.3p -6.409250e-07 155.4p -8.122061e-07 155.5p -9.352534e-07 155.6p -1.000417e-06 155.7p -1.002650e-06 155.8p -9.419856e-07 155.9p -8.235503e-07 156p -6.571145e-07 156.1p -4.562079e-07 156.2p -2.369019e-07 156.3p -1.638586e-08 156.4p 1.885117e-07 156.5p 3.627096e-07 156.6p 4.940422e-07
+ 156.7p 5.741151e-07 156.8p 5.987967e-07 156.9p 5.683354e-07 157p 4.871263e-07 157.1p 3.631841e-07 157.2p 2.073899e-07 157.3p 3.258992e-08 157.4p -1.473827e-07 157.5p -3.187002e-07 157.6p -4.684967e-07 157.7p -5.857493e-07 157.8p -6.620448e-07 157.9p -6.921944e-07 158p -6.746515e-07 158.1p -6.116842e-07 158.2p -5.092584e-07 158.3p -3.766066e-07 158.4p -2.254839e-07
+ 158.5p -6.915605e-08 158.6p 7.879636e-08 158.7p 2.057381e-07 158.8p 3.011676e-07 158.9p 3.576988e-07 159p 3.717240e-07 159.1p 3.436846e-07 159.2p 2.779254e-07 159.3p 1.821543e-07 159.4p 6.657847e-08 159.5p -5.718112e-08 159.6p -1.772698e-07 159.7p -2.827432e-07 159.8p -3.645521e-07 159.9p -4.162712e-07 160p -4.345123e-07 160.1p -4.190065e-07 160.2p -3.723818e-07
+ 160.3p -2.997021e-07 160.4p -2.078489e-07 160.5p -1.048372e-07 160.6p 8.621871e-10 160.7p 1.009372e-07 160.8p 1.877633e-07 160.9p 2.548395e-07 161p 2.971441e-07 161.1p 3.114169e-07 161.2p 2.963736e-07 161.3p 2.528366e-07 161.4p 1.837611e-07 161.5p 9.412437e-08 161.6p -9.345040e-09 161.7p -1.186084e-07 161.8p -2.249134e-07 161.9p -3.195056e-07 162p -3.943890e-07
+ 162.1p -4.430576e-07 162.2p -4.611128e-07 162.3p -4.466943e-07 162.4p -4.006724e-07 162.5p -3.265782e-07 162.6p -2.302809e-07 162.7p -1.194519e-07 162.8p -2.875126e-09 162.9p 1.103214e-07 163p 2.114346e-07 163.1p 2.928884e-07 163.2p 3.488090e-07 163.3p 3.754379e-07 163.4p 3.713583e-07 163.5p 3.375342e-07 163.6p 2.771693e-07 163.7p 1.954070e-07 163.8p 9.889887e-08
+ 163.9p -4.726728e-09 164p -1.074581e-07 164.1p -2.015162e-07 164.2p -2.799505e-07 164.3p -3.371708e-07 164.4p -3.693723e-07 164.5p -3.748176e-07 164.6p -3.539469e-07 164.7p -3.093036e-07 164.8p -2.452787e-07 164.9p -1.676949e-07 165p -8.327091e-08 165.1p 9.825664e-10 165.2p 7.837673e-08 165.3p 1.431080e-07 165.4p 1.907187e-07 165.5p 2.184156e-07 165.6p 2.252210e-07
+ 165.7p 2.119522e-07 165.8p 1.810412e-07 165.9p 1.362214e-07 166p 8.212264e-08 166.1p 2.381852e-08 166.2p -3.362417e-08 166.3p -8.555401e-08 166.4p -1.280680e-07 166.5p -1.582507e-07 166.6p -1.743132e-07 166.7p -1.756394e-07 166.8p -1.627529e-07 166.9p -1.372217e-07 167p -1.015146e-07 167.1p -5.881990e-08 167.2p -1.283140e-08 167.3p 3.249798e-08 167.4p 7.323067e-08
+ 167.5p 1.057398e-07 167.6p 1.270090e-07 167.7p 1.349128e-07 167.8p 1.284453e-07 167.9p 1.078671e-07 168p 7.474067e-08 168.1p 3.184019e-08 168.2p -1.706764e-08 168.3p -6.755469e-08 168.4p -1.149433e-07 168.5p -1.547554e-07 168.6p -1.831488e-07 168.7p -1.972929e-07 168.8p -1.956422e-07 168.9p -1.780795e-07 169p -1.459162e-07 169.1p -1.017541e-07 169.2p -4.922923e-08
+ 169.3p 7.333252e-09 169.4p 6.331309e-08 169.5p 1.141988e-07 169.6p 1.559638e-07 169.7p 1.853834e-07 169.8p 2.002702e-07 169.9p 1.996150e-07 170p 1.836278e-07 170.1p 1.536848e-07 170.2p 1.121889e-07 170.3p 6.236051e-08 170.4p 7.975841e-09 170.5p -4.692693e-08 170.6p -9.835262e-08 170.7p -1.426436e-07 170.8p -1.767432e-07 170.9p -1.984103e-07 171p -2.063681e-07
+ 171.1p -2.003780e-07 171.2p -1.812329e-07 171.3p -1.506706e-07 171.4p -1.112165e-07 171.5p -6.596869e-08 171.6p -1.834430e-08 171.7p 2.819005e-08 171.8p 7.038222e-08 171.9p 1.054306e-07 172p 1.311743e-07 172.1p 1.462256e-07 172.2p 1.500349e-07 172.3p 1.428912e-07 172.4p 1.258595e-07 172.5p 1.006665e-07 172.6p 6.954609e-08 172.7p 3.505914e-08 172.8p -1.001962e-10
+ 172.9p -3.329824e-08 173p -6.214532e-08 173.1p -8.465963e-08 173.2p -9.940290e-08 173.3p -1.055800e-07 173.4p -1.030951e-07 173.5p -9.255742e-08 173.6p -7.523303e-08 173.7p -5.294076e-08 173.8p -2.789730e-08 173.9p -2.521095e-09 174p 2.078867e-08 174.1p 3.987719e-08 174.2p 5.304003e-08 174.3p 5.918720e-08 174.4p 5.794623e-08 174.5p 4.969193e-08 174.6p 3.549883e-08
+ 174.7p 1.702148e-08 174.8p -3.683746e-09 174.9p -2.437496e-08 175p -4.285489e-08 175.1p -5.718976e-08 175.2p -6.589394e-08 175.3p -6.806246e-08 175.4p -6.344015e-08 175.5p -5.242398e-08 175.6p -3.600260e-08 175.7p -1.564363e-08 175.8p 6.856241e-09 175.9p 2.954108e-08 176p 5.046806e-08 176.1p 6.786708e-08 176.2p 8.027567e-08 176.3p 8.664133e-08 176.4p 8.638723e-08
+ 176.5p 7.944067e-08 176.6p 6.622618e-08 176.7p 4.762640e-08 176.8p 2.491516e-08 176.9p -3.327941e-10 177p -2.635038e-08 177.1p -5.129927e-08 177.2p -7.339716e-08 177.3p -9.104369e-08 177.4p -1.029367e-07 177.5p -1.081704e-07 177.6p -1.063068e-07 177.7p -9.741450e-08 177.8p -8.206899e-08 177.9p -6.131486e-08 178p -3.659037e-08 178.1p -9.620949e-09 178.2p 1.771015e-08
+ 178.3p 4.350349e-08 178.4p 6.598559e-08 178.5p 8.364014e-08 178.6p 9.531812e-08 178.7p 1.003183e-07 178.8p 9.843309e-08 178.9p 8.995591e-08 179p 7.565165e-08 179.1p 5.669166e-08 179.2p 3.455914e-08 179.3p 1.093196e-08 179.4p -1.244835e-08 179.5p -3.391154e-08 179.6p -5.198691e-08 179.7p -6.551463e-08 179.8p -7.373076e-08 179.9p -7.631837e-08 180p -7.342005e-08
+ 180.1p -6.561045e-08 180.2p -5.383144e-08 180.3p -3.929605e-08 180.4p -2.337078e-08 180.5p -7.448033e-09 180.6p 7.178649e-09 180.7p 1.942443e-08 180.8p 2.849778e-08 180.9p 3.395268e-08 181p 3.570494e-08 181.1p 3.401306e-08 181.2p 2.942799e-08 181.3p 2.271872e-08 181.4p 1.478312e-08 181.5p 6.553892e-09 181.6p -1.090741e-09 181.7p -7.403373e-09 181.8p -1.182488e-08
+ 181.9p -1.401968e-08 182p -1.388824e-08 182.1p -1.155849e-08 182.2p -7.359721e-09 182.3p -1.783320e-09 182.4p 4.565057e-09 182.5p 1.101762e-08 182.6p 1.689753e-08 182.7p 2.157023e-08 182.8p 2.449112e-08 182.9p 2.524771e-08 183p 2.359442e-08 183.1p 1.947805e-08 183.2p 1.305142e-08 183.3p 4.672932e-09 183.4p -5.109806e-09 183.5p -1.559299e-08 183.6p -2.596550e-08
+ 183.7p -3.537101e-08 183.8p -4.297867e-08 183.9p -4.805636e-08 184p -5.003955e-08 184.1p -4.858857e-08 184.2p -4.362812e-08 184.3p -3.536435e-08 184.4p -2.427706e-08 184.5p -1.108717e-08 184.6p 3.297855e-09 184.7p 1.785570e-08 184.8p 3.153155e-08 184.9p 4.332359e-08 185p 5.236387e-08 185.1p 5.798768e-08 185.2p 5.978552e-08 185.3p 5.763352e-08 185.4p 5.170015e-08
+ 185.5p 4.242932e-08 185.6p 3.050171e-08 185.7p 1.677808e-08 185.8p 2.229746e-09 185.9p -1.213772e-08 186p -2.536120e-08 186.1p -3.659076e-08 186.2p -4.514900e-08 186.3p -5.057444e-08 186.4p -5.264620e-08 186.5p -5.138878e-08 186.6p -4.705760e-08 186.7p -4.010737e-08 186.8p -3.114716e-08 186.9p -2.088626e-08 187p -1.007620e-08 187.1p 5.464337e-10 187.2p 1.031178e-08
+ 187.3p 1.865947e-08 187.4p 2.516984e-08 187.5p 2.958221e-08 187.6p 3.180004e-08 187.7p 3.188393e-08 187.8p 3.003420e-08 187.9p 2.656530e-08 188p 2.187466e-08 188.1p 1.640874e-08 188.2p 1.062835e-08 188.3p 4.975700e-09 188.4p -1.554835e-10 188.5p -4.445106e-09 188.6p -7.666152e-09 188.7p -9.697405e-09 188.8p -1.052866e-08 188.9p -1.025783e-08 189p -9.079676e-09
+ 189.1p -7.266475e-09 189.2p -5.141435e-09 189.3p -3.046754e-09 189.4p -1.308770e-09 189.5p -2.034520e-10 189.6p 7.421051e-11 189.7p -5.665789e-10 189.8p -2.099552e-09 189.9p -4.380807e-09 190p -7.161159e-09 190.1p -1.011052e-08 190.2p -1.285199e-08 190.3p -1.500203e-08 190.4p -1.621251e-08 190.5p -1.620985e-08 190.6p -1.482714e-08 190.7p -1.202560e-08 190.8p -7.903229e-09
+ 190.9p -2.689716e-09 191p 3.271690e-09 191.1p 9.553319e-09 191.2p 1.568018e-08 191.3p 2.117120e-08 191.4p 2.558063e-08 191.5p 2.853578e-08 191.6p 2.976773e-08 191.7p 2.913277e-08 191.8p 2.662304e-08 191.9p 2.236602e-08 192p 1.661363e-08 192.1p 9.722200e-09 192.2p 2.125473e-09 192.3p -5.696953e-09 192.4p -1.325330e-08 192.5p -2.007291e-08 192.6p -2.573690e-08
+ 192.7p -2.990448e-08 192.8p -3.233329e-08 192.9p -3.289288e-08 193p -3.157071e-08 193.1p -2.847065e-08 193.2p -2.380420e-08 193.3p -1.787514e-08 193.4p -1.105884e-08 193.5p -3.777306e-09 193.6p 3.528115e-09 193.7p 1.042490e-08 193.8p 1.651643e-08 193.9p 2.146641e-08 194p 2.501897e-08 194.1p 2.701323e-08 194.2p 2.739148e-08 194.3p 2.620036e-08 194.4p 2.358500e-08
+ 194.5p 1.977652e-08 194.6p 1.507378e-08 194.7p 9.820474e-09 194.8p 4.379429e-09 194.9p -8.942324e-10 195p -5.678813e-09 195.1p -9.708680e-09 195.2p -1.279189e-08 195.3p -1.482127e-08 195.4p -1.577802e-08 195.5p -1.572744e-08 195.6p -1.480733e-08 195.7p -1.321029e-08 195.8p -1.116169e-08 195.9p -8.895755e-09 196p -6.632099e-09 196.1p -4.555355e-09 196.2p -2.799726e-09
+ 196.3p -1.440006e-09 196.4p -4.896668e-10 196.5p 9.413257e-11 196.6p 3.995654e-10 196.7p 5.447579e-10 196.8p 6.599874e-10 196.9p 8.695984e-10 197p 1.275673e-09 197.1p 1.945158e-09 197.2p 2.901650e-09 197.3p 4.122437e-09 197.4p 5.540762e-09 197.5p 7.052743e-09 197.6p 8.527921e-09 197.7p 9.822149e-09 197.8p 1.079143e-08 197.9p 1.130542e-08 198p 1.125938e-08
+ 198.1p 1.058385e-08 198.2p 9.251392e-09 198.3p 7.280211e-09 198.4p 4.734563e-09 198.5p 1.722157e-09 198.6p -1.611233e-09 198.7p -5.089594e-09 198.8p -8.516569e-09 198.9p -1.168696e-08 199p -1.439934e-08 199.1p -1.646910e-08 199.2p -1.774126e-08 199.3p -1.810217e-08 199.4p -1.748924e-08 199.5p -1.589782e-08 199.6p -1.338452e-08 199.7p -1.006639e-08 199.8p -6.115743e-09
+ 199.9p -1.750690e-09)

.tran 0.1p 200p

.print V(QBIN) V(QBOUT)
.print I(I_REPLAY)
.print I(LIN|XBQ1) V(LIN|XBQ1) I(L1|XBQ1) V(L1|XBQ1) I(L2|XBQ1) V(L2|XBQ1) I(L3|XBQ1) V(L3|XBQ1)
.print I(RJ1|XBQ1) V(RJ1|XBQ1) I(RJ2|XBQ1) V(RJ2|XBQ1) I(IB|XBQ1)
.print P(BJS|XBQ1) V(BJS|XBQ1) I(BJS|XBQ1)
.print P(BJ1|XBQ1) V(BJ1|XBQ1) I(BJ1|XBQ1)
.print P(BJ2|XBQ1) V(BJ2|XBQ1) I(BJ2|XBQ1)
.print P(B01|XJTL1_1) V(B01|XJTL1_1) I(B01|XJTL1_1) P(B02|XJTL1_1) V(B02|XJTL1_1) I(B02|XJTL1_1)
.print V(JTL1_OUT)
.print P(B01|XJTL1_2) V(B01|XJTL1_2) I(B01|XJTL1_2) P(B02|XJTL1_2) V(B02|XJTL1_2) I(B02|XJTL1_2)
.print V(JTL2_OUT)
.print P(B01|XJTL1_3) V(B01|XJTL1_3) I(B01|XJTL1_3) P(B02|XJTL1_3) V(B02|XJTL1_3) I(B02|XJTL1_3)
.print V(JTL3_OUT)
.print P(B01|XJTL1_4) V(B01|XJTL1_4) I(B01|XJTL1_4) P(B02|XJTL1_4) V(B02|XJTL1_4) I(B02|XJTL1_4)
.print V(JTL4_OUT)
.print P(B01|XJTL1_5) V(B01|XJTL1_5) I(B01|XJTL1_5) P(B02|XJTL1_5) V(B02|XJTL1_5) I(B02|XJTL1_5)
.print V(JTL5_OUT)
.print P(B01|XJTL1_6) V(B01|XJTL1_6) I(B01|XJTL1_6) P(B02|XJTL1_6) V(B02|XJTL1_6) I(B02|XJTL1_6)
.print V(JTL6_OUT)
.print I(R_TERM)
.end
