* GENERATED COMMON-SL 12-JSL QB INTEGRATION DECK: mask=1100
* source_class=HISTORICAL_BVMSIM_JM2_CONNECTED_COMMON_SL_12JSL_QB_VARIANT
* causal continuity: passive COMMON_SL -> same 12x500uA JSL -> GND
* authorized boundary only: JSL12 downstream GND -> QBIN
* all four BVMs stored-1111; exactly one final selective READ; no history READ
* final READ active BVMs: BVM1, BVM2

.include ../../../../../circuits/models/jjmit.cir
.include ../../../bvmsim-jm2-connected-single-ab-v1-20260903/variants/bvm_jm2_connected.cir
.include ../../../../../BVMSim/BQ.cir
.include ../../../../../BVMSim/library_josim/jtl2.cir

XBVM1 WL1 BL1 SE1 COMMON_SL BVM
XBVM2 WL2 BL2 SE2 COMMON_SL BVM
XBVM3 WL3 BL3 SE3 COMMON_SL BVM
XBVM4 WL4 BL4 SE4 COMMON_SL BVM

* Same twelve shared JSL elements as passive baseline; only B_JSL12 endpoint is QBIN.
B_JSL01 COMMON_SL COL01 jjmit area=5.0
B_JSL02 COL01 COL02 jjmit area=5.0
B_JSL03 COL02 COL03 jjmit area=5.0
B_JSL04 COL03 COL04 jjmit area=5.0
B_JSL05 COL04 COL05 jjmit area=5.0
B_JSL06 COL05 COL06 jjmit area=5.0
B_JSL07 COL06 COL07 jjmit area=5.0
B_JSL08 COL07 COL08 jjmit area=5.0
B_JSL09 COL08 COL09 jjmit area=5.0
B_JSL10 COL09 COL10 jjmit area=5.0
B_JSL11 COL10 COL11 jjmit area=5.0
B_JSL12 COL11 QBIN jjmit area=5.0

* Frozen historical BVMSim QB and six-stage BVMSim JTL chain.
XBQ1 QBIN QBOUT BQ
xjtl1_1 QBOUT JTL1_OUT jtl
xjtl1_2 JTL1_OUT JTL2_OUT jtl
xjtl1_3 JTL2_OUT JTL3_OUT jtl
xjtl1_4 JTL3_OUT JTL4_OUT jtl
xjtl1_5 JTL4_OUT JTL5_OUT jtl
xjtl1_6 JTL5_OUT JTL6_OUT jtl
R_TERM JTL6_OUT 0 10

I_WL1 0 WL1 pwl(0 0 50p 0 51p -100u 60p -100u 61p 0 70p 0 81p 0 90p 0 91p 100u 100p 100u 101p 0 110p 0 111p 100u 120p 100u 121p 0 200p 0)
I_BL1 0 BL1 pwl(0 0 50p 0 51p -100u 60p -100u 61p 0 70p 0 90p 0 91p 100u 100p 100u 101p 0 110p 0 111p 0 120p 0 121p 0 200p 0)
I_SE1 0 SE1 pwl(0 0 50p 0 70p 0 90p 0 110p 0 111p 100u 120p 100u 121p 0 200p 0)
I_WL2 0 WL2 pwl(0 0 50p 0 51p -100u 60p -100u 61p 0 70p 0 81p 0 90p 0 91p 100u 100p 100u 101p 0 110p 0 111p 100u 120p 100u 121p 0 200p 0)
I_BL2 0 BL2 pwl(0 0 50p 0 51p -100u 60p -100u 61p 0 70p 0 90p 0 91p 100u 100p 100u 101p 0 110p 0 111p 0 120p 0 121p 0 200p 0)
I_SE2 0 SE2 pwl(0 0 50p 0 70p 0 90p 0 110p 0 111p 100u 120p 100u 121p 0 200p 0)
I_WL3 0 WL3 pwl(0 0 50p 0 51p -100u 60p -100u 61p 0 70p 0 81p 0 90p 0 91p 100u 100p 100u 101p 0 110p 0 111p 0 120p 0 121p 0 200p 0)
I_BL3 0 BL3 pwl(0 0 50p 0 51p -100u 60p -100u 61p 0 70p 0 90p 0 91p 100u 100p 100u 101p 0 110p 0 111p 0 120p 0 121p 0 200p 0)
I_SE3 0 SE3 pwl(0 0 50p 0 70p 0 90p 0 110p 0 111p 0 120p 0 121p 0 200p 0)
I_WL4 0 WL4 pwl(0 0 50p 0 51p -100u 60p -100u 61p 0 70p 0 81p 0 90p 0 91p 100u 100p 100u 101p 0 110p 0 111p 0 120p 0 121p 0 200p 0)
I_BL4 0 BL4 pwl(0 0 50p 0 51p -100u 60p -100u 61p 0 70p 0 90p 0 91p 100u 100p 100u 101p 0 110p 0 111p 0 120p 0 121p 0 200p 0)
I_SE4 0 SE4 pwl(0 0 50p 0 70p 0 90p 0 110p 0 111p 0 120p 0 121p 0 200p 0)

.tran 0.1p 200p 45p

* Full registered probe schema: BVM source, JSL interface, QB, JTL, termination.
.print I(I_WL1) I(I_BL1) I(I_SE1) P(B_JM1|XBVM1) V(B_JM1|XBVM1) I(B_JM1|XBVM1) P(B_JM2|XBVM1) V(B_JM2|XBVM1)
.print I(B_JM2|XBVM1) P(B_JS1|XBVM1) V(B_JS1|XBVM1) I(B_JS1|XBVM1) P(B_JS2|XBVM1) V(B_JS2|XBVM1) I(B_JS2|XBVM1) I(L_M1|XBVM1)
.print V(L_M1|XBVM1) I(L_M2|XBVM1) V(L_M2|XBVM1) I(L_M3|XBVM1) V(L_M3|XBVM1) I(L_PM|XBVM1) V(L_PM|XBVM1) I(R_JM1|XBVM1)
.print V(R_JM1|XBVM1) I(L_S1|XBVM1) V(L_S1|XBVM1) I(L_S2|XBVM1) V(L_S2|XBVM1) I(R_S|XBVM1) V(R_S|XBVM1) I(L_S3|XBVM1)
.print V(L_S3|XBVM1) I(R_SE|XBVM1) V(R_SE|XBVM1) I(L_PSE|XBVM1) V(L_PSE|XBVM1) I(L_PSL|XBVM1) V(L_PSL|XBVM1) I(R_SL|XBVM1)
.print V(R_SL|XBVM1) I(L_SL|XBVM1) V(L_SL|XBVM1) I(I_WL2) I(I_BL2) I(I_SE2) P(B_JM1|XBVM2) V(B_JM1|XBVM2)
.print I(B_JM1|XBVM2) P(B_JM2|XBVM2) V(B_JM2|XBVM2) I(B_JM2|XBVM2) P(B_JS1|XBVM2) V(B_JS1|XBVM2) I(B_JS1|XBVM2) P(B_JS2|XBVM2)
.print V(B_JS2|XBVM2) I(B_JS2|XBVM2) I(L_M1|XBVM2) V(L_M1|XBVM2) I(L_M2|XBVM2) V(L_M2|XBVM2) I(L_M3|XBVM2) V(L_M3|XBVM2)
.print I(L_PM|XBVM2) V(L_PM|XBVM2) I(R_JM1|XBVM2) V(R_JM1|XBVM2) I(L_S1|XBVM2) V(L_S1|XBVM2) I(L_S2|XBVM2) V(L_S2|XBVM2)
.print I(R_S|XBVM2) V(R_S|XBVM2) I(L_S3|XBVM2) V(L_S3|XBVM2) I(R_SE|XBVM2) V(R_SE|XBVM2) I(L_PSE|XBVM2) V(L_PSE|XBVM2)
.print I(L_PSL|XBVM2) V(L_PSL|XBVM2) I(R_SL|XBVM2) V(R_SL|XBVM2) I(L_SL|XBVM2) V(L_SL|XBVM2) I(I_WL3) I(I_BL3)
.print I(I_SE3) P(B_JM1|XBVM3) V(B_JM1|XBVM3) I(B_JM1|XBVM3) P(B_JM2|XBVM3) V(B_JM2|XBVM3) I(B_JM2|XBVM3) P(B_JS1|XBVM3)
.print V(B_JS1|XBVM3) I(B_JS1|XBVM3) P(B_JS2|XBVM3) V(B_JS2|XBVM3) I(B_JS2|XBVM3) I(L_M1|XBVM3) V(L_M1|XBVM3) I(L_M2|XBVM3)
.print V(L_M2|XBVM3) I(L_M3|XBVM3) V(L_M3|XBVM3) I(L_PM|XBVM3) V(L_PM|XBVM3) I(R_JM1|XBVM3) V(R_JM1|XBVM3) I(L_S1|XBVM3)
.print V(L_S1|XBVM3) I(L_S2|XBVM3) V(L_S2|XBVM3) I(R_S|XBVM3) V(R_S|XBVM3) I(L_S3|XBVM3) V(L_S3|XBVM3) I(R_SE|XBVM3)
.print V(R_SE|XBVM3) I(L_PSE|XBVM3) V(L_PSE|XBVM3) I(L_PSL|XBVM3) V(L_PSL|XBVM3) I(R_SL|XBVM3) V(R_SL|XBVM3) I(L_SL|XBVM3)
.print V(L_SL|XBVM3) I(I_WL4) I(I_BL4) I(I_SE4) P(B_JM1|XBVM4) V(B_JM1|XBVM4) I(B_JM1|XBVM4) P(B_JM2|XBVM4)
.print V(B_JM2|XBVM4) I(B_JM2|XBVM4) P(B_JS1|XBVM4) V(B_JS1|XBVM4) I(B_JS1|XBVM4) P(B_JS2|XBVM4) V(B_JS2|XBVM4) I(B_JS2|XBVM4)
.print I(L_M1|XBVM4) V(L_M1|XBVM4) I(L_M2|XBVM4) V(L_M2|XBVM4) I(L_M3|XBVM4) V(L_M3|XBVM4) I(L_PM|XBVM4) V(L_PM|XBVM4)
.print I(R_JM1|XBVM4) V(R_JM1|XBVM4) I(L_S1|XBVM4) V(L_S1|XBVM4) I(L_S2|XBVM4) V(L_S2|XBVM4) I(R_S|XBVM4) V(R_S|XBVM4)
.print I(L_S3|XBVM4) V(L_S3|XBVM4) I(R_SE|XBVM4) V(R_SE|XBVM4) I(L_PSE|XBVM4) V(L_PSE|XBVM4) I(L_PSL|XBVM4) V(L_PSL|XBVM4)
.print I(R_SL|XBVM4) V(R_SL|XBVM4) I(L_SL|XBVM4) V(L_SL|XBVM4) V(COMMON_SL) P(B_JSL01) V(B_JSL01) I(B_JSL01)
.print P(B_JSL02) V(B_JSL02) I(B_JSL02) P(B_JSL03) V(B_JSL03) I(B_JSL03) P(B_JSL04) V(B_JSL04)
.print I(B_JSL04) P(B_JSL05) V(B_JSL05) I(B_JSL05) P(B_JSL06) V(B_JSL06) I(B_JSL06) P(B_JSL07)
.print V(B_JSL07) I(B_JSL07) P(B_JSL08) V(B_JSL08) I(B_JSL08) P(B_JSL09) V(B_JSL09) I(B_JSL09)
.print P(B_JSL10) V(B_JSL10) I(B_JSL10) P(B_JSL11) V(B_JSL11) I(B_JSL11) P(B_JSL12) V(B_JSL12)
.print I(B_JSL12) V(QBIN) V(QBOUT) V(JTL1_OUT) V(JTL2_OUT) V(JTL3_OUT) V(JTL4_OUT) V(JTL5_OUT)
.print V(JTL6_OUT) I(R_TERM) I(LIN|XBQ1) I(L1|XBQ1) I(L2|XBQ1) I(L3|XBQ1) I(RJ1|XBQ1) I(RJ2|XBQ1)
.print I(IB|XBQ1) P(BJS|XBQ1) V(BJS|XBQ1) I(BJS|XBQ1) P(BJ1|XBQ1) V(BJ1|XBQ1) I(BJ1|XBQ1) P(BJ2|XBQ1)
.print V(BJ2|XBQ1) I(BJ2|XBQ1) P(B01|XJTL1_1) V(B01|XJTL1_1) P(B02|XJTL1_1) V(B02|XJTL1_1) P(B01|XJTL1_2) V(B01|XJTL1_2)
.print P(B02|XJTL1_2) V(B02|XJTL1_2) P(B01|XJTL1_3) V(B01|XJTL1_3) P(B02|XJTL1_3) V(B02|XJTL1_3) P(B01|XJTL1_4) V(B01|XJTL1_4)
.print P(B02|XJTL1_4) V(B02|XJTL1_4) P(B01|XJTL1_5) V(B01|XJTL1_5) P(B02|XJTL1_5) V(B02|XJTL1_5) P(B01|XJTL1_6) V(B01|XJTL1_6)
.print P(B02|XJTL1_6) V(B02|XJTL1_6)
.end
