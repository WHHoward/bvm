* BVM S2 init-timing A-negative -- S2_REGISTERED, R_LD=12ohm, dt=0.0125ps, tstop=92ps, no-read (frozen)
* Closure: copied jjmit + bvm_cell; XBVM1 WL1 BL1 SE1 SL1 BVM; only variable is registered rising edge
* Init: S2 9-10ps rising edge, +/-100uA plateau through 20ps, 0 at 21ps.
* Read: NO read pulse; SE 0 uA throughout; tstop=92ps precedes the historical 95ps read onset.
.include jjmit.cir
.include bvm_cell.cir

XBVM1 WL1 BL1 SE1 SL1 BVM

R_LD SL1 0 12

I_WL1 0 WL1 pwl(0p 0 9p 0 10p -100U 20p -100U 21p 0 92p 0)
I_BL1 0 BL1 pwl(0p 0 9p 0 10p -100U 20p -100U 21p 0 92p 0)
I_SE1 0 SE1 pwl(0p 0 92p 0)

.tran 0.0125p 92p

* Direct probes (preregistration.yaml):
.print P(B_JM1|XBVM1) V(B_JM1|XBVM1)
.print P(B_JM2|XBVM1) V(B_JM2|XBVM1)
.print P(B_JS1|XBVM1) V(B_JS1|XBVM1)
.print P(B_JS2|XBVM1) V(B_JS2|XBVM1)
.print V(SL1) I(L_SL|XBVM1)
.print I(I_WL1) I(I_BL1) I(I_SE1)
.end
