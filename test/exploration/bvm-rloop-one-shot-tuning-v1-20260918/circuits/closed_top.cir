* CLOSED: BVM array -> COMMON_SL -> JSL1..8 -> current QB -> JTL6 -> 10 ohm terminal.
{{JJ_INCLUDE}}
{{BVM_INCLUDE}}
{{QB_INCLUDE}}
{{JTL_INCLUDE}}
{{STIMULUS_INCLUDE}}

{{BVM_INSTANCES}}

B_JSL1 COMMON_SL JSL_NODE1 jjmit area=5.0
B_JSL2 JSL_NODE1 JSL_NODE2 jjmit area=5.0
B_JSL3 JSL_NODE2 JSL_NODE3 jjmit area=5.0
B_JSL4 JSL_NODE3 JSL_NODE4 jjmit area=5.0
B_JSL5 JSL_NODE4 JSL_NODE5 jjmit area=5.0
B_JSL6 JSL_NODE5 JSL_NODE6 jjmit area=5.0
B_JSL7 JSL_NODE6 JSL_NODE7 jjmit area=5.0
B_JSL8 JSL_NODE7 QBIN jjmit area=5.0

XBQ1 QBIN QBOUT BQ
XJTL1_1 QBOUT JTL1_OUT jtl
XJTL1_2 JTL1_OUT JTL2_OUT jtl
XJTL1_3 JTL2_OUT JTL3_OUT jtl
XJTL1_4 JTL3_OUT JTL4_OUT jtl
XJTL1_5 JTL4_OUT JTL5_OUT jtl
XJTL1_6 JTL5_OUT JTL6_OUT jtl
R_TERM JTL6_OUT 0 10

{{PROBES}}
.tran {{DT}} {{STOP_TIME}}
.end
