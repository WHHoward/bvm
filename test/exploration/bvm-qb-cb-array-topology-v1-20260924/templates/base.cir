* Generated top-level deck; component parameters live only in source snapshots.
.title BVM array -> QB/CB/sJTL topology fixture
{{SOURCE_INCLUDES}}
{{STIMULUS_INCLUDE}}

{{TOPOLOGY_BLOCK}}

R_TERM FINAL_OUT 0 {{TERM_R}}
{{PROBE_BLOCK}}
.tran {{DT}} {{STOP}}
.end
