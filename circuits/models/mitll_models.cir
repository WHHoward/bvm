* MITLL SFQ5ee JJ Models for BVM Simulation v2
* Realistic parameters for Nb/AlOx-Al/Nb junctions
* Jc ~ 4.5 kA/cm², βc ~ 1, RN·IC ~ 0.25mV

* JM1 - Storage Loop switching junction (120uA)
* RN = 0.25mV/120uA ≈ 2Ω, C ≈ 0.6pF (for βc~1)
.model jj120 jj(RTYPE=1, IC=120U, RN=2, R0=6, CAP=0.6P, VG=2.8M, DELV=0.1M)

* JM2 - Storage Loop non-switching junction (140uA)
.model jj140 jj(RTYPE=1, IC=140U, RN=1.8, R0=5.4, CAP=0.7P, VG=2.8M, DELV=0.1M)

* JS1, JS2 - Readout Loop sense junctions (74uA)
.model jj74  jj(RTYPE=1, IC=74U, RN=3.5, R0=10.5, CAP=0.4P, VG=2.8M, DELV=0.1M)

* Non-switching load junctions for SL termination (320uA)
.model jj320 jj(RTYPE=1, IC=320U, RN=0.8, R0=2.4, CAP=1.5P, VG=2.8M, DELV=0.1M)

* BQ JS - Series junction on main path (133uA)
.model jj133 jj(RTYPE=1, IC=133U, RN=1.9, R0=5.7, CAP=0.7P, VG=2.8M, DELV=0.1M)

* BQ JL1 - Left shunt junction (112uA)
.model jj112 jj(RTYPE=1, IC=112U, RN=2.2, R0=6.6, CAP=0.55P, VG=2.8M, DELV=0.1M)

* BQ JL2 - Right shunt junction (189uA)
.model jj189 jj(RTYPE=1, IC=189U, RN=1.3, R0=3.9, CAP=1.0P, VG=2.8M, DELV=0.1M)
