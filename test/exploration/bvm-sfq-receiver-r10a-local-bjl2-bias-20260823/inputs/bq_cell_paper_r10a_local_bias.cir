* R10-A experiment-local copy of native paper QB.
* Native topology and all JJ/L/R values are unchanged from R9-A.
* Only addition: finite-impedance local bias feed into native node 4,
* which is the top terminal of BJL2.  BIAS is an external source port.
*
* Feed direction: BIAS -> R_LOCAL_BJL2 -> L_LOCAL_BJL2 -> node 4.
* This is an independent DC bias injection, not a resistor directly across
* BJL2 and not a passive damping shunt.

.subckt BQ_PAPER_R10A IN OUT IB BIAS

Lin IN 1 0.8p
L0 4 OUT 1.323p
L1 2 3 2.50p
L2 3 4 2.50p
BJs 1 2 jjmit area=1.33
BJL1 2 0 jjmit area=1.12
RJ1 2 0 33
BJL2 4 0 jjmit area=1.89
RJ2 4 0 22
RB IB 3 8.5

* Local output-side bias feed; finite DC and transient source impedance.
R_LOCAL_BJL2 BIAS N_LOCAL_BJL2 100.0
L_LOCAL_BJL2 N_LOCAL_BJL2 4 10.0p

.ends BQ_PAPER_R10A
